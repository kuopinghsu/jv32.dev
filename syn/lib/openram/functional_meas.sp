.meas tran vdout0_0ck40 FIND v(dout0_0) AT=25.025n

.meas tran vdout0_1ck40 FIND v(dout0_1) AT=25.025n

.meas tran vdout0_2ck40 FIND v(dout0_2) AT=25.025n

.meas tran vdout0_3ck40 FIND v(dout0_3) AT=25.025n

.meas tran vdout0_4ck40 FIND v(dout0_4) AT=25.025n

.meas tran vdout0_5ck40 FIND v(dout0_5) AT=25.025n

.meas tran vdout0_6ck40 FIND v(dout0_6) AT=25.025n

.meas tran vdout0_7ck40 FIND v(dout0_7) AT=25.025n

.meas tran vdout0_8ck40 FIND v(dout0_8) AT=25.025n

.meas tran vdout0_9ck40 FIND v(dout0_9) AT=25.025n

.meas tran vdout0_10ck40 FIND v(dout0_10) AT=25.025n

.meas tran vdout0_11ck40 FIND v(dout0_11) AT=25.025n

.meas tran vdout0_12ck40 FIND v(dout0_12) AT=25.025n

.meas tran vdout0_13ck40 FIND v(dout0_13) AT=25.025n

.meas tran vdout0_14ck40 FIND v(dout0_14) AT=25.025n

.meas tran vdout0_15ck40 FIND v(dout0_15) AT=25.025n

.meas tran vdout0_16ck40 FIND v(dout0_16) AT=25.025n

.meas tran vdout0_17ck40 FIND v(dout0_17) AT=25.025n

.meas tran vdout0_18ck40 FIND v(dout0_18) AT=25.025n

.meas tran vdout0_19ck40 FIND v(dout0_19) AT=25.025n

.meas tran vdout0_20ck40 FIND v(dout0_20) AT=25.025n

.meas tran vdout0_21ck40 FIND v(dout0_21) AT=25.025n

.meas tran vdout0_22ck40 FIND v(dout0_22) AT=25.025n

.meas tran vdout0_23ck40 FIND v(dout0_23) AT=25.025n

.meas tran vdout0_24ck40 FIND v(dout0_24) AT=25.025n

.meas tran vdout0_25ck40 FIND v(dout0_25) AT=25.025n

.meas tran vdout0_26ck40 FIND v(dout0_26) AT=25.025n

.meas tran vdout0_27ck40 FIND v(dout0_27) AT=25.025n

.meas tran vdout0_28ck40 FIND v(dout0_28) AT=25.025n

.meas tran vdout0_29ck40 FIND v(dout0_29) AT=25.025n

.meas tran vdout0_30ck40 FIND v(dout0_30) AT=25.025n

.meas tran vdout0_31ck40 FIND v(dout0_31) AT=25.025n

.meas tran vdout0_32ck40 FIND v(dout0_32) AT=25.025n

.meas tran vdout0_33ck40 FIND v(dout0_33) AT=25.025n

.meas tran vdout0_34ck40 FIND v(dout0_34) AT=25.025n

.meas tran vdout0_35ck40 FIND v(dout0_35) AT=25.025n

.meas tran vdout0_36ck40 FIND v(dout0_36) AT=25.025n

.meas tran vdout0_37ck40 FIND v(dout0_37) AT=25.025n

.meas tran vdout0_38ck40 FIND v(dout0_38) AT=25.025n

.meas tran vdout0_39ck40 FIND v(dout0_39) AT=25.025n

.meas tran vdout0_40ck40 FIND v(dout0_40) AT=25.025n

.meas tran vdout0_41ck40 FIND v(dout0_41) AT=25.025n

.meas tran vdout0_42ck40 FIND v(dout0_42) AT=25.025n

.meas tran vdout0_43ck40 FIND v(dout0_43) AT=25.025n

.meas tran vdout0_44ck40 FIND v(dout0_44) AT=25.025n

.meas tran vdout0_45ck40 FIND v(dout0_45) AT=25.025n

.meas tran vdout0_46ck40 FIND v(dout0_46) AT=25.025n

.meas tran vdout0_47ck40 FIND v(dout0_47) AT=25.025n

.meas tran vdout0_48ck40 FIND v(dout0_48) AT=25.025n

.meas tran vdout0_49ck40 FIND v(dout0_49) AT=25.025n

.meas tran vdout0_50ck40 FIND v(dout0_50) AT=25.025n

.meas tran vdout0_51ck40 FIND v(dout0_51) AT=25.025n

.meas tran vdout0_52ck40 FIND v(dout0_52) AT=25.025n

.meas tran vdout0_53ck40 FIND v(dout0_53) AT=25.025n

.meas tran vdout0_54ck40 FIND v(dout0_54) AT=25.025n

.meas tran vdout0_55ck40 FIND v(dout0_55) AT=25.025n

.meas tran vdout0_56ck40 FIND v(dout0_56) AT=25.025n

.meas tran vdout0_57ck40 FIND v(dout0_57) AT=25.025n

.meas tran vdout0_58ck40 FIND v(dout0_58) AT=25.025n

.meas tran vdout0_59ck40 FIND v(dout0_59) AT=25.025n

.meas tran vdout0_60ck40 FIND v(dout0_60) AT=25.025n

.meas tran vdout0_61ck40 FIND v(dout0_61) AT=25.025n

.meas tran vdout0_62ck40 FIND v(dout0_62) AT=25.025n

.meas tran vdout0_63ck40 FIND v(dout0_63) AT=25.025n

.meas tran vdout0_0ck80 FIND v(dout0_0) AT=45.025n

.meas tran vdout0_1ck80 FIND v(dout0_1) AT=45.025n

.meas tran vdout0_2ck80 FIND v(dout0_2) AT=45.025n

.meas tran vdout0_3ck80 FIND v(dout0_3) AT=45.025n

.meas tran vdout0_4ck80 FIND v(dout0_4) AT=45.025n

.meas tran vdout0_5ck80 FIND v(dout0_5) AT=45.025n

.meas tran vdout0_6ck80 FIND v(dout0_6) AT=45.025n

.meas tran vdout0_7ck80 FIND v(dout0_7) AT=45.025n

.meas tran vdout0_8ck80 FIND v(dout0_8) AT=45.025n

.meas tran vdout0_9ck80 FIND v(dout0_9) AT=45.025n

.meas tran vdout0_10ck80 FIND v(dout0_10) AT=45.025n

.meas tran vdout0_11ck80 FIND v(dout0_11) AT=45.025n

.meas tran vdout0_12ck80 FIND v(dout0_12) AT=45.025n

.meas tran vdout0_13ck80 FIND v(dout0_13) AT=45.025n

.meas tran vdout0_14ck80 FIND v(dout0_14) AT=45.025n

.meas tran vdout0_15ck80 FIND v(dout0_15) AT=45.025n

.meas tran vdout0_16ck80 FIND v(dout0_16) AT=45.025n

.meas tran vdout0_17ck80 FIND v(dout0_17) AT=45.025n

.meas tran vdout0_18ck80 FIND v(dout0_18) AT=45.025n

.meas tran vdout0_19ck80 FIND v(dout0_19) AT=45.025n

.meas tran vdout0_20ck80 FIND v(dout0_20) AT=45.025n

.meas tran vdout0_21ck80 FIND v(dout0_21) AT=45.025n

.meas tran vdout0_22ck80 FIND v(dout0_22) AT=45.025n

.meas tran vdout0_23ck80 FIND v(dout0_23) AT=45.025n

.meas tran vdout0_24ck80 FIND v(dout0_24) AT=45.025n

.meas tran vdout0_25ck80 FIND v(dout0_25) AT=45.025n

.meas tran vdout0_26ck80 FIND v(dout0_26) AT=45.025n

.meas tran vdout0_27ck80 FIND v(dout0_27) AT=45.025n

.meas tran vdout0_28ck80 FIND v(dout0_28) AT=45.025n

.meas tran vdout0_29ck80 FIND v(dout0_29) AT=45.025n

.meas tran vdout0_30ck80 FIND v(dout0_30) AT=45.025n

.meas tran vdout0_31ck80 FIND v(dout0_31) AT=45.025n

.meas tran vdout0_32ck80 FIND v(dout0_32) AT=45.025n

.meas tran vdout0_33ck80 FIND v(dout0_33) AT=45.025n

.meas tran vdout0_34ck80 FIND v(dout0_34) AT=45.025n

.meas tran vdout0_35ck80 FIND v(dout0_35) AT=45.025n

.meas tran vdout0_36ck80 FIND v(dout0_36) AT=45.025n

.meas tran vdout0_37ck80 FIND v(dout0_37) AT=45.025n

.meas tran vdout0_38ck80 FIND v(dout0_38) AT=45.025n

.meas tran vdout0_39ck80 FIND v(dout0_39) AT=45.025n

.meas tran vdout0_40ck80 FIND v(dout0_40) AT=45.025n

.meas tran vdout0_41ck80 FIND v(dout0_41) AT=45.025n

.meas tran vdout0_42ck80 FIND v(dout0_42) AT=45.025n

.meas tran vdout0_43ck80 FIND v(dout0_43) AT=45.025n

.meas tran vdout0_44ck80 FIND v(dout0_44) AT=45.025n

.meas tran vdout0_45ck80 FIND v(dout0_45) AT=45.025n

.meas tran vdout0_46ck80 FIND v(dout0_46) AT=45.025n

.meas tran vdout0_47ck80 FIND v(dout0_47) AT=45.025n

.meas tran vdout0_48ck80 FIND v(dout0_48) AT=45.025n

.meas tran vdout0_49ck80 FIND v(dout0_49) AT=45.025n

.meas tran vdout0_50ck80 FIND v(dout0_50) AT=45.025n

.meas tran vdout0_51ck80 FIND v(dout0_51) AT=45.025n

.meas tran vdout0_52ck80 FIND v(dout0_52) AT=45.025n

.meas tran vdout0_53ck80 FIND v(dout0_53) AT=45.025n

.meas tran vdout0_54ck80 FIND v(dout0_54) AT=45.025n

.meas tran vdout0_55ck80 FIND v(dout0_55) AT=45.025n

.meas tran vdout0_56ck80 FIND v(dout0_56) AT=45.025n

.meas tran vdout0_57ck80 FIND v(dout0_57) AT=45.025n

.meas tran vdout0_58ck80 FIND v(dout0_58) AT=45.025n

.meas tran vdout0_59ck80 FIND v(dout0_59) AT=45.025n

.meas tran vdout0_60ck80 FIND v(dout0_60) AT=45.025n

.meas tran vdout0_61ck80 FIND v(dout0_61) AT=45.025n

.meas tran vdout0_62ck80 FIND v(dout0_62) AT=45.025n

.meas tran vdout0_63ck80 FIND v(dout0_63) AT=45.025n

.meas tran vdout0_0ck100 FIND v(dout0_0) AT=55.025n

.meas tran vdout0_1ck100 FIND v(dout0_1) AT=55.025n

.meas tran vdout0_2ck100 FIND v(dout0_2) AT=55.025n

.meas tran vdout0_3ck100 FIND v(dout0_3) AT=55.025n

.meas tran vdout0_4ck100 FIND v(dout0_4) AT=55.025n

.meas tran vdout0_5ck100 FIND v(dout0_5) AT=55.025n

.meas tran vdout0_6ck100 FIND v(dout0_6) AT=55.025n

.meas tran vdout0_7ck100 FIND v(dout0_7) AT=55.025n

.meas tran vdout0_8ck100 FIND v(dout0_8) AT=55.025n

.meas tran vdout0_9ck100 FIND v(dout0_9) AT=55.025n

.meas tran vdout0_10ck100 FIND v(dout0_10) AT=55.025n

.meas tran vdout0_11ck100 FIND v(dout0_11) AT=55.025n

.meas tran vdout0_12ck100 FIND v(dout0_12) AT=55.025n

.meas tran vdout0_13ck100 FIND v(dout0_13) AT=55.025n

.meas tran vdout0_14ck100 FIND v(dout0_14) AT=55.025n

.meas tran vdout0_15ck100 FIND v(dout0_15) AT=55.025n

.meas tran vdout0_16ck100 FIND v(dout0_16) AT=55.025n

.meas tran vdout0_17ck100 FIND v(dout0_17) AT=55.025n

.meas tran vdout0_18ck100 FIND v(dout0_18) AT=55.025n

.meas tran vdout0_19ck100 FIND v(dout0_19) AT=55.025n

.meas tran vdout0_20ck100 FIND v(dout0_20) AT=55.025n

.meas tran vdout0_21ck100 FIND v(dout0_21) AT=55.025n

.meas tran vdout0_22ck100 FIND v(dout0_22) AT=55.025n

.meas tran vdout0_23ck100 FIND v(dout0_23) AT=55.025n

.meas tran vdout0_24ck100 FIND v(dout0_24) AT=55.025n

.meas tran vdout0_25ck100 FIND v(dout0_25) AT=55.025n

.meas tran vdout0_26ck100 FIND v(dout0_26) AT=55.025n

.meas tran vdout0_27ck100 FIND v(dout0_27) AT=55.025n

.meas tran vdout0_28ck100 FIND v(dout0_28) AT=55.025n

.meas tran vdout0_29ck100 FIND v(dout0_29) AT=55.025n

.meas tran vdout0_30ck100 FIND v(dout0_30) AT=55.025n

.meas tran vdout0_31ck100 FIND v(dout0_31) AT=55.025n

.meas tran vdout0_32ck100 FIND v(dout0_32) AT=55.025n

.meas tran vdout0_33ck100 FIND v(dout0_33) AT=55.025n

.meas tran vdout0_34ck100 FIND v(dout0_34) AT=55.025n

.meas tran vdout0_35ck100 FIND v(dout0_35) AT=55.025n

.meas tran vdout0_36ck100 FIND v(dout0_36) AT=55.025n

.meas tran vdout0_37ck100 FIND v(dout0_37) AT=55.025n

.meas tran vdout0_38ck100 FIND v(dout0_38) AT=55.025n

.meas tran vdout0_39ck100 FIND v(dout0_39) AT=55.025n

.meas tran vdout0_40ck100 FIND v(dout0_40) AT=55.025n

.meas tran vdout0_41ck100 FIND v(dout0_41) AT=55.025n

.meas tran vdout0_42ck100 FIND v(dout0_42) AT=55.025n

.meas tran vdout0_43ck100 FIND v(dout0_43) AT=55.025n

.meas tran vdout0_44ck100 FIND v(dout0_44) AT=55.025n

.meas tran vdout0_45ck100 FIND v(dout0_45) AT=55.025n

.meas tran vdout0_46ck100 FIND v(dout0_46) AT=55.025n

.meas tran vdout0_47ck100 FIND v(dout0_47) AT=55.025n

.meas tran vdout0_48ck100 FIND v(dout0_48) AT=55.025n

.meas tran vdout0_49ck100 FIND v(dout0_49) AT=55.025n

.meas tran vdout0_50ck100 FIND v(dout0_50) AT=55.025n

.meas tran vdout0_51ck100 FIND v(dout0_51) AT=55.025n

.meas tran vdout0_52ck100 FIND v(dout0_52) AT=55.025n

.meas tran vdout0_53ck100 FIND v(dout0_53) AT=55.025n

.meas tran vdout0_54ck100 FIND v(dout0_54) AT=55.025n

.meas tran vdout0_55ck100 FIND v(dout0_55) AT=55.025n

.meas tran vdout0_56ck100 FIND v(dout0_56) AT=55.025n

.meas tran vdout0_57ck100 FIND v(dout0_57) AT=55.025n

.meas tran vdout0_58ck100 FIND v(dout0_58) AT=55.025n

.meas tran vdout0_59ck100 FIND v(dout0_59) AT=55.025n

.meas tran vdout0_60ck100 FIND v(dout0_60) AT=55.025n

.meas tran vdout0_61ck100 FIND v(dout0_61) AT=55.025n

.meas tran vdout0_62ck100 FIND v(dout0_62) AT=55.025n

.meas tran vdout0_63ck100 FIND v(dout0_63) AT=55.025n

.meas tran vdout0_0ck140 FIND v(dout0_0) AT=75.025n

.meas tran vdout0_1ck140 FIND v(dout0_1) AT=75.025n

.meas tran vdout0_2ck140 FIND v(dout0_2) AT=75.025n

.meas tran vdout0_3ck140 FIND v(dout0_3) AT=75.025n

.meas tran vdout0_4ck140 FIND v(dout0_4) AT=75.025n

.meas tran vdout0_5ck140 FIND v(dout0_5) AT=75.025n

.meas tran vdout0_6ck140 FIND v(dout0_6) AT=75.025n

.meas tran vdout0_7ck140 FIND v(dout0_7) AT=75.025n

.meas tran vdout0_8ck140 FIND v(dout0_8) AT=75.025n

.meas tran vdout0_9ck140 FIND v(dout0_9) AT=75.025n

.meas tran vdout0_10ck140 FIND v(dout0_10) AT=75.025n

.meas tran vdout0_11ck140 FIND v(dout0_11) AT=75.025n

.meas tran vdout0_12ck140 FIND v(dout0_12) AT=75.025n

.meas tran vdout0_13ck140 FIND v(dout0_13) AT=75.025n

.meas tran vdout0_14ck140 FIND v(dout0_14) AT=75.025n

.meas tran vdout0_15ck140 FIND v(dout0_15) AT=75.025n

.meas tran vdout0_16ck140 FIND v(dout0_16) AT=75.025n

.meas tran vdout0_17ck140 FIND v(dout0_17) AT=75.025n

.meas tran vdout0_18ck140 FIND v(dout0_18) AT=75.025n

.meas tran vdout0_19ck140 FIND v(dout0_19) AT=75.025n

.meas tran vdout0_20ck140 FIND v(dout0_20) AT=75.025n

.meas tran vdout0_21ck140 FIND v(dout0_21) AT=75.025n

.meas tran vdout0_22ck140 FIND v(dout0_22) AT=75.025n

.meas tran vdout0_23ck140 FIND v(dout0_23) AT=75.025n

.meas tran vdout0_24ck140 FIND v(dout0_24) AT=75.025n

.meas tran vdout0_25ck140 FIND v(dout0_25) AT=75.025n

.meas tran vdout0_26ck140 FIND v(dout0_26) AT=75.025n

.meas tran vdout0_27ck140 FIND v(dout0_27) AT=75.025n

.meas tran vdout0_28ck140 FIND v(dout0_28) AT=75.025n

.meas tran vdout0_29ck140 FIND v(dout0_29) AT=75.025n

.meas tran vdout0_30ck140 FIND v(dout0_30) AT=75.025n

.meas tran vdout0_31ck140 FIND v(dout0_31) AT=75.025n

.meas tran vdout0_32ck140 FIND v(dout0_32) AT=75.025n

.meas tran vdout0_33ck140 FIND v(dout0_33) AT=75.025n

.meas tran vdout0_34ck140 FIND v(dout0_34) AT=75.025n

.meas tran vdout0_35ck140 FIND v(dout0_35) AT=75.025n

.meas tran vdout0_36ck140 FIND v(dout0_36) AT=75.025n

.meas tran vdout0_37ck140 FIND v(dout0_37) AT=75.025n

.meas tran vdout0_38ck140 FIND v(dout0_38) AT=75.025n

.meas tran vdout0_39ck140 FIND v(dout0_39) AT=75.025n

.meas tran vdout0_40ck140 FIND v(dout0_40) AT=75.025n

.meas tran vdout0_41ck140 FIND v(dout0_41) AT=75.025n

.meas tran vdout0_42ck140 FIND v(dout0_42) AT=75.025n

.meas tran vdout0_43ck140 FIND v(dout0_43) AT=75.025n

.meas tran vdout0_44ck140 FIND v(dout0_44) AT=75.025n

.meas tran vdout0_45ck140 FIND v(dout0_45) AT=75.025n

.meas tran vdout0_46ck140 FIND v(dout0_46) AT=75.025n

.meas tran vdout0_47ck140 FIND v(dout0_47) AT=75.025n

.meas tran vdout0_48ck140 FIND v(dout0_48) AT=75.025n

.meas tran vdout0_49ck140 FIND v(dout0_49) AT=75.025n

.meas tran vdout0_50ck140 FIND v(dout0_50) AT=75.025n

.meas tran vdout0_51ck140 FIND v(dout0_51) AT=75.025n

.meas tran vdout0_52ck140 FIND v(dout0_52) AT=75.025n

.meas tran vdout0_53ck140 FIND v(dout0_53) AT=75.025n

.meas tran vdout0_54ck140 FIND v(dout0_54) AT=75.025n

.meas tran vdout0_55ck140 FIND v(dout0_55) AT=75.025n

.meas tran vdout0_56ck140 FIND v(dout0_56) AT=75.025n

.meas tran vdout0_57ck140 FIND v(dout0_57) AT=75.025n

.meas tran vdout0_58ck140 FIND v(dout0_58) AT=75.025n

.meas tran vdout0_59ck140 FIND v(dout0_59) AT=75.025n

.meas tran vdout0_60ck140 FIND v(dout0_60) AT=75.025n

.meas tran vdout0_61ck140 FIND v(dout0_61) AT=75.025n

.meas tran vdout0_62ck140 FIND v(dout0_62) AT=75.025n

.meas tran vdout0_63ck140 FIND v(dout0_63) AT=75.025n

.meas tran vdout0_0ck150 FIND v(dout0_0) AT=80.025n

.meas tran vdout0_1ck150 FIND v(dout0_1) AT=80.025n

.meas tran vdout0_2ck150 FIND v(dout0_2) AT=80.025n

.meas tran vdout0_3ck150 FIND v(dout0_3) AT=80.025n

.meas tran vdout0_4ck150 FIND v(dout0_4) AT=80.025n

.meas tran vdout0_5ck150 FIND v(dout0_5) AT=80.025n

.meas tran vdout0_6ck150 FIND v(dout0_6) AT=80.025n

.meas tran vdout0_7ck150 FIND v(dout0_7) AT=80.025n

.meas tran vdout0_8ck150 FIND v(dout0_8) AT=80.025n

.meas tran vdout0_9ck150 FIND v(dout0_9) AT=80.025n

.meas tran vdout0_10ck150 FIND v(dout0_10) AT=80.025n

.meas tran vdout0_11ck150 FIND v(dout0_11) AT=80.025n

.meas tran vdout0_12ck150 FIND v(dout0_12) AT=80.025n

.meas tran vdout0_13ck150 FIND v(dout0_13) AT=80.025n

.meas tran vdout0_14ck150 FIND v(dout0_14) AT=80.025n

.meas tran vdout0_15ck150 FIND v(dout0_15) AT=80.025n

.meas tran vdout0_16ck150 FIND v(dout0_16) AT=80.025n

.meas tran vdout0_17ck150 FIND v(dout0_17) AT=80.025n

.meas tran vdout0_18ck150 FIND v(dout0_18) AT=80.025n

.meas tran vdout0_19ck150 FIND v(dout0_19) AT=80.025n

.meas tran vdout0_20ck150 FIND v(dout0_20) AT=80.025n

.meas tran vdout0_21ck150 FIND v(dout0_21) AT=80.025n

.meas tran vdout0_22ck150 FIND v(dout0_22) AT=80.025n

.meas tran vdout0_23ck150 FIND v(dout0_23) AT=80.025n

.meas tran vdout0_24ck150 FIND v(dout0_24) AT=80.025n

.meas tran vdout0_25ck150 FIND v(dout0_25) AT=80.025n

.meas tran vdout0_26ck150 FIND v(dout0_26) AT=80.025n

.meas tran vdout0_27ck150 FIND v(dout0_27) AT=80.025n

.meas tran vdout0_28ck150 FIND v(dout0_28) AT=80.025n

.meas tran vdout0_29ck150 FIND v(dout0_29) AT=80.025n

.meas tran vdout0_30ck150 FIND v(dout0_30) AT=80.025n

.meas tran vdout0_31ck150 FIND v(dout0_31) AT=80.025n

.meas tran vdout0_32ck150 FIND v(dout0_32) AT=80.025n

.meas tran vdout0_33ck150 FIND v(dout0_33) AT=80.025n

.meas tran vdout0_34ck150 FIND v(dout0_34) AT=80.025n

.meas tran vdout0_35ck150 FIND v(dout0_35) AT=80.025n

.meas tran vdout0_36ck150 FIND v(dout0_36) AT=80.025n

.meas tran vdout0_37ck150 FIND v(dout0_37) AT=80.025n

.meas tran vdout0_38ck150 FIND v(dout0_38) AT=80.025n

.meas tran vdout0_39ck150 FIND v(dout0_39) AT=80.025n

.meas tran vdout0_40ck150 FIND v(dout0_40) AT=80.025n

.meas tran vdout0_41ck150 FIND v(dout0_41) AT=80.025n

.meas tran vdout0_42ck150 FIND v(dout0_42) AT=80.025n

.meas tran vdout0_43ck150 FIND v(dout0_43) AT=80.025n

.meas tran vdout0_44ck150 FIND v(dout0_44) AT=80.025n

.meas tran vdout0_45ck150 FIND v(dout0_45) AT=80.025n

.meas tran vdout0_46ck150 FIND v(dout0_46) AT=80.025n

.meas tran vdout0_47ck150 FIND v(dout0_47) AT=80.025n

.meas tran vdout0_48ck150 FIND v(dout0_48) AT=80.025n

.meas tran vdout0_49ck150 FIND v(dout0_49) AT=80.025n

.meas tran vdout0_50ck150 FIND v(dout0_50) AT=80.025n

.meas tran vdout0_51ck150 FIND v(dout0_51) AT=80.025n

.meas tran vdout0_52ck150 FIND v(dout0_52) AT=80.025n

.meas tran vdout0_53ck150 FIND v(dout0_53) AT=80.025n

.meas tran vdout0_54ck150 FIND v(dout0_54) AT=80.025n

.meas tran vdout0_55ck150 FIND v(dout0_55) AT=80.025n

.meas tran vdout0_56ck150 FIND v(dout0_56) AT=80.025n

.meas tran vdout0_57ck150 FIND v(dout0_57) AT=80.025n

.meas tran vdout0_58ck150 FIND v(dout0_58) AT=80.025n

.meas tran vdout0_59ck150 FIND v(dout0_59) AT=80.025n

.meas tran vdout0_60ck150 FIND v(dout0_60) AT=80.025n

.meas tran vdout0_61ck150 FIND v(dout0_61) AT=80.025n

.meas tran vdout0_62ck150 FIND v(dout0_62) AT=80.025n

.meas tran vdout0_63ck150 FIND v(dout0_63) AT=80.025n

.meas tran vdout0_0ck180 FIND v(dout0_0) AT=95.025n

.meas tran vdout0_1ck180 FIND v(dout0_1) AT=95.025n

.meas tran vdout0_2ck180 FIND v(dout0_2) AT=95.025n

.meas tran vdout0_3ck180 FIND v(dout0_3) AT=95.025n

.meas tran vdout0_4ck180 FIND v(dout0_4) AT=95.025n

.meas tran vdout0_5ck180 FIND v(dout0_5) AT=95.025n

.meas tran vdout0_6ck180 FIND v(dout0_6) AT=95.025n

.meas tran vdout0_7ck180 FIND v(dout0_7) AT=95.025n

.meas tran vdout0_8ck180 FIND v(dout0_8) AT=95.025n

.meas tran vdout0_9ck180 FIND v(dout0_9) AT=95.025n

.meas tran vdout0_10ck180 FIND v(dout0_10) AT=95.025n

.meas tran vdout0_11ck180 FIND v(dout0_11) AT=95.025n

.meas tran vdout0_12ck180 FIND v(dout0_12) AT=95.025n

.meas tran vdout0_13ck180 FIND v(dout0_13) AT=95.025n

.meas tran vdout0_14ck180 FIND v(dout0_14) AT=95.025n

.meas tran vdout0_15ck180 FIND v(dout0_15) AT=95.025n

.meas tran vdout0_16ck180 FIND v(dout0_16) AT=95.025n

.meas tran vdout0_17ck180 FIND v(dout0_17) AT=95.025n

.meas tran vdout0_18ck180 FIND v(dout0_18) AT=95.025n

.meas tran vdout0_19ck180 FIND v(dout0_19) AT=95.025n

.meas tran vdout0_20ck180 FIND v(dout0_20) AT=95.025n

.meas tran vdout0_21ck180 FIND v(dout0_21) AT=95.025n

.meas tran vdout0_22ck180 FIND v(dout0_22) AT=95.025n

.meas tran vdout0_23ck180 FIND v(dout0_23) AT=95.025n

.meas tran vdout0_24ck180 FIND v(dout0_24) AT=95.025n

.meas tran vdout0_25ck180 FIND v(dout0_25) AT=95.025n

.meas tran vdout0_26ck180 FIND v(dout0_26) AT=95.025n

.meas tran vdout0_27ck180 FIND v(dout0_27) AT=95.025n

.meas tran vdout0_28ck180 FIND v(dout0_28) AT=95.025n

.meas tran vdout0_29ck180 FIND v(dout0_29) AT=95.025n

.meas tran vdout0_30ck180 FIND v(dout0_30) AT=95.025n

.meas tran vdout0_31ck180 FIND v(dout0_31) AT=95.025n

.meas tran vdout0_32ck180 FIND v(dout0_32) AT=95.025n

.meas tran vdout0_33ck180 FIND v(dout0_33) AT=95.025n

.meas tran vdout0_34ck180 FIND v(dout0_34) AT=95.025n

.meas tran vdout0_35ck180 FIND v(dout0_35) AT=95.025n

.meas tran vdout0_36ck180 FIND v(dout0_36) AT=95.025n

.meas tran vdout0_37ck180 FIND v(dout0_37) AT=95.025n

.meas tran vdout0_38ck180 FIND v(dout0_38) AT=95.025n

.meas tran vdout0_39ck180 FIND v(dout0_39) AT=95.025n

.meas tran vdout0_40ck180 FIND v(dout0_40) AT=95.025n

.meas tran vdout0_41ck180 FIND v(dout0_41) AT=95.025n

.meas tran vdout0_42ck180 FIND v(dout0_42) AT=95.025n

.meas tran vdout0_43ck180 FIND v(dout0_43) AT=95.025n

.meas tran vdout0_44ck180 FIND v(dout0_44) AT=95.025n

.meas tran vdout0_45ck180 FIND v(dout0_45) AT=95.025n

.meas tran vdout0_46ck180 FIND v(dout0_46) AT=95.025n

.meas tran vdout0_47ck180 FIND v(dout0_47) AT=95.025n

.meas tran vdout0_48ck180 FIND v(dout0_48) AT=95.025n

.meas tran vdout0_49ck180 FIND v(dout0_49) AT=95.025n

.meas tran vdout0_50ck180 FIND v(dout0_50) AT=95.025n

.meas tran vdout0_51ck180 FIND v(dout0_51) AT=95.025n

.meas tran vdout0_52ck180 FIND v(dout0_52) AT=95.025n

.meas tran vdout0_53ck180 FIND v(dout0_53) AT=95.025n

.meas tran vdout0_54ck180 FIND v(dout0_54) AT=95.025n

.meas tran vdout0_55ck180 FIND v(dout0_55) AT=95.025n

.meas tran vdout0_56ck180 FIND v(dout0_56) AT=95.025n

.meas tran vdout0_57ck180 FIND v(dout0_57) AT=95.025n

.meas tran vdout0_58ck180 FIND v(dout0_58) AT=95.025n

.meas tran vdout0_59ck180 FIND v(dout0_59) AT=95.025n

.meas tran vdout0_60ck180 FIND v(dout0_60) AT=95.025n

.meas tran vdout0_61ck180 FIND v(dout0_61) AT=95.025n

.meas tran vdout0_62ck180 FIND v(dout0_62) AT=95.025n

.meas tran vdout0_63ck180 FIND v(dout0_63) AT=95.025n

.meas tran vdout0_0ck190 FIND v(dout0_0) AT=100.025n

.meas tran vdout0_1ck190 FIND v(dout0_1) AT=100.025n

.meas tran vdout0_2ck190 FIND v(dout0_2) AT=100.025n

.meas tran vdout0_3ck190 FIND v(dout0_3) AT=100.025n

.meas tran vdout0_4ck190 FIND v(dout0_4) AT=100.025n

.meas tran vdout0_5ck190 FIND v(dout0_5) AT=100.025n

.meas tran vdout0_6ck190 FIND v(dout0_6) AT=100.025n

.meas tran vdout0_7ck190 FIND v(dout0_7) AT=100.025n

.meas tran vdout0_8ck190 FIND v(dout0_8) AT=100.025n

.meas tran vdout0_9ck190 FIND v(dout0_9) AT=100.025n

.meas tran vdout0_10ck190 FIND v(dout0_10) AT=100.025n

.meas tran vdout0_11ck190 FIND v(dout0_11) AT=100.025n

.meas tran vdout0_12ck190 FIND v(dout0_12) AT=100.025n

.meas tran vdout0_13ck190 FIND v(dout0_13) AT=100.025n

.meas tran vdout0_14ck190 FIND v(dout0_14) AT=100.025n

.meas tran vdout0_15ck190 FIND v(dout0_15) AT=100.025n

.meas tran vdout0_16ck190 FIND v(dout0_16) AT=100.025n

.meas tran vdout0_17ck190 FIND v(dout0_17) AT=100.025n

.meas tran vdout0_18ck190 FIND v(dout0_18) AT=100.025n

.meas tran vdout0_19ck190 FIND v(dout0_19) AT=100.025n

.meas tran vdout0_20ck190 FIND v(dout0_20) AT=100.025n

.meas tran vdout0_21ck190 FIND v(dout0_21) AT=100.025n

.meas tran vdout0_22ck190 FIND v(dout0_22) AT=100.025n

.meas tran vdout0_23ck190 FIND v(dout0_23) AT=100.025n

.meas tran vdout0_24ck190 FIND v(dout0_24) AT=100.025n

.meas tran vdout0_25ck190 FIND v(dout0_25) AT=100.025n

.meas tran vdout0_26ck190 FIND v(dout0_26) AT=100.025n

.meas tran vdout0_27ck190 FIND v(dout0_27) AT=100.025n

.meas tran vdout0_28ck190 FIND v(dout0_28) AT=100.025n

.meas tran vdout0_29ck190 FIND v(dout0_29) AT=100.025n

.meas tran vdout0_30ck190 FIND v(dout0_30) AT=100.025n

.meas tran vdout0_31ck190 FIND v(dout0_31) AT=100.025n

.meas tran vdout0_32ck190 FIND v(dout0_32) AT=100.025n

.meas tran vdout0_33ck190 FIND v(dout0_33) AT=100.025n

.meas tran vdout0_34ck190 FIND v(dout0_34) AT=100.025n

.meas tran vdout0_35ck190 FIND v(dout0_35) AT=100.025n

.meas tran vdout0_36ck190 FIND v(dout0_36) AT=100.025n

.meas tran vdout0_37ck190 FIND v(dout0_37) AT=100.025n

.meas tran vdout0_38ck190 FIND v(dout0_38) AT=100.025n

.meas tran vdout0_39ck190 FIND v(dout0_39) AT=100.025n

.meas tran vdout0_40ck190 FIND v(dout0_40) AT=100.025n

.meas tran vdout0_41ck190 FIND v(dout0_41) AT=100.025n

.meas tran vdout0_42ck190 FIND v(dout0_42) AT=100.025n

.meas tran vdout0_43ck190 FIND v(dout0_43) AT=100.025n

.meas tran vdout0_44ck190 FIND v(dout0_44) AT=100.025n

.meas tran vdout0_45ck190 FIND v(dout0_45) AT=100.025n

.meas tran vdout0_46ck190 FIND v(dout0_46) AT=100.025n

.meas tran vdout0_47ck190 FIND v(dout0_47) AT=100.025n

.meas tran vdout0_48ck190 FIND v(dout0_48) AT=100.025n

.meas tran vdout0_49ck190 FIND v(dout0_49) AT=100.025n

.meas tran vdout0_50ck190 FIND v(dout0_50) AT=100.025n

.meas tran vdout0_51ck190 FIND v(dout0_51) AT=100.025n

.meas tran vdout0_52ck190 FIND v(dout0_52) AT=100.025n

.meas tran vdout0_53ck190 FIND v(dout0_53) AT=100.025n

.meas tran vdout0_54ck190 FIND v(dout0_54) AT=100.025n

.meas tran vdout0_55ck190 FIND v(dout0_55) AT=100.025n

.meas tran vdout0_56ck190 FIND v(dout0_56) AT=100.025n

.meas tran vdout0_57ck190 FIND v(dout0_57) AT=100.025n

.meas tran vdout0_58ck190 FIND v(dout0_58) AT=100.025n

.meas tran vdout0_59ck190 FIND v(dout0_59) AT=100.025n

.meas tran vdout0_60ck190 FIND v(dout0_60) AT=100.025n

.meas tran vdout0_61ck190 FIND v(dout0_61) AT=100.025n

.meas tran vdout0_62ck190 FIND v(dout0_62) AT=100.025n

.meas tran vdout0_63ck190 FIND v(dout0_63) AT=100.025n

.meas tran vdout0_0ck200 FIND v(dout0_0) AT=105.025n

.meas tran vdout0_1ck200 FIND v(dout0_1) AT=105.025n

.meas tran vdout0_2ck200 FIND v(dout0_2) AT=105.025n

.meas tran vdout0_3ck200 FIND v(dout0_3) AT=105.025n

.meas tran vdout0_4ck200 FIND v(dout0_4) AT=105.025n

.meas tran vdout0_5ck200 FIND v(dout0_5) AT=105.025n

.meas tran vdout0_6ck200 FIND v(dout0_6) AT=105.025n

.meas tran vdout0_7ck200 FIND v(dout0_7) AT=105.025n

.meas tran vdout0_8ck200 FIND v(dout0_8) AT=105.025n

.meas tran vdout0_9ck200 FIND v(dout0_9) AT=105.025n

.meas tran vdout0_10ck200 FIND v(dout0_10) AT=105.025n

.meas tran vdout0_11ck200 FIND v(dout0_11) AT=105.025n

.meas tran vdout0_12ck200 FIND v(dout0_12) AT=105.025n

.meas tran vdout0_13ck200 FIND v(dout0_13) AT=105.025n

.meas tran vdout0_14ck200 FIND v(dout0_14) AT=105.025n

.meas tran vdout0_15ck200 FIND v(dout0_15) AT=105.025n

.meas tran vdout0_16ck200 FIND v(dout0_16) AT=105.025n

.meas tran vdout0_17ck200 FIND v(dout0_17) AT=105.025n

.meas tran vdout0_18ck200 FIND v(dout0_18) AT=105.025n

.meas tran vdout0_19ck200 FIND v(dout0_19) AT=105.025n

.meas tran vdout0_20ck200 FIND v(dout0_20) AT=105.025n

.meas tran vdout0_21ck200 FIND v(dout0_21) AT=105.025n

.meas tran vdout0_22ck200 FIND v(dout0_22) AT=105.025n

.meas tran vdout0_23ck200 FIND v(dout0_23) AT=105.025n

.meas tran vdout0_24ck200 FIND v(dout0_24) AT=105.025n

.meas tran vdout0_25ck200 FIND v(dout0_25) AT=105.025n

.meas tran vdout0_26ck200 FIND v(dout0_26) AT=105.025n

.meas tran vdout0_27ck200 FIND v(dout0_27) AT=105.025n

.meas tran vdout0_28ck200 FIND v(dout0_28) AT=105.025n

.meas tran vdout0_29ck200 FIND v(dout0_29) AT=105.025n

.meas tran vdout0_30ck200 FIND v(dout0_30) AT=105.025n

.meas tran vdout0_31ck200 FIND v(dout0_31) AT=105.025n

.meas tran vdout0_32ck200 FIND v(dout0_32) AT=105.025n

.meas tran vdout0_33ck200 FIND v(dout0_33) AT=105.025n

.meas tran vdout0_34ck200 FIND v(dout0_34) AT=105.025n

.meas tran vdout0_35ck200 FIND v(dout0_35) AT=105.025n

.meas tran vdout0_36ck200 FIND v(dout0_36) AT=105.025n

.meas tran vdout0_37ck200 FIND v(dout0_37) AT=105.025n

.meas tran vdout0_38ck200 FIND v(dout0_38) AT=105.025n

.meas tran vdout0_39ck200 FIND v(dout0_39) AT=105.025n

.meas tran vdout0_40ck200 FIND v(dout0_40) AT=105.025n

.meas tran vdout0_41ck200 FIND v(dout0_41) AT=105.025n

.meas tran vdout0_42ck200 FIND v(dout0_42) AT=105.025n

.meas tran vdout0_43ck200 FIND v(dout0_43) AT=105.025n

.meas tran vdout0_44ck200 FIND v(dout0_44) AT=105.025n

.meas tran vdout0_45ck200 FIND v(dout0_45) AT=105.025n

.meas tran vdout0_46ck200 FIND v(dout0_46) AT=105.025n

.meas tran vdout0_47ck200 FIND v(dout0_47) AT=105.025n

.meas tran vdout0_48ck200 FIND v(dout0_48) AT=105.025n

.meas tran vdout0_49ck200 FIND v(dout0_49) AT=105.025n

.meas tran vdout0_50ck200 FIND v(dout0_50) AT=105.025n

.meas tran vdout0_51ck200 FIND v(dout0_51) AT=105.025n

.meas tran vdout0_52ck200 FIND v(dout0_52) AT=105.025n

.meas tran vdout0_53ck200 FIND v(dout0_53) AT=105.025n

.meas tran vdout0_54ck200 FIND v(dout0_54) AT=105.025n

.meas tran vdout0_55ck200 FIND v(dout0_55) AT=105.025n

.meas tran vdout0_56ck200 FIND v(dout0_56) AT=105.025n

.meas tran vdout0_57ck200 FIND v(dout0_57) AT=105.025n

.meas tran vdout0_58ck200 FIND v(dout0_58) AT=105.025n

.meas tran vdout0_59ck200 FIND v(dout0_59) AT=105.025n

.meas tran vdout0_60ck200 FIND v(dout0_60) AT=105.025n

.meas tran vdout0_61ck200 FIND v(dout0_61) AT=105.025n

.meas tran vdout0_62ck200 FIND v(dout0_62) AT=105.025n

.meas tran vdout0_63ck200 FIND v(dout0_63) AT=105.025n

.meas tran vdout0_0ck210 FIND v(dout0_0) AT=110.025n

.meas tran vdout0_1ck210 FIND v(dout0_1) AT=110.025n

.meas tran vdout0_2ck210 FIND v(dout0_2) AT=110.025n

.meas tran vdout0_3ck210 FIND v(dout0_3) AT=110.025n

.meas tran vdout0_4ck210 FIND v(dout0_4) AT=110.025n

.meas tran vdout0_5ck210 FIND v(dout0_5) AT=110.025n

.meas tran vdout0_6ck210 FIND v(dout0_6) AT=110.025n

.meas tran vdout0_7ck210 FIND v(dout0_7) AT=110.025n

.meas tran vdout0_8ck210 FIND v(dout0_8) AT=110.025n

.meas tran vdout0_9ck210 FIND v(dout0_9) AT=110.025n

.meas tran vdout0_10ck210 FIND v(dout0_10) AT=110.025n

.meas tran vdout0_11ck210 FIND v(dout0_11) AT=110.025n

.meas tran vdout0_12ck210 FIND v(dout0_12) AT=110.025n

.meas tran vdout0_13ck210 FIND v(dout0_13) AT=110.025n

.meas tran vdout0_14ck210 FIND v(dout0_14) AT=110.025n

.meas tran vdout0_15ck210 FIND v(dout0_15) AT=110.025n

.meas tran vdout0_16ck210 FIND v(dout0_16) AT=110.025n

.meas tran vdout0_17ck210 FIND v(dout0_17) AT=110.025n

.meas tran vdout0_18ck210 FIND v(dout0_18) AT=110.025n

.meas tran vdout0_19ck210 FIND v(dout0_19) AT=110.025n

.meas tran vdout0_20ck210 FIND v(dout0_20) AT=110.025n

.meas tran vdout0_21ck210 FIND v(dout0_21) AT=110.025n

.meas tran vdout0_22ck210 FIND v(dout0_22) AT=110.025n

.meas tran vdout0_23ck210 FIND v(dout0_23) AT=110.025n

.meas tran vdout0_24ck210 FIND v(dout0_24) AT=110.025n

.meas tran vdout0_25ck210 FIND v(dout0_25) AT=110.025n

.meas tran vdout0_26ck210 FIND v(dout0_26) AT=110.025n

.meas tran vdout0_27ck210 FIND v(dout0_27) AT=110.025n

.meas tran vdout0_28ck210 FIND v(dout0_28) AT=110.025n

.meas tran vdout0_29ck210 FIND v(dout0_29) AT=110.025n

.meas tran vdout0_30ck210 FIND v(dout0_30) AT=110.025n

.meas tran vdout0_31ck210 FIND v(dout0_31) AT=110.025n

.meas tran vdout0_32ck210 FIND v(dout0_32) AT=110.025n

.meas tran vdout0_33ck210 FIND v(dout0_33) AT=110.025n

.meas tran vdout0_34ck210 FIND v(dout0_34) AT=110.025n

.meas tran vdout0_35ck210 FIND v(dout0_35) AT=110.025n

.meas tran vdout0_36ck210 FIND v(dout0_36) AT=110.025n

.meas tran vdout0_37ck210 FIND v(dout0_37) AT=110.025n

.meas tran vdout0_38ck210 FIND v(dout0_38) AT=110.025n

.meas tran vdout0_39ck210 FIND v(dout0_39) AT=110.025n

.meas tran vdout0_40ck210 FIND v(dout0_40) AT=110.025n

.meas tran vdout0_41ck210 FIND v(dout0_41) AT=110.025n

.meas tran vdout0_42ck210 FIND v(dout0_42) AT=110.025n

.meas tran vdout0_43ck210 FIND v(dout0_43) AT=110.025n

.meas tran vdout0_44ck210 FIND v(dout0_44) AT=110.025n

.meas tran vdout0_45ck210 FIND v(dout0_45) AT=110.025n

.meas tran vdout0_46ck210 FIND v(dout0_46) AT=110.025n

.meas tran vdout0_47ck210 FIND v(dout0_47) AT=110.025n

.meas tran vdout0_48ck210 FIND v(dout0_48) AT=110.025n

.meas tran vdout0_49ck210 FIND v(dout0_49) AT=110.025n

.meas tran vdout0_50ck210 FIND v(dout0_50) AT=110.025n

.meas tran vdout0_51ck210 FIND v(dout0_51) AT=110.025n

.meas tran vdout0_52ck210 FIND v(dout0_52) AT=110.025n

.meas tran vdout0_53ck210 FIND v(dout0_53) AT=110.025n

.meas tran vdout0_54ck210 FIND v(dout0_54) AT=110.025n

.meas tran vdout0_55ck210 FIND v(dout0_55) AT=110.025n

.meas tran vdout0_56ck210 FIND v(dout0_56) AT=110.025n

.meas tran vdout0_57ck210 FIND v(dout0_57) AT=110.025n

.meas tran vdout0_58ck210 FIND v(dout0_58) AT=110.025n

.meas tran vdout0_59ck210 FIND v(dout0_59) AT=110.025n

.meas tran vdout0_60ck210 FIND v(dout0_60) AT=110.025n

.meas tran vdout0_61ck210 FIND v(dout0_61) AT=110.025n

.meas tran vdout0_62ck210 FIND v(dout0_62) AT=110.025n

.meas tran vdout0_63ck210 FIND v(dout0_63) AT=110.025n

.meas tran vdout0_0ck230 FIND v(dout0_0) AT=120.025n

.meas tran vdout0_1ck230 FIND v(dout0_1) AT=120.025n

.meas tran vdout0_2ck230 FIND v(dout0_2) AT=120.025n

.meas tran vdout0_3ck230 FIND v(dout0_3) AT=120.025n

.meas tran vdout0_4ck230 FIND v(dout0_4) AT=120.025n

.meas tran vdout0_5ck230 FIND v(dout0_5) AT=120.025n

.meas tran vdout0_6ck230 FIND v(dout0_6) AT=120.025n

.meas tran vdout0_7ck230 FIND v(dout0_7) AT=120.025n

.meas tran vdout0_8ck230 FIND v(dout0_8) AT=120.025n

.meas tran vdout0_9ck230 FIND v(dout0_9) AT=120.025n

.meas tran vdout0_10ck230 FIND v(dout0_10) AT=120.025n

.meas tran vdout0_11ck230 FIND v(dout0_11) AT=120.025n

.meas tran vdout0_12ck230 FIND v(dout0_12) AT=120.025n

.meas tran vdout0_13ck230 FIND v(dout0_13) AT=120.025n

.meas tran vdout0_14ck230 FIND v(dout0_14) AT=120.025n

.meas tran vdout0_15ck230 FIND v(dout0_15) AT=120.025n

.meas tran vdout0_16ck230 FIND v(dout0_16) AT=120.025n

.meas tran vdout0_17ck230 FIND v(dout0_17) AT=120.025n

.meas tran vdout0_18ck230 FIND v(dout0_18) AT=120.025n

.meas tran vdout0_19ck230 FIND v(dout0_19) AT=120.025n

.meas tran vdout0_20ck230 FIND v(dout0_20) AT=120.025n

.meas tran vdout0_21ck230 FIND v(dout0_21) AT=120.025n

.meas tran vdout0_22ck230 FIND v(dout0_22) AT=120.025n

.meas tran vdout0_23ck230 FIND v(dout0_23) AT=120.025n

.meas tran vdout0_24ck230 FIND v(dout0_24) AT=120.025n

.meas tran vdout0_25ck230 FIND v(dout0_25) AT=120.025n

.meas tran vdout0_26ck230 FIND v(dout0_26) AT=120.025n

.meas tran vdout0_27ck230 FIND v(dout0_27) AT=120.025n

.meas tran vdout0_28ck230 FIND v(dout0_28) AT=120.025n

.meas tran vdout0_29ck230 FIND v(dout0_29) AT=120.025n

.meas tran vdout0_30ck230 FIND v(dout0_30) AT=120.025n

.meas tran vdout0_31ck230 FIND v(dout0_31) AT=120.025n

.meas tran vdout0_32ck230 FIND v(dout0_32) AT=120.025n

.meas tran vdout0_33ck230 FIND v(dout0_33) AT=120.025n

.meas tran vdout0_34ck230 FIND v(dout0_34) AT=120.025n

.meas tran vdout0_35ck230 FIND v(dout0_35) AT=120.025n

.meas tran vdout0_36ck230 FIND v(dout0_36) AT=120.025n

.meas tran vdout0_37ck230 FIND v(dout0_37) AT=120.025n

.meas tran vdout0_38ck230 FIND v(dout0_38) AT=120.025n

.meas tran vdout0_39ck230 FIND v(dout0_39) AT=120.025n

.meas tran vdout0_40ck230 FIND v(dout0_40) AT=120.025n

.meas tran vdout0_41ck230 FIND v(dout0_41) AT=120.025n

.meas tran vdout0_42ck230 FIND v(dout0_42) AT=120.025n

.meas tran vdout0_43ck230 FIND v(dout0_43) AT=120.025n

.meas tran vdout0_44ck230 FIND v(dout0_44) AT=120.025n

.meas tran vdout0_45ck230 FIND v(dout0_45) AT=120.025n

.meas tran vdout0_46ck230 FIND v(dout0_46) AT=120.025n

.meas tran vdout0_47ck230 FIND v(dout0_47) AT=120.025n

.meas tran vdout0_48ck230 FIND v(dout0_48) AT=120.025n

.meas tran vdout0_49ck230 FIND v(dout0_49) AT=120.025n

.meas tran vdout0_50ck230 FIND v(dout0_50) AT=120.025n

.meas tran vdout0_51ck230 FIND v(dout0_51) AT=120.025n

.meas tran vdout0_52ck230 FIND v(dout0_52) AT=120.025n

.meas tran vdout0_53ck230 FIND v(dout0_53) AT=120.025n

.meas tran vdout0_54ck230 FIND v(dout0_54) AT=120.025n

.meas tran vdout0_55ck230 FIND v(dout0_55) AT=120.025n

.meas tran vdout0_56ck230 FIND v(dout0_56) AT=120.025n

.meas tran vdout0_57ck230 FIND v(dout0_57) AT=120.025n

.meas tran vdout0_58ck230 FIND v(dout0_58) AT=120.025n

.meas tran vdout0_59ck230 FIND v(dout0_59) AT=120.025n

.meas tran vdout0_60ck230 FIND v(dout0_60) AT=120.025n

.meas tran vdout0_61ck230 FIND v(dout0_61) AT=120.025n

.meas tran vdout0_62ck230 FIND v(dout0_62) AT=120.025n

.meas tran vdout0_63ck230 FIND v(dout0_63) AT=120.025n

.meas tran vdout0_0ck240 FIND v(dout0_0) AT=125.025n

.meas tran vdout0_1ck240 FIND v(dout0_1) AT=125.025n

.meas tran vdout0_2ck240 FIND v(dout0_2) AT=125.025n

.meas tran vdout0_3ck240 FIND v(dout0_3) AT=125.025n

.meas tran vdout0_4ck240 FIND v(dout0_4) AT=125.025n

.meas tran vdout0_5ck240 FIND v(dout0_5) AT=125.025n

.meas tran vdout0_6ck240 FIND v(dout0_6) AT=125.025n

.meas tran vdout0_7ck240 FIND v(dout0_7) AT=125.025n

.meas tran vdout0_8ck240 FIND v(dout0_8) AT=125.025n

.meas tran vdout0_9ck240 FIND v(dout0_9) AT=125.025n

.meas tran vdout0_10ck240 FIND v(dout0_10) AT=125.025n

.meas tran vdout0_11ck240 FIND v(dout0_11) AT=125.025n

.meas tran vdout0_12ck240 FIND v(dout0_12) AT=125.025n

.meas tran vdout0_13ck240 FIND v(dout0_13) AT=125.025n

.meas tran vdout0_14ck240 FIND v(dout0_14) AT=125.025n

.meas tran vdout0_15ck240 FIND v(dout0_15) AT=125.025n

.meas tran vdout0_16ck240 FIND v(dout0_16) AT=125.025n

.meas tran vdout0_17ck240 FIND v(dout0_17) AT=125.025n

.meas tran vdout0_18ck240 FIND v(dout0_18) AT=125.025n

.meas tran vdout0_19ck240 FIND v(dout0_19) AT=125.025n

.meas tran vdout0_20ck240 FIND v(dout0_20) AT=125.025n

.meas tran vdout0_21ck240 FIND v(dout0_21) AT=125.025n

.meas tran vdout0_22ck240 FIND v(dout0_22) AT=125.025n

.meas tran vdout0_23ck240 FIND v(dout0_23) AT=125.025n

.meas tran vdout0_24ck240 FIND v(dout0_24) AT=125.025n

.meas tran vdout0_25ck240 FIND v(dout0_25) AT=125.025n

.meas tran vdout0_26ck240 FIND v(dout0_26) AT=125.025n

.meas tran vdout0_27ck240 FIND v(dout0_27) AT=125.025n

.meas tran vdout0_28ck240 FIND v(dout0_28) AT=125.025n

.meas tran vdout0_29ck240 FIND v(dout0_29) AT=125.025n

.meas tran vdout0_30ck240 FIND v(dout0_30) AT=125.025n

.meas tran vdout0_31ck240 FIND v(dout0_31) AT=125.025n

.meas tran vdout0_32ck240 FIND v(dout0_32) AT=125.025n

.meas tran vdout0_33ck240 FIND v(dout0_33) AT=125.025n

.meas tran vdout0_34ck240 FIND v(dout0_34) AT=125.025n

.meas tran vdout0_35ck240 FIND v(dout0_35) AT=125.025n

.meas tran vdout0_36ck240 FIND v(dout0_36) AT=125.025n

.meas tran vdout0_37ck240 FIND v(dout0_37) AT=125.025n

.meas tran vdout0_38ck240 FIND v(dout0_38) AT=125.025n

.meas tran vdout0_39ck240 FIND v(dout0_39) AT=125.025n

.meas tran vdout0_40ck240 FIND v(dout0_40) AT=125.025n

.meas tran vdout0_41ck240 FIND v(dout0_41) AT=125.025n

.meas tran vdout0_42ck240 FIND v(dout0_42) AT=125.025n

.meas tran vdout0_43ck240 FIND v(dout0_43) AT=125.025n

.meas tran vdout0_44ck240 FIND v(dout0_44) AT=125.025n

.meas tran vdout0_45ck240 FIND v(dout0_45) AT=125.025n

.meas tran vdout0_46ck240 FIND v(dout0_46) AT=125.025n

.meas tran vdout0_47ck240 FIND v(dout0_47) AT=125.025n

.meas tran vdout0_48ck240 FIND v(dout0_48) AT=125.025n

.meas tran vdout0_49ck240 FIND v(dout0_49) AT=125.025n

.meas tran vdout0_50ck240 FIND v(dout0_50) AT=125.025n

.meas tran vdout0_51ck240 FIND v(dout0_51) AT=125.025n

.meas tran vdout0_52ck240 FIND v(dout0_52) AT=125.025n

.meas tran vdout0_53ck240 FIND v(dout0_53) AT=125.025n

.meas tran vdout0_54ck240 FIND v(dout0_54) AT=125.025n

.meas tran vdout0_55ck240 FIND v(dout0_55) AT=125.025n

.meas tran vdout0_56ck240 FIND v(dout0_56) AT=125.025n

.meas tran vdout0_57ck240 FIND v(dout0_57) AT=125.025n

.meas tran vdout0_58ck240 FIND v(dout0_58) AT=125.025n

.meas tran vdout0_59ck240 FIND v(dout0_59) AT=125.025n

.meas tran vdout0_60ck240 FIND v(dout0_60) AT=125.025n

.meas tran vdout0_61ck240 FIND v(dout0_61) AT=125.025n

.meas tran vdout0_62ck240 FIND v(dout0_62) AT=125.025n

.meas tran vdout0_63ck240 FIND v(dout0_63) AT=125.025n

.meas tran vdout0_0ck260 FIND v(dout0_0) AT=135.025n

.meas tran vdout0_1ck260 FIND v(dout0_1) AT=135.025n

.meas tran vdout0_2ck260 FIND v(dout0_2) AT=135.025n

.meas tran vdout0_3ck260 FIND v(dout0_3) AT=135.025n

.meas tran vdout0_4ck260 FIND v(dout0_4) AT=135.025n

.meas tran vdout0_5ck260 FIND v(dout0_5) AT=135.025n

.meas tran vdout0_6ck260 FIND v(dout0_6) AT=135.025n

.meas tran vdout0_7ck260 FIND v(dout0_7) AT=135.025n

.meas tran vdout0_8ck260 FIND v(dout0_8) AT=135.025n

.meas tran vdout0_9ck260 FIND v(dout0_9) AT=135.025n

.meas tran vdout0_10ck260 FIND v(dout0_10) AT=135.025n

.meas tran vdout0_11ck260 FIND v(dout0_11) AT=135.025n

.meas tran vdout0_12ck260 FIND v(dout0_12) AT=135.025n

.meas tran vdout0_13ck260 FIND v(dout0_13) AT=135.025n

.meas tran vdout0_14ck260 FIND v(dout0_14) AT=135.025n

.meas tran vdout0_15ck260 FIND v(dout0_15) AT=135.025n

.meas tran vdout0_16ck260 FIND v(dout0_16) AT=135.025n

.meas tran vdout0_17ck260 FIND v(dout0_17) AT=135.025n

.meas tran vdout0_18ck260 FIND v(dout0_18) AT=135.025n

.meas tran vdout0_19ck260 FIND v(dout0_19) AT=135.025n

.meas tran vdout0_20ck260 FIND v(dout0_20) AT=135.025n

.meas tran vdout0_21ck260 FIND v(dout0_21) AT=135.025n

.meas tran vdout0_22ck260 FIND v(dout0_22) AT=135.025n

.meas tran vdout0_23ck260 FIND v(dout0_23) AT=135.025n

.meas tran vdout0_24ck260 FIND v(dout0_24) AT=135.025n

.meas tran vdout0_25ck260 FIND v(dout0_25) AT=135.025n

.meas tran vdout0_26ck260 FIND v(dout0_26) AT=135.025n

.meas tran vdout0_27ck260 FIND v(dout0_27) AT=135.025n

.meas tran vdout0_28ck260 FIND v(dout0_28) AT=135.025n

.meas tran vdout0_29ck260 FIND v(dout0_29) AT=135.025n

.meas tran vdout0_30ck260 FIND v(dout0_30) AT=135.025n

.meas tran vdout0_31ck260 FIND v(dout0_31) AT=135.025n

.meas tran vdout0_32ck260 FIND v(dout0_32) AT=135.025n

.meas tran vdout0_33ck260 FIND v(dout0_33) AT=135.025n

.meas tran vdout0_34ck260 FIND v(dout0_34) AT=135.025n

.meas tran vdout0_35ck260 FIND v(dout0_35) AT=135.025n

.meas tran vdout0_36ck260 FIND v(dout0_36) AT=135.025n

.meas tran vdout0_37ck260 FIND v(dout0_37) AT=135.025n

.meas tran vdout0_38ck260 FIND v(dout0_38) AT=135.025n

.meas tran vdout0_39ck260 FIND v(dout0_39) AT=135.025n

.meas tran vdout0_40ck260 FIND v(dout0_40) AT=135.025n

.meas tran vdout0_41ck260 FIND v(dout0_41) AT=135.025n

.meas tran vdout0_42ck260 FIND v(dout0_42) AT=135.025n

.meas tran vdout0_43ck260 FIND v(dout0_43) AT=135.025n

.meas tran vdout0_44ck260 FIND v(dout0_44) AT=135.025n

.meas tran vdout0_45ck260 FIND v(dout0_45) AT=135.025n

.meas tran vdout0_46ck260 FIND v(dout0_46) AT=135.025n

.meas tran vdout0_47ck260 FIND v(dout0_47) AT=135.025n

.meas tran vdout0_48ck260 FIND v(dout0_48) AT=135.025n

.meas tran vdout0_49ck260 FIND v(dout0_49) AT=135.025n

.meas tran vdout0_50ck260 FIND v(dout0_50) AT=135.025n

.meas tran vdout0_51ck260 FIND v(dout0_51) AT=135.025n

.meas tran vdout0_52ck260 FIND v(dout0_52) AT=135.025n

.meas tran vdout0_53ck260 FIND v(dout0_53) AT=135.025n

.meas tran vdout0_54ck260 FIND v(dout0_54) AT=135.025n

.meas tran vdout0_55ck260 FIND v(dout0_55) AT=135.025n

.meas tran vdout0_56ck260 FIND v(dout0_56) AT=135.025n

.meas tran vdout0_57ck260 FIND v(dout0_57) AT=135.025n

.meas tran vdout0_58ck260 FIND v(dout0_58) AT=135.025n

.meas tran vdout0_59ck260 FIND v(dout0_59) AT=135.025n

.meas tran vdout0_60ck260 FIND v(dout0_60) AT=135.025n

.meas tran vdout0_61ck260 FIND v(dout0_61) AT=135.025n

.meas tran vdout0_62ck260 FIND v(dout0_62) AT=135.025n

.meas tran vdout0_63ck260 FIND v(dout0_63) AT=135.025n

.meas tran vdout0_0ck330 FIND v(dout0_0) AT=170.025n

.meas tran vdout0_1ck330 FIND v(dout0_1) AT=170.025n

.meas tran vdout0_2ck330 FIND v(dout0_2) AT=170.025n

.meas tran vdout0_3ck330 FIND v(dout0_3) AT=170.025n

.meas tran vdout0_4ck330 FIND v(dout0_4) AT=170.025n

.meas tran vdout0_5ck330 FIND v(dout0_5) AT=170.025n

.meas tran vdout0_6ck330 FIND v(dout0_6) AT=170.025n

.meas tran vdout0_7ck330 FIND v(dout0_7) AT=170.025n

.meas tran vdout0_8ck330 FIND v(dout0_8) AT=170.025n

.meas tran vdout0_9ck330 FIND v(dout0_9) AT=170.025n

.meas tran vdout0_10ck330 FIND v(dout0_10) AT=170.025n

.meas tran vdout0_11ck330 FIND v(dout0_11) AT=170.025n

.meas tran vdout0_12ck330 FIND v(dout0_12) AT=170.025n

.meas tran vdout0_13ck330 FIND v(dout0_13) AT=170.025n

.meas tran vdout0_14ck330 FIND v(dout0_14) AT=170.025n

.meas tran vdout0_15ck330 FIND v(dout0_15) AT=170.025n

.meas tran vdout0_16ck330 FIND v(dout0_16) AT=170.025n

.meas tran vdout0_17ck330 FIND v(dout0_17) AT=170.025n

.meas tran vdout0_18ck330 FIND v(dout0_18) AT=170.025n

.meas tran vdout0_19ck330 FIND v(dout0_19) AT=170.025n

.meas tran vdout0_20ck330 FIND v(dout0_20) AT=170.025n

.meas tran vdout0_21ck330 FIND v(dout0_21) AT=170.025n

.meas tran vdout0_22ck330 FIND v(dout0_22) AT=170.025n

.meas tran vdout0_23ck330 FIND v(dout0_23) AT=170.025n

.meas tran vdout0_24ck330 FIND v(dout0_24) AT=170.025n

.meas tran vdout0_25ck330 FIND v(dout0_25) AT=170.025n

.meas tran vdout0_26ck330 FIND v(dout0_26) AT=170.025n

.meas tran vdout0_27ck330 FIND v(dout0_27) AT=170.025n

.meas tran vdout0_28ck330 FIND v(dout0_28) AT=170.025n

.meas tran vdout0_29ck330 FIND v(dout0_29) AT=170.025n

.meas tran vdout0_30ck330 FIND v(dout0_30) AT=170.025n

.meas tran vdout0_31ck330 FIND v(dout0_31) AT=170.025n

.meas tran vdout0_32ck330 FIND v(dout0_32) AT=170.025n

.meas tran vdout0_33ck330 FIND v(dout0_33) AT=170.025n

.meas tran vdout0_34ck330 FIND v(dout0_34) AT=170.025n

.meas tran vdout0_35ck330 FIND v(dout0_35) AT=170.025n

.meas tran vdout0_36ck330 FIND v(dout0_36) AT=170.025n

.meas tran vdout0_37ck330 FIND v(dout0_37) AT=170.025n

.meas tran vdout0_38ck330 FIND v(dout0_38) AT=170.025n

.meas tran vdout0_39ck330 FIND v(dout0_39) AT=170.025n

.meas tran vdout0_40ck330 FIND v(dout0_40) AT=170.025n

.meas tran vdout0_41ck330 FIND v(dout0_41) AT=170.025n

.meas tran vdout0_42ck330 FIND v(dout0_42) AT=170.025n

.meas tran vdout0_43ck330 FIND v(dout0_43) AT=170.025n

.meas tran vdout0_44ck330 FIND v(dout0_44) AT=170.025n

.meas tran vdout0_45ck330 FIND v(dout0_45) AT=170.025n

.meas tran vdout0_46ck330 FIND v(dout0_46) AT=170.025n

.meas tran vdout0_47ck330 FIND v(dout0_47) AT=170.025n

.meas tran vdout0_48ck330 FIND v(dout0_48) AT=170.025n

.meas tran vdout0_49ck330 FIND v(dout0_49) AT=170.025n

.meas tran vdout0_50ck330 FIND v(dout0_50) AT=170.025n

.meas tran vdout0_51ck330 FIND v(dout0_51) AT=170.025n

.meas tran vdout0_52ck330 FIND v(dout0_52) AT=170.025n

.meas tran vdout0_53ck330 FIND v(dout0_53) AT=170.025n

.meas tran vdout0_54ck330 FIND v(dout0_54) AT=170.025n

.meas tran vdout0_55ck330 FIND v(dout0_55) AT=170.025n

.meas tran vdout0_56ck330 FIND v(dout0_56) AT=170.025n

.meas tran vdout0_57ck330 FIND v(dout0_57) AT=170.025n

.meas tran vdout0_58ck330 FIND v(dout0_58) AT=170.025n

.meas tran vdout0_59ck330 FIND v(dout0_59) AT=170.025n

.meas tran vdout0_60ck330 FIND v(dout0_60) AT=170.025n

.meas tran vdout0_61ck330 FIND v(dout0_61) AT=170.025n

.meas tran vdout0_62ck330 FIND v(dout0_62) AT=170.025n

.meas tran vdout0_63ck330 FIND v(dout0_63) AT=170.025n

.meas tran vdout0_0ck390 FIND v(dout0_0) AT=200.025n

.meas tran vdout0_1ck390 FIND v(dout0_1) AT=200.025n

.meas tran vdout0_2ck390 FIND v(dout0_2) AT=200.025n

.meas tran vdout0_3ck390 FIND v(dout0_3) AT=200.025n

.meas tran vdout0_4ck390 FIND v(dout0_4) AT=200.025n

.meas tran vdout0_5ck390 FIND v(dout0_5) AT=200.025n

.meas tran vdout0_6ck390 FIND v(dout0_6) AT=200.025n

.meas tran vdout0_7ck390 FIND v(dout0_7) AT=200.025n

.meas tran vdout0_8ck390 FIND v(dout0_8) AT=200.025n

.meas tran vdout0_9ck390 FIND v(dout0_9) AT=200.025n

.meas tran vdout0_10ck390 FIND v(dout0_10) AT=200.025n

.meas tran vdout0_11ck390 FIND v(dout0_11) AT=200.025n

.meas tran vdout0_12ck390 FIND v(dout0_12) AT=200.025n

.meas tran vdout0_13ck390 FIND v(dout0_13) AT=200.025n

.meas tran vdout0_14ck390 FIND v(dout0_14) AT=200.025n

.meas tran vdout0_15ck390 FIND v(dout0_15) AT=200.025n

.meas tran vdout0_16ck390 FIND v(dout0_16) AT=200.025n

.meas tran vdout0_17ck390 FIND v(dout0_17) AT=200.025n

.meas tran vdout0_18ck390 FIND v(dout0_18) AT=200.025n

.meas tran vdout0_19ck390 FIND v(dout0_19) AT=200.025n

.meas tran vdout0_20ck390 FIND v(dout0_20) AT=200.025n

.meas tran vdout0_21ck390 FIND v(dout0_21) AT=200.025n

.meas tran vdout0_22ck390 FIND v(dout0_22) AT=200.025n

.meas tran vdout0_23ck390 FIND v(dout0_23) AT=200.025n

.meas tran vdout0_24ck390 FIND v(dout0_24) AT=200.025n

.meas tran vdout0_25ck390 FIND v(dout0_25) AT=200.025n

.meas tran vdout0_26ck390 FIND v(dout0_26) AT=200.025n

.meas tran vdout0_27ck390 FIND v(dout0_27) AT=200.025n

.meas tran vdout0_28ck390 FIND v(dout0_28) AT=200.025n

.meas tran vdout0_29ck390 FIND v(dout0_29) AT=200.025n

.meas tran vdout0_30ck390 FIND v(dout0_30) AT=200.025n

.meas tran vdout0_31ck390 FIND v(dout0_31) AT=200.025n

.meas tran vdout0_32ck390 FIND v(dout0_32) AT=200.025n

.meas tran vdout0_33ck390 FIND v(dout0_33) AT=200.025n

.meas tran vdout0_34ck390 FIND v(dout0_34) AT=200.025n

.meas tran vdout0_35ck390 FIND v(dout0_35) AT=200.025n

.meas tran vdout0_36ck390 FIND v(dout0_36) AT=200.025n

.meas tran vdout0_37ck390 FIND v(dout0_37) AT=200.025n

.meas tran vdout0_38ck390 FIND v(dout0_38) AT=200.025n

.meas tran vdout0_39ck390 FIND v(dout0_39) AT=200.025n

.meas tran vdout0_40ck390 FIND v(dout0_40) AT=200.025n

.meas tran vdout0_41ck390 FIND v(dout0_41) AT=200.025n

.meas tran vdout0_42ck390 FIND v(dout0_42) AT=200.025n

.meas tran vdout0_43ck390 FIND v(dout0_43) AT=200.025n

.meas tran vdout0_44ck390 FIND v(dout0_44) AT=200.025n

.meas tran vdout0_45ck390 FIND v(dout0_45) AT=200.025n

.meas tran vdout0_46ck390 FIND v(dout0_46) AT=200.025n

.meas tran vdout0_47ck390 FIND v(dout0_47) AT=200.025n

.meas tran vdout0_48ck390 FIND v(dout0_48) AT=200.025n

.meas tran vdout0_49ck390 FIND v(dout0_49) AT=200.025n

.meas tran vdout0_50ck390 FIND v(dout0_50) AT=200.025n

.meas tran vdout0_51ck390 FIND v(dout0_51) AT=200.025n

.meas tran vdout0_52ck390 FIND v(dout0_52) AT=200.025n

.meas tran vdout0_53ck390 FIND v(dout0_53) AT=200.025n

.meas tran vdout0_54ck390 FIND v(dout0_54) AT=200.025n

.meas tran vdout0_55ck390 FIND v(dout0_55) AT=200.025n

.meas tran vdout0_56ck390 FIND v(dout0_56) AT=200.025n

.meas tran vdout0_57ck390 FIND v(dout0_57) AT=200.025n

.meas tran vdout0_58ck390 FIND v(dout0_58) AT=200.025n

.meas tran vdout0_59ck390 FIND v(dout0_59) AT=200.025n

.meas tran vdout0_60ck390 FIND v(dout0_60) AT=200.025n

.meas tran vdout0_61ck390 FIND v(dout0_61) AT=200.025n

.meas tran vdout0_62ck390 FIND v(dout0_62) AT=200.025n

.meas tran vdout0_63ck390 FIND v(dout0_63) AT=200.025n

.meas tran vdout0_0ck410 FIND v(dout0_0) AT=210.025n

.meas tran vdout0_1ck410 FIND v(dout0_1) AT=210.025n

.meas tran vdout0_2ck410 FIND v(dout0_2) AT=210.025n

.meas tran vdout0_3ck410 FIND v(dout0_3) AT=210.025n

.meas tran vdout0_4ck410 FIND v(dout0_4) AT=210.025n

.meas tran vdout0_5ck410 FIND v(dout0_5) AT=210.025n

.meas tran vdout0_6ck410 FIND v(dout0_6) AT=210.025n

.meas tran vdout0_7ck410 FIND v(dout0_7) AT=210.025n

.meas tran vdout0_8ck410 FIND v(dout0_8) AT=210.025n

.meas tran vdout0_9ck410 FIND v(dout0_9) AT=210.025n

.meas tran vdout0_10ck410 FIND v(dout0_10) AT=210.025n

.meas tran vdout0_11ck410 FIND v(dout0_11) AT=210.025n

.meas tran vdout0_12ck410 FIND v(dout0_12) AT=210.025n

.meas tran vdout0_13ck410 FIND v(dout0_13) AT=210.025n

.meas tran vdout0_14ck410 FIND v(dout0_14) AT=210.025n

.meas tran vdout0_15ck410 FIND v(dout0_15) AT=210.025n

.meas tran vdout0_16ck410 FIND v(dout0_16) AT=210.025n

.meas tran vdout0_17ck410 FIND v(dout0_17) AT=210.025n

.meas tran vdout0_18ck410 FIND v(dout0_18) AT=210.025n

.meas tran vdout0_19ck410 FIND v(dout0_19) AT=210.025n

.meas tran vdout0_20ck410 FIND v(dout0_20) AT=210.025n

.meas tran vdout0_21ck410 FIND v(dout0_21) AT=210.025n

.meas tran vdout0_22ck410 FIND v(dout0_22) AT=210.025n

.meas tran vdout0_23ck410 FIND v(dout0_23) AT=210.025n

.meas tran vdout0_24ck410 FIND v(dout0_24) AT=210.025n

.meas tran vdout0_25ck410 FIND v(dout0_25) AT=210.025n

.meas tran vdout0_26ck410 FIND v(dout0_26) AT=210.025n

.meas tran vdout0_27ck410 FIND v(dout0_27) AT=210.025n

.meas tran vdout0_28ck410 FIND v(dout0_28) AT=210.025n

.meas tran vdout0_29ck410 FIND v(dout0_29) AT=210.025n

.meas tran vdout0_30ck410 FIND v(dout0_30) AT=210.025n

.meas tran vdout0_31ck410 FIND v(dout0_31) AT=210.025n

.meas tran vdout0_32ck410 FIND v(dout0_32) AT=210.025n

.meas tran vdout0_33ck410 FIND v(dout0_33) AT=210.025n

.meas tran vdout0_34ck410 FIND v(dout0_34) AT=210.025n

.meas tran vdout0_35ck410 FIND v(dout0_35) AT=210.025n

.meas tran vdout0_36ck410 FIND v(dout0_36) AT=210.025n

.meas tran vdout0_37ck410 FIND v(dout0_37) AT=210.025n

.meas tran vdout0_38ck410 FIND v(dout0_38) AT=210.025n

.meas tran vdout0_39ck410 FIND v(dout0_39) AT=210.025n

.meas tran vdout0_40ck410 FIND v(dout0_40) AT=210.025n

.meas tran vdout0_41ck410 FIND v(dout0_41) AT=210.025n

.meas tran vdout0_42ck410 FIND v(dout0_42) AT=210.025n

.meas tran vdout0_43ck410 FIND v(dout0_43) AT=210.025n

.meas tran vdout0_44ck410 FIND v(dout0_44) AT=210.025n

.meas tran vdout0_45ck410 FIND v(dout0_45) AT=210.025n

.meas tran vdout0_46ck410 FIND v(dout0_46) AT=210.025n

.meas tran vdout0_47ck410 FIND v(dout0_47) AT=210.025n

.meas tran vdout0_48ck410 FIND v(dout0_48) AT=210.025n

.meas tran vdout0_49ck410 FIND v(dout0_49) AT=210.025n

.meas tran vdout0_50ck410 FIND v(dout0_50) AT=210.025n

.meas tran vdout0_51ck410 FIND v(dout0_51) AT=210.025n

.meas tran vdout0_52ck410 FIND v(dout0_52) AT=210.025n

.meas tran vdout0_53ck410 FIND v(dout0_53) AT=210.025n

.meas tran vdout0_54ck410 FIND v(dout0_54) AT=210.025n

.meas tran vdout0_55ck410 FIND v(dout0_55) AT=210.025n

.meas tran vdout0_56ck410 FIND v(dout0_56) AT=210.025n

.meas tran vdout0_57ck410 FIND v(dout0_57) AT=210.025n

.meas tran vdout0_58ck410 FIND v(dout0_58) AT=210.025n

.meas tran vdout0_59ck410 FIND v(dout0_59) AT=210.025n

.meas tran vdout0_60ck410 FIND v(dout0_60) AT=210.025n

.meas tran vdout0_61ck410 FIND v(dout0_61) AT=210.025n

.meas tran vdout0_62ck410 FIND v(dout0_62) AT=210.025n

.meas tran vdout0_63ck410 FIND v(dout0_63) AT=210.025n

.meas tran vdout0_0ck420 FIND v(dout0_0) AT=215.025n

.meas tran vdout0_1ck420 FIND v(dout0_1) AT=215.025n

.meas tran vdout0_2ck420 FIND v(dout0_2) AT=215.025n

.meas tran vdout0_3ck420 FIND v(dout0_3) AT=215.025n

.meas tran vdout0_4ck420 FIND v(dout0_4) AT=215.025n

.meas tran vdout0_5ck420 FIND v(dout0_5) AT=215.025n

.meas tran vdout0_6ck420 FIND v(dout0_6) AT=215.025n

.meas tran vdout0_7ck420 FIND v(dout0_7) AT=215.025n

.meas tran vdout0_8ck420 FIND v(dout0_8) AT=215.025n

.meas tran vdout0_9ck420 FIND v(dout0_9) AT=215.025n

.meas tran vdout0_10ck420 FIND v(dout0_10) AT=215.025n

.meas tran vdout0_11ck420 FIND v(dout0_11) AT=215.025n

.meas tran vdout0_12ck420 FIND v(dout0_12) AT=215.025n

.meas tran vdout0_13ck420 FIND v(dout0_13) AT=215.025n

.meas tran vdout0_14ck420 FIND v(dout0_14) AT=215.025n

.meas tran vdout0_15ck420 FIND v(dout0_15) AT=215.025n

.meas tran vdout0_16ck420 FIND v(dout0_16) AT=215.025n

.meas tran vdout0_17ck420 FIND v(dout0_17) AT=215.025n

.meas tran vdout0_18ck420 FIND v(dout0_18) AT=215.025n

.meas tran vdout0_19ck420 FIND v(dout0_19) AT=215.025n

.meas tran vdout0_20ck420 FIND v(dout0_20) AT=215.025n

.meas tran vdout0_21ck420 FIND v(dout0_21) AT=215.025n

.meas tran vdout0_22ck420 FIND v(dout0_22) AT=215.025n

.meas tran vdout0_23ck420 FIND v(dout0_23) AT=215.025n

.meas tran vdout0_24ck420 FIND v(dout0_24) AT=215.025n

.meas tran vdout0_25ck420 FIND v(dout0_25) AT=215.025n

.meas tran vdout0_26ck420 FIND v(dout0_26) AT=215.025n

.meas tran vdout0_27ck420 FIND v(dout0_27) AT=215.025n

.meas tran vdout0_28ck420 FIND v(dout0_28) AT=215.025n

.meas tran vdout0_29ck420 FIND v(dout0_29) AT=215.025n

.meas tran vdout0_30ck420 FIND v(dout0_30) AT=215.025n

.meas tran vdout0_31ck420 FIND v(dout0_31) AT=215.025n

.meas tran vdout0_32ck420 FIND v(dout0_32) AT=215.025n

.meas tran vdout0_33ck420 FIND v(dout0_33) AT=215.025n

.meas tran vdout0_34ck420 FIND v(dout0_34) AT=215.025n

.meas tran vdout0_35ck420 FIND v(dout0_35) AT=215.025n

.meas tran vdout0_36ck420 FIND v(dout0_36) AT=215.025n

.meas tran vdout0_37ck420 FIND v(dout0_37) AT=215.025n

.meas tran vdout0_38ck420 FIND v(dout0_38) AT=215.025n

.meas tran vdout0_39ck420 FIND v(dout0_39) AT=215.025n

.meas tran vdout0_40ck420 FIND v(dout0_40) AT=215.025n

.meas tran vdout0_41ck420 FIND v(dout0_41) AT=215.025n

.meas tran vdout0_42ck420 FIND v(dout0_42) AT=215.025n

.meas tran vdout0_43ck420 FIND v(dout0_43) AT=215.025n

.meas tran vdout0_44ck420 FIND v(dout0_44) AT=215.025n

.meas tran vdout0_45ck420 FIND v(dout0_45) AT=215.025n

.meas tran vdout0_46ck420 FIND v(dout0_46) AT=215.025n

.meas tran vdout0_47ck420 FIND v(dout0_47) AT=215.025n

.meas tran vdout0_48ck420 FIND v(dout0_48) AT=215.025n

.meas tran vdout0_49ck420 FIND v(dout0_49) AT=215.025n

.meas tran vdout0_50ck420 FIND v(dout0_50) AT=215.025n

.meas tran vdout0_51ck420 FIND v(dout0_51) AT=215.025n

.meas tran vdout0_52ck420 FIND v(dout0_52) AT=215.025n

.meas tran vdout0_53ck420 FIND v(dout0_53) AT=215.025n

.meas tran vdout0_54ck420 FIND v(dout0_54) AT=215.025n

.meas tran vdout0_55ck420 FIND v(dout0_55) AT=215.025n

.meas tran vdout0_56ck420 FIND v(dout0_56) AT=215.025n

.meas tran vdout0_57ck420 FIND v(dout0_57) AT=215.025n

.meas tran vdout0_58ck420 FIND v(dout0_58) AT=215.025n

.meas tran vdout0_59ck420 FIND v(dout0_59) AT=215.025n

.meas tran vdout0_60ck420 FIND v(dout0_60) AT=215.025n

.meas tran vdout0_61ck420 FIND v(dout0_61) AT=215.025n

.meas tran vdout0_62ck420 FIND v(dout0_62) AT=215.025n

.meas tran vdout0_63ck420 FIND v(dout0_63) AT=215.025n

.meas tran vdout0_0ck430 FIND v(dout0_0) AT=220.025n

.meas tran vdout0_1ck430 FIND v(dout0_1) AT=220.025n

.meas tran vdout0_2ck430 FIND v(dout0_2) AT=220.025n

.meas tran vdout0_3ck430 FIND v(dout0_3) AT=220.025n

.meas tran vdout0_4ck430 FIND v(dout0_4) AT=220.025n

.meas tran vdout0_5ck430 FIND v(dout0_5) AT=220.025n

.meas tran vdout0_6ck430 FIND v(dout0_6) AT=220.025n

.meas tran vdout0_7ck430 FIND v(dout0_7) AT=220.025n

.meas tran vdout0_8ck430 FIND v(dout0_8) AT=220.025n

.meas tran vdout0_9ck430 FIND v(dout0_9) AT=220.025n

.meas tran vdout0_10ck430 FIND v(dout0_10) AT=220.025n

.meas tran vdout0_11ck430 FIND v(dout0_11) AT=220.025n

.meas tran vdout0_12ck430 FIND v(dout0_12) AT=220.025n

.meas tran vdout0_13ck430 FIND v(dout0_13) AT=220.025n

.meas tran vdout0_14ck430 FIND v(dout0_14) AT=220.025n

.meas tran vdout0_15ck430 FIND v(dout0_15) AT=220.025n

.meas tran vdout0_16ck430 FIND v(dout0_16) AT=220.025n

.meas tran vdout0_17ck430 FIND v(dout0_17) AT=220.025n

.meas tran vdout0_18ck430 FIND v(dout0_18) AT=220.025n

.meas tran vdout0_19ck430 FIND v(dout0_19) AT=220.025n

.meas tran vdout0_20ck430 FIND v(dout0_20) AT=220.025n

.meas tran vdout0_21ck430 FIND v(dout0_21) AT=220.025n

.meas tran vdout0_22ck430 FIND v(dout0_22) AT=220.025n

.meas tran vdout0_23ck430 FIND v(dout0_23) AT=220.025n

.meas tran vdout0_24ck430 FIND v(dout0_24) AT=220.025n

.meas tran vdout0_25ck430 FIND v(dout0_25) AT=220.025n

.meas tran vdout0_26ck430 FIND v(dout0_26) AT=220.025n

.meas tran vdout0_27ck430 FIND v(dout0_27) AT=220.025n

.meas tran vdout0_28ck430 FIND v(dout0_28) AT=220.025n

.meas tran vdout0_29ck430 FIND v(dout0_29) AT=220.025n

.meas tran vdout0_30ck430 FIND v(dout0_30) AT=220.025n

.meas tran vdout0_31ck430 FIND v(dout0_31) AT=220.025n

.meas tran vdout0_32ck430 FIND v(dout0_32) AT=220.025n

.meas tran vdout0_33ck430 FIND v(dout0_33) AT=220.025n

.meas tran vdout0_34ck430 FIND v(dout0_34) AT=220.025n

.meas tran vdout0_35ck430 FIND v(dout0_35) AT=220.025n

.meas tran vdout0_36ck430 FIND v(dout0_36) AT=220.025n

.meas tran vdout0_37ck430 FIND v(dout0_37) AT=220.025n

.meas tran vdout0_38ck430 FIND v(dout0_38) AT=220.025n

.meas tran vdout0_39ck430 FIND v(dout0_39) AT=220.025n

.meas tran vdout0_40ck430 FIND v(dout0_40) AT=220.025n

.meas tran vdout0_41ck430 FIND v(dout0_41) AT=220.025n

.meas tran vdout0_42ck430 FIND v(dout0_42) AT=220.025n

.meas tran vdout0_43ck430 FIND v(dout0_43) AT=220.025n

.meas tran vdout0_44ck430 FIND v(dout0_44) AT=220.025n

.meas tran vdout0_45ck430 FIND v(dout0_45) AT=220.025n

.meas tran vdout0_46ck430 FIND v(dout0_46) AT=220.025n

.meas tran vdout0_47ck430 FIND v(dout0_47) AT=220.025n

.meas tran vdout0_48ck430 FIND v(dout0_48) AT=220.025n

.meas tran vdout0_49ck430 FIND v(dout0_49) AT=220.025n

.meas tran vdout0_50ck430 FIND v(dout0_50) AT=220.025n

.meas tran vdout0_51ck430 FIND v(dout0_51) AT=220.025n

.meas tran vdout0_52ck430 FIND v(dout0_52) AT=220.025n

.meas tran vdout0_53ck430 FIND v(dout0_53) AT=220.025n

.meas tran vdout0_54ck430 FIND v(dout0_54) AT=220.025n

.meas tran vdout0_55ck430 FIND v(dout0_55) AT=220.025n

.meas tran vdout0_56ck430 FIND v(dout0_56) AT=220.025n

.meas tran vdout0_57ck430 FIND v(dout0_57) AT=220.025n

.meas tran vdout0_58ck430 FIND v(dout0_58) AT=220.025n

.meas tran vdout0_59ck430 FIND v(dout0_59) AT=220.025n

.meas tran vdout0_60ck430 FIND v(dout0_60) AT=220.025n

.meas tran vdout0_61ck430 FIND v(dout0_61) AT=220.025n

.meas tran vdout0_62ck430 FIND v(dout0_62) AT=220.025n

.meas tran vdout0_63ck430 FIND v(dout0_63) AT=220.025n

.meas tran vdout0_0ck440 FIND v(dout0_0) AT=225.025n

.meas tran vdout0_1ck440 FIND v(dout0_1) AT=225.025n

.meas tran vdout0_2ck440 FIND v(dout0_2) AT=225.025n

.meas tran vdout0_3ck440 FIND v(dout0_3) AT=225.025n

.meas tran vdout0_4ck440 FIND v(dout0_4) AT=225.025n

.meas tran vdout0_5ck440 FIND v(dout0_5) AT=225.025n

.meas tran vdout0_6ck440 FIND v(dout0_6) AT=225.025n

.meas tran vdout0_7ck440 FIND v(dout0_7) AT=225.025n

.meas tran vdout0_8ck440 FIND v(dout0_8) AT=225.025n

.meas tran vdout0_9ck440 FIND v(dout0_9) AT=225.025n

.meas tran vdout0_10ck440 FIND v(dout0_10) AT=225.025n

.meas tran vdout0_11ck440 FIND v(dout0_11) AT=225.025n

.meas tran vdout0_12ck440 FIND v(dout0_12) AT=225.025n

.meas tran vdout0_13ck440 FIND v(dout0_13) AT=225.025n

.meas tran vdout0_14ck440 FIND v(dout0_14) AT=225.025n

.meas tran vdout0_15ck440 FIND v(dout0_15) AT=225.025n

.meas tran vdout0_16ck440 FIND v(dout0_16) AT=225.025n

.meas tran vdout0_17ck440 FIND v(dout0_17) AT=225.025n

.meas tran vdout0_18ck440 FIND v(dout0_18) AT=225.025n

.meas tran vdout0_19ck440 FIND v(dout0_19) AT=225.025n

.meas tran vdout0_20ck440 FIND v(dout0_20) AT=225.025n

.meas tran vdout0_21ck440 FIND v(dout0_21) AT=225.025n

.meas tran vdout0_22ck440 FIND v(dout0_22) AT=225.025n

.meas tran vdout0_23ck440 FIND v(dout0_23) AT=225.025n

.meas tran vdout0_24ck440 FIND v(dout0_24) AT=225.025n

.meas tran vdout0_25ck440 FIND v(dout0_25) AT=225.025n

.meas tran vdout0_26ck440 FIND v(dout0_26) AT=225.025n

.meas tran vdout0_27ck440 FIND v(dout0_27) AT=225.025n

.meas tran vdout0_28ck440 FIND v(dout0_28) AT=225.025n

.meas tran vdout0_29ck440 FIND v(dout0_29) AT=225.025n

.meas tran vdout0_30ck440 FIND v(dout0_30) AT=225.025n

.meas tran vdout0_31ck440 FIND v(dout0_31) AT=225.025n

.meas tran vdout0_32ck440 FIND v(dout0_32) AT=225.025n

.meas tran vdout0_33ck440 FIND v(dout0_33) AT=225.025n

.meas tran vdout0_34ck440 FIND v(dout0_34) AT=225.025n

.meas tran vdout0_35ck440 FIND v(dout0_35) AT=225.025n

.meas tran vdout0_36ck440 FIND v(dout0_36) AT=225.025n

.meas tran vdout0_37ck440 FIND v(dout0_37) AT=225.025n

.meas tran vdout0_38ck440 FIND v(dout0_38) AT=225.025n

.meas tran vdout0_39ck440 FIND v(dout0_39) AT=225.025n

.meas tran vdout0_40ck440 FIND v(dout0_40) AT=225.025n

.meas tran vdout0_41ck440 FIND v(dout0_41) AT=225.025n

.meas tran vdout0_42ck440 FIND v(dout0_42) AT=225.025n

.meas tran vdout0_43ck440 FIND v(dout0_43) AT=225.025n

.meas tran vdout0_44ck440 FIND v(dout0_44) AT=225.025n

.meas tran vdout0_45ck440 FIND v(dout0_45) AT=225.025n

.meas tran vdout0_46ck440 FIND v(dout0_46) AT=225.025n

.meas tran vdout0_47ck440 FIND v(dout0_47) AT=225.025n

.meas tran vdout0_48ck440 FIND v(dout0_48) AT=225.025n

.meas tran vdout0_49ck440 FIND v(dout0_49) AT=225.025n

.meas tran vdout0_50ck440 FIND v(dout0_50) AT=225.025n

.meas tran vdout0_51ck440 FIND v(dout0_51) AT=225.025n

.meas tran vdout0_52ck440 FIND v(dout0_52) AT=225.025n

.meas tran vdout0_53ck440 FIND v(dout0_53) AT=225.025n

.meas tran vdout0_54ck440 FIND v(dout0_54) AT=225.025n

.meas tran vdout0_55ck440 FIND v(dout0_55) AT=225.025n

.meas tran vdout0_56ck440 FIND v(dout0_56) AT=225.025n

.meas tran vdout0_57ck440 FIND v(dout0_57) AT=225.025n

.meas tran vdout0_58ck440 FIND v(dout0_58) AT=225.025n

.meas tran vdout0_59ck440 FIND v(dout0_59) AT=225.025n

.meas tran vdout0_60ck440 FIND v(dout0_60) AT=225.025n

.meas tran vdout0_61ck440 FIND v(dout0_61) AT=225.025n

.meas tran vdout0_62ck440 FIND v(dout0_62) AT=225.025n

.meas tran vdout0_63ck440 FIND v(dout0_63) AT=225.025n

.meas tran vdout0_0ck450 FIND v(dout0_0) AT=230.025n

.meas tran vdout0_1ck450 FIND v(dout0_1) AT=230.025n

.meas tran vdout0_2ck450 FIND v(dout0_2) AT=230.025n

.meas tran vdout0_3ck450 FIND v(dout0_3) AT=230.025n

.meas tran vdout0_4ck450 FIND v(dout0_4) AT=230.025n

.meas tran vdout0_5ck450 FIND v(dout0_5) AT=230.025n

.meas tran vdout0_6ck450 FIND v(dout0_6) AT=230.025n

.meas tran vdout0_7ck450 FIND v(dout0_7) AT=230.025n

.meas tran vdout0_8ck450 FIND v(dout0_8) AT=230.025n

.meas tran vdout0_9ck450 FIND v(dout0_9) AT=230.025n

.meas tran vdout0_10ck450 FIND v(dout0_10) AT=230.025n

.meas tran vdout0_11ck450 FIND v(dout0_11) AT=230.025n

.meas tran vdout0_12ck450 FIND v(dout0_12) AT=230.025n

.meas tran vdout0_13ck450 FIND v(dout0_13) AT=230.025n

.meas tran vdout0_14ck450 FIND v(dout0_14) AT=230.025n

.meas tran vdout0_15ck450 FIND v(dout0_15) AT=230.025n

.meas tran vdout0_16ck450 FIND v(dout0_16) AT=230.025n

.meas tran vdout0_17ck450 FIND v(dout0_17) AT=230.025n

.meas tran vdout0_18ck450 FIND v(dout0_18) AT=230.025n

.meas tran vdout0_19ck450 FIND v(dout0_19) AT=230.025n

.meas tran vdout0_20ck450 FIND v(dout0_20) AT=230.025n

.meas tran vdout0_21ck450 FIND v(dout0_21) AT=230.025n

.meas tran vdout0_22ck450 FIND v(dout0_22) AT=230.025n

.meas tran vdout0_23ck450 FIND v(dout0_23) AT=230.025n

.meas tran vdout0_24ck450 FIND v(dout0_24) AT=230.025n

.meas tran vdout0_25ck450 FIND v(dout0_25) AT=230.025n

.meas tran vdout0_26ck450 FIND v(dout0_26) AT=230.025n

.meas tran vdout0_27ck450 FIND v(dout0_27) AT=230.025n

.meas tran vdout0_28ck450 FIND v(dout0_28) AT=230.025n

.meas tran vdout0_29ck450 FIND v(dout0_29) AT=230.025n

.meas tran vdout0_30ck450 FIND v(dout0_30) AT=230.025n

.meas tran vdout0_31ck450 FIND v(dout0_31) AT=230.025n

.meas tran vdout0_32ck450 FIND v(dout0_32) AT=230.025n

.meas tran vdout0_33ck450 FIND v(dout0_33) AT=230.025n

.meas tran vdout0_34ck450 FIND v(dout0_34) AT=230.025n

.meas tran vdout0_35ck450 FIND v(dout0_35) AT=230.025n

.meas tran vdout0_36ck450 FIND v(dout0_36) AT=230.025n

.meas tran vdout0_37ck450 FIND v(dout0_37) AT=230.025n

.meas tran vdout0_38ck450 FIND v(dout0_38) AT=230.025n

.meas tran vdout0_39ck450 FIND v(dout0_39) AT=230.025n

.meas tran vdout0_40ck450 FIND v(dout0_40) AT=230.025n

.meas tran vdout0_41ck450 FIND v(dout0_41) AT=230.025n

.meas tran vdout0_42ck450 FIND v(dout0_42) AT=230.025n

.meas tran vdout0_43ck450 FIND v(dout0_43) AT=230.025n

.meas tran vdout0_44ck450 FIND v(dout0_44) AT=230.025n

.meas tran vdout0_45ck450 FIND v(dout0_45) AT=230.025n

.meas tran vdout0_46ck450 FIND v(dout0_46) AT=230.025n

.meas tran vdout0_47ck450 FIND v(dout0_47) AT=230.025n

.meas tran vdout0_48ck450 FIND v(dout0_48) AT=230.025n

.meas tran vdout0_49ck450 FIND v(dout0_49) AT=230.025n

.meas tran vdout0_50ck450 FIND v(dout0_50) AT=230.025n

.meas tran vdout0_51ck450 FIND v(dout0_51) AT=230.025n

.meas tran vdout0_52ck450 FIND v(dout0_52) AT=230.025n

.meas tran vdout0_53ck450 FIND v(dout0_53) AT=230.025n

.meas tran vdout0_54ck450 FIND v(dout0_54) AT=230.025n

.meas tran vdout0_55ck450 FIND v(dout0_55) AT=230.025n

.meas tran vdout0_56ck450 FIND v(dout0_56) AT=230.025n

.meas tran vdout0_57ck450 FIND v(dout0_57) AT=230.025n

.meas tran vdout0_58ck450 FIND v(dout0_58) AT=230.025n

.meas tran vdout0_59ck450 FIND v(dout0_59) AT=230.025n

.meas tran vdout0_60ck450 FIND v(dout0_60) AT=230.025n

.meas tran vdout0_61ck450 FIND v(dout0_61) AT=230.025n

.meas tran vdout0_62ck450 FIND v(dout0_62) AT=230.025n

.meas tran vdout0_63ck450 FIND v(dout0_63) AT=230.025n

.meas tran vdout0_0ck460 FIND v(dout0_0) AT=235.025n

.meas tran vdout0_1ck460 FIND v(dout0_1) AT=235.025n

.meas tran vdout0_2ck460 FIND v(dout0_2) AT=235.025n

.meas tran vdout0_3ck460 FIND v(dout0_3) AT=235.025n

.meas tran vdout0_4ck460 FIND v(dout0_4) AT=235.025n

.meas tran vdout0_5ck460 FIND v(dout0_5) AT=235.025n

.meas tran vdout0_6ck460 FIND v(dout0_6) AT=235.025n

.meas tran vdout0_7ck460 FIND v(dout0_7) AT=235.025n

.meas tran vdout0_8ck460 FIND v(dout0_8) AT=235.025n

.meas tran vdout0_9ck460 FIND v(dout0_9) AT=235.025n

.meas tran vdout0_10ck460 FIND v(dout0_10) AT=235.025n

.meas tran vdout0_11ck460 FIND v(dout0_11) AT=235.025n

.meas tran vdout0_12ck460 FIND v(dout0_12) AT=235.025n

.meas tran vdout0_13ck460 FIND v(dout0_13) AT=235.025n

.meas tran vdout0_14ck460 FIND v(dout0_14) AT=235.025n

.meas tran vdout0_15ck460 FIND v(dout0_15) AT=235.025n

.meas tran vdout0_16ck460 FIND v(dout0_16) AT=235.025n

.meas tran vdout0_17ck460 FIND v(dout0_17) AT=235.025n

.meas tran vdout0_18ck460 FIND v(dout0_18) AT=235.025n

.meas tran vdout0_19ck460 FIND v(dout0_19) AT=235.025n

.meas tran vdout0_20ck460 FIND v(dout0_20) AT=235.025n

.meas tran vdout0_21ck460 FIND v(dout0_21) AT=235.025n

.meas tran vdout0_22ck460 FIND v(dout0_22) AT=235.025n

.meas tran vdout0_23ck460 FIND v(dout0_23) AT=235.025n

.meas tran vdout0_24ck460 FIND v(dout0_24) AT=235.025n

.meas tran vdout0_25ck460 FIND v(dout0_25) AT=235.025n

.meas tran vdout0_26ck460 FIND v(dout0_26) AT=235.025n

.meas tran vdout0_27ck460 FIND v(dout0_27) AT=235.025n

.meas tran vdout0_28ck460 FIND v(dout0_28) AT=235.025n

.meas tran vdout0_29ck460 FIND v(dout0_29) AT=235.025n

.meas tran vdout0_30ck460 FIND v(dout0_30) AT=235.025n

.meas tran vdout0_31ck460 FIND v(dout0_31) AT=235.025n

.meas tran vdout0_32ck460 FIND v(dout0_32) AT=235.025n

.meas tran vdout0_33ck460 FIND v(dout0_33) AT=235.025n

.meas tran vdout0_34ck460 FIND v(dout0_34) AT=235.025n

.meas tran vdout0_35ck460 FIND v(dout0_35) AT=235.025n

.meas tran vdout0_36ck460 FIND v(dout0_36) AT=235.025n

.meas tran vdout0_37ck460 FIND v(dout0_37) AT=235.025n

.meas tran vdout0_38ck460 FIND v(dout0_38) AT=235.025n

.meas tran vdout0_39ck460 FIND v(dout0_39) AT=235.025n

.meas tran vdout0_40ck460 FIND v(dout0_40) AT=235.025n

.meas tran vdout0_41ck460 FIND v(dout0_41) AT=235.025n

.meas tran vdout0_42ck460 FIND v(dout0_42) AT=235.025n

.meas tran vdout0_43ck460 FIND v(dout0_43) AT=235.025n

.meas tran vdout0_44ck460 FIND v(dout0_44) AT=235.025n

.meas tran vdout0_45ck460 FIND v(dout0_45) AT=235.025n

.meas tran vdout0_46ck460 FIND v(dout0_46) AT=235.025n

.meas tran vdout0_47ck460 FIND v(dout0_47) AT=235.025n

.meas tran vdout0_48ck460 FIND v(dout0_48) AT=235.025n

.meas tran vdout0_49ck460 FIND v(dout0_49) AT=235.025n

.meas tran vdout0_50ck460 FIND v(dout0_50) AT=235.025n

.meas tran vdout0_51ck460 FIND v(dout0_51) AT=235.025n

.meas tran vdout0_52ck460 FIND v(dout0_52) AT=235.025n

.meas tran vdout0_53ck460 FIND v(dout0_53) AT=235.025n

.meas tran vdout0_54ck460 FIND v(dout0_54) AT=235.025n

.meas tran vdout0_55ck460 FIND v(dout0_55) AT=235.025n

.meas tran vdout0_56ck460 FIND v(dout0_56) AT=235.025n

.meas tran vdout0_57ck460 FIND v(dout0_57) AT=235.025n

.meas tran vdout0_58ck460 FIND v(dout0_58) AT=235.025n

.meas tran vdout0_59ck460 FIND v(dout0_59) AT=235.025n

.meas tran vdout0_60ck460 FIND v(dout0_60) AT=235.025n

.meas tran vdout0_61ck460 FIND v(dout0_61) AT=235.025n

.meas tran vdout0_62ck460 FIND v(dout0_62) AT=235.025n

.meas tran vdout0_63ck460 FIND v(dout0_63) AT=235.025n

.meas tran vdout0_0ck480 FIND v(dout0_0) AT=245.025n

.meas tran vdout0_1ck480 FIND v(dout0_1) AT=245.025n

.meas tran vdout0_2ck480 FIND v(dout0_2) AT=245.025n

.meas tran vdout0_3ck480 FIND v(dout0_3) AT=245.025n

.meas tran vdout0_4ck480 FIND v(dout0_4) AT=245.025n

.meas tran vdout0_5ck480 FIND v(dout0_5) AT=245.025n

.meas tran vdout0_6ck480 FIND v(dout0_6) AT=245.025n

.meas tran vdout0_7ck480 FIND v(dout0_7) AT=245.025n

.meas tran vdout0_8ck480 FIND v(dout0_8) AT=245.025n

.meas tran vdout0_9ck480 FIND v(dout0_9) AT=245.025n

.meas tran vdout0_10ck480 FIND v(dout0_10) AT=245.025n

.meas tran vdout0_11ck480 FIND v(dout0_11) AT=245.025n

.meas tran vdout0_12ck480 FIND v(dout0_12) AT=245.025n

.meas tran vdout0_13ck480 FIND v(dout0_13) AT=245.025n

.meas tran vdout0_14ck480 FIND v(dout0_14) AT=245.025n

.meas tran vdout0_15ck480 FIND v(dout0_15) AT=245.025n

.meas tran vdout0_16ck480 FIND v(dout0_16) AT=245.025n

.meas tran vdout0_17ck480 FIND v(dout0_17) AT=245.025n

.meas tran vdout0_18ck480 FIND v(dout0_18) AT=245.025n

.meas tran vdout0_19ck480 FIND v(dout0_19) AT=245.025n

.meas tran vdout0_20ck480 FIND v(dout0_20) AT=245.025n

.meas tran vdout0_21ck480 FIND v(dout0_21) AT=245.025n

.meas tran vdout0_22ck480 FIND v(dout0_22) AT=245.025n

.meas tran vdout0_23ck480 FIND v(dout0_23) AT=245.025n

.meas tran vdout0_24ck480 FIND v(dout0_24) AT=245.025n

.meas tran vdout0_25ck480 FIND v(dout0_25) AT=245.025n

.meas tran vdout0_26ck480 FIND v(dout0_26) AT=245.025n

.meas tran vdout0_27ck480 FIND v(dout0_27) AT=245.025n

.meas tran vdout0_28ck480 FIND v(dout0_28) AT=245.025n

.meas tran vdout0_29ck480 FIND v(dout0_29) AT=245.025n

.meas tran vdout0_30ck480 FIND v(dout0_30) AT=245.025n

.meas tran vdout0_31ck480 FIND v(dout0_31) AT=245.025n

.meas tran vdout0_32ck480 FIND v(dout0_32) AT=245.025n

.meas tran vdout0_33ck480 FIND v(dout0_33) AT=245.025n

.meas tran vdout0_34ck480 FIND v(dout0_34) AT=245.025n

.meas tran vdout0_35ck480 FIND v(dout0_35) AT=245.025n

.meas tran vdout0_36ck480 FIND v(dout0_36) AT=245.025n

.meas tran vdout0_37ck480 FIND v(dout0_37) AT=245.025n

.meas tran vdout0_38ck480 FIND v(dout0_38) AT=245.025n

.meas tran vdout0_39ck480 FIND v(dout0_39) AT=245.025n

.meas tran vdout0_40ck480 FIND v(dout0_40) AT=245.025n

.meas tran vdout0_41ck480 FIND v(dout0_41) AT=245.025n

.meas tran vdout0_42ck480 FIND v(dout0_42) AT=245.025n

.meas tran vdout0_43ck480 FIND v(dout0_43) AT=245.025n

.meas tran vdout0_44ck480 FIND v(dout0_44) AT=245.025n

.meas tran vdout0_45ck480 FIND v(dout0_45) AT=245.025n

.meas tran vdout0_46ck480 FIND v(dout0_46) AT=245.025n

.meas tran vdout0_47ck480 FIND v(dout0_47) AT=245.025n

.meas tran vdout0_48ck480 FIND v(dout0_48) AT=245.025n

.meas tran vdout0_49ck480 FIND v(dout0_49) AT=245.025n

.meas tran vdout0_50ck480 FIND v(dout0_50) AT=245.025n

.meas tran vdout0_51ck480 FIND v(dout0_51) AT=245.025n

.meas tran vdout0_52ck480 FIND v(dout0_52) AT=245.025n

.meas tran vdout0_53ck480 FIND v(dout0_53) AT=245.025n

.meas tran vdout0_54ck480 FIND v(dout0_54) AT=245.025n

.meas tran vdout0_55ck480 FIND v(dout0_55) AT=245.025n

.meas tran vdout0_56ck480 FIND v(dout0_56) AT=245.025n

.meas tran vdout0_57ck480 FIND v(dout0_57) AT=245.025n

.meas tran vdout0_58ck480 FIND v(dout0_58) AT=245.025n

.meas tran vdout0_59ck480 FIND v(dout0_59) AT=245.025n

.meas tran vdout0_60ck480 FIND v(dout0_60) AT=245.025n

.meas tran vdout0_61ck480 FIND v(dout0_61) AT=245.025n

.meas tran vdout0_62ck480 FIND v(dout0_62) AT=245.025n

.meas tran vdout0_63ck480 FIND v(dout0_63) AT=245.025n

.meas tran vdout0_0ck520 FIND v(dout0_0) AT=265.025n

.meas tran vdout0_1ck520 FIND v(dout0_1) AT=265.025n

.meas tran vdout0_2ck520 FIND v(dout0_2) AT=265.025n

.meas tran vdout0_3ck520 FIND v(dout0_3) AT=265.025n

.meas tran vdout0_4ck520 FIND v(dout0_4) AT=265.025n

.meas tran vdout0_5ck520 FIND v(dout0_5) AT=265.025n

.meas tran vdout0_6ck520 FIND v(dout0_6) AT=265.025n

.meas tran vdout0_7ck520 FIND v(dout0_7) AT=265.025n

.meas tran vdout0_8ck520 FIND v(dout0_8) AT=265.025n

.meas tran vdout0_9ck520 FIND v(dout0_9) AT=265.025n

.meas tran vdout0_10ck520 FIND v(dout0_10) AT=265.025n

.meas tran vdout0_11ck520 FIND v(dout0_11) AT=265.025n

.meas tran vdout0_12ck520 FIND v(dout0_12) AT=265.025n

.meas tran vdout0_13ck520 FIND v(dout0_13) AT=265.025n

.meas tran vdout0_14ck520 FIND v(dout0_14) AT=265.025n

.meas tran vdout0_15ck520 FIND v(dout0_15) AT=265.025n

.meas tran vdout0_16ck520 FIND v(dout0_16) AT=265.025n

.meas tran vdout0_17ck520 FIND v(dout0_17) AT=265.025n

.meas tran vdout0_18ck520 FIND v(dout0_18) AT=265.025n

.meas tran vdout0_19ck520 FIND v(dout0_19) AT=265.025n

.meas tran vdout0_20ck520 FIND v(dout0_20) AT=265.025n

.meas tran vdout0_21ck520 FIND v(dout0_21) AT=265.025n

.meas tran vdout0_22ck520 FIND v(dout0_22) AT=265.025n

.meas tran vdout0_23ck520 FIND v(dout0_23) AT=265.025n

.meas tran vdout0_24ck520 FIND v(dout0_24) AT=265.025n

.meas tran vdout0_25ck520 FIND v(dout0_25) AT=265.025n

.meas tran vdout0_26ck520 FIND v(dout0_26) AT=265.025n

.meas tran vdout0_27ck520 FIND v(dout0_27) AT=265.025n

.meas tran vdout0_28ck520 FIND v(dout0_28) AT=265.025n

.meas tran vdout0_29ck520 FIND v(dout0_29) AT=265.025n

.meas tran vdout0_30ck520 FIND v(dout0_30) AT=265.025n

.meas tran vdout0_31ck520 FIND v(dout0_31) AT=265.025n

.meas tran vdout0_32ck520 FIND v(dout0_32) AT=265.025n

.meas tran vdout0_33ck520 FIND v(dout0_33) AT=265.025n

.meas tran vdout0_34ck520 FIND v(dout0_34) AT=265.025n

.meas tran vdout0_35ck520 FIND v(dout0_35) AT=265.025n

.meas tran vdout0_36ck520 FIND v(dout0_36) AT=265.025n

.meas tran vdout0_37ck520 FIND v(dout0_37) AT=265.025n

.meas tran vdout0_38ck520 FIND v(dout0_38) AT=265.025n

.meas tran vdout0_39ck520 FIND v(dout0_39) AT=265.025n

.meas tran vdout0_40ck520 FIND v(dout0_40) AT=265.025n

.meas tran vdout0_41ck520 FIND v(dout0_41) AT=265.025n

.meas tran vdout0_42ck520 FIND v(dout0_42) AT=265.025n

.meas tran vdout0_43ck520 FIND v(dout0_43) AT=265.025n

.meas tran vdout0_44ck520 FIND v(dout0_44) AT=265.025n

.meas tran vdout0_45ck520 FIND v(dout0_45) AT=265.025n

.meas tran vdout0_46ck520 FIND v(dout0_46) AT=265.025n

.meas tran vdout0_47ck520 FIND v(dout0_47) AT=265.025n

.meas tran vdout0_48ck520 FIND v(dout0_48) AT=265.025n

.meas tran vdout0_49ck520 FIND v(dout0_49) AT=265.025n

.meas tran vdout0_50ck520 FIND v(dout0_50) AT=265.025n

.meas tran vdout0_51ck520 FIND v(dout0_51) AT=265.025n

.meas tran vdout0_52ck520 FIND v(dout0_52) AT=265.025n

.meas tran vdout0_53ck520 FIND v(dout0_53) AT=265.025n

.meas tran vdout0_54ck520 FIND v(dout0_54) AT=265.025n

.meas tran vdout0_55ck520 FIND v(dout0_55) AT=265.025n

.meas tran vdout0_56ck520 FIND v(dout0_56) AT=265.025n

.meas tran vdout0_57ck520 FIND v(dout0_57) AT=265.025n

.meas tran vdout0_58ck520 FIND v(dout0_58) AT=265.025n

.meas tran vdout0_59ck520 FIND v(dout0_59) AT=265.025n

.meas tran vdout0_60ck520 FIND v(dout0_60) AT=265.025n

.meas tran vdout0_61ck520 FIND v(dout0_61) AT=265.025n

.meas tran vdout0_62ck520 FIND v(dout0_62) AT=265.025n

.meas tran vdout0_63ck520 FIND v(dout0_63) AT=265.025n

.meas tran vdout0_0ck540 FIND v(dout0_0) AT=275.025n

.meas tran vdout0_1ck540 FIND v(dout0_1) AT=275.025n

.meas tran vdout0_2ck540 FIND v(dout0_2) AT=275.025n

.meas tran vdout0_3ck540 FIND v(dout0_3) AT=275.025n

.meas tran vdout0_4ck540 FIND v(dout0_4) AT=275.025n

.meas tran vdout0_5ck540 FIND v(dout0_5) AT=275.025n

.meas tran vdout0_6ck540 FIND v(dout0_6) AT=275.025n

.meas tran vdout0_7ck540 FIND v(dout0_7) AT=275.025n

.meas tran vdout0_8ck540 FIND v(dout0_8) AT=275.025n

.meas tran vdout0_9ck540 FIND v(dout0_9) AT=275.025n

.meas tran vdout0_10ck540 FIND v(dout0_10) AT=275.025n

.meas tran vdout0_11ck540 FIND v(dout0_11) AT=275.025n

.meas tran vdout0_12ck540 FIND v(dout0_12) AT=275.025n

.meas tran vdout0_13ck540 FIND v(dout0_13) AT=275.025n

.meas tran vdout0_14ck540 FIND v(dout0_14) AT=275.025n

.meas tran vdout0_15ck540 FIND v(dout0_15) AT=275.025n

.meas tran vdout0_16ck540 FIND v(dout0_16) AT=275.025n

.meas tran vdout0_17ck540 FIND v(dout0_17) AT=275.025n

.meas tran vdout0_18ck540 FIND v(dout0_18) AT=275.025n

.meas tran vdout0_19ck540 FIND v(dout0_19) AT=275.025n

.meas tran vdout0_20ck540 FIND v(dout0_20) AT=275.025n

.meas tran vdout0_21ck540 FIND v(dout0_21) AT=275.025n

.meas tran vdout0_22ck540 FIND v(dout0_22) AT=275.025n

.meas tran vdout0_23ck540 FIND v(dout0_23) AT=275.025n

.meas tran vdout0_24ck540 FIND v(dout0_24) AT=275.025n

.meas tran vdout0_25ck540 FIND v(dout0_25) AT=275.025n

.meas tran vdout0_26ck540 FIND v(dout0_26) AT=275.025n

.meas tran vdout0_27ck540 FIND v(dout0_27) AT=275.025n

.meas tran vdout0_28ck540 FIND v(dout0_28) AT=275.025n

.meas tran vdout0_29ck540 FIND v(dout0_29) AT=275.025n

.meas tran vdout0_30ck540 FIND v(dout0_30) AT=275.025n

.meas tran vdout0_31ck540 FIND v(dout0_31) AT=275.025n

.meas tran vdout0_32ck540 FIND v(dout0_32) AT=275.025n

.meas tran vdout0_33ck540 FIND v(dout0_33) AT=275.025n

.meas tran vdout0_34ck540 FIND v(dout0_34) AT=275.025n

.meas tran vdout0_35ck540 FIND v(dout0_35) AT=275.025n

.meas tran vdout0_36ck540 FIND v(dout0_36) AT=275.025n

.meas tran vdout0_37ck540 FIND v(dout0_37) AT=275.025n

.meas tran vdout0_38ck540 FIND v(dout0_38) AT=275.025n

.meas tran vdout0_39ck540 FIND v(dout0_39) AT=275.025n

.meas tran vdout0_40ck540 FIND v(dout0_40) AT=275.025n

.meas tran vdout0_41ck540 FIND v(dout0_41) AT=275.025n

.meas tran vdout0_42ck540 FIND v(dout0_42) AT=275.025n

.meas tran vdout0_43ck540 FIND v(dout0_43) AT=275.025n

.meas tran vdout0_44ck540 FIND v(dout0_44) AT=275.025n

.meas tran vdout0_45ck540 FIND v(dout0_45) AT=275.025n

.meas tran vdout0_46ck540 FIND v(dout0_46) AT=275.025n

.meas tran vdout0_47ck540 FIND v(dout0_47) AT=275.025n

.meas tran vdout0_48ck540 FIND v(dout0_48) AT=275.025n

.meas tran vdout0_49ck540 FIND v(dout0_49) AT=275.025n

.meas tran vdout0_50ck540 FIND v(dout0_50) AT=275.025n

.meas tran vdout0_51ck540 FIND v(dout0_51) AT=275.025n

.meas tran vdout0_52ck540 FIND v(dout0_52) AT=275.025n

.meas tran vdout0_53ck540 FIND v(dout0_53) AT=275.025n

.meas tran vdout0_54ck540 FIND v(dout0_54) AT=275.025n

.meas tran vdout0_55ck540 FIND v(dout0_55) AT=275.025n

.meas tran vdout0_56ck540 FIND v(dout0_56) AT=275.025n

.meas tran vdout0_57ck540 FIND v(dout0_57) AT=275.025n

.meas tran vdout0_58ck540 FIND v(dout0_58) AT=275.025n

.meas tran vdout0_59ck540 FIND v(dout0_59) AT=275.025n

.meas tran vdout0_60ck540 FIND v(dout0_60) AT=275.025n

.meas tran vdout0_61ck540 FIND v(dout0_61) AT=275.025n

.meas tran vdout0_62ck540 FIND v(dout0_62) AT=275.025n

.meas tran vdout0_63ck540 FIND v(dout0_63) AT=275.025n

.meas tran vdout0_0ck570 FIND v(dout0_0) AT=290.025n

.meas tran vdout0_1ck570 FIND v(dout0_1) AT=290.025n

.meas tran vdout0_2ck570 FIND v(dout0_2) AT=290.025n

.meas tran vdout0_3ck570 FIND v(dout0_3) AT=290.025n

.meas tran vdout0_4ck570 FIND v(dout0_4) AT=290.025n

.meas tran vdout0_5ck570 FIND v(dout0_5) AT=290.025n

.meas tran vdout0_6ck570 FIND v(dout0_6) AT=290.025n

.meas tran vdout0_7ck570 FIND v(dout0_7) AT=290.025n

.meas tran vdout0_8ck570 FIND v(dout0_8) AT=290.025n

.meas tran vdout0_9ck570 FIND v(dout0_9) AT=290.025n

.meas tran vdout0_10ck570 FIND v(dout0_10) AT=290.025n

.meas tran vdout0_11ck570 FIND v(dout0_11) AT=290.025n

.meas tran vdout0_12ck570 FIND v(dout0_12) AT=290.025n

.meas tran vdout0_13ck570 FIND v(dout0_13) AT=290.025n

.meas tran vdout0_14ck570 FIND v(dout0_14) AT=290.025n

.meas tran vdout0_15ck570 FIND v(dout0_15) AT=290.025n

.meas tran vdout0_16ck570 FIND v(dout0_16) AT=290.025n

.meas tran vdout0_17ck570 FIND v(dout0_17) AT=290.025n

.meas tran vdout0_18ck570 FIND v(dout0_18) AT=290.025n

.meas tran vdout0_19ck570 FIND v(dout0_19) AT=290.025n

.meas tran vdout0_20ck570 FIND v(dout0_20) AT=290.025n

.meas tran vdout0_21ck570 FIND v(dout0_21) AT=290.025n

.meas tran vdout0_22ck570 FIND v(dout0_22) AT=290.025n

.meas tran vdout0_23ck570 FIND v(dout0_23) AT=290.025n

.meas tran vdout0_24ck570 FIND v(dout0_24) AT=290.025n

.meas tran vdout0_25ck570 FIND v(dout0_25) AT=290.025n

.meas tran vdout0_26ck570 FIND v(dout0_26) AT=290.025n

.meas tran vdout0_27ck570 FIND v(dout0_27) AT=290.025n

.meas tran vdout0_28ck570 FIND v(dout0_28) AT=290.025n

.meas tran vdout0_29ck570 FIND v(dout0_29) AT=290.025n

.meas tran vdout0_30ck570 FIND v(dout0_30) AT=290.025n

.meas tran vdout0_31ck570 FIND v(dout0_31) AT=290.025n

.meas tran vdout0_32ck570 FIND v(dout0_32) AT=290.025n

.meas tran vdout0_33ck570 FIND v(dout0_33) AT=290.025n

.meas tran vdout0_34ck570 FIND v(dout0_34) AT=290.025n

.meas tran vdout0_35ck570 FIND v(dout0_35) AT=290.025n

.meas tran vdout0_36ck570 FIND v(dout0_36) AT=290.025n

.meas tran vdout0_37ck570 FIND v(dout0_37) AT=290.025n

.meas tran vdout0_38ck570 FIND v(dout0_38) AT=290.025n

.meas tran vdout0_39ck570 FIND v(dout0_39) AT=290.025n

.meas tran vdout0_40ck570 FIND v(dout0_40) AT=290.025n

.meas tran vdout0_41ck570 FIND v(dout0_41) AT=290.025n

.meas tran vdout0_42ck570 FIND v(dout0_42) AT=290.025n

.meas tran vdout0_43ck570 FIND v(dout0_43) AT=290.025n

.meas tran vdout0_44ck570 FIND v(dout0_44) AT=290.025n

.meas tran vdout0_45ck570 FIND v(dout0_45) AT=290.025n

.meas tran vdout0_46ck570 FIND v(dout0_46) AT=290.025n

.meas tran vdout0_47ck570 FIND v(dout0_47) AT=290.025n

.meas tran vdout0_48ck570 FIND v(dout0_48) AT=290.025n

.meas tran vdout0_49ck570 FIND v(dout0_49) AT=290.025n

.meas tran vdout0_50ck570 FIND v(dout0_50) AT=290.025n

.meas tran vdout0_51ck570 FIND v(dout0_51) AT=290.025n

.meas tran vdout0_52ck570 FIND v(dout0_52) AT=290.025n

.meas tran vdout0_53ck570 FIND v(dout0_53) AT=290.025n

.meas tran vdout0_54ck570 FIND v(dout0_54) AT=290.025n

.meas tran vdout0_55ck570 FIND v(dout0_55) AT=290.025n

.meas tran vdout0_56ck570 FIND v(dout0_56) AT=290.025n

.meas tran vdout0_57ck570 FIND v(dout0_57) AT=290.025n

.meas tran vdout0_58ck570 FIND v(dout0_58) AT=290.025n

.meas tran vdout0_59ck570 FIND v(dout0_59) AT=290.025n

.meas tran vdout0_60ck570 FIND v(dout0_60) AT=290.025n

.meas tran vdout0_61ck570 FIND v(dout0_61) AT=290.025n

.meas tran vdout0_62ck570 FIND v(dout0_62) AT=290.025n

.meas tran vdout0_63ck570 FIND v(dout0_63) AT=290.025n

.meas tran vdout0_0ck580 FIND v(dout0_0) AT=295.025n

.meas tran vdout0_1ck580 FIND v(dout0_1) AT=295.025n

.meas tran vdout0_2ck580 FIND v(dout0_2) AT=295.025n

.meas tran vdout0_3ck580 FIND v(dout0_3) AT=295.025n

.meas tran vdout0_4ck580 FIND v(dout0_4) AT=295.025n

.meas tran vdout0_5ck580 FIND v(dout0_5) AT=295.025n

.meas tran vdout0_6ck580 FIND v(dout0_6) AT=295.025n

.meas tran vdout0_7ck580 FIND v(dout0_7) AT=295.025n

.meas tran vdout0_8ck580 FIND v(dout0_8) AT=295.025n

.meas tran vdout0_9ck580 FIND v(dout0_9) AT=295.025n

.meas tran vdout0_10ck580 FIND v(dout0_10) AT=295.025n

.meas tran vdout0_11ck580 FIND v(dout0_11) AT=295.025n

.meas tran vdout0_12ck580 FIND v(dout0_12) AT=295.025n

.meas tran vdout0_13ck580 FIND v(dout0_13) AT=295.025n

.meas tran vdout0_14ck580 FIND v(dout0_14) AT=295.025n

.meas tran vdout0_15ck580 FIND v(dout0_15) AT=295.025n

.meas tran vdout0_16ck580 FIND v(dout0_16) AT=295.025n

.meas tran vdout0_17ck580 FIND v(dout0_17) AT=295.025n

.meas tran vdout0_18ck580 FIND v(dout0_18) AT=295.025n

.meas tran vdout0_19ck580 FIND v(dout0_19) AT=295.025n

.meas tran vdout0_20ck580 FIND v(dout0_20) AT=295.025n

.meas tran vdout0_21ck580 FIND v(dout0_21) AT=295.025n

.meas tran vdout0_22ck580 FIND v(dout0_22) AT=295.025n

.meas tran vdout0_23ck580 FIND v(dout0_23) AT=295.025n

.meas tran vdout0_24ck580 FIND v(dout0_24) AT=295.025n

.meas tran vdout0_25ck580 FIND v(dout0_25) AT=295.025n

.meas tran vdout0_26ck580 FIND v(dout0_26) AT=295.025n

.meas tran vdout0_27ck580 FIND v(dout0_27) AT=295.025n

.meas tran vdout0_28ck580 FIND v(dout0_28) AT=295.025n

.meas tran vdout0_29ck580 FIND v(dout0_29) AT=295.025n

.meas tran vdout0_30ck580 FIND v(dout0_30) AT=295.025n

.meas tran vdout0_31ck580 FIND v(dout0_31) AT=295.025n

.meas tran vdout0_32ck580 FIND v(dout0_32) AT=295.025n

.meas tran vdout0_33ck580 FIND v(dout0_33) AT=295.025n

.meas tran vdout0_34ck580 FIND v(dout0_34) AT=295.025n

.meas tran vdout0_35ck580 FIND v(dout0_35) AT=295.025n

.meas tran vdout0_36ck580 FIND v(dout0_36) AT=295.025n

.meas tran vdout0_37ck580 FIND v(dout0_37) AT=295.025n

.meas tran vdout0_38ck580 FIND v(dout0_38) AT=295.025n

.meas tran vdout0_39ck580 FIND v(dout0_39) AT=295.025n

.meas tran vdout0_40ck580 FIND v(dout0_40) AT=295.025n

.meas tran vdout0_41ck580 FIND v(dout0_41) AT=295.025n

.meas tran vdout0_42ck580 FIND v(dout0_42) AT=295.025n

.meas tran vdout0_43ck580 FIND v(dout0_43) AT=295.025n

.meas tran vdout0_44ck580 FIND v(dout0_44) AT=295.025n

.meas tran vdout0_45ck580 FIND v(dout0_45) AT=295.025n

.meas tran vdout0_46ck580 FIND v(dout0_46) AT=295.025n

.meas tran vdout0_47ck580 FIND v(dout0_47) AT=295.025n

.meas tran vdout0_48ck580 FIND v(dout0_48) AT=295.025n

.meas tran vdout0_49ck580 FIND v(dout0_49) AT=295.025n

.meas tran vdout0_50ck580 FIND v(dout0_50) AT=295.025n

.meas tran vdout0_51ck580 FIND v(dout0_51) AT=295.025n

.meas tran vdout0_52ck580 FIND v(dout0_52) AT=295.025n

.meas tran vdout0_53ck580 FIND v(dout0_53) AT=295.025n

.meas tran vdout0_54ck580 FIND v(dout0_54) AT=295.025n

.meas tran vdout0_55ck580 FIND v(dout0_55) AT=295.025n

.meas tran vdout0_56ck580 FIND v(dout0_56) AT=295.025n

.meas tran vdout0_57ck580 FIND v(dout0_57) AT=295.025n

.meas tran vdout0_58ck580 FIND v(dout0_58) AT=295.025n

.meas tran vdout0_59ck580 FIND v(dout0_59) AT=295.025n

.meas tran vdout0_60ck580 FIND v(dout0_60) AT=295.025n

.meas tran vdout0_61ck580 FIND v(dout0_61) AT=295.025n

.meas tran vdout0_62ck580 FIND v(dout0_62) AT=295.025n

.meas tran vdout0_63ck580 FIND v(dout0_63) AT=295.025n

.meas tran vdout0_0ck600 FIND v(dout0_0) AT=305.025n

.meas tran vdout0_1ck600 FIND v(dout0_1) AT=305.025n

.meas tran vdout0_2ck600 FIND v(dout0_2) AT=305.025n

.meas tran vdout0_3ck600 FIND v(dout0_3) AT=305.025n

.meas tran vdout0_4ck600 FIND v(dout0_4) AT=305.025n

.meas tran vdout0_5ck600 FIND v(dout0_5) AT=305.025n

.meas tran vdout0_6ck600 FIND v(dout0_6) AT=305.025n

.meas tran vdout0_7ck600 FIND v(dout0_7) AT=305.025n

.meas tran vdout0_8ck600 FIND v(dout0_8) AT=305.025n

.meas tran vdout0_9ck600 FIND v(dout0_9) AT=305.025n

.meas tran vdout0_10ck600 FIND v(dout0_10) AT=305.025n

.meas tran vdout0_11ck600 FIND v(dout0_11) AT=305.025n

.meas tran vdout0_12ck600 FIND v(dout0_12) AT=305.025n

.meas tran vdout0_13ck600 FIND v(dout0_13) AT=305.025n

.meas tran vdout0_14ck600 FIND v(dout0_14) AT=305.025n

.meas tran vdout0_15ck600 FIND v(dout0_15) AT=305.025n

.meas tran vdout0_16ck600 FIND v(dout0_16) AT=305.025n

.meas tran vdout0_17ck600 FIND v(dout0_17) AT=305.025n

.meas tran vdout0_18ck600 FIND v(dout0_18) AT=305.025n

.meas tran vdout0_19ck600 FIND v(dout0_19) AT=305.025n

.meas tran vdout0_20ck600 FIND v(dout0_20) AT=305.025n

.meas tran vdout0_21ck600 FIND v(dout0_21) AT=305.025n

.meas tran vdout0_22ck600 FIND v(dout0_22) AT=305.025n

.meas tran vdout0_23ck600 FIND v(dout0_23) AT=305.025n

.meas tran vdout0_24ck600 FIND v(dout0_24) AT=305.025n

.meas tran vdout0_25ck600 FIND v(dout0_25) AT=305.025n

.meas tran vdout0_26ck600 FIND v(dout0_26) AT=305.025n

.meas tran vdout0_27ck600 FIND v(dout0_27) AT=305.025n

.meas tran vdout0_28ck600 FIND v(dout0_28) AT=305.025n

.meas tran vdout0_29ck600 FIND v(dout0_29) AT=305.025n

.meas tran vdout0_30ck600 FIND v(dout0_30) AT=305.025n

.meas tran vdout0_31ck600 FIND v(dout0_31) AT=305.025n

.meas tran vdout0_32ck600 FIND v(dout0_32) AT=305.025n

.meas tran vdout0_33ck600 FIND v(dout0_33) AT=305.025n

.meas tran vdout0_34ck600 FIND v(dout0_34) AT=305.025n

.meas tran vdout0_35ck600 FIND v(dout0_35) AT=305.025n

.meas tran vdout0_36ck600 FIND v(dout0_36) AT=305.025n

.meas tran vdout0_37ck600 FIND v(dout0_37) AT=305.025n

.meas tran vdout0_38ck600 FIND v(dout0_38) AT=305.025n

.meas tran vdout0_39ck600 FIND v(dout0_39) AT=305.025n

.meas tran vdout0_40ck600 FIND v(dout0_40) AT=305.025n

.meas tran vdout0_41ck600 FIND v(dout0_41) AT=305.025n

.meas tran vdout0_42ck600 FIND v(dout0_42) AT=305.025n

.meas tran vdout0_43ck600 FIND v(dout0_43) AT=305.025n

.meas tran vdout0_44ck600 FIND v(dout0_44) AT=305.025n

.meas tran vdout0_45ck600 FIND v(dout0_45) AT=305.025n

.meas tran vdout0_46ck600 FIND v(dout0_46) AT=305.025n

.meas tran vdout0_47ck600 FIND v(dout0_47) AT=305.025n

.meas tran vdout0_48ck600 FIND v(dout0_48) AT=305.025n

.meas tran vdout0_49ck600 FIND v(dout0_49) AT=305.025n

.meas tran vdout0_50ck600 FIND v(dout0_50) AT=305.025n

.meas tran vdout0_51ck600 FIND v(dout0_51) AT=305.025n

.meas tran vdout0_52ck600 FIND v(dout0_52) AT=305.025n

.meas tran vdout0_53ck600 FIND v(dout0_53) AT=305.025n

.meas tran vdout0_54ck600 FIND v(dout0_54) AT=305.025n

.meas tran vdout0_55ck600 FIND v(dout0_55) AT=305.025n

.meas tran vdout0_56ck600 FIND v(dout0_56) AT=305.025n

.meas tran vdout0_57ck600 FIND v(dout0_57) AT=305.025n

.meas tran vdout0_58ck600 FIND v(dout0_58) AT=305.025n

.meas tran vdout0_59ck600 FIND v(dout0_59) AT=305.025n

.meas tran vdout0_60ck600 FIND v(dout0_60) AT=305.025n

.meas tran vdout0_61ck600 FIND v(dout0_61) AT=305.025n

.meas tran vdout0_62ck600 FIND v(dout0_62) AT=305.025n

.meas tran vdout0_63ck600 FIND v(dout0_63) AT=305.025n

.meas tran vdout0_0ck610 FIND v(dout0_0) AT=310.025n

.meas tran vdout0_1ck610 FIND v(dout0_1) AT=310.025n

.meas tran vdout0_2ck610 FIND v(dout0_2) AT=310.025n

.meas tran vdout0_3ck610 FIND v(dout0_3) AT=310.025n

.meas tran vdout0_4ck610 FIND v(dout0_4) AT=310.025n

.meas tran vdout0_5ck610 FIND v(dout0_5) AT=310.025n

.meas tran vdout0_6ck610 FIND v(dout0_6) AT=310.025n

.meas tran vdout0_7ck610 FIND v(dout0_7) AT=310.025n

.meas tran vdout0_8ck610 FIND v(dout0_8) AT=310.025n

.meas tran vdout0_9ck610 FIND v(dout0_9) AT=310.025n

.meas tran vdout0_10ck610 FIND v(dout0_10) AT=310.025n

.meas tran vdout0_11ck610 FIND v(dout0_11) AT=310.025n

.meas tran vdout0_12ck610 FIND v(dout0_12) AT=310.025n

.meas tran vdout0_13ck610 FIND v(dout0_13) AT=310.025n

.meas tran vdout0_14ck610 FIND v(dout0_14) AT=310.025n

.meas tran vdout0_15ck610 FIND v(dout0_15) AT=310.025n

.meas tran vdout0_16ck610 FIND v(dout0_16) AT=310.025n

.meas tran vdout0_17ck610 FIND v(dout0_17) AT=310.025n

.meas tran vdout0_18ck610 FIND v(dout0_18) AT=310.025n

.meas tran vdout0_19ck610 FIND v(dout0_19) AT=310.025n

.meas tran vdout0_20ck610 FIND v(dout0_20) AT=310.025n

.meas tran vdout0_21ck610 FIND v(dout0_21) AT=310.025n

.meas tran vdout0_22ck610 FIND v(dout0_22) AT=310.025n

.meas tran vdout0_23ck610 FIND v(dout0_23) AT=310.025n

.meas tran vdout0_24ck610 FIND v(dout0_24) AT=310.025n

.meas tran vdout0_25ck610 FIND v(dout0_25) AT=310.025n

.meas tran vdout0_26ck610 FIND v(dout0_26) AT=310.025n

.meas tran vdout0_27ck610 FIND v(dout0_27) AT=310.025n

.meas tran vdout0_28ck610 FIND v(dout0_28) AT=310.025n

.meas tran vdout0_29ck610 FIND v(dout0_29) AT=310.025n

.meas tran vdout0_30ck610 FIND v(dout0_30) AT=310.025n

.meas tran vdout0_31ck610 FIND v(dout0_31) AT=310.025n

.meas tran vdout0_32ck610 FIND v(dout0_32) AT=310.025n

.meas tran vdout0_33ck610 FIND v(dout0_33) AT=310.025n

.meas tran vdout0_34ck610 FIND v(dout0_34) AT=310.025n

.meas tran vdout0_35ck610 FIND v(dout0_35) AT=310.025n

.meas tran vdout0_36ck610 FIND v(dout0_36) AT=310.025n

.meas tran vdout0_37ck610 FIND v(dout0_37) AT=310.025n

.meas tran vdout0_38ck610 FIND v(dout0_38) AT=310.025n

.meas tran vdout0_39ck610 FIND v(dout0_39) AT=310.025n

.meas tran vdout0_40ck610 FIND v(dout0_40) AT=310.025n

.meas tran vdout0_41ck610 FIND v(dout0_41) AT=310.025n

.meas tran vdout0_42ck610 FIND v(dout0_42) AT=310.025n

.meas tran vdout0_43ck610 FIND v(dout0_43) AT=310.025n

.meas tran vdout0_44ck610 FIND v(dout0_44) AT=310.025n

.meas tran vdout0_45ck610 FIND v(dout0_45) AT=310.025n

.meas tran vdout0_46ck610 FIND v(dout0_46) AT=310.025n

.meas tran vdout0_47ck610 FIND v(dout0_47) AT=310.025n

.meas tran vdout0_48ck610 FIND v(dout0_48) AT=310.025n

.meas tran vdout0_49ck610 FIND v(dout0_49) AT=310.025n

.meas tran vdout0_50ck610 FIND v(dout0_50) AT=310.025n

.meas tran vdout0_51ck610 FIND v(dout0_51) AT=310.025n

.meas tran vdout0_52ck610 FIND v(dout0_52) AT=310.025n

.meas tran vdout0_53ck610 FIND v(dout0_53) AT=310.025n

.meas tran vdout0_54ck610 FIND v(dout0_54) AT=310.025n

.meas tran vdout0_55ck610 FIND v(dout0_55) AT=310.025n

.meas tran vdout0_56ck610 FIND v(dout0_56) AT=310.025n

.meas tran vdout0_57ck610 FIND v(dout0_57) AT=310.025n

.meas tran vdout0_58ck610 FIND v(dout0_58) AT=310.025n

.meas tran vdout0_59ck610 FIND v(dout0_59) AT=310.025n

.meas tran vdout0_60ck610 FIND v(dout0_60) AT=310.025n

.meas tran vdout0_61ck610 FIND v(dout0_61) AT=310.025n

.meas tran vdout0_62ck610 FIND v(dout0_62) AT=310.025n

.meas tran vdout0_63ck610 FIND v(dout0_63) AT=310.025n

.meas tran vdout0_0ck630 FIND v(dout0_0) AT=320.025n

.meas tran vdout0_1ck630 FIND v(dout0_1) AT=320.025n

.meas tran vdout0_2ck630 FIND v(dout0_2) AT=320.025n

.meas tran vdout0_3ck630 FIND v(dout0_3) AT=320.025n

.meas tran vdout0_4ck630 FIND v(dout0_4) AT=320.025n

.meas tran vdout0_5ck630 FIND v(dout0_5) AT=320.025n

.meas tran vdout0_6ck630 FIND v(dout0_6) AT=320.025n

.meas tran vdout0_7ck630 FIND v(dout0_7) AT=320.025n

.meas tran vdout0_8ck630 FIND v(dout0_8) AT=320.025n

.meas tran vdout0_9ck630 FIND v(dout0_9) AT=320.025n

.meas tran vdout0_10ck630 FIND v(dout0_10) AT=320.025n

.meas tran vdout0_11ck630 FIND v(dout0_11) AT=320.025n

.meas tran vdout0_12ck630 FIND v(dout0_12) AT=320.025n

.meas tran vdout0_13ck630 FIND v(dout0_13) AT=320.025n

.meas tran vdout0_14ck630 FIND v(dout0_14) AT=320.025n

.meas tran vdout0_15ck630 FIND v(dout0_15) AT=320.025n

.meas tran vdout0_16ck630 FIND v(dout0_16) AT=320.025n

.meas tran vdout0_17ck630 FIND v(dout0_17) AT=320.025n

.meas tran vdout0_18ck630 FIND v(dout0_18) AT=320.025n

.meas tran vdout0_19ck630 FIND v(dout0_19) AT=320.025n

.meas tran vdout0_20ck630 FIND v(dout0_20) AT=320.025n

.meas tran vdout0_21ck630 FIND v(dout0_21) AT=320.025n

.meas tran vdout0_22ck630 FIND v(dout0_22) AT=320.025n

.meas tran vdout0_23ck630 FIND v(dout0_23) AT=320.025n

.meas tran vdout0_24ck630 FIND v(dout0_24) AT=320.025n

.meas tran vdout0_25ck630 FIND v(dout0_25) AT=320.025n

.meas tran vdout0_26ck630 FIND v(dout0_26) AT=320.025n

.meas tran vdout0_27ck630 FIND v(dout0_27) AT=320.025n

.meas tran vdout0_28ck630 FIND v(dout0_28) AT=320.025n

.meas tran vdout0_29ck630 FIND v(dout0_29) AT=320.025n

.meas tran vdout0_30ck630 FIND v(dout0_30) AT=320.025n

.meas tran vdout0_31ck630 FIND v(dout0_31) AT=320.025n

.meas tran vdout0_32ck630 FIND v(dout0_32) AT=320.025n

.meas tran vdout0_33ck630 FIND v(dout0_33) AT=320.025n

.meas tran vdout0_34ck630 FIND v(dout0_34) AT=320.025n

.meas tran vdout0_35ck630 FIND v(dout0_35) AT=320.025n

.meas tran vdout0_36ck630 FIND v(dout0_36) AT=320.025n

.meas tran vdout0_37ck630 FIND v(dout0_37) AT=320.025n

.meas tran vdout0_38ck630 FIND v(dout0_38) AT=320.025n

.meas tran vdout0_39ck630 FIND v(dout0_39) AT=320.025n

.meas tran vdout0_40ck630 FIND v(dout0_40) AT=320.025n

.meas tran vdout0_41ck630 FIND v(dout0_41) AT=320.025n

.meas tran vdout0_42ck630 FIND v(dout0_42) AT=320.025n

.meas tran vdout0_43ck630 FIND v(dout0_43) AT=320.025n

.meas tran vdout0_44ck630 FIND v(dout0_44) AT=320.025n

.meas tran vdout0_45ck630 FIND v(dout0_45) AT=320.025n

.meas tran vdout0_46ck630 FIND v(dout0_46) AT=320.025n

.meas tran vdout0_47ck630 FIND v(dout0_47) AT=320.025n

.meas tran vdout0_48ck630 FIND v(dout0_48) AT=320.025n

.meas tran vdout0_49ck630 FIND v(dout0_49) AT=320.025n

.meas tran vdout0_50ck630 FIND v(dout0_50) AT=320.025n

.meas tran vdout0_51ck630 FIND v(dout0_51) AT=320.025n

.meas tran vdout0_52ck630 FIND v(dout0_52) AT=320.025n

.meas tran vdout0_53ck630 FIND v(dout0_53) AT=320.025n

.meas tran vdout0_54ck630 FIND v(dout0_54) AT=320.025n

.meas tran vdout0_55ck630 FIND v(dout0_55) AT=320.025n

.meas tran vdout0_56ck630 FIND v(dout0_56) AT=320.025n

.meas tran vdout0_57ck630 FIND v(dout0_57) AT=320.025n

.meas tran vdout0_58ck630 FIND v(dout0_58) AT=320.025n

.meas tran vdout0_59ck630 FIND v(dout0_59) AT=320.025n

.meas tran vdout0_60ck630 FIND v(dout0_60) AT=320.025n

.meas tran vdout0_61ck630 FIND v(dout0_61) AT=320.025n

.meas tran vdout0_62ck630 FIND v(dout0_62) AT=320.025n

.meas tran vdout0_63ck630 FIND v(dout0_63) AT=320.025n

.meas tran vdout0_0ck650 FIND v(dout0_0) AT=330.025n

.meas tran vdout0_1ck650 FIND v(dout0_1) AT=330.025n

.meas tran vdout0_2ck650 FIND v(dout0_2) AT=330.025n

.meas tran vdout0_3ck650 FIND v(dout0_3) AT=330.025n

.meas tran vdout0_4ck650 FIND v(dout0_4) AT=330.025n

.meas tran vdout0_5ck650 FIND v(dout0_5) AT=330.025n

.meas tran vdout0_6ck650 FIND v(dout0_6) AT=330.025n

.meas tran vdout0_7ck650 FIND v(dout0_7) AT=330.025n

.meas tran vdout0_8ck650 FIND v(dout0_8) AT=330.025n

.meas tran vdout0_9ck650 FIND v(dout0_9) AT=330.025n

.meas tran vdout0_10ck650 FIND v(dout0_10) AT=330.025n

.meas tran vdout0_11ck650 FIND v(dout0_11) AT=330.025n

.meas tran vdout0_12ck650 FIND v(dout0_12) AT=330.025n

.meas tran vdout0_13ck650 FIND v(dout0_13) AT=330.025n

.meas tran vdout0_14ck650 FIND v(dout0_14) AT=330.025n

.meas tran vdout0_15ck650 FIND v(dout0_15) AT=330.025n

.meas tran vdout0_16ck650 FIND v(dout0_16) AT=330.025n

.meas tran vdout0_17ck650 FIND v(dout0_17) AT=330.025n

.meas tran vdout0_18ck650 FIND v(dout0_18) AT=330.025n

.meas tran vdout0_19ck650 FIND v(dout0_19) AT=330.025n

.meas tran vdout0_20ck650 FIND v(dout0_20) AT=330.025n

.meas tran vdout0_21ck650 FIND v(dout0_21) AT=330.025n

.meas tran vdout0_22ck650 FIND v(dout0_22) AT=330.025n

.meas tran vdout0_23ck650 FIND v(dout0_23) AT=330.025n

.meas tran vdout0_24ck650 FIND v(dout0_24) AT=330.025n

.meas tran vdout0_25ck650 FIND v(dout0_25) AT=330.025n

.meas tran vdout0_26ck650 FIND v(dout0_26) AT=330.025n

.meas tran vdout0_27ck650 FIND v(dout0_27) AT=330.025n

.meas tran vdout0_28ck650 FIND v(dout0_28) AT=330.025n

.meas tran vdout0_29ck650 FIND v(dout0_29) AT=330.025n

.meas tran vdout0_30ck650 FIND v(dout0_30) AT=330.025n

.meas tran vdout0_31ck650 FIND v(dout0_31) AT=330.025n

.meas tran vdout0_32ck650 FIND v(dout0_32) AT=330.025n

.meas tran vdout0_33ck650 FIND v(dout0_33) AT=330.025n

.meas tran vdout0_34ck650 FIND v(dout0_34) AT=330.025n

.meas tran vdout0_35ck650 FIND v(dout0_35) AT=330.025n

.meas tran vdout0_36ck650 FIND v(dout0_36) AT=330.025n

.meas tran vdout0_37ck650 FIND v(dout0_37) AT=330.025n

.meas tran vdout0_38ck650 FIND v(dout0_38) AT=330.025n

.meas tran vdout0_39ck650 FIND v(dout0_39) AT=330.025n

.meas tran vdout0_40ck650 FIND v(dout0_40) AT=330.025n

.meas tran vdout0_41ck650 FIND v(dout0_41) AT=330.025n

.meas tran vdout0_42ck650 FIND v(dout0_42) AT=330.025n

.meas tran vdout0_43ck650 FIND v(dout0_43) AT=330.025n

.meas tran vdout0_44ck650 FIND v(dout0_44) AT=330.025n

.meas tran vdout0_45ck650 FIND v(dout0_45) AT=330.025n

.meas tran vdout0_46ck650 FIND v(dout0_46) AT=330.025n

.meas tran vdout0_47ck650 FIND v(dout0_47) AT=330.025n

.meas tran vdout0_48ck650 FIND v(dout0_48) AT=330.025n

.meas tran vdout0_49ck650 FIND v(dout0_49) AT=330.025n

.meas tran vdout0_50ck650 FIND v(dout0_50) AT=330.025n

.meas tran vdout0_51ck650 FIND v(dout0_51) AT=330.025n

.meas tran vdout0_52ck650 FIND v(dout0_52) AT=330.025n

.meas tran vdout0_53ck650 FIND v(dout0_53) AT=330.025n

.meas tran vdout0_54ck650 FIND v(dout0_54) AT=330.025n

.meas tran vdout0_55ck650 FIND v(dout0_55) AT=330.025n

.meas tran vdout0_56ck650 FIND v(dout0_56) AT=330.025n

.meas tran vdout0_57ck650 FIND v(dout0_57) AT=330.025n

.meas tran vdout0_58ck650 FIND v(dout0_58) AT=330.025n

.meas tran vdout0_59ck650 FIND v(dout0_59) AT=330.025n

.meas tran vdout0_60ck650 FIND v(dout0_60) AT=330.025n

.meas tran vdout0_61ck650 FIND v(dout0_61) AT=330.025n

.meas tran vdout0_62ck650 FIND v(dout0_62) AT=330.025n

.meas tran vdout0_63ck650 FIND v(dout0_63) AT=330.025n

.meas tran vdout0_0ck670 FIND v(dout0_0) AT=340.025n

.meas tran vdout0_1ck670 FIND v(dout0_1) AT=340.025n

.meas tran vdout0_2ck670 FIND v(dout0_2) AT=340.025n

.meas tran vdout0_3ck670 FIND v(dout0_3) AT=340.025n

.meas tran vdout0_4ck670 FIND v(dout0_4) AT=340.025n

.meas tran vdout0_5ck670 FIND v(dout0_5) AT=340.025n

.meas tran vdout0_6ck670 FIND v(dout0_6) AT=340.025n

.meas tran vdout0_7ck670 FIND v(dout0_7) AT=340.025n

.meas tran vdout0_8ck670 FIND v(dout0_8) AT=340.025n

.meas tran vdout0_9ck670 FIND v(dout0_9) AT=340.025n

.meas tran vdout0_10ck670 FIND v(dout0_10) AT=340.025n

.meas tran vdout0_11ck670 FIND v(dout0_11) AT=340.025n

.meas tran vdout0_12ck670 FIND v(dout0_12) AT=340.025n

.meas tran vdout0_13ck670 FIND v(dout0_13) AT=340.025n

.meas tran vdout0_14ck670 FIND v(dout0_14) AT=340.025n

.meas tran vdout0_15ck670 FIND v(dout0_15) AT=340.025n

.meas tran vdout0_16ck670 FIND v(dout0_16) AT=340.025n

.meas tran vdout0_17ck670 FIND v(dout0_17) AT=340.025n

.meas tran vdout0_18ck670 FIND v(dout0_18) AT=340.025n

.meas tran vdout0_19ck670 FIND v(dout0_19) AT=340.025n

.meas tran vdout0_20ck670 FIND v(dout0_20) AT=340.025n

.meas tran vdout0_21ck670 FIND v(dout0_21) AT=340.025n

.meas tran vdout0_22ck670 FIND v(dout0_22) AT=340.025n

.meas tran vdout0_23ck670 FIND v(dout0_23) AT=340.025n

.meas tran vdout0_24ck670 FIND v(dout0_24) AT=340.025n

.meas tran vdout0_25ck670 FIND v(dout0_25) AT=340.025n

.meas tran vdout0_26ck670 FIND v(dout0_26) AT=340.025n

.meas tran vdout0_27ck670 FIND v(dout0_27) AT=340.025n

.meas tran vdout0_28ck670 FIND v(dout0_28) AT=340.025n

.meas tran vdout0_29ck670 FIND v(dout0_29) AT=340.025n

.meas tran vdout0_30ck670 FIND v(dout0_30) AT=340.025n

.meas tran vdout0_31ck670 FIND v(dout0_31) AT=340.025n

.meas tran vdout0_32ck670 FIND v(dout0_32) AT=340.025n

.meas tran vdout0_33ck670 FIND v(dout0_33) AT=340.025n

.meas tran vdout0_34ck670 FIND v(dout0_34) AT=340.025n

.meas tran vdout0_35ck670 FIND v(dout0_35) AT=340.025n

.meas tran vdout0_36ck670 FIND v(dout0_36) AT=340.025n

.meas tran vdout0_37ck670 FIND v(dout0_37) AT=340.025n

.meas tran vdout0_38ck670 FIND v(dout0_38) AT=340.025n

.meas tran vdout0_39ck670 FIND v(dout0_39) AT=340.025n

.meas tran vdout0_40ck670 FIND v(dout0_40) AT=340.025n

.meas tran vdout0_41ck670 FIND v(dout0_41) AT=340.025n

.meas tran vdout0_42ck670 FIND v(dout0_42) AT=340.025n

.meas tran vdout0_43ck670 FIND v(dout0_43) AT=340.025n

.meas tran vdout0_44ck670 FIND v(dout0_44) AT=340.025n

.meas tran vdout0_45ck670 FIND v(dout0_45) AT=340.025n

.meas tran vdout0_46ck670 FIND v(dout0_46) AT=340.025n

.meas tran vdout0_47ck670 FIND v(dout0_47) AT=340.025n

.meas tran vdout0_48ck670 FIND v(dout0_48) AT=340.025n

.meas tran vdout0_49ck670 FIND v(dout0_49) AT=340.025n

.meas tran vdout0_50ck670 FIND v(dout0_50) AT=340.025n

.meas tran vdout0_51ck670 FIND v(dout0_51) AT=340.025n

.meas tran vdout0_52ck670 FIND v(dout0_52) AT=340.025n

.meas tran vdout0_53ck670 FIND v(dout0_53) AT=340.025n

.meas tran vdout0_54ck670 FIND v(dout0_54) AT=340.025n

.meas tran vdout0_55ck670 FIND v(dout0_55) AT=340.025n

.meas tran vdout0_56ck670 FIND v(dout0_56) AT=340.025n

.meas tran vdout0_57ck670 FIND v(dout0_57) AT=340.025n

.meas tran vdout0_58ck670 FIND v(dout0_58) AT=340.025n

.meas tran vdout0_59ck670 FIND v(dout0_59) AT=340.025n

.meas tran vdout0_60ck670 FIND v(dout0_60) AT=340.025n

.meas tran vdout0_61ck670 FIND v(dout0_61) AT=340.025n

.meas tran vdout0_62ck670 FIND v(dout0_62) AT=340.025n

.meas tran vdout0_63ck670 FIND v(dout0_63) AT=340.025n

.meas tran vdout0_0ck680 FIND v(dout0_0) AT=345.025n

.meas tran vdout0_1ck680 FIND v(dout0_1) AT=345.025n

.meas tran vdout0_2ck680 FIND v(dout0_2) AT=345.025n

.meas tran vdout0_3ck680 FIND v(dout0_3) AT=345.025n

.meas tran vdout0_4ck680 FIND v(dout0_4) AT=345.025n

.meas tran vdout0_5ck680 FIND v(dout0_5) AT=345.025n

.meas tran vdout0_6ck680 FIND v(dout0_6) AT=345.025n

.meas tran vdout0_7ck680 FIND v(dout0_7) AT=345.025n

.meas tran vdout0_8ck680 FIND v(dout0_8) AT=345.025n

.meas tran vdout0_9ck680 FIND v(dout0_9) AT=345.025n

.meas tran vdout0_10ck680 FIND v(dout0_10) AT=345.025n

.meas tran vdout0_11ck680 FIND v(dout0_11) AT=345.025n

.meas tran vdout0_12ck680 FIND v(dout0_12) AT=345.025n

.meas tran vdout0_13ck680 FIND v(dout0_13) AT=345.025n

.meas tran vdout0_14ck680 FIND v(dout0_14) AT=345.025n

.meas tran vdout0_15ck680 FIND v(dout0_15) AT=345.025n

.meas tran vdout0_16ck680 FIND v(dout0_16) AT=345.025n

.meas tran vdout0_17ck680 FIND v(dout0_17) AT=345.025n

.meas tran vdout0_18ck680 FIND v(dout0_18) AT=345.025n

.meas tran vdout0_19ck680 FIND v(dout0_19) AT=345.025n

.meas tran vdout0_20ck680 FIND v(dout0_20) AT=345.025n

.meas tran vdout0_21ck680 FIND v(dout0_21) AT=345.025n

.meas tran vdout0_22ck680 FIND v(dout0_22) AT=345.025n

.meas tran vdout0_23ck680 FIND v(dout0_23) AT=345.025n

.meas tran vdout0_24ck680 FIND v(dout0_24) AT=345.025n

.meas tran vdout0_25ck680 FIND v(dout0_25) AT=345.025n

.meas tran vdout0_26ck680 FIND v(dout0_26) AT=345.025n

.meas tran vdout0_27ck680 FIND v(dout0_27) AT=345.025n

.meas tran vdout0_28ck680 FIND v(dout0_28) AT=345.025n

.meas tran vdout0_29ck680 FIND v(dout0_29) AT=345.025n

.meas tran vdout0_30ck680 FIND v(dout0_30) AT=345.025n

.meas tran vdout0_31ck680 FIND v(dout0_31) AT=345.025n

.meas tran vdout0_32ck680 FIND v(dout0_32) AT=345.025n

.meas tran vdout0_33ck680 FIND v(dout0_33) AT=345.025n

.meas tran vdout0_34ck680 FIND v(dout0_34) AT=345.025n

.meas tran vdout0_35ck680 FIND v(dout0_35) AT=345.025n

.meas tran vdout0_36ck680 FIND v(dout0_36) AT=345.025n

.meas tran vdout0_37ck680 FIND v(dout0_37) AT=345.025n

.meas tran vdout0_38ck680 FIND v(dout0_38) AT=345.025n

.meas tran vdout0_39ck680 FIND v(dout0_39) AT=345.025n

.meas tran vdout0_40ck680 FIND v(dout0_40) AT=345.025n

.meas tran vdout0_41ck680 FIND v(dout0_41) AT=345.025n

.meas tran vdout0_42ck680 FIND v(dout0_42) AT=345.025n

.meas tran vdout0_43ck680 FIND v(dout0_43) AT=345.025n

.meas tran vdout0_44ck680 FIND v(dout0_44) AT=345.025n

.meas tran vdout0_45ck680 FIND v(dout0_45) AT=345.025n

.meas tran vdout0_46ck680 FIND v(dout0_46) AT=345.025n

.meas tran vdout0_47ck680 FIND v(dout0_47) AT=345.025n

.meas tran vdout0_48ck680 FIND v(dout0_48) AT=345.025n

.meas tran vdout0_49ck680 FIND v(dout0_49) AT=345.025n

.meas tran vdout0_50ck680 FIND v(dout0_50) AT=345.025n

.meas tran vdout0_51ck680 FIND v(dout0_51) AT=345.025n

.meas tran vdout0_52ck680 FIND v(dout0_52) AT=345.025n

.meas tran vdout0_53ck680 FIND v(dout0_53) AT=345.025n

.meas tran vdout0_54ck680 FIND v(dout0_54) AT=345.025n

.meas tran vdout0_55ck680 FIND v(dout0_55) AT=345.025n

.meas tran vdout0_56ck680 FIND v(dout0_56) AT=345.025n

.meas tran vdout0_57ck680 FIND v(dout0_57) AT=345.025n

.meas tran vdout0_58ck680 FIND v(dout0_58) AT=345.025n

.meas tran vdout0_59ck680 FIND v(dout0_59) AT=345.025n

.meas tran vdout0_60ck680 FIND v(dout0_60) AT=345.025n

.meas tran vdout0_61ck680 FIND v(dout0_61) AT=345.025n

.meas tran vdout0_62ck680 FIND v(dout0_62) AT=345.025n

.meas tran vdout0_63ck680 FIND v(dout0_63) AT=345.025n

.meas tran vdout0_0ck730 FIND v(dout0_0) AT=370.025n

.meas tran vdout0_1ck730 FIND v(dout0_1) AT=370.025n

.meas tran vdout0_2ck730 FIND v(dout0_2) AT=370.025n

.meas tran vdout0_3ck730 FIND v(dout0_3) AT=370.025n

.meas tran vdout0_4ck730 FIND v(dout0_4) AT=370.025n

.meas tran vdout0_5ck730 FIND v(dout0_5) AT=370.025n

.meas tran vdout0_6ck730 FIND v(dout0_6) AT=370.025n

.meas tran vdout0_7ck730 FIND v(dout0_7) AT=370.025n

.meas tran vdout0_8ck730 FIND v(dout0_8) AT=370.025n

.meas tran vdout0_9ck730 FIND v(dout0_9) AT=370.025n

.meas tran vdout0_10ck730 FIND v(dout0_10) AT=370.025n

.meas tran vdout0_11ck730 FIND v(dout0_11) AT=370.025n

.meas tran vdout0_12ck730 FIND v(dout0_12) AT=370.025n

.meas tran vdout0_13ck730 FIND v(dout0_13) AT=370.025n

.meas tran vdout0_14ck730 FIND v(dout0_14) AT=370.025n

.meas tran vdout0_15ck730 FIND v(dout0_15) AT=370.025n

.meas tran vdout0_16ck730 FIND v(dout0_16) AT=370.025n

.meas tran vdout0_17ck730 FIND v(dout0_17) AT=370.025n

.meas tran vdout0_18ck730 FIND v(dout0_18) AT=370.025n

.meas tran vdout0_19ck730 FIND v(dout0_19) AT=370.025n

.meas tran vdout0_20ck730 FIND v(dout0_20) AT=370.025n

.meas tran vdout0_21ck730 FIND v(dout0_21) AT=370.025n

.meas tran vdout0_22ck730 FIND v(dout0_22) AT=370.025n

.meas tran vdout0_23ck730 FIND v(dout0_23) AT=370.025n

.meas tran vdout0_24ck730 FIND v(dout0_24) AT=370.025n

.meas tran vdout0_25ck730 FIND v(dout0_25) AT=370.025n

.meas tran vdout0_26ck730 FIND v(dout0_26) AT=370.025n

.meas tran vdout0_27ck730 FIND v(dout0_27) AT=370.025n

.meas tran vdout0_28ck730 FIND v(dout0_28) AT=370.025n

.meas tran vdout0_29ck730 FIND v(dout0_29) AT=370.025n

.meas tran vdout0_30ck730 FIND v(dout0_30) AT=370.025n

.meas tran vdout0_31ck730 FIND v(dout0_31) AT=370.025n

.meas tran vdout0_32ck730 FIND v(dout0_32) AT=370.025n

.meas tran vdout0_33ck730 FIND v(dout0_33) AT=370.025n

.meas tran vdout0_34ck730 FIND v(dout0_34) AT=370.025n

.meas tran vdout0_35ck730 FIND v(dout0_35) AT=370.025n

.meas tran vdout0_36ck730 FIND v(dout0_36) AT=370.025n

.meas tran vdout0_37ck730 FIND v(dout0_37) AT=370.025n

.meas tran vdout0_38ck730 FIND v(dout0_38) AT=370.025n

.meas tran vdout0_39ck730 FIND v(dout0_39) AT=370.025n

.meas tran vdout0_40ck730 FIND v(dout0_40) AT=370.025n

.meas tran vdout0_41ck730 FIND v(dout0_41) AT=370.025n

.meas tran vdout0_42ck730 FIND v(dout0_42) AT=370.025n

.meas tran vdout0_43ck730 FIND v(dout0_43) AT=370.025n

.meas tran vdout0_44ck730 FIND v(dout0_44) AT=370.025n

.meas tran vdout0_45ck730 FIND v(dout0_45) AT=370.025n

.meas tran vdout0_46ck730 FIND v(dout0_46) AT=370.025n

.meas tran vdout0_47ck730 FIND v(dout0_47) AT=370.025n

.meas tran vdout0_48ck730 FIND v(dout0_48) AT=370.025n

.meas tran vdout0_49ck730 FIND v(dout0_49) AT=370.025n

.meas tran vdout0_50ck730 FIND v(dout0_50) AT=370.025n

.meas tran vdout0_51ck730 FIND v(dout0_51) AT=370.025n

.meas tran vdout0_52ck730 FIND v(dout0_52) AT=370.025n

.meas tran vdout0_53ck730 FIND v(dout0_53) AT=370.025n

.meas tran vdout0_54ck730 FIND v(dout0_54) AT=370.025n

.meas tran vdout0_55ck730 FIND v(dout0_55) AT=370.025n

.meas tran vdout0_56ck730 FIND v(dout0_56) AT=370.025n

.meas tran vdout0_57ck730 FIND v(dout0_57) AT=370.025n

.meas tran vdout0_58ck730 FIND v(dout0_58) AT=370.025n

.meas tran vdout0_59ck730 FIND v(dout0_59) AT=370.025n

.meas tran vdout0_60ck730 FIND v(dout0_60) AT=370.025n

.meas tran vdout0_61ck730 FIND v(dout0_61) AT=370.025n

.meas tran vdout0_62ck730 FIND v(dout0_62) AT=370.025n

.meas tran vdout0_63ck730 FIND v(dout0_63) AT=370.025n

.meas tran vdout0_0ck740 FIND v(dout0_0) AT=375.025n

.meas tran vdout0_1ck740 FIND v(dout0_1) AT=375.025n

.meas tran vdout0_2ck740 FIND v(dout0_2) AT=375.025n

.meas tran vdout0_3ck740 FIND v(dout0_3) AT=375.025n

.meas tran vdout0_4ck740 FIND v(dout0_4) AT=375.025n

.meas tran vdout0_5ck740 FIND v(dout0_5) AT=375.025n

.meas tran vdout0_6ck740 FIND v(dout0_6) AT=375.025n

.meas tran vdout0_7ck740 FIND v(dout0_7) AT=375.025n

.meas tran vdout0_8ck740 FIND v(dout0_8) AT=375.025n

.meas tran vdout0_9ck740 FIND v(dout0_9) AT=375.025n

.meas tran vdout0_10ck740 FIND v(dout0_10) AT=375.025n

.meas tran vdout0_11ck740 FIND v(dout0_11) AT=375.025n

.meas tran vdout0_12ck740 FIND v(dout0_12) AT=375.025n

.meas tran vdout0_13ck740 FIND v(dout0_13) AT=375.025n

.meas tran vdout0_14ck740 FIND v(dout0_14) AT=375.025n

.meas tran vdout0_15ck740 FIND v(dout0_15) AT=375.025n

.meas tran vdout0_16ck740 FIND v(dout0_16) AT=375.025n

.meas tran vdout0_17ck740 FIND v(dout0_17) AT=375.025n

.meas tran vdout0_18ck740 FIND v(dout0_18) AT=375.025n

.meas tran vdout0_19ck740 FIND v(dout0_19) AT=375.025n

.meas tran vdout0_20ck740 FIND v(dout0_20) AT=375.025n

.meas tran vdout0_21ck740 FIND v(dout0_21) AT=375.025n

.meas tran vdout0_22ck740 FIND v(dout0_22) AT=375.025n

.meas tran vdout0_23ck740 FIND v(dout0_23) AT=375.025n

.meas tran vdout0_24ck740 FIND v(dout0_24) AT=375.025n

.meas tran vdout0_25ck740 FIND v(dout0_25) AT=375.025n

.meas tran vdout0_26ck740 FIND v(dout0_26) AT=375.025n

.meas tran vdout0_27ck740 FIND v(dout0_27) AT=375.025n

.meas tran vdout0_28ck740 FIND v(dout0_28) AT=375.025n

.meas tran vdout0_29ck740 FIND v(dout0_29) AT=375.025n

.meas tran vdout0_30ck740 FIND v(dout0_30) AT=375.025n

.meas tran vdout0_31ck740 FIND v(dout0_31) AT=375.025n

.meas tran vdout0_32ck740 FIND v(dout0_32) AT=375.025n

.meas tran vdout0_33ck740 FIND v(dout0_33) AT=375.025n

.meas tran vdout0_34ck740 FIND v(dout0_34) AT=375.025n

.meas tran vdout0_35ck740 FIND v(dout0_35) AT=375.025n

.meas tran vdout0_36ck740 FIND v(dout0_36) AT=375.025n

.meas tran vdout0_37ck740 FIND v(dout0_37) AT=375.025n

.meas tran vdout0_38ck740 FIND v(dout0_38) AT=375.025n

.meas tran vdout0_39ck740 FIND v(dout0_39) AT=375.025n

.meas tran vdout0_40ck740 FIND v(dout0_40) AT=375.025n

.meas tran vdout0_41ck740 FIND v(dout0_41) AT=375.025n

.meas tran vdout0_42ck740 FIND v(dout0_42) AT=375.025n

.meas tran vdout0_43ck740 FIND v(dout0_43) AT=375.025n

.meas tran vdout0_44ck740 FIND v(dout0_44) AT=375.025n

.meas tran vdout0_45ck740 FIND v(dout0_45) AT=375.025n

.meas tran vdout0_46ck740 FIND v(dout0_46) AT=375.025n

.meas tran vdout0_47ck740 FIND v(dout0_47) AT=375.025n

.meas tran vdout0_48ck740 FIND v(dout0_48) AT=375.025n

.meas tran vdout0_49ck740 FIND v(dout0_49) AT=375.025n

.meas tran vdout0_50ck740 FIND v(dout0_50) AT=375.025n

.meas tran vdout0_51ck740 FIND v(dout0_51) AT=375.025n

.meas tran vdout0_52ck740 FIND v(dout0_52) AT=375.025n

.meas tran vdout0_53ck740 FIND v(dout0_53) AT=375.025n

.meas tran vdout0_54ck740 FIND v(dout0_54) AT=375.025n

.meas tran vdout0_55ck740 FIND v(dout0_55) AT=375.025n

.meas tran vdout0_56ck740 FIND v(dout0_56) AT=375.025n

.meas tran vdout0_57ck740 FIND v(dout0_57) AT=375.025n

.meas tran vdout0_58ck740 FIND v(dout0_58) AT=375.025n

.meas tran vdout0_59ck740 FIND v(dout0_59) AT=375.025n

.meas tran vdout0_60ck740 FIND v(dout0_60) AT=375.025n

.meas tran vdout0_61ck740 FIND v(dout0_61) AT=375.025n

.meas tran vdout0_62ck740 FIND v(dout0_62) AT=375.025n

.meas tran vdout0_63ck740 FIND v(dout0_63) AT=375.025n

.meas tran vdout0_0ck750 FIND v(dout0_0) AT=380.025n

.meas tran vdout0_1ck750 FIND v(dout0_1) AT=380.025n

.meas tran vdout0_2ck750 FIND v(dout0_2) AT=380.025n

.meas tran vdout0_3ck750 FIND v(dout0_3) AT=380.025n

.meas tran vdout0_4ck750 FIND v(dout0_4) AT=380.025n

.meas tran vdout0_5ck750 FIND v(dout0_5) AT=380.025n

.meas tran vdout0_6ck750 FIND v(dout0_6) AT=380.025n

.meas tran vdout0_7ck750 FIND v(dout0_7) AT=380.025n

.meas tran vdout0_8ck750 FIND v(dout0_8) AT=380.025n

.meas tran vdout0_9ck750 FIND v(dout0_9) AT=380.025n

.meas tran vdout0_10ck750 FIND v(dout0_10) AT=380.025n

.meas tran vdout0_11ck750 FIND v(dout0_11) AT=380.025n

.meas tran vdout0_12ck750 FIND v(dout0_12) AT=380.025n

.meas tran vdout0_13ck750 FIND v(dout0_13) AT=380.025n

.meas tran vdout0_14ck750 FIND v(dout0_14) AT=380.025n

.meas tran vdout0_15ck750 FIND v(dout0_15) AT=380.025n

.meas tran vdout0_16ck750 FIND v(dout0_16) AT=380.025n

.meas tran vdout0_17ck750 FIND v(dout0_17) AT=380.025n

.meas tran vdout0_18ck750 FIND v(dout0_18) AT=380.025n

.meas tran vdout0_19ck750 FIND v(dout0_19) AT=380.025n

.meas tran vdout0_20ck750 FIND v(dout0_20) AT=380.025n

.meas tran vdout0_21ck750 FIND v(dout0_21) AT=380.025n

.meas tran vdout0_22ck750 FIND v(dout0_22) AT=380.025n

.meas tran vdout0_23ck750 FIND v(dout0_23) AT=380.025n

.meas tran vdout0_24ck750 FIND v(dout0_24) AT=380.025n

.meas tran vdout0_25ck750 FIND v(dout0_25) AT=380.025n

.meas tran vdout0_26ck750 FIND v(dout0_26) AT=380.025n

.meas tran vdout0_27ck750 FIND v(dout0_27) AT=380.025n

.meas tran vdout0_28ck750 FIND v(dout0_28) AT=380.025n

.meas tran vdout0_29ck750 FIND v(dout0_29) AT=380.025n

.meas tran vdout0_30ck750 FIND v(dout0_30) AT=380.025n

.meas tran vdout0_31ck750 FIND v(dout0_31) AT=380.025n

.meas tran vdout0_32ck750 FIND v(dout0_32) AT=380.025n

.meas tran vdout0_33ck750 FIND v(dout0_33) AT=380.025n

.meas tran vdout0_34ck750 FIND v(dout0_34) AT=380.025n

.meas tran vdout0_35ck750 FIND v(dout0_35) AT=380.025n

.meas tran vdout0_36ck750 FIND v(dout0_36) AT=380.025n

.meas tran vdout0_37ck750 FIND v(dout0_37) AT=380.025n

.meas tran vdout0_38ck750 FIND v(dout0_38) AT=380.025n

.meas tran vdout0_39ck750 FIND v(dout0_39) AT=380.025n

.meas tran vdout0_40ck750 FIND v(dout0_40) AT=380.025n

.meas tran vdout0_41ck750 FIND v(dout0_41) AT=380.025n

.meas tran vdout0_42ck750 FIND v(dout0_42) AT=380.025n

.meas tran vdout0_43ck750 FIND v(dout0_43) AT=380.025n

.meas tran vdout0_44ck750 FIND v(dout0_44) AT=380.025n

.meas tran vdout0_45ck750 FIND v(dout0_45) AT=380.025n

.meas tran vdout0_46ck750 FIND v(dout0_46) AT=380.025n

.meas tran vdout0_47ck750 FIND v(dout0_47) AT=380.025n

.meas tran vdout0_48ck750 FIND v(dout0_48) AT=380.025n

.meas tran vdout0_49ck750 FIND v(dout0_49) AT=380.025n

.meas tran vdout0_50ck750 FIND v(dout0_50) AT=380.025n

.meas tran vdout0_51ck750 FIND v(dout0_51) AT=380.025n

.meas tran vdout0_52ck750 FIND v(dout0_52) AT=380.025n

.meas tran vdout0_53ck750 FIND v(dout0_53) AT=380.025n

.meas tran vdout0_54ck750 FIND v(dout0_54) AT=380.025n

.meas tran vdout0_55ck750 FIND v(dout0_55) AT=380.025n

.meas tran vdout0_56ck750 FIND v(dout0_56) AT=380.025n

.meas tran vdout0_57ck750 FIND v(dout0_57) AT=380.025n

.meas tran vdout0_58ck750 FIND v(dout0_58) AT=380.025n

.meas tran vdout0_59ck750 FIND v(dout0_59) AT=380.025n

.meas tran vdout0_60ck750 FIND v(dout0_60) AT=380.025n

.meas tran vdout0_61ck750 FIND v(dout0_61) AT=380.025n

.meas tran vdout0_62ck750 FIND v(dout0_62) AT=380.025n

.meas tran vdout0_63ck750 FIND v(dout0_63) AT=380.025n

.meas tran vdout0_0ck780 FIND v(dout0_0) AT=395.025n

.meas tran vdout0_1ck780 FIND v(dout0_1) AT=395.025n

.meas tran vdout0_2ck780 FIND v(dout0_2) AT=395.025n

.meas tran vdout0_3ck780 FIND v(dout0_3) AT=395.025n

.meas tran vdout0_4ck780 FIND v(dout0_4) AT=395.025n

.meas tran vdout0_5ck780 FIND v(dout0_5) AT=395.025n

.meas tran vdout0_6ck780 FIND v(dout0_6) AT=395.025n

.meas tran vdout0_7ck780 FIND v(dout0_7) AT=395.025n

.meas tran vdout0_8ck780 FIND v(dout0_8) AT=395.025n

.meas tran vdout0_9ck780 FIND v(dout0_9) AT=395.025n

.meas tran vdout0_10ck780 FIND v(dout0_10) AT=395.025n

.meas tran vdout0_11ck780 FIND v(dout0_11) AT=395.025n

.meas tran vdout0_12ck780 FIND v(dout0_12) AT=395.025n

.meas tran vdout0_13ck780 FIND v(dout0_13) AT=395.025n

.meas tran vdout0_14ck780 FIND v(dout0_14) AT=395.025n

.meas tran vdout0_15ck780 FIND v(dout0_15) AT=395.025n

.meas tran vdout0_16ck780 FIND v(dout0_16) AT=395.025n

.meas tran vdout0_17ck780 FIND v(dout0_17) AT=395.025n

.meas tran vdout0_18ck780 FIND v(dout0_18) AT=395.025n

.meas tran vdout0_19ck780 FIND v(dout0_19) AT=395.025n

.meas tran vdout0_20ck780 FIND v(dout0_20) AT=395.025n

.meas tran vdout0_21ck780 FIND v(dout0_21) AT=395.025n

.meas tran vdout0_22ck780 FIND v(dout0_22) AT=395.025n

.meas tran vdout0_23ck780 FIND v(dout0_23) AT=395.025n

.meas tran vdout0_24ck780 FIND v(dout0_24) AT=395.025n

.meas tran vdout0_25ck780 FIND v(dout0_25) AT=395.025n

.meas tran vdout0_26ck780 FIND v(dout0_26) AT=395.025n

.meas tran vdout0_27ck780 FIND v(dout0_27) AT=395.025n

.meas tran vdout0_28ck780 FIND v(dout0_28) AT=395.025n

.meas tran vdout0_29ck780 FIND v(dout0_29) AT=395.025n

.meas tran vdout0_30ck780 FIND v(dout0_30) AT=395.025n

.meas tran vdout0_31ck780 FIND v(dout0_31) AT=395.025n

.meas tran vdout0_32ck780 FIND v(dout0_32) AT=395.025n

.meas tran vdout0_33ck780 FIND v(dout0_33) AT=395.025n

.meas tran vdout0_34ck780 FIND v(dout0_34) AT=395.025n

.meas tran vdout0_35ck780 FIND v(dout0_35) AT=395.025n

.meas tran vdout0_36ck780 FIND v(dout0_36) AT=395.025n

.meas tran vdout0_37ck780 FIND v(dout0_37) AT=395.025n

.meas tran vdout0_38ck780 FIND v(dout0_38) AT=395.025n

.meas tran vdout0_39ck780 FIND v(dout0_39) AT=395.025n

.meas tran vdout0_40ck780 FIND v(dout0_40) AT=395.025n

.meas tran vdout0_41ck780 FIND v(dout0_41) AT=395.025n

.meas tran vdout0_42ck780 FIND v(dout0_42) AT=395.025n

.meas tran vdout0_43ck780 FIND v(dout0_43) AT=395.025n

.meas tran vdout0_44ck780 FIND v(dout0_44) AT=395.025n

.meas tran vdout0_45ck780 FIND v(dout0_45) AT=395.025n

.meas tran vdout0_46ck780 FIND v(dout0_46) AT=395.025n

.meas tran vdout0_47ck780 FIND v(dout0_47) AT=395.025n

.meas tran vdout0_48ck780 FIND v(dout0_48) AT=395.025n

.meas tran vdout0_49ck780 FIND v(dout0_49) AT=395.025n

.meas tran vdout0_50ck780 FIND v(dout0_50) AT=395.025n

.meas tran vdout0_51ck780 FIND v(dout0_51) AT=395.025n

.meas tran vdout0_52ck780 FIND v(dout0_52) AT=395.025n

.meas tran vdout0_53ck780 FIND v(dout0_53) AT=395.025n

.meas tran vdout0_54ck780 FIND v(dout0_54) AT=395.025n

.meas tran vdout0_55ck780 FIND v(dout0_55) AT=395.025n

.meas tran vdout0_56ck780 FIND v(dout0_56) AT=395.025n

.meas tran vdout0_57ck780 FIND v(dout0_57) AT=395.025n

.meas tran vdout0_58ck780 FIND v(dout0_58) AT=395.025n

.meas tran vdout0_59ck780 FIND v(dout0_59) AT=395.025n

.meas tran vdout0_60ck780 FIND v(dout0_60) AT=395.025n

.meas tran vdout0_61ck780 FIND v(dout0_61) AT=395.025n

.meas tran vdout0_62ck780 FIND v(dout0_62) AT=395.025n

.meas tran vdout0_63ck780 FIND v(dout0_63) AT=395.025n

.meas tran vdout0_0ck840 FIND v(dout0_0) AT=425.025n

.meas tran vdout0_1ck840 FIND v(dout0_1) AT=425.025n

.meas tran vdout0_2ck840 FIND v(dout0_2) AT=425.025n

.meas tran vdout0_3ck840 FIND v(dout0_3) AT=425.025n

.meas tran vdout0_4ck840 FIND v(dout0_4) AT=425.025n

.meas tran vdout0_5ck840 FIND v(dout0_5) AT=425.025n

.meas tran vdout0_6ck840 FIND v(dout0_6) AT=425.025n

.meas tran vdout0_7ck840 FIND v(dout0_7) AT=425.025n

.meas tran vdout0_8ck840 FIND v(dout0_8) AT=425.025n

.meas tran vdout0_9ck840 FIND v(dout0_9) AT=425.025n

.meas tran vdout0_10ck840 FIND v(dout0_10) AT=425.025n

.meas tran vdout0_11ck840 FIND v(dout0_11) AT=425.025n

.meas tran vdout0_12ck840 FIND v(dout0_12) AT=425.025n

.meas tran vdout0_13ck840 FIND v(dout0_13) AT=425.025n

.meas tran vdout0_14ck840 FIND v(dout0_14) AT=425.025n

.meas tran vdout0_15ck840 FIND v(dout0_15) AT=425.025n

.meas tran vdout0_16ck840 FIND v(dout0_16) AT=425.025n

.meas tran vdout0_17ck840 FIND v(dout0_17) AT=425.025n

.meas tran vdout0_18ck840 FIND v(dout0_18) AT=425.025n

.meas tran vdout0_19ck840 FIND v(dout0_19) AT=425.025n

.meas tran vdout0_20ck840 FIND v(dout0_20) AT=425.025n

.meas tran vdout0_21ck840 FIND v(dout0_21) AT=425.025n

.meas tran vdout0_22ck840 FIND v(dout0_22) AT=425.025n

.meas tran vdout0_23ck840 FIND v(dout0_23) AT=425.025n

.meas tran vdout0_24ck840 FIND v(dout0_24) AT=425.025n

.meas tran vdout0_25ck840 FIND v(dout0_25) AT=425.025n

.meas tran vdout0_26ck840 FIND v(dout0_26) AT=425.025n

.meas tran vdout0_27ck840 FIND v(dout0_27) AT=425.025n

.meas tran vdout0_28ck840 FIND v(dout0_28) AT=425.025n

.meas tran vdout0_29ck840 FIND v(dout0_29) AT=425.025n

.meas tran vdout0_30ck840 FIND v(dout0_30) AT=425.025n

.meas tran vdout0_31ck840 FIND v(dout0_31) AT=425.025n

.meas tran vdout0_32ck840 FIND v(dout0_32) AT=425.025n

.meas tran vdout0_33ck840 FIND v(dout0_33) AT=425.025n

.meas tran vdout0_34ck840 FIND v(dout0_34) AT=425.025n

.meas tran vdout0_35ck840 FIND v(dout0_35) AT=425.025n

.meas tran vdout0_36ck840 FIND v(dout0_36) AT=425.025n

.meas tran vdout0_37ck840 FIND v(dout0_37) AT=425.025n

.meas tran vdout0_38ck840 FIND v(dout0_38) AT=425.025n

.meas tran vdout0_39ck840 FIND v(dout0_39) AT=425.025n

.meas tran vdout0_40ck840 FIND v(dout0_40) AT=425.025n

.meas tran vdout0_41ck840 FIND v(dout0_41) AT=425.025n

.meas tran vdout0_42ck840 FIND v(dout0_42) AT=425.025n

.meas tran vdout0_43ck840 FIND v(dout0_43) AT=425.025n

.meas tran vdout0_44ck840 FIND v(dout0_44) AT=425.025n

.meas tran vdout0_45ck840 FIND v(dout0_45) AT=425.025n

.meas tran vdout0_46ck840 FIND v(dout0_46) AT=425.025n

.meas tran vdout0_47ck840 FIND v(dout0_47) AT=425.025n

.meas tran vdout0_48ck840 FIND v(dout0_48) AT=425.025n

.meas tran vdout0_49ck840 FIND v(dout0_49) AT=425.025n

.meas tran vdout0_50ck840 FIND v(dout0_50) AT=425.025n

.meas tran vdout0_51ck840 FIND v(dout0_51) AT=425.025n

.meas tran vdout0_52ck840 FIND v(dout0_52) AT=425.025n

.meas tran vdout0_53ck840 FIND v(dout0_53) AT=425.025n

.meas tran vdout0_54ck840 FIND v(dout0_54) AT=425.025n

.meas tran vdout0_55ck840 FIND v(dout0_55) AT=425.025n

.meas tran vdout0_56ck840 FIND v(dout0_56) AT=425.025n

.meas tran vdout0_57ck840 FIND v(dout0_57) AT=425.025n

.meas tran vdout0_58ck840 FIND v(dout0_58) AT=425.025n

.meas tran vdout0_59ck840 FIND v(dout0_59) AT=425.025n

.meas tran vdout0_60ck840 FIND v(dout0_60) AT=425.025n

.meas tran vdout0_61ck840 FIND v(dout0_61) AT=425.025n

.meas tran vdout0_62ck840 FIND v(dout0_62) AT=425.025n

.meas tran vdout0_63ck840 FIND v(dout0_63) AT=425.025n

.meas tran vdout0_0ck860 FIND v(dout0_0) AT=435.025n

.meas tran vdout0_1ck860 FIND v(dout0_1) AT=435.025n

.meas tran vdout0_2ck860 FIND v(dout0_2) AT=435.025n

.meas tran vdout0_3ck860 FIND v(dout0_3) AT=435.025n

.meas tran vdout0_4ck860 FIND v(dout0_4) AT=435.025n

.meas tran vdout0_5ck860 FIND v(dout0_5) AT=435.025n

.meas tran vdout0_6ck860 FIND v(dout0_6) AT=435.025n

.meas tran vdout0_7ck860 FIND v(dout0_7) AT=435.025n

.meas tran vdout0_8ck860 FIND v(dout0_8) AT=435.025n

.meas tran vdout0_9ck860 FIND v(dout0_9) AT=435.025n

.meas tran vdout0_10ck860 FIND v(dout0_10) AT=435.025n

.meas tran vdout0_11ck860 FIND v(dout0_11) AT=435.025n

.meas tran vdout0_12ck860 FIND v(dout0_12) AT=435.025n

.meas tran vdout0_13ck860 FIND v(dout0_13) AT=435.025n

.meas tran vdout0_14ck860 FIND v(dout0_14) AT=435.025n

.meas tran vdout0_15ck860 FIND v(dout0_15) AT=435.025n

.meas tran vdout0_16ck860 FIND v(dout0_16) AT=435.025n

.meas tran vdout0_17ck860 FIND v(dout0_17) AT=435.025n

.meas tran vdout0_18ck860 FIND v(dout0_18) AT=435.025n

.meas tran vdout0_19ck860 FIND v(dout0_19) AT=435.025n

.meas tran vdout0_20ck860 FIND v(dout0_20) AT=435.025n

.meas tran vdout0_21ck860 FIND v(dout0_21) AT=435.025n

.meas tran vdout0_22ck860 FIND v(dout0_22) AT=435.025n

.meas tran vdout0_23ck860 FIND v(dout0_23) AT=435.025n

.meas tran vdout0_24ck860 FIND v(dout0_24) AT=435.025n

.meas tran vdout0_25ck860 FIND v(dout0_25) AT=435.025n

.meas tran vdout0_26ck860 FIND v(dout0_26) AT=435.025n

.meas tran vdout0_27ck860 FIND v(dout0_27) AT=435.025n

.meas tran vdout0_28ck860 FIND v(dout0_28) AT=435.025n

.meas tran vdout0_29ck860 FIND v(dout0_29) AT=435.025n

.meas tran vdout0_30ck860 FIND v(dout0_30) AT=435.025n

.meas tran vdout0_31ck860 FIND v(dout0_31) AT=435.025n

.meas tran vdout0_32ck860 FIND v(dout0_32) AT=435.025n

.meas tran vdout0_33ck860 FIND v(dout0_33) AT=435.025n

.meas tran vdout0_34ck860 FIND v(dout0_34) AT=435.025n

.meas tran vdout0_35ck860 FIND v(dout0_35) AT=435.025n

.meas tran vdout0_36ck860 FIND v(dout0_36) AT=435.025n

.meas tran vdout0_37ck860 FIND v(dout0_37) AT=435.025n

.meas tran vdout0_38ck860 FIND v(dout0_38) AT=435.025n

.meas tran vdout0_39ck860 FIND v(dout0_39) AT=435.025n

.meas tran vdout0_40ck860 FIND v(dout0_40) AT=435.025n

.meas tran vdout0_41ck860 FIND v(dout0_41) AT=435.025n

.meas tran vdout0_42ck860 FIND v(dout0_42) AT=435.025n

.meas tran vdout0_43ck860 FIND v(dout0_43) AT=435.025n

.meas tran vdout0_44ck860 FIND v(dout0_44) AT=435.025n

.meas tran vdout0_45ck860 FIND v(dout0_45) AT=435.025n

.meas tran vdout0_46ck860 FIND v(dout0_46) AT=435.025n

.meas tran vdout0_47ck860 FIND v(dout0_47) AT=435.025n

.meas tran vdout0_48ck860 FIND v(dout0_48) AT=435.025n

.meas tran vdout0_49ck860 FIND v(dout0_49) AT=435.025n

.meas tran vdout0_50ck860 FIND v(dout0_50) AT=435.025n

.meas tran vdout0_51ck860 FIND v(dout0_51) AT=435.025n

.meas tran vdout0_52ck860 FIND v(dout0_52) AT=435.025n

.meas tran vdout0_53ck860 FIND v(dout0_53) AT=435.025n

.meas tran vdout0_54ck860 FIND v(dout0_54) AT=435.025n

.meas tran vdout0_55ck860 FIND v(dout0_55) AT=435.025n

.meas tran vdout0_56ck860 FIND v(dout0_56) AT=435.025n

.meas tran vdout0_57ck860 FIND v(dout0_57) AT=435.025n

.meas tran vdout0_58ck860 FIND v(dout0_58) AT=435.025n

.meas tran vdout0_59ck860 FIND v(dout0_59) AT=435.025n

.meas tran vdout0_60ck860 FIND v(dout0_60) AT=435.025n

.meas tran vdout0_61ck860 FIND v(dout0_61) AT=435.025n

.meas tran vdout0_62ck860 FIND v(dout0_62) AT=435.025n

.meas tran vdout0_63ck860 FIND v(dout0_63) AT=435.025n

.meas tran vdout0_0ck890 FIND v(dout0_0) AT=450.025n

.meas tran vdout0_1ck890 FIND v(dout0_1) AT=450.025n

.meas tran vdout0_2ck890 FIND v(dout0_2) AT=450.025n

.meas tran vdout0_3ck890 FIND v(dout0_3) AT=450.025n

.meas tran vdout0_4ck890 FIND v(dout0_4) AT=450.025n

.meas tran vdout0_5ck890 FIND v(dout0_5) AT=450.025n

.meas tran vdout0_6ck890 FIND v(dout0_6) AT=450.025n

.meas tran vdout0_7ck890 FIND v(dout0_7) AT=450.025n

.meas tran vdout0_8ck890 FIND v(dout0_8) AT=450.025n

.meas tran vdout0_9ck890 FIND v(dout0_9) AT=450.025n

.meas tran vdout0_10ck890 FIND v(dout0_10) AT=450.025n

.meas tran vdout0_11ck890 FIND v(dout0_11) AT=450.025n

.meas tran vdout0_12ck890 FIND v(dout0_12) AT=450.025n

.meas tran vdout0_13ck890 FIND v(dout0_13) AT=450.025n

.meas tran vdout0_14ck890 FIND v(dout0_14) AT=450.025n

.meas tran vdout0_15ck890 FIND v(dout0_15) AT=450.025n

.meas tran vdout0_16ck890 FIND v(dout0_16) AT=450.025n

.meas tran vdout0_17ck890 FIND v(dout0_17) AT=450.025n

.meas tran vdout0_18ck890 FIND v(dout0_18) AT=450.025n

.meas tran vdout0_19ck890 FIND v(dout0_19) AT=450.025n

.meas tran vdout0_20ck890 FIND v(dout0_20) AT=450.025n

.meas tran vdout0_21ck890 FIND v(dout0_21) AT=450.025n

.meas tran vdout0_22ck890 FIND v(dout0_22) AT=450.025n

.meas tran vdout0_23ck890 FIND v(dout0_23) AT=450.025n

.meas tran vdout0_24ck890 FIND v(dout0_24) AT=450.025n

.meas tran vdout0_25ck890 FIND v(dout0_25) AT=450.025n

.meas tran vdout0_26ck890 FIND v(dout0_26) AT=450.025n

.meas tran vdout0_27ck890 FIND v(dout0_27) AT=450.025n

.meas tran vdout0_28ck890 FIND v(dout0_28) AT=450.025n

.meas tran vdout0_29ck890 FIND v(dout0_29) AT=450.025n

.meas tran vdout0_30ck890 FIND v(dout0_30) AT=450.025n

.meas tran vdout0_31ck890 FIND v(dout0_31) AT=450.025n

.meas tran vdout0_32ck890 FIND v(dout0_32) AT=450.025n

.meas tran vdout0_33ck890 FIND v(dout0_33) AT=450.025n

.meas tran vdout0_34ck890 FIND v(dout0_34) AT=450.025n

.meas tran vdout0_35ck890 FIND v(dout0_35) AT=450.025n

.meas tran vdout0_36ck890 FIND v(dout0_36) AT=450.025n

.meas tran vdout0_37ck890 FIND v(dout0_37) AT=450.025n

.meas tran vdout0_38ck890 FIND v(dout0_38) AT=450.025n

.meas tran vdout0_39ck890 FIND v(dout0_39) AT=450.025n

.meas tran vdout0_40ck890 FIND v(dout0_40) AT=450.025n

.meas tran vdout0_41ck890 FIND v(dout0_41) AT=450.025n

.meas tran vdout0_42ck890 FIND v(dout0_42) AT=450.025n

.meas tran vdout0_43ck890 FIND v(dout0_43) AT=450.025n

.meas tran vdout0_44ck890 FIND v(dout0_44) AT=450.025n

.meas tran vdout0_45ck890 FIND v(dout0_45) AT=450.025n

.meas tran vdout0_46ck890 FIND v(dout0_46) AT=450.025n

.meas tran vdout0_47ck890 FIND v(dout0_47) AT=450.025n

.meas tran vdout0_48ck890 FIND v(dout0_48) AT=450.025n

.meas tran vdout0_49ck890 FIND v(dout0_49) AT=450.025n

.meas tran vdout0_50ck890 FIND v(dout0_50) AT=450.025n

.meas tran vdout0_51ck890 FIND v(dout0_51) AT=450.025n

.meas tran vdout0_52ck890 FIND v(dout0_52) AT=450.025n

.meas tran vdout0_53ck890 FIND v(dout0_53) AT=450.025n

.meas tran vdout0_54ck890 FIND v(dout0_54) AT=450.025n

.meas tran vdout0_55ck890 FIND v(dout0_55) AT=450.025n

.meas tran vdout0_56ck890 FIND v(dout0_56) AT=450.025n

.meas tran vdout0_57ck890 FIND v(dout0_57) AT=450.025n

.meas tran vdout0_58ck890 FIND v(dout0_58) AT=450.025n

.meas tran vdout0_59ck890 FIND v(dout0_59) AT=450.025n

.meas tran vdout0_60ck890 FIND v(dout0_60) AT=450.025n

.meas tran vdout0_61ck890 FIND v(dout0_61) AT=450.025n

.meas tran vdout0_62ck890 FIND v(dout0_62) AT=450.025n

.meas tran vdout0_63ck890 FIND v(dout0_63) AT=450.025n

.meas tran vdout0_0ck900 FIND v(dout0_0) AT=455.025n

.meas tran vdout0_1ck900 FIND v(dout0_1) AT=455.025n

.meas tran vdout0_2ck900 FIND v(dout0_2) AT=455.025n

.meas tran vdout0_3ck900 FIND v(dout0_3) AT=455.025n

.meas tran vdout0_4ck900 FIND v(dout0_4) AT=455.025n

.meas tran vdout0_5ck900 FIND v(dout0_5) AT=455.025n

.meas tran vdout0_6ck900 FIND v(dout0_6) AT=455.025n

.meas tran vdout0_7ck900 FIND v(dout0_7) AT=455.025n

.meas tran vdout0_8ck900 FIND v(dout0_8) AT=455.025n

.meas tran vdout0_9ck900 FIND v(dout0_9) AT=455.025n

.meas tran vdout0_10ck900 FIND v(dout0_10) AT=455.025n

.meas tran vdout0_11ck900 FIND v(dout0_11) AT=455.025n

.meas tran vdout0_12ck900 FIND v(dout0_12) AT=455.025n

.meas tran vdout0_13ck900 FIND v(dout0_13) AT=455.025n

.meas tran vdout0_14ck900 FIND v(dout0_14) AT=455.025n

.meas tran vdout0_15ck900 FIND v(dout0_15) AT=455.025n

.meas tran vdout0_16ck900 FIND v(dout0_16) AT=455.025n

.meas tran vdout0_17ck900 FIND v(dout0_17) AT=455.025n

.meas tran vdout0_18ck900 FIND v(dout0_18) AT=455.025n

.meas tran vdout0_19ck900 FIND v(dout0_19) AT=455.025n

.meas tran vdout0_20ck900 FIND v(dout0_20) AT=455.025n

.meas tran vdout0_21ck900 FIND v(dout0_21) AT=455.025n

.meas tran vdout0_22ck900 FIND v(dout0_22) AT=455.025n

.meas tran vdout0_23ck900 FIND v(dout0_23) AT=455.025n

.meas tran vdout0_24ck900 FIND v(dout0_24) AT=455.025n

.meas tran vdout0_25ck900 FIND v(dout0_25) AT=455.025n

.meas tran vdout0_26ck900 FIND v(dout0_26) AT=455.025n

.meas tran vdout0_27ck900 FIND v(dout0_27) AT=455.025n

.meas tran vdout0_28ck900 FIND v(dout0_28) AT=455.025n

.meas tran vdout0_29ck900 FIND v(dout0_29) AT=455.025n

.meas tran vdout0_30ck900 FIND v(dout0_30) AT=455.025n

.meas tran vdout0_31ck900 FIND v(dout0_31) AT=455.025n

.meas tran vdout0_32ck900 FIND v(dout0_32) AT=455.025n

.meas tran vdout0_33ck900 FIND v(dout0_33) AT=455.025n

.meas tran vdout0_34ck900 FIND v(dout0_34) AT=455.025n

.meas tran vdout0_35ck900 FIND v(dout0_35) AT=455.025n

.meas tran vdout0_36ck900 FIND v(dout0_36) AT=455.025n

.meas tran vdout0_37ck900 FIND v(dout0_37) AT=455.025n

.meas tran vdout0_38ck900 FIND v(dout0_38) AT=455.025n

.meas tran vdout0_39ck900 FIND v(dout0_39) AT=455.025n

.meas tran vdout0_40ck900 FIND v(dout0_40) AT=455.025n

.meas tran vdout0_41ck900 FIND v(dout0_41) AT=455.025n

.meas tran vdout0_42ck900 FIND v(dout0_42) AT=455.025n

.meas tran vdout0_43ck900 FIND v(dout0_43) AT=455.025n

.meas tran vdout0_44ck900 FIND v(dout0_44) AT=455.025n

.meas tran vdout0_45ck900 FIND v(dout0_45) AT=455.025n

.meas tran vdout0_46ck900 FIND v(dout0_46) AT=455.025n

.meas tran vdout0_47ck900 FIND v(dout0_47) AT=455.025n

.meas tran vdout0_48ck900 FIND v(dout0_48) AT=455.025n

.meas tran vdout0_49ck900 FIND v(dout0_49) AT=455.025n

.meas tran vdout0_50ck900 FIND v(dout0_50) AT=455.025n

.meas tran vdout0_51ck900 FIND v(dout0_51) AT=455.025n

.meas tran vdout0_52ck900 FIND v(dout0_52) AT=455.025n

.meas tran vdout0_53ck900 FIND v(dout0_53) AT=455.025n

.meas tran vdout0_54ck900 FIND v(dout0_54) AT=455.025n

.meas tran vdout0_55ck900 FIND v(dout0_55) AT=455.025n

.meas tran vdout0_56ck900 FIND v(dout0_56) AT=455.025n

.meas tran vdout0_57ck900 FIND v(dout0_57) AT=455.025n

.meas tran vdout0_58ck900 FIND v(dout0_58) AT=455.025n

.meas tran vdout0_59ck900 FIND v(dout0_59) AT=455.025n

.meas tran vdout0_60ck900 FIND v(dout0_60) AT=455.025n

.meas tran vdout0_61ck900 FIND v(dout0_61) AT=455.025n

.meas tran vdout0_62ck900 FIND v(dout0_62) AT=455.025n

.meas tran vdout0_63ck900 FIND v(dout0_63) AT=455.025n

.meas tran vdout0_0ck910 FIND v(dout0_0) AT=460.025n

.meas tran vdout0_1ck910 FIND v(dout0_1) AT=460.025n

.meas tran vdout0_2ck910 FIND v(dout0_2) AT=460.025n

.meas tran vdout0_3ck910 FIND v(dout0_3) AT=460.025n

.meas tran vdout0_4ck910 FIND v(dout0_4) AT=460.025n

.meas tran vdout0_5ck910 FIND v(dout0_5) AT=460.025n

.meas tran vdout0_6ck910 FIND v(dout0_6) AT=460.025n

.meas tran vdout0_7ck910 FIND v(dout0_7) AT=460.025n

.meas tran vdout0_8ck910 FIND v(dout0_8) AT=460.025n

.meas tran vdout0_9ck910 FIND v(dout0_9) AT=460.025n

.meas tran vdout0_10ck910 FIND v(dout0_10) AT=460.025n

.meas tran vdout0_11ck910 FIND v(dout0_11) AT=460.025n

.meas tran vdout0_12ck910 FIND v(dout0_12) AT=460.025n

.meas tran vdout0_13ck910 FIND v(dout0_13) AT=460.025n

.meas tran vdout0_14ck910 FIND v(dout0_14) AT=460.025n

.meas tran vdout0_15ck910 FIND v(dout0_15) AT=460.025n

.meas tran vdout0_16ck910 FIND v(dout0_16) AT=460.025n

.meas tran vdout0_17ck910 FIND v(dout0_17) AT=460.025n

.meas tran vdout0_18ck910 FIND v(dout0_18) AT=460.025n

.meas tran vdout0_19ck910 FIND v(dout0_19) AT=460.025n

.meas tran vdout0_20ck910 FIND v(dout0_20) AT=460.025n

.meas tran vdout0_21ck910 FIND v(dout0_21) AT=460.025n

.meas tran vdout0_22ck910 FIND v(dout0_22) AT=460.025n

.meas tran vdout0_23ck910 FIND v(dout0_23) AT=460.025n

.meas tran vdout0_24ck910 FIND v(dout0_24) AT=460.025n

.meas tran vdout0_25ck910 FIND v(dout0_25) AT=460.025n

.meas tran vdout0_26ck910 FIND v(dout0_26) AT=460.025n

.meas tran vdout0_27ck910 FIND v(dout0_27) AT=460.025n

.meas tran vdout0_28ck910 FIND v(dout0_28) AT=460.025n

.meas tran vdout0_29ck910 FIND v(dout0_29) AT=460.025n

.meas tran vdout0_30ck910 FIND v(dout0_30) AT=460.025n

.meas tran vdout0_31ck910 FIND v(dout0_31) AT=460.025n

.meas tran vdout0_32ck910 FIND v(dout0_32) AT=460.025n

.meas tran vdout0_33ck910 FIND v(dout0_33) AT=460.025n

.meas tran vdout0_34ck910 FIND v(dout0_34) AT=460.025n

.meas tran vdout0_35ck910 FIND v(dout0_35) AT=460.025n

.meas tran vdout0_36ck910 FIND v(dout0_36) AT=460.025n

.meas tran vdout0_37ck910 FIND v(dout0_37) AT=460.025n

.meas tran vdout0_38ck910 FIND v(dout0_38) AT=460.025n

.meas tran vdout0_39ck910 FIND v(dout0_39) AT=460.025n

.meas tran vdout0_40ck910 FIND v(dout0_40) AT=460.025n

.meas tran vdout0_41ck910 FIND v(dout0_41) AT=460.025n

.meas tran vdout0_42ck910 FIND v(dout0_42) AT=460.025n

.meas tran vdout0_43ck910 FIND v(dout0_43) AT=460.025n

.meas tran vdout0_44ck910 FIND v(dout0_44) AT=460.025n

.meas tran vdout0_45ck910 FIND v(dout0_45) AT=460.025n

.meas tran vdout0_46ck910 FIND v(dout0_46) AT=460.025n

.meas tran vdout0_47ck910 FIND v(dout0_47) AT=460.025n

.meas tran vdout0_48ck910 FIND v(dout0_48) AT=460.025n

.meas tran vdout0_49ck910 FIND v(dout0_49) AT=460.025n

.meas tran vdout0_50ck910 FIND v(dout0_50) AT=460.025n

.meas tran vdout0_51ck910 FIND v(dout0_51) AT=460.025n

.meas tran vdout0_52ck910 FIND v(dout0_52) AT=460.025n

.meas tran vdout0_53ck910 FIND v(dout0_53) AT=460.025n

.meas tran vdout0_54ck910 FIND v(dout0_54) AT=460.025n

.meas tran vdout0_55ck910 FIND v(dout0_55) AT=460.025n

.meas tran vdout0_56ck910 FIND v(dout0_56) AT=460.025n

.meas tran vdout0_57ck910 FIND v(dout0_57) AT=460.025n

.meas tran vdout0_58ck910 FIND v(dout0_58) AT=460.025n

.meas tran vdout0_59ck910 FIND v(dout0_59) AT=460.025n

.meas tran vdout0_60ck910 FIND v(dout0_60) AT=460.025n

.meas tran vdout0_61ck910 FIND v(dout0_61) AT=460.025n

.meas tran vdout0_62ck910 FIND v(dout0_62) AT=460.025n

.meas tran vdout0_63ck910 FIND v(dout0_63) AT=460.025n

.meas tran vdout0_0ck920 FIND v(dout0_0) AT=465.025n

.meas tran vdout0_1ck920 FIND v(dout0_1) AT=465.025n

.meas tran vdout0_2ck920 FIND v(dout0_2) AT=465.025n

.meas tran vdout0_3ck920 FIND v(dout0_3) AT=465.025n

.meas tran vdout0_4ck920 FIND v(dout0_4) AT=465.025n

.meas tran vdout0_5ck920 FIND v(dout0_5) AT=465.025n

.meas tran vdout0_6ck920 FIND v(dout0_6) AT=465.025n

.meas tran vdout0_7ck920 FIND v(dout0_7) AT=465.025n

.meas tran vdout0_8ck920 FIND v(dout0_8) AT=465.025n

.meas tran vdout0_9ck920 FIND v(dout0_9) AT=465.025n

.meas tran vdout0_10ck920 FIND v(dout0_10) AT=465.025n

.meas tran vdout0_11ck920 FIND v(dout0_11) AT=465.025n

.meas tran vdout0_12ck920 FIND v(dout0_12) AT=465.025n

.meas tran vdout0_13ck920 FIND v(dout0_13) AT=465.025n

.meas tran vdout0_14ck920 FIND v(dout0_14) AT=465.025n

.meas tran vdout0_15ck920 FIND v(dout0_15) AT=465.025n

.meas tran vdout0_16ck920 FIND v(dout0_16) AT=465.025n

.meas tran vdout0_17ck920 FIND v(dout0_17) AT=465.025n

.meas tran vdout0_18ck920 FIND v(dout0_18) AT=465.025n

.meas tran vdout0_19ck920 FIND v(dout0_19) AT=465.025n

.meas tran vdout0_20ck920 FIND v(dout0_20) AT=465.025n

.meas tran vdout0_21ck920 FIND v(dout0_21) AT=465.025n

.meas tran vdout0_22ck920 FIND v(dout0_22) AT=465.025n

.meas tran vdout0_23ck920 FIND v(dout0_23) AT=465.025n

.meas tran vdout0_24ck920 FIND v(dout0_24) AT=465.025n

.meas tran vdout0_25ck920 FIND v(dout0_25) AT=465.025n

.meas tran vdout0_26ck920 FIND v(dout0_26) AT=465.025n

.meas tran vdout0_27ck920 FIND v(dout0_27) AT=465.025n

.meas tran vdout0_28ck920 FIND v(dout0_28) AT=465.025n

.meas tran vdout0_29ck920 FIND v(dout0_29) AT=465.025n

.meas tran vdout0_30ck920 FIND v(dout0_30) AT=465.025n

.meas tran vdout0_31ck920 FIND v(dout0_31) AT=465.025n

.meas tran vdout0_32ck920 FIND v(dout0_32) AT=465.025n

.meas tran vdout0_33ck920 FIND v(dout0_33) AT=465.025n

.meas tran vdout0_34ck920 FIND v(dout0_34) AT=465.025n

.meas tran vdout0_35ck920 FIND v(dout0_35) AT=465.025n

.meas tran vdout0_36ck920 FIND v(dout0_36) AT=465.025n

.meas tran vdout0_37ck920 FIND v(dout0_37) AT=465.025n

.meas tran vdout0_38ck920 FIND v(dout0_38) AT=465.025n

.meas tran vdout0_39ck920 FIND v(dout0_39) AT=465.025n

.meas tran vdout0_40ck920 FIND v(dout0_40) AT=465.025n

.meas tran vdout0_41ck920 FIND v(dout0_41) AT=465.025n

.meas tran vdout0_42ck920 FIND v(dout0_42) AT=465.025n

.meas tran vdout0_43ck920 FIND v(dout0_43) AT=465.025n

.meas tran vdout0_44ck920 FIND v(dout0_44) AT=465.025n

.meas tran vdout0_45ck920 FIND v(dout0_45) AT=465.025n

.meas tran vdout0_46ck920 FIND v(dout0_46) AT=465.025n

.meas tran vdout0_47ck920 FIND v(dout0_47) AT=465.025n

.meas tran vdout0_48ck920 FIND v(dout0_48) AT=465.025n

.meas tran vdout0_49ck920 FIND v(dout0_49) AT=465.025n

.meas tran vdout0_50ck920 FIND v(dout0_50) AT=465.025n

.meas tran vdout0_51ck920 FIND v(dout0_51) AT=465.025n

.meas tran vdout0_52ck920 FIND v(dout0_52) AT=465.025n

.meas tran vdout0_53ck920 FIND v(dout0_53) AT=465.025n

.meas tran vdout0_54ck920 FIND v(dout0_54) AT=465.025n

.meas tran vdout0_55ck920 FIND v(dout0_55) AT=465.025n

.meas tran vdout0_56ck920 FIND v(dout0_56) AT=465.025n

.meas tran vdout0_57ck920 FIND v(dout0_57) AT=465.025n

.meas tran vdout0_58ck920 FIND v(dout0_58) AT=465.025n

.meas tran vdout0_59ck920 FIND v(dout0_59) AT=465.025n

.meas tran vdout0_60ck920 FIND v(dout0_60) AT=465.025n

.meas tran vdout0_61ck920 FIND v(dout0_61) AT=465.025n

.meas tran vdout0_62ck920 FIND v(dout0_62) AT=465.025n

.meas tran vdout0_63ck920 FIND v(dout0_63) AT=465.025n

.meas tran vdout0_0ck960 FIND v(dout0_0) AT=485.025n

.meas tran vdout0_1ck960 FIND v(dout0_1) AT=485.025n

.meas tran vdout0_2ck960 FIND v(dout0_2) AT=485.025n

.meas tran vdout0_3ck960 FIND v(dout0_3) AT=485.025n

.meas tran vdout0_4ck960 FIND v(dout0_4) AT=485.025n

.meas tran vdout0_5ck960 FIND v(dout0_5) AT=485.025n

.meas tran vdout0_6ck960 FIND v(dout0_6) AT=485.025n

.meas tran vdout0_7ck960 FIND v(dout0_7) AT=485.025n

.meas tran vdout0_8ck960 FIND v(dout0_8) AT=485.025n

.meas tran vdout0_9ck960 FIND v(dout0_9) AT=485.025n

.meas tran vdout0_10ck960 FIND v(dout0_10) AT=485.025n

.meas tran vdout0_11ck960 FIND v(dout0_11) AT=485.025n

.meas tran vdout0_12ck960 FIND v(dout0_12) AT=485.025n

.meas tran vdout0_13ck960 FIND v(dout0_13) AT=485.025n

.meas tran vdout0_14ck960 FIND v(dout0_14) AT=485.025n

.meas tran vdout0_15ck960 FIND v(dout0_15) AT=485.025n

.meas tran vdout0_16ck960 FIND v(dout0_16) AT=485.025n

.meas tran vdout0_17ck960 FIND v(dout0_17) AT=485.025n

.meas tran vdout0_18ck960 FIND v(dout0_18) AT=485.025n

.meas tran vdout0_19ck960 FIND v(dout0_19) AT=485.025n

.meas tran vdout0_20ck960 FIND v(dout0_20) AT=485.025n

.meas tran vdout0_21ck960 FIND v(dout0_21) AT=485.025n

.meas tran vdout0_22ck960 FIND v(dout0_22) AT=485.025n

.meas tran vdout0_23ck960 FIND v(dout0_23) AT=485.025n

.meas tran vdout0_24ck960 FIND v(dout0_24) AT=485.025n

.meas tran vdout0_25ck960 FIND v(dout0_25) AT=485.025n

.meas tran vdout0_26ck960 FIND v(dout0_26) AT=485.025n

.meas tran vdout0_27ck960 FIND v(dout0_27) AT=485.025n

.meas tran vdout0_28ck960 FIND v(dout0_28) AT=485.025n

.meas tran vdout0_29ck960 FIND v(dout0_29) AT=485.025n

.meas tran vdout0_30ck960 FIND v(dout0_30) AT=485.025n

.meas tran vdout0_31ck960 FIND v(dout0_31) AT=485.025n

.meas tran vdout0_32ck960 FIND v(dout0_32) AT=485.025n

.meas tran vdout0_33ck960 FIND v(dout0_33) AT=485.025n

.meas tran vdout0_34ck960 FIND v(dout0_34) AT=485.025n

.meas tran vdout0_35ck960 FIND v(dout0_35) AT=485.025n

.meas tran vdout0_36ck960 FIND v(dout0_36) AT=485.025n

.meas tran vdout0_37ck960 FIND v(dout0_37) AT=485.025n

.meas tran vdout0_38ck960 FIND v(dout0_38) AT=485.025n

.meas tran vdout0_39ck960 FIND v(dout0_39) AT=485.025n

.meas tran vdout0_40ck960 FIND v(dout0_40) AT=485.025n

.meas tran vdout0_41ck960 FIND v(dout0_41) AT=485.025n

.meas tran vdout0_42ck960 FIND v(dout0_42) AT=485.025n

.meas tran vdout0_43ck960 FIND v(dout0_43) AT=485.025n

.meas tran vdout0_44ck960 FIND v(dout0_44) AT=485.025n

.meas tran vdout0_45ck960 FIND v(dout0_45) AT=485.025n

.meas tran vdout0_46ck960 FIND v(dout0_46) AT=485.025n

.meas tran vdout0_47ck960 FIND v(dout0_47) AT=485.025n

.meas tran vdout0_48ck960 FIND v(dout0_48) AT=485.025n

.meas tran vdout0_49ck960 FIND v(dout0_49) AT=485.025n

.meas tran vdout0_50ck960 FIND v(dout0_50) AT=485.025n

.meas tran vdout0_51ck960 FIND v(dout0_51) AT=485.025n

.meas tran vdout0_52ck960 FIND v(dout0_52) AT=485.025n

.meas tran vdout0_53ck960 FIND v(dout0_53) AT=485.025n

.meas tran vdout0_54ck960 FIND v(dout0_54) AT=485.025n

.meas tran vdout0_55ck960 FIND v(dout0_55) AT=485.025n

.meas tran vdout0_56ck960 FIND v(dout0_56) AT=485.025n

.meas tran vdout0_57ck960 FIND v(dout0_57) AT=485.025n

.meas tran vdout0_58ck960 FIND v(dout0_58) AT=485.025n

.meas tran vdout0_59ck960 FIND v(dout0_59) AT=485.025n

.meas tran vdout0_60ck960 FIND v(dout0_60) AT=485.025n

.meas tran vdout0_61ck960 FIND v(dout0_61) AT=485.025n

.meas tran vdout0_62ck960 FIND v(dout0_62) AT=485.025n

.meas tran vdout0_63ck960 FIND v(dout0_63) AT=485.025n

.meas tran vdout0_0ck970 FIND v(dout0_0) AT=490.025n

.meas tran vdout0_1ck970 FIND v(dout0_1) AT=490.025n

.meas tran vdout0_2ck970 FIND v(dout0_2) AT=490.025n

.meas tran vdout0_3ck970 FIND v(dout0_3) AT=490.025n

.meas tran vdout0_4ck970 FIND v(dout0_4) AT=490.025n

.meas tran vdout0_5ck970 FIND v(dout0_5) AT=490.025n

.meas tran vdout0_6ck970 FIND v(dout0_6) AT=490.025n

.meas tran vdout0_7ck970 FIND v(dout0_7) AT=490.025n

.meas tran vdout0_8ck970 FIND v(dout0_8) AT=490.025n

.meas tran vdout0_9ck970 FIND v(dout0_9) AT=490.025n

.meas tran vdout0_10ck970 FIND v(dout0_10) AT=490.025n

.meas tran vdout0_11ck970 FIND v(dout0_11) AT=490.025n

.meas tran vdout0_12ck970 FIND v(dout0_12) AT=490.025n

.meas tran vdout0_13ck970 FIND v(dout0_13) AT=490.025n

.meas tran vdout0_14ck970 FIND v(dout0_14) AT=490.025n

.meas tran vdout0_15ck970 FIND v(dout0_15) AT=490.025n

.meas tran vdout0_16ck970 FIND v(dout0_16) AT=490.025n

.meas tran vdout0_17ck970 FIND v(dout0_17) AT=490.025n

.meas tran vdout0_18ck970 FIND v(dout0_18) AT=490.025n

.meas tran vdout0_19ck970 FIND v(dout0_19) AT=490.025n

.meas tran vdout0_20ck970 FIND v(dout0_20) AT=490.025n

.meas tran vdout0_21ck970 FIND v(dout0_21) AT=490.025n

.meas tran vdout0_22ck970 FIND v(dout0_22) AT=490.025n

.meas tran vdout0_23ck970 FIND v(dout0_23) AT=490.025n

.meas tran vdout0_24ck970 FIND v(dout0_24) AT=490.025n

.meas tran vdout0_25ck970 FIND v(dout0_25) AT=490.025n

.meas tran vdout0_26ck970 FIND v(dout0_26) AT=490.025n

.meas tran vdout0_27ck970 FIND v(dout0_27) AT=490.025n

.meas tran vdout0_28ck970 FIND v(dout0_28) AT=490.025n

.meas tran vdout0_29ck970 FIND v(dout0_29) AT=490.025n

.meas tran vdout0_30ck970 FIND v(dout0_30) AT=490.025n

.meas tran vdout0_31ck970 FIND v(dout0_31) AT=490.025n

.meas tran vdout0_32ck970 FIND v(dout0_32) AT=490.025n

.meas tran vdout0_33ck970 FIND v(dout0_33) AT=490.025n

.meas tran vdout0_34ck970 FIND v(dout0_34) AT=490.025n

.meas tran vdout0_35ck970 FIND v(dout0_35) AT=490.025n

.meas tran vdout0_36ck970 FIND v(dout0_36) AT=490.025n

.meas tran vdout0_37ck970 FIND v(dout0_37) AT=490.025n

.meas tran vdout0_38ck970 FIND v(dout0_38) AT=490.025n

.meas tran vdout0_39ck970 FIND v(dout0_39) AT=490.025n

.meas tran vdout0_40ck970 FIND v(dout0_40) AT=490.025n

.meas tran vdout0_41ck970 FIND v(dout0_41) AT=490.025n

.meas tran vdout0_42ck970 FIND v(dout0_42) AT=490.025n

.meas tran vdout0_43ck970 FIND v(dout0_43) AT=490.025n

.meas tran vdout0_44ck970 FIND v(dout0_44) AT=490.025n

.meas tran vdout0_45ck970 FIND v(dout0_45) AT=490.025n

.meas tran vdout0_46ck970 FIND v(dout0_46) AT=490.025n

.meas tran vdout0_47ck970 FIND v(dout0_47) AT=490.025n

.meas tran vdout0_48ck970 FIND v(dout0_48) AT=490.025n

.meas tran vdout0_49ck970 FIND v(dout0_49) AT=490.025n

.meas tran vdout0_50ck970 FIND v(dout0_50) AT=490.025n

.meas tran vdout0_51ck970 FIND v(dout0_51) AT=490.025n

.meas tran vdout0_52ck970 FIND v(dout0_52) AT=490.025n

.meas tran vdout0_53ck970 FIND v(dout0_53) AT=490.025n

.meas tran vdout0_54ck970 FIND v(dout0_54) AT=490.025n

.meas tran vdout0_55ck970 FIND v(dout0_55) AT=490.025n

.meas tran vdout0_56ck970 FIND v(dout0_56) AT=490.025n

.meas tran vdout0_57ck970 FIND v(dout0_57) AT=490.025n

.meas tran vdout0_58ck970 FIND v(dout0_58) AT=490.025n

.meas tran vdout0_59ck970 FIND v(dout0_59) AT=490.025n

.meas tran vdout0_60ck970 FIND v(dout0_60) AT=490.025n

.meas tran vdout0_61ck970 FIND v(dout0_61) AT=490.025n

.meas tran vdout0_62ck970 FIND v(dout0_62) AT=490.025n

.meas tran vdout0_63ck970 FIND v(dout0_63) AT=490.025n

.meas tran vdout0_0ck980 FIND v(dout0_0) AT=495.025n

.meas tran vdout0_1ck980 FIND v(dout0_1) AT=495.025n

.meas tran vdout0_2ck980 FIND v(dout0_2) AT=495.025n

.meas tran vdout0_3ck980 FIND v(dout0_3) AT=495.025n

.meas tran vdout0_4ck980 FIND v(dout0_4) AT=495.025n

.meas tran vdout0_5ck980 FIND v(dout0_5) AT=495.025n

.meas tran vdout0_6ck980 FIND v(dout0_6) AT=495.025n

.meas tran vdout0_7ck980 FIND v(dout0_7) AT=495.025n

.meas tran vdout0_8ck980 FIND v(dout0_8) AT=495.025n

.meas tran vdout0_9ck980 FIND v(dout0_9) AT=495.025n

.meas tran vdout0_10ck980 FIND v(dout0_10) AT=495.025n

.meas tran vdout0_11ck980 FIND v(dout0_11) AT=495.025n

.meas tran vdout0_12ck980 FIND v(dout0_12) AT=495.025n

.meas tran vdout0_13ck980 FIND v(dout0_13) AT=495.025n

.meas tran vdout0_14ck980 FIND v(dout0_14) AT=495.025n

.meas tran vdout0_15ck980 FIND v(dout0_15) AT=495.025n

.meas tran vdout0_16ck980 FIND v(dout0_16) AT=495.025n

.meas tran vdout0_17ck980 FIND v(dout0_17) AT=495.025n

.meas tran vdout0_18ck980 FIND v(dout0_18) AT=495.025n

.meas tran vdout0_19ck980 FIND v(dout0_19) AT=495.025n

.meas tran vdout0_20ck980 FIND v(dout0_20) AT=495.025n

.meas tran vdout0_21ck980 FIND v(dout0_21) AT=495.025n

.meas tran vdout0_22ck980 FIND v(dout0_22) AT=495.025n

.meas tran vdout0_23ck980 FIND v(dout0_23) AT=495.025n

.meas tran vdout0_24ck980 FIND v(dout0_24) AT=495.025n

.meas tran vdout0_25ck980 FIND v(dout0_25) AT=495.025n

.meas tran vdout0_26ck980 FIND v(dout0_26) AT=495.025n

.meas tran vdout0_27ck980 FIND v(dout0_27) AT=495.025n

.meas tran vdout0_28ck980 FIND v(dout0_28) AT=495.025n

.meas tran vdout0_29ck980 FIND v(dout0_29) AT=495.025n

.meas tran vdout0_30ck980 FIND v(dout0_30) AT=495.025n

.meas tran vdout0_31ck980 FIND v(dout0_31) AT=495.025n

.meas tran vdout0_32ck980 FIND v(dout0_32) AT=495.025n

.meas tran vdout0_33ck980 FIND v(dout0_33) AT=495.025n

.meas tran vdout0_34ck980 FIND v(dout0_34) AT=495.025n

.meas tran vdout0_35ck980 FIND v(dout0_35) AT=495.025n

.meas tran vdout0_36ck980 FIND v(dout0_36) AT=495.025n

.meas tran vdout0_37ck980 FIND v(dout0_37) AT=495.025n

.meas tran vdout0_38ck980 FIND v(dout0_38) AT=495.025n

.meas tran vdout0_39ck980 FIND v(dout0_39) AT=495.025n

.meas tran vdout0_40ck980 FIND v(dout0_40) AT=495.025n

.meas tran vdout0_41ck980 FIND v(dout0_41) AT=495.025n

.meas tran vdout0_42ck980 FIND v(dout0_42) AT=495.025n

.meas tran vdout0_43ck980 FIND v(dout0_43) AT=495.025n

.meas tran vdout0_44ck980 FIND v(dout0_44) AT=495.025n

.meas tran vdout0_45ck980 FIND v(dout0_45) AT=495.025n

.meas tran vdout0_46ck980 FIND v(dout0_46) AT=495.025n

.meas tran vdout0_47ck980 FIND v(dout0_47) AT=495.025n

.meas tran vdout0_48ck980 FIND v(dout0_48) AT=495.025n

.meas tran vdout0_49ck980 FIND v(dout0_49) AT=495.025n

.meas tran vdout0_50ck980 FIND v(dout0_50) AT=495.025n

.meas tran vdout0_51ck980 FIND v(dout0_51) AT=495.025n

.meas tran vdout0_52ck980 FIND v(dout0_52) AT=495.025n

.meas tran vdout0_53ck980 FIND v(dout0_53) AT=495.025n

.meas tran vdout0_54ck980 FIND v(dout0_54) AT=495.025n

.meas tran vdout0_55ck980 FIND v(dout0_55) AT=495.025n

.meas tran vdout0_56ck980 FIND v(dout0_56) AT=495.025n

.meas tran vdout0_57ck980 FIND v(dout0_57) AT=495.025n

.meas tran vdout0_58ck980 FIND v(dout0_58) AT=495.025n

.meas tran vdout0_59ck980 FIND v(dout0_59) AT=495.025n

.meas tran vdout0_60ck980 FIND v(dout0_60) AT=495.025n

.meas tran vdout0_61ck980 FIND v(dout0_61) AT=495.025n

.meas tran vdout0_62ck980 FIND v(dout0_62) AT=495.025n

.meas tran vdout0_63ck980 FIND v(dout0_63) AT=495.025n

.meas tran vdout0_0ck1020 FIND v(dout0_0) AT=515.025n

.meas tran vdout0_1ck1020 FIND v(dout0_1) AT=515.025n

.meas tran vdout0_2ck1020 FIND v(dout0_2) AT=515.025n

.meas tran vdout0_3ck1020 FIND v(dout0_3) AT=515.025n

.meas tran vdout0_4ck1020 FIND v(dout0_4) AT=515.025n

.meas tran vdout0_5ck1020 FIND v(dout0_5) AT=515.025n

.meas tran vdout0_6ck1020 FIND v(dout0_6) AT=515.025n

.meas tran vdout0_7ck1020 FIND v(dout0_7) AT=515.025n

.meas tran vdout0_8ck1020 FIND v(dout0_8) AT=515.025n

.meas tran vdout0_9ck1020 FIND v(dout0_9) AT=515.025n

.meas tran vdout0_10ck1020 FIND v(dout0_10) AT=515.025n

.meas tran vdout0_11ck1020 FIND v(dout0_11) AT=515.025n

.meas tran vdout0_12ck1020 FIND v(dout0_12) AT=515.025n

.meas tran vdout0_13ck1020 FIND v(dout0_13) AT=515.025n

.meas tran vdout0_14ck1020 FIND v(dout0_14) AT=515.025n

.meas tran vdout0_15ck1020 FIND v(dout0_15) AT=515.025n

.meas tran vdout0_16ck1020 FIND v(dout0_16) AT=515.025n

.meas tran vdout0_17ck1020 FIND v(dout0_17) AT=515.025n

.meas tran vdout0_18ck1020 FIND v(dout0_18) AT=515.025n

.meas tran vdout0_19ck1020 FIND v(dout0_19) AT=515.025n

.meas tran vdout0_20ck1020 FIND v(dout0_20) AT=515.025n

.meas tran vdout0_21ck1020 FIND v(dout0_21) AT=515.025n

.meas tran vdout0_22ck1020 FIND v(dout0_22) AT=515.025n

.meas tran vdout0_23ck1020 FIND v(dout0_23) AT=515.025n

.meas tran vdout0_24ck1020 FIND v(dout0_24) AT=515.025n

.meas tran vdout0_25ck1020 FIND v(dout0_25) AT=515.025n

.meas tran vdout0_26ck1020 FIND v(dout0_26) AT=515.025n

.meas tran vdout0_27ck1020 FIND v(dout0_27) AT=515.025n

.meas tran vdout0_28ck1020 FIND v(dout0_28) AT=515.025n

.meas tran vdout0_29ck1020 FIND v(dout0_29) AT=515.025n

.meas tran vdout0_30ck1020 FIND v(dout0_30) AT=515.025n

.meas tran vdout0_31ck1020 FIND v(dout0_31) AT=515.025n

.meas tran vdout0_32ck1020 FIND v(dout0_32) AT=515.025n

.meas tran vdout0_33ck1020 FIND v(dout0_33) AT=515.025n

.meas tran vdout0_34ck1020 FIND v(dout0_34) AT=515.025n

.meas tran vdout0_35ck1020 FIND v(dout0_35) AT=515.025n

.meas tran vdout0_36ck1020 FIND v(dout0_36) AT=515.025n

.meas tran vdout0_37ck1020 FIND v(dout0_37) AT=515.025n

.meas tran vdout0_38ck1020 FIND v(dout0_38) AT=515.025n

.meas tran vdout0_39ck1020 FIND v(dout0_39) AT=515.025n

.meas tran vdout0_40ck1020 FIND v(dout0_40) AT=515.025n

.meas tran vdout0_41ck1020 FIND v(dout0_41) AT=515.025n

.meas tran vdout0_42ck1020 FIND v(dout0_42) AT=515.025n

.meas tran vdout0_43ck1020 FIND v(dout0_43) AT=515.025n

.meas tran vdout0_44ck1020 FIND v(dout0_44) AT=515.025n

.meas tran vdout0_45ck1020 FIND v(dout0_45) AT=515.025n

.meas tran vdout0_46ck1020 FIND v(dout0_46) AT=515.025n

.meas tran vdout0_47ck1020 FIND v(dout0_47) AT=515.025n

.meas tran vdout0_48ck1020 FIND v(dout0_48) AT=515.025n

.meas tran vdout0_49ck1020 FIND v(dout0_49) AT=515.025n

.meas tran vdout0_50ck1020 FIND v(dout0_50) AT=515.025n

.meas tran vdout0_51ck1020 FIND v(dout0_51) AT=515.025n

.meas tran vdout0_52ck1020 FIND v(dout0_52) AT=515.025n

.meas tran vdout0_53ck1020 FIND v(dout0_53) AT=515.025n

.meas tran vdout0_54ck1020 FIND v(dout0_54) AT=515.025n

.meas tran vdout0_55ck1020 FIND v(dout0_55) AT=515.025n

.meas tran vdout0_56ck1020 FIND v(dout0_56) AT=515.025n

.meas tran vdout0_57ck1020 FIND v(dout0_57) AT=515.025n

.meas tran vdout0_58ck1020 FIND v(dout0_58) AT=515.025n

.meas tran vdout0_59ck1020 FIND v(dout0_59) AT=515.025n

.meas tran vdout0_60ck1020 FIND v(dout0_60) AT=515.025n

.meas tran vdout0_61ck1020 FIND v(dout0_61) AT=515.025n

.meas tran vdout0_62ck1020 FIND v(dout0_62) AT=515.025n

.meas tran vdout0_63ck1020 FIND v(dout0_63) AT=515.025n

.meas tran vdout0_0ck1040 FIND v(dout0_0) AT=525.025n

.meas tran vdout0_1ck1040 FIND v(dout0_1) AT=525.025n

.meas tran vdout0_2ck1040 FIND v(dout0_2) AT=525.025n

.meas tran vdout0_3ck1040 FIND v(dout0_3) AT=525.025n

.meas tran vdout0_4ck1040 FIND v(dout0_4) AT=525.025n

.meas tran vdout0_5ck1040 FIND v(dout0_5) AT=525.025n

.meas tran vdout0_6ck1040 FIND v(dout0_6) AT=525.025n

.meas tran vdout0_7ck1040 FIND v(dout0_7) AT=525.025n

.meas tran vdout0_8ck1040 FIND v(dout0_8) AT=525.025n

.meas tran vdout0_9ck1040 FIND v(dout0_9) AT=525.025n

.meas tran vdout0_10ck1040 FIND v(dout0_10) AT=525.025n

.meas tran vdout0_11ck1040 FIND v(dout0_11) AT=525.025n

.meas tran vdout0_12ck1040 FIND v(dout0_12) AT=525.025n

.meas tran vdout0_13ck1040 FIND v(dout0_13) AT=525.025n

.meas tran vdout0_14ck1040 FIND v(dout0_14) AT=525.025n

.meas tran vdout0_15ck1040 FIND v(dout0_15) AT=525.025n

.meas tran vdout0_16ck1040 FIND v(dout0_16) AT=525.025n

.meas tran vdout0_17ck1040 FIND v(dout0_17) AT=525.025n

.meas tran vdout0_18ck1040 FIND v(dout0_18) AT=525.025n

.meas tran vdout0_19ck1040 FIND v(dout0_19) AT=525.025n

.meas tran vdout0_20ck1040 FIND v(dout0_20) AT=525.025n

.meas tran vdout0_21ck1040 FIND v(dout0_21) AT=525.025n

.meas tran vdout0_22ck1040 FIND v(dout0_22) AT=525.025n

.meas tran vdout0_23ck1040 FIND v(dout0_23) AT=525.025n

.meas tran vdout0_24ck1040 FIND v(dout0_24) AT=525.025n

.meas tran vdout0_25ck1040 FIND v(dout0_25) AT=525.025n

.meas tran vdout0_26ck1040 FIND v(dout0_26) AT=525.025n

.meas tran vdout0_27ck1040 FIND v(dout0_27) AT=525.025n

.meas tran vdout0_28ck1040 FIND v(dout0_28) AT=525.025n

.meas tran vdout0_29ck1040 FIND v(dout0_29) AT=525.025n

.meas tran vdout0_30ck1040 FIND v(dout0_30) AT=525.025n

.meas tran vdout0_31ck1040 FIND v(dout0_31) AT=525.025n

.meas tran vdout0_32ck1040 FIND v(dout0_32) AT=525.025n

.meas tran vdout0_33ck1040 FIND v(dout0_33) AT=525.025n

.meas tran vdout0_34ck1040 FIND v(dout0_34) AT=525.025n

.meas tran vdout0_35ck1040 FIND v(dout0_35) AT=525.025n

.meas tran vdout0_36ck1040 FIND v(dout0_36) AT=525.025n

.meas tran vdout0_37ck1040 FIND v(dout0_37) AT=525.025n

.meas tran vdout0_38ck1040 FIND v(dout0_38) AT=525.025n

.meas tran vdout0_39ck1040 FIND v(dout0_39) AT=525.025n

.meas tran vdout0_40ck1040 FIND v(dout0_40) AT=525.025n

.meas tran vdout0_41ck1040 FIND v(dout0_41) AT=525.025n

.meas tran vdout0_42ck1040 FIND v(dout0_42) AT=525.025n

.meas tran vdout0_43ck1040 FIND v(dout0_43) AT=525.025n

.meas tran vdout0_44ck1040 FIND v(dout0_44) AT=525.025n

.meas tran vdout0_45ck1040 FIND v(dout0_45) AT=525.025n

.meas tran vdout0_46ck1040 FIND v(dout0_46) AT=525.025n

.meas tran vdout0_47ck1040 FIND v(dout0_47) AT=525.025n

.meas tran vdout0_48ck1040 FIND v(dout0_48) AT=525.025n

.meas tran vdout0_49ck1040 FIND v(dout0_49) AT=525.025n

.meas tran vdout0_50ck1040 FIND v(dout0_50) AT=525.025n

.meas tran vdout0_51ck1040 FIND v(dout0_51) AT=525.025n

.meas tran vdout0_52ck1040 FIND v(dout0_52) AT=525.025n

.meas tran vdout0_53ck1040 FIND v(dout0_53) AT=525.025n

.meas tran vdout0_54ck1040 FIND v(dout0_54) AT=525.025n

.meas tran vdout0_55ck1040 FIND v(dout0_55) AT=525.025n

.meas tran vdout0_56ck1040 FIND v(dout0_56) AT=525.025n

.meas tran vdout0_57ck1040 FIND v(dout0_57) AT=525.025n

.meas tran vdout0_58ck1040 FIND v(dout0_58) AT=525.025n

.meas tran vdout0_59ck1040 FIND v(dout0_59) AT=525.025n

.meas tran vdout0_60ck1040 FIND v(dout0_60) AT=525.025n

.meas tran vdout0_61ck1040 FIND v(dout0_61) AT=525.025n

.meas tran vdout0_62ck1040 FIND v(dout0_62) AT=525.025n

.meas tran vdout0_63ck1040 FIND v(dout0_63) AT=525.025n

.meas tran vdout0_0ck1050 FIND v(dout0_0) AT=530.025n

.meas tran vdout0_1ck1050 FIND v(dout0_1) AT=530.025n

.meas tran vdout0_2ck1050 FIND v(dout0_2) AT=530.025n

.meas tran vdout0_3ck1050 FIND v(dout0_3) AT=530.025n

.meas tran vdout0_4ck1050 FIND v(dout0_4) AT=530.025n

.meas tran vdout0_5ck1050 FIND v(dout0_5) AT=530.025n

.meas tran vdout0_6ck1050 FIND v(dout0_6) AT=530.025n

.meas tran vdout0_7ck1050 FIND v(dout0_7) AT=530.025n

.meas tran vdout0_8ck1050 FIND v(dout0_8) AT=530.025n

.meas tran vdout0_9ck1050 FIND v(dout0_9) AT=530.025n

.meas tran vdout0_10ck1050 FIND v(dout0_10) AT=530.025n

.meas tran vdout0_11ck1050 FIND v(dout0_11) AT=530.025n

.meas tran vdout0_12ck1050 FIND v(dout0_12) AT=530.025n

.meas tran vdout0_13ck1050 FIND v(dout0_13) AT=530.025n

.meas tran vdout0_14ck1050 FIND v(dout0_14) AT=530.025n

.meas tran vdout0_15ck1050 FIND v(dout0_15) AT=530.025n

.meas tran vdout0_16ck1050 FIND v(dout0_16) AT=530.025n

.meas tran vdout0_17ck1050 FIND v(dout0_17) AT=530.025n

.meas tran vdout0_18ck1050 FIND v(dout0_18) AT=530.025n

.meas tran vdout0_19ck1050 FIND v(dout0_19) AT=530.025n

.meas tran vdout0_20ck1050 FIND v(dout0_20) AT=530.025n

.meas tran vdout0_21ck1050 FIND v(dout0_21) AT=530.025n

.meas tran vdout0_22ck1050 FIND v(dout0_22) AT=530.025n

.meas tran vdout0_23ck1050 FIND v(dout0_23) AT=530.025n

.meas tran vdout0_24ck1050 FIND v(dout0_24) AT=530.025n

.meas tran vdout0_25ck1050 FIND v(dout0_25) AT=530.025n

.meas tran vdout0_26ck1050 FIND v(dout0_26) AT=530.025n

.meas tran vdout0_27ck1050 FIND v(dout0_27) AT=530.025n

.meas tran vdout0_28ck1050 FIND v(dout0_28) AT=530.025n

.meas tran vdout0_29ck1050 FIND v(dout0_29) AT=530.025n

.meas tran vdout0_30ck1050 FIND v(dout0_30) AT=530.025n

.meas tran vdout0_31ck1050 FIND v(dout0_31) AT=530.025n

.meas tran vdout0_32ck1050 FIND v(dout0_32) AT=530.025n

.meas tran vdout0_33ck1050 FIND v(dout0_33) AT=530.025n

.meas tran vdout0_34ck1050 FIND v(dout0_34) AT=530.025n

.meas tran vdout0_35ck1050 FIND v(dout0_35) AT=530.025n

.meas tran vdout0_36ck1050 FIND v(dout0_36) AT=530.025n

.meas tran vdout0_37ck1050 FIND v(dout0_37) AT=530.025n

.meas tran vdout0_38ck1050 FIND v(dout0_38) AT=530.025n

.meas tran vdout0_39ck1050 FIND v(dout0_39) AT=530.025n

.meas tran vdout0_40ck1050 FIND v(dout0_40) AT=530.025n

.meas tran vdout0_41ck1050 FIND v(dout0_41) AT=530.025n

.meas tran vdout0_42ck1050 FIND v(dout0_42) AT=530.025n

.meas tran vdout0_43ck1050 FIND v(dout0_43) AT=530.025n

.meas tran vdout0_44ck1050 FIND v(dout0_44) AT=530.025n

.meas tran vdout0_45ck1050 FIND v(dout0_45) AT=530.025n

.meas tran vdout0_46ck1050 FIND v(dout0_46) AT=530.025n

.meas tran vdout0_47ck1050 FIND v(dout0_47) AT=530.025n

.meas tran vdout0_48ck1050 FIND v(dout0_48) AT=530.025n

.meas tran vdout0_49ck1050 FIND v(dout0_49) AT=530.025n

.meas tran vdout0_50ck1050 FIND v(dout0_50) AT=530.025n

.meas tran vdout0_51ck1050 FIND v(dout0_51) AT=530.025n

.meas tran vdout0_52ck1050 FIND v(dout0_52) AT=530.025n

.meas tran vdout0_53ck1050 FIND v(dout0_53) AT=530.025n

.meas tran vdout0_54ck1050 FIND v(dout0_54) AT=530.025n

.meas tran vdout0_55ck1050 FIND v(dout0_55) AT=530.025n

.meas tran vdout0_56ck1050 FIND v(dout0_56) AT=530.025n

.meas tran vdout0_57ck1050 FIND v(dout0_57) AT=530.025n

.meas tran vdout0_58ck1050 FIND v(dout0_58) AT=530.025n

.meas tran vdout0_59ck1050 FIND v(dout0_59) AT=530.025n

.meas tran vdout0_60ck1050 FIND v(dout0_60) AT=530.025n

.meas tran vdout0_61ck1050 FIND v(dout0_61) AT=530.025n

.meas tran vdout0_62ck1050 FIND v(dout0_62) AT=530.025n

.meas tran vdout0_63ck1050 FIND v(dout0_63) AT=530.025n

.meas tran vdout0_0ck1060 FIND v(dout0_0) AT=535.025n

.meas tran vdout0_1ck1060 FIND v(dout0_1) AT=535.025n

.meas tran vdout0_2ck1060 FIND v(dout0_2) AT=535.025n

.meas tran vdout0_3ck1060 FIND v(dout0_3) AT=535.025n

.meas tran vdout0_4ck1060 FIND v(dout0_4) AT=535.025n

.meas tran vdout0_5ck1060 FIND v(dout0_5) AT=535.025n

.meas tran vdout0_6ck1060 FIND v(dout0_6) AT=535.025n

.meas tran vdout0_7ck1060 FIND v(dout0_7) AT=535.025n

.meas tran vdout0_8ck1060 FIND v(dout0_8) AT=535.025n

.meas tran vdout0_9ck1060 FIND v(dout0_9) AT=535.025n

.meas tran vdout0_10ck1060 FIND v(dout0_10) AT=535.025n

.meas tran vdout0_11ck1060 FIND v(dout0_11) AT=535.025n

.meas tran vdout0_12ck1060 FIND v(dout0_12) AT=535.025n

.meas tran vdout0_13ck1060 FIND v(dout0_13) AT=535.025n

.meas tran vdout0_14ck1060 FIND v(dout0_14) AT=535.025n

.meas tran vdout0_15ck1060 FIND v(dout0_15) AT=535.025n

.meas tran vdout0_16ck1060 FIND v(dout0_16) AT=535.025n

.meas tran vdout0_17ck1060 FIND v(dout0_17) AT=535.025n

.meas tran vdout0_18ck1060 FIND v(dout0_18) AT=535.025n

.meas tran vdout0_19ck1060 FIND v(dout0_19) AT=535.025n

.meas tran vdout0_20ck1060 FIND v(dout0_20) AT=535.025n

.meas tran vdout0_21ck1060 FIND v(dout0_21) AT=535.025n

.meas tran vdout0_22ck1060 FIND v(dout0_22) AT=535.025n

.meas tran vdout0_23ck1060 FIND v(dout0_23) AT=535.025n

.meas tran vdout0_24ck1060 FIND v(dout0_24) AT=535.025n

.meas tran vdout0_25ck1060 FIND v(dout0_25) AT=535.025n

.meas tran vdout0_26ck1060 FIND v(dout0_26) AT=535.025n

.meas tran vdout0_27ck1060 FIND v(dout0_27) AT=535.025n

.meas tran vdout0_28ck1060 FIND v(dout0_28) AT=535.025n

.meas tran vdout0_29ck1060 FIND v(dout0_29) AT=535.025n

.meas tran vdout0_30ck1060 FIND v(dout0_30) AT=535.025n

.meas tran vdout0_31ck1060 FIND v(dout0_31) AT=535.025n

.meas tran vdout0_32ck1060 FIND v(dout0_32) AT=535.025n

.meas tran vdout0_33ck1060 FIND v(dout0_33) AT=535.025n

.meas tran vdout0_34ck1060 FIND v(dout0_34) AT=535.025n

.meas tran vdout0_35ck1060 FIND v(dout0_35) AT=535.025n

.meas tran vdout0_36ck1060 FIND v(dout0_36) AT=535.025n

.meas tran vdout0_37ck1060 FIND v(dout0_37) AT=535.025n

.meas tran vdout0_38ck1060 FIND v(dout0_38) AT=535.025n

.meas tran vdout0_39ck1060 FIND v(dout0_39) AT=535.025n

.meas tran vdout0_40ck1060 FIND v(dout0_40) AT=535.025n

.meas tran vdout0_41ck1060 FIND v(dout0_41) AT=535.025n

.meas tran vdout0_42ck1060 FIND v(dout0_42) AT=535.025n

.meas tran vdout0_43ck1060 FIND v(dout0_43) AT=535.025n

.meas tran vdout0_44ck1060 FIND v(dout0_44) AT=535.025n

.meas tran vdout0_45ck1060 FIND v(dout0_45) AT=535.025n

.meas tran vdout0_46ck1060 FIND v(dout0_46) AT=535.025n

.meas tran vdout0_47ck1060 FIND v(dout0_47) AT=535.025n

.meas tran vdout0_48ck1060 FIND v(dout0_48) AT=535.025n

.meas tran vdout0_49ck1060 FIND v(dout0_49) AT=535.025n

.meas tran vdout0_50ck1060 FIND v(dout0_50) AT=535.025n

.meas tran vdout0_51ck1060 FIND v(dout0_51) AT=535.025n

.meas tran vdout0_52ck1060 FIND v(dout0_52) AT=535.025n

.meas tran vdout0_53ck1060 FIND v(dout0_53) AT=535.025n

.meas tran vdout0_54ck1060 FIND v(dout0_54) AT=535.025n

.meas tran vdout0_55ck1060 FIND v(dout0_55) AT=535.025n

.meas tran vdout0_56ck1060 FIND v(dout0_56) AT=535.025n

.meas tran vdout0_57ck1060 FIND v(dout0_57) AT=535.025n

.meas tran vdout0_58ck1060 FIND v(dout0_58) AT=535.025n

.meas tran vdout0_59ck1060 FIND v(dout0_59) AT=535.025n

.meas tran vdout0_60ck1060 FIND v(dout0_60) AT=535.025n

.meas tran vdout0_61ck1060 FIND v(dout0_61) AT=535.025n

.meas tran vdout0_62ck1060 FIND v(dout0_62) AT=535.025n

.meas tran vdout0_63ck1060 FIND v(dout0_63) AT=535.025n

.meas tran vdout0_0ck1070 FIND v(dout0_0) AT=540.025n

.meas tran vdout0_1ck1070 FIND v(dout0_1) AT=540.025n

.meas tran vdout0_2ck1070 FIND v(dout0_2) AT=540.025n

.meas tran vdout0_3ck1070 FIND v(dout0_3) AT=540.025n

.meas tran vdout0_4ck1070 FIND v(dout0_4) AT=540.025n

.meas tran vdout0_5ck1070 FIND v(dout0_5) AT=540.025n

.meas tran vdout0_6ck1070 FIND v(dout0_6) AT=540.025n

.meas tran vdout0_7ck1070 FIND v(dout0_7) AT=540.025n

.meas tran vdout0_8ck1070 FIND v(dout0_8) AT=540.025n

.meas tran vdout0_9ck1070 FIND v(dout0_9) AT=540.025n

.meas tran vdout0_10ck1070 FIND v(dout0_10) AT=540.025n

.meas tran vdout0_11ck1070 FIND v(dout0_11) AT=540.025n

.meas tran vdout0_12ck1070 FIND v(dout0_12) AT=540.025n

.meas tran vdout0_13ck1070 FIND v(dout0_13) AT=540.025n

.meas tran vdout0_14ck1070 FIND v(dout0_14) AT=540.025n

.meas tran vdout0_15ck1070 FIND v(dout0_15) AT=540.025n

.meas tran vdout0_16ck1070 FIND v(dout0_16) AT=540.025n

.meas tran vdout0_17ck1070 FIND v(dout0_17) AT=540.025n

.meas tran vdout0_18ck1070 FIND v(dout0_18) AT=540.025n

.meas tran vdout0_19ck1070 FIND v(dout0_19) AT=540.025n

.meas tran vdout0_20ck1070 FIND v(dout0_20) AT=540.025n

.meas tran vdout0_21ck1070 FIND v(dout0_21) AT=540.025n

.meas tran vdout0_22ck1070 FIND v(dout0_22) AT=540.025n

.meas tran vdout0_23ck1070 FIND v(dout0_23) AT=540.025n

.meas tran vdout0_24ck1070 FIND v(dout0_24) AT=540.025n

.meas tran vdout0_25ck1070 FIND v(dout0_25) AT=540.025n

.meas tran vdout0_26ck1070 FIND v(dout0_26) AT=540.025n

.meas tran vdout0_27ck1070 FIND v(dout0_27) AT=540.025n

.meas tran vdout0_28ck1070 FIND v(dout0_28) AT=540.025n

.meas tran vdout0_29ck1070 FIND v(dout0_29) AT=540.025n

.meas tran vdout0_30ck1070 FIND v(dout0_30) AT=540.025n

.meas tran vdout0_31ck1070 FIND v(dout0_31) AT=540.025n

.meas tran vdout0_32ck1070 FIND v(dout0_32) AT=540.025n

.meas tran vdout0_33ck1070 FIND v(dout0_33) AT=540.025n

.meas tran vdout0_34ck1070 FIND v(dout0_34) AT=540.025n

.meas tran vdout0_35ck1070 FIND v(dout0_35) AT=540.025n

.meas tran vdout0_36ck1070 FIND v(dout0_36) AT=540.025n

.meas tran vdout0_37ck1070 FIND v(dout0_37) AT=540.025n

.meas tran vdout0_38ck1070 FIND v(dout0_38) AT=540.025n

.meas tran vdout0_39ck1070 FIND v(dout0_39) AT=540.025n

.meas tran vdout0_40ck1070 FIND v(dout0_40) AT=540.025n

.meas tran vdout0_41ck1070 FIND v(dout0_41) AT=540.025n

.meas tran vdout0_42ck1070 FIND v(dout0_42) AT=540.025n

.meas tran vdout0_43ck1070 FIND v(dout0_43) AT=540.025n

.meas tran vdout0_44ck1070 FIND v(dout0_44) AT=540.025n

.meas tran vdout0_45ck1070 FIND v(dout0_45) AT=540.025n

.meas tran vdout0_46ck1070 FIND v(dout0_46) AT=540.025n

.meas tran vdout0_47ck1070 FIND v(dout0_47) AT=540.025n

.meas tran vdout0_48ck1070 FIND v(dout0_48) AT=540.025n

.meas tran vdout0_49ck1070 FIND v(dout0_49) AT=540.025n

.meas tran vdout0_50ck1070 FIND v(dout0_50) AT=540.025n

.meas tran vdout0_51ck1070 FIND v(dout0_51) AT=540.025n

.meas tran vdout0_52ck1070 FIND v(dout0_52) AT=540.025n

.meas tran vdout0_53ck1070 FIND v(dout0_53) AT=540.025n

.meas tran vdout0_54ck1070 FIND v(dout0_54) AT=540.025n

.meas tran vdout0_55ck1070 FIND v(dout0_55) AT=540.025n

.meas tran vdout0_56ck1070 FIND v(dout0_56) AT=540.025n

.meas tran vdout0_57ck1070 FIND v(dout0_57) AT=540.025n

.meas tran vdout0_58ck1070 FIND v(dout0_58) AT=540.025n

.meas tran vdout0_59ck1070 FIND v(dout0_59) AT=540.025n

.meas tran vdout0_60ck1070 FIND v(dout0_60) AT=540.025n

.meas tran vdout0_61ck1070 FIND v(dout0_61) AT=540.025n

.meas tran vdout0_62ck1070 FIND v(dout0_62) AT=540.025n

.meas tran vdout0_63ck1070 FIND v(dout0_63) AT=540.025n

.meas tran vdout0_0ck1080 FIND v(dout0_0) AT=545.025n

.meas tran vdout0_1ck1080 FIND v(dout0_1) AT=545.025n

.meas tran vdout0_2ck1080 FIND v(dout0_2) AT=545.025n

.meas tran vdout0_3ck1080 FIND v(dout0_3) AT=545.025n

.meas tran vdout0_4ck1080 FIND v(dout0_4) AT=545.025n

.meas tran vdout0_5ck1080 FIND v(dout0_5) AT=545.025n

.meas tran vdout0_6ck1080 FIND v(dout0_6) AT=545.025n

.meas tran vdout0_7ck1080 FIND v(dout0_7) AT=545.025n

.meas tran vdout0_8ck1080 FIND v(dout0_8) AT=545.025n

.meas tran vdout0_9ck1080 FIND v(dout0_9) AT=545.025n

.meas tran vdout0_10ck1080 FIND v(dout0_10) AT=545.025n

.meas tran vdout0_11ck1080 FIND v(dout0_11) AT=545.025n

.meas tran vdout0_12ck1080 FIND v(dout0_12) AT=545.025n

.meas tran vdout0_13ck1080 FIND v(dout0_13) AT=545.025n

.meas tran vdout0_14ck1080 FIND v(dout0_14) AT=545.025n

.meas tran vdout0_15ck1080 FIND v(dout0_15) AT=545.025n

.meas tran vdout0_16ck1080 FIND v(dout0_16) AT=545.025n

.meas tran vdout0_17ck1080 FIND v(dout0_17) AT=545.025n

.meas tran vdout0_18ck1080 FIND v(dout0_18) AT=545.025n

.meas tran vdout0_19ck1080 FIND v(dout0_19) AT=545.025n

.meas tran vdout0_20ck1080 FIND v(dout0_20) AT=545.025n

.meas tran vdout0_21ck1080 FIND v(dout0_21) AT=545.025n

.meas tran vdout0_22ck1080 FIND v(dout0_22) AT=545.025n

.meas tran vdout0_23ck1080 FIND v(dout0_23) AT=545.025n

.meas tran vdout0_24ck1080 FIND v(dout0_24) AT=545.025n

.meas tran vdout0_25ck1080 FIND v(dout0_25) AT=545.025n

.meas tran vdout0_26ck1080 FIND v(dout0_26) AT=545.025n

.meas tran vdout0_27ck1080 FIND v(dout0_27) AT=545.025n

.meas tran vdout0_28ck1080 FIND v(dout0_28) AT=545.025n

.meas tran vdout0_29ck1080 FIND v(dout0_29) AT=545.025n

.meas tran vdout0_30ck1080 FIND v(dout0_30) AT=545.025n

.meas tran vdout0_31ck1080 FIND v(dout0_31) AT=545.025n

.meas tran vdout0_32ck1080 FIND v(dout0_32) AT=545.025n

.meas tran vdout0_33ck1080 FIND v(dout0_33) AT=545.025n

.meas tran vdout0_34ck1080 FIND v(dout0_34) AT=545.025n

.meas tran vdout0_35ck1080 FIND v(dout0_35) AT=545.025n

.meas tran vdout0_36ck1080 FIND v(dout0_36) AT=545.025n

.meas tran vdout0_37ck1080 FIND v(dout0_37) AT=545.025n

.meas tran vdout0_38ck1080 FIND v(dout0_38) AT=545.025n

.meas tran vdout0_39ck1080 FIND v(dout0_39) AT=545.025n

.meas tran vdout0_40ck1080 FIND v(dout0_40) AT=545.025n

.meas tran vdout0_41ck1080 FIND v(dout0_41) AT=545.025n

.meas tran vdout0_42ck1080 FIND v(dout0_42) AT=545.025n

.meas tran vdout0_43ck1080 FIND v(dout0_43) AT=545.025n

.meas tran vdout0_44ck1080 FIND v(dout0_44) AT=545.025n

.meas tran vdout0_45ck1080 FIND v(dout0_45) AT=545.025n

.meas tran vdout0_46ck1080 FIND v(dout0_46) AT=545.025n

.meas tran vdout0_47ck1080 FIND v(dout0_47) AT=545.025n

.meas tran vdout0_48ck1080 FIND v(dout0_48) AT=545.025n

.meas tran vdout0_49ck1080 FIND v(dout0_49) AT=545.025n

.meas tran vdout0_50ck1080 FIND v(dout0_50) AT=545.025n

.meas tran vdout0_51ck1080 FIND v(dout0_51) AT=545.025n

.meas tran vdout0_52ck1080 FIND v(dout0_52) AT=545.025n

.meas tran vdout0_53ck1080 FIND v(dout0_53) AT=545.025n

.meas tran vdout0_54ck1080 FIND v(dout0_54) AT=545.025n

.meas tran vdout0_55ck1080 FIND v(dout0_55) AT=545.025n

.meas tran vdout0_56ck1080 FIND v(dout0_56) AT=545.025n

.meas tran vdout0_57ck1080 FIND v(dout0_57) AT=545.025n

.meas tran vdout0_58ck1080 FIND v(dout0_58) AT=545.025n

.meas tran vdout0_59ck1080 FIND v(dout0_59) AT=545.025n

.meas tran vdout0_60ck1080 FIND v(dout0_60) AT=545.025n

.meas tran vdout0_61ck1080 FIND v(dout0_61) AT=545.025n

.meas tran vdout0_62ck1080 FIND v(dout0_62) AT=545.025n

.meas tran vdout0_63ck1080 FIND v(dout0_63) AT=545.025n

.meas tran vdout0_0ck1090 FIND v(dout0_0) AT=550.025n

.meas tran vdout0_1ck1090 FIND v(dout0_1) AT=550.025n

.meas tran vdout0_2ck1090 FIND v(dout0_2) AT=550.025n

.meas tran vdout0_3ck1090 FIND v(dout0_3) AT=550.025n

.meas tran vdout0_4ck1090 FIND v(dout0_4) AT=550.025n

.meas tran vdout0_5ck1090 FIND v(dout0_5) AT=550.025n

.meas tran vdout0_6ck1090 FIND v(dout0_6) AT=550.025n

.meas tran vdout0_7ck1090 FIND v(dout0_7) AT=550.025n

.meas tran vdout0_8ck1090 FIND v(dout0_8) AT=550.025n

.meas tran vdout0_9ck1090 FIND v(dout0_9) AT=550.025n

.meas tran vdout0_10ck1090 FIND v(dout0_10) AT=550.025n

.meas tran vdout0_11ck1090 FIND v(dout0_11) AT=550.025n

.meas tran vdout0_12ck1090 FIND v(dout0_12) AT=550.025n

.meas tran vdout0_13ck1090 FIND v(dout0_13) AT=550.025n

.meas tran vdout0_14ck1090 FIND v(dout0_14) AT=550.025n

.meas tran vdout0_15ck1090 FIND v(dout0_15) AT=550.025n

.meas tran vdout0_16ck1090 FIND v(dout0_16) AT=550.025n

.meas tran vdout0_17ck1090 FIND v(dout0_17) AT=550.025n

.meas tran vdout0_18ck1090 FIND v(dout0_18) AT=550.025n

.meas tran vdout0_19ck1090 FIND v(dout0_19) AT=550.025n

.meas tran vdout0_20ck1090 FIND v(dout0_20) AT=550.025n

.meas tran vdout0_21ck1090 FIND v(dout0_21) AT=550.025n

.meas tran vdout0_22ck1090 FIND v(dout0_22) AT=550.025n

.meas tran vdout0_23ck1090 FIND v(dout0_23) AT=550.025n

.meas tran vdout0_24ck1090 FIND v(dout0_24) AT=550.025n

.meas tran vdout0_25ck1090 FIND v(dout0_25) AT=550.025n

.meas tran vdout0_26ck1090 FIND v(dout0_26) AT=550.025n

.meas tran vdout0_27ck1090 FIND v(dout0_27) AT=550.025n

.meas tran vdout0_28ck1090 FIND v(dout0_28) AT=550.025n

.meas tran vdout0_29ck1090 FIND v(dout0_29) AT=550.025n

.meas tran vdout0_30ck1090 FIND v(dout0_30) AT=550.025n

.meas tran vdout0_31ck1090 FIND v(dout0_31) AT=550.025n

.meas tran vdout0_32ck1090 FIND v(dout0_32) AT=550.025n

.meas tran vdout0_33ck1090 FIND v(dout0_33) AT=550.025n

.meas tran vdout0_34ck1090 FIND v(dout0_34) AT=550.025n

.meas tran vdout0_35ck1090 FIND v(dout0_35) AT=550.025n

.meas tran vdout0_36ck1090 FIND v(dout0_36) AT=550.025n

.meas tran vdout0_37ck1090 FIND v(dout0_37) AT=550.025n

.meas tran vdout0_38ck1090 FIND v(dout0_38) AT=550.025n

.meas tran vdout0_39ck1090 FIND v(dout0_39) AT=550.025n

.meas tran vdout0_40ck1090 FIND v(dout0_40) AT=550.025n

.meas tran vdout0_41ck1090 FIND v(dout0_41) AT=550.025n

.meas tran vdout0_42ck1090 FIND v(dout0_42) AT=550.025n

.meas tran vdout0_43ck1090 FIND v(dout0_43) AT=550.025n

.meas tran vdout0_44ck1090 FIND v(dout0_44) AT=550.025n

.meas tran vdout0_45ck1090 FIND v(dout0_45) AT=550.025n

.meas tran vdout0_46ck1090 FIND v(dout0_46) AT=550.025n

.meas tran vdout0_47ck1090 FIND v(dout0_47) AT=550.025n

.meas tran vdout0_48ck1090 FIND v(dout0_48) AT=550.025n

.meas tran vdout0_49ck1090 FIND v(dout0_49) AT=550.025n

.meas tran vdout0_50ck1090 FIND v(dout0_50) AT=550.025n

.meas tran vdout0_51ck1090 FIND v(dout0_51) AT=550.025n

.meas tran vdout0_52ck1090 FIND v(dout0_52) AT=550.025n

.meas tran vdout0_53ck1090 FIND v(dout0_53) AT=550.025n

.meas tran vdout0_54ck1090 FIND v(dout0_54) AT=550.025n

.meas tran vdout0_55ck1090 FIND v(dout0_55) AT=550.025n

.meas tran vdout0_56ck1090 FIND v(dout0_56) AT=550.025n

.meas tran vdout0_57ck1090 FIND v(dout0_57) AT=550.025n

.meas tran vdout0_58ck1090 FIND v(dout0_58) AT=550.025n

.meas tran vdout0_59ck1090 FIND v(dout0_59) AT=550.025n

.meas tran vdout0_60ck1090 FIND v(dout0_60) AT=550.025n

.meas tran vdout0_61ck1090 FIND v(dout0_61) AT=550.025n

.meas tran vdout0_62ck1090 FIND v(dout0_62) AT=550.025n

.meas tran vdout0_63ck1090 FIND v(dout0_63) AT=550.025n

.meas tran vdout0_0ck1100 FIND v(dout0_0) AT=555.025n

.meas tran vdout0_1ck1100 FIND v(dout0_1) AT=555.025n

.meas tran vdout0_2ck1100 FIND v(dout0_2) AT=555.025n

.meas tran vdout0_3ck1100 FIND v(dout0_3) AT=555.025n

.meas tran vdout0_4ck1100 FIND v(dout0_4) AT=555.025n

.meas tran vdout0_5ck1100 FIND v(dout0_5) AT=555.025n

.meas tran vdout0_6ck1100 FIND v(dout0_6) AT=555.025n

.meas tran vdout0_7ck1100 FIND v(dout0_7) AT=555.025n

.meas tran vdout0_8ck1100 FIND v(dout0_8) AT=555.025n

.meas tran vdout0_9ck1100 FIND v(dout0_9) AT=555.025n

.meas tran vdout0_10ck1100 FIND v(dout0_10) AT=555.025n

.meas tran vdout0_11ck1100 FIND v(dout0_11) AT=555.025n

.meas tran vdout0_12ck1100 FIND v(dout0_12) AT=555.025n

.meas tran vdout0_13ck1100 FIND v(dout0_13) AT=555.025n

.meas tran vdout0_14ck1100 FIND v(dout0_14) AT=555.025n

.meas tran vdout0_15ck1100 FIND v(dout0_15) AT=555.025n

.meas tran vdout0_16ck1100 FIND v(dout0_16) AT=555.025n

.meas tran vdout0_17ck1100 FIND v(dout0_17) AT=555.025n

.meas tran vdout0_18ck1100 FIND v(dout0_18) AT=555.025n

.meas tran vdout0_19ck1100 FIND v(dout0_19) AT=555.025n

.meas tran vdout0_20ck1100 FIND v(dout0_20) AT=555.025n

.meas tran vdout0_21ck1100 FIND v(dout0_21) AT=555.025n

.meas tran vdout0_22ck1100 FIND v(dout0_22) AT=555.025n

.meas tran vdout0_23ck1100 FIND v(dout0_23) AT=555.025n

.meas tran vdout0_24ck1100 FIND v(dout0_24) AT=555.025n

.meas tran vdout0_25ck1100 FIND v(dout0_25) AT=555.025n

.meas tran vdout0_26ck1100 FIND v(dout0_26) AT=555.025n

.meas tran vdout0_27ck1100 FIND v(dout0_27) AT=555.025n

.meas tran vdout0_28ck1100 FIND v(dout0_28) AT=555.025n

.meas tran vdout0_29ck1100 FIND v(dout0_29) AT=555.025n

.meas tran vdout0_30ck1100 FIND v(dout0_30) AT=555.025n

.meas tran vdout0_31ck1100 FIND v(dout0_31) AT=555.025n

.meas tran vdout0_32ck1100 FIND v(dout0_32) AT=555.025n

.meas tran vdout0_33ck1100 FIND v(dout0_33) AT=555.025n

.meas tran vdout0_34ck1100 FIND v(dout0_34) AT=555.025n

.meas tran vdout0_35ck1100 FIND v(dout0_35) AT=555.025n

.meas tran vdout0_36ck1100 FIND v(dout0_36) AT=555.025n

.meas tran vdout0_37ck1100 FIND v(dout0_37) AT=555.025n

.meas tran vdout0_38ck1100 FIND v(dout0_38) AT=555.025n

.meas tran vdout0_39ck1100 FIND v(dout0_39) AT=555.025n

.meas tran vdout0_40ck1100 FIND v(dout0_40) AT=555.025n

.meas tran vdout0_41ck1100 FIND v(dout0_41) AT=555.025n

.meas tran vdout0_42ck1100 FIND v(dout0_42) AT=555.025n

.meas tran vdout0_43ck1100 FIND v(dout0_43) AT=555.025n

.meas tran vdout0_44ck1100 FIND v(dout0_44) AT=555.025n

.meas tran vdout0_45ck1100 FIND v(dout0_45) AT=555.025n

.meas tran vdout0_46ck1100 FIND v(dout0_46) AT=555.025n

.meas tran vdout0_47ck1100 FIND v(dout0_47) AT=555.025n

.meas tran vdout0_48ck1100 FIND v(dout0_48) AT=555.025n

.meas tran vdout0_49ck1100 FIND v(dout0_49) AT=555.025n

.meas tran vdout0_50ck1100 FIND v(dout0_50) AT=555.025n

.meas tran vdout0_51ck1100 FIND v(dout0_51) AT=555.025n

.meas tran vdout0_52ck1100 FIND v(dout0_52) AT=555.025n

.meas tran vdout0_53ck1100 FIND v(dout0_53) AT=555.025n

.meas tran vdout0_54ck1100 FIND v(dout0_54) AT=555.025n

.meas tran vdout0_55ck1100 FIND v(dout0_55) AT=555.025n

.meas tran vdout0_56ck1100 FIND v(dout0_56) AT=555.025n

.meas tran vdout0_57ck1100 FIND v(dout0_57) AT=555.025n

.meas tran vdout0_58ck1100 FIND v(dout0_58) AT=555.025n

.meas tran vdout0_59ck1100 FIND v(dout0_59) AT=555.025n

.meas tran vdout0_60ck1100 FIND v(dout0_60) AT=555.025n

.meas tran vdout0_61ck1100 FIND v(dout0_61) AT=555.025n

.meas tran vdout0_62ck1100 FIND v(dout0_62) AT=555.025n

.meas tran vdout0_63ck1100 FIND v(dout0_63) AT=555.025n

.meas tran vdout0_0ck1110 FIND v(dout0_0) AT=560.025n

.meas tran vdout0_1ck1110 FIND v(dout0_1) AT=560.025n

.meas tran vdout0_2ck1110 FIND v(dout0_2) AT=560.025n

.meas tran vdout0_3ck1110 FIND v(dout0_3) AT=560.025n

.meas tran vdout0_4ck1110 FIND v(dout0_4) AT=560.025n

.meas tran vdout0_5ck1110 FIND v(dout0_5) AT=560.025n

.meas tran vdout0_6ck1110 FIND v(dout0_6) AT=560.025n

.meas tran vdout0_7ck1110 FIND v(dout0_7) AT=560.025n

.meas tran vdout0_8ck1110 FIND v(dout0_8) AT=560.025n

.meas tran vdout0_9ck1110 FIND v(dout0_9) AT=560.025n

.meas tran vdout0_10ck1110 FIND v(dout0_10) AT=560.025n

.meas tran vdout0_11ck1110 FIND v(dout0_11) AT=560.025n

.meas tran vdout0_12ck1110 FIND v(dout0_12) AT=560.025n

.meas tran vdout0_13ck1110 FIND v(dout0_13) AT=560.025n

.meas tran vdout0_14ck1110 FIND v(dout0_14) AT=560.025n

.meas tran vdout0_15ck1110 FIND v(dout0_15) AT=560.025n

.meas tran vdout0_16ck1110 FIND v(dout0_16) AT=560.025n

.meas tran vdout0_17ck1110 FIND v(dout0_17) AT=560.025n

.meas tran vdout0_18ck1110 FIND v(dout0_18) AT=560.025n

.meas tran vdout0_19ck1110 FIND v(dout0_19) AT=560.025n

.meas tran vdout0_20ck1110 FIND v(dout0_20) AT=560.025n

.meas tran vdout0_21ck1110 FIND v(dout0_21) AT=560.025n

.meas tran vdout0_22ck1110 FIND v(dout0_22) AT=560.025n

.meas tran vdout0_23ck1110 FIND v(dout0_23) AT=560.025n

.meas tran vdout0_24ck1110 FIND v(dout0_24) AT=560.025n

.meas tran vdout0_25ck1110 FIND v(dout0_25) AT=560.025n

.meas tran vdout0_26ck1110 FIND v(dout0_26) AT=560.025n

.meas tran vdout0_27ck1110 FIND v(dout0_27) AT=560.025n

.meas tran vdout0_28ck1110 FIND v(dout0_28) AT=560.025n

.meas tran vdout0_29ck1110 FIND v(dout0_29) AT=560.025n

.meas tran vdout0_30ck1110 FIND v(dout0_30) AT=560.025n

.meas tran vdout0_31ck1110 FIND v(dout0_31) AT=560.025n

.meas tran vdout0_32ck1110 FIND v(dout0_32) AT=560.025n

.meas tran vdout0_33ck1110 FIND v(dout0_33) AT=560.025n

.meas tran vdout0_34ck1110 FIND v(dout0_34) AT=560.025n

.meas tran vdout0_35ck1110 FIND v(dout0_35) AT=560.025n

.meas tran vdout0_36ck1110 FIND v(dout0_36) AT=560.025n

.meas tran vdout0_37ck1110 FIND v(dout0_37) AT=560.025n

.meas tran vdout0_38ck1110 FIND v(dout0_38) AT=560.025n

.meas tran vdout0_39ck1110 FIND v(dout0_39) AT=560.025n

.meas tran vdout0_40ck1110 FIND v(dout0_40) AT=560.025n

.meas tran vdout0_41ck1110 FIND v(dout0_41) AT=560.025n

.meas tran vdout0_42ck1110 FIND v(dout0_42) AT=560.025n

.meas tran vdout0_43ck1110 FIND v(dout0_43) AT=560.025n

.meas tran vdout0_44ck1110 FIND v(dout0_44) AT=560.025n

.meas tran vdout0_45ck1110 FIND v(dout0_45) AT=560.025n

.meas tran vdout0_46ck1110 FIND v(dout0_46) AT=560.025n

.meas tran vdout0_47ck1110 FIND v(dout0_47) AT=560.025n

.meas tran vdout0_48ck1110 FIND v(dout0_48) AT=560.025n

.meas tran vdout0_49ck1110 FIND v(dout0_49) AT=560.025n

.meas tran vdout0_50ck1110 FIND v(dout0_50) AT=560.025n

.meas tran vdout0_51ck1110 FIND v(dout0_51) AT=560.025n

.meas tran vdout0_52ck1110 FIND v(dout0_52) AT=560.025n

.meas tran vdout0_53ck1110 FIND v(dout0_53) AT=560.025n

.meas tran vdout0_54ck1110 FIND v(dout0_54) AT=560.025n

.meas tran vdout0_55ck1110 FIND v(dout0_55) AT=560.025n

.meas tran vdout0_56ck1110 FIND v(dout0_56) AT=560.025n

.meas tran vdout0_57ck1110 FIND v(dout0_57) AT=560.025n

.meas tran vdout0_58ck1110 FIND v(dout0_58) AT=560.025n

.meas tran vdout0_59ck1110 FIND v(dout0_59) AT=560.025n

.meas tran vdout0_60ck1110 FIND v(dout0_60) AT=560.025n

.meas tran vdout0_61ck1110 FIND v(dout0_61) AT=560.025n

.meas tran vdout0_62ck1110 FIND v(dout0_62) AT=560.025n

.meas tran vdout0_63ck1110 FIND v(dout0_63) AT=560.025n

.meas tran vdout0_0ck1200 FIND v(dout0_0) AT=605.025n

.meas tran vdout0_1ck1200 FIND v(dout0_1) AT=605.025n

.meas tran vdout0_2ck1200 FIND v(dout0_2) AT=605.025n

.meas tran vdout0_3ck1200 FIND v(dout0_3) AT=605.025n

.meas tran vdout0_4ck1200 FIND v(dout0_4) AT=605.025n

.meas tran vdout0_5ck1200 FIND v(dout0_5) AT=605.025n

.meas tran vdout0_6ck1200 FIND v(dout0_6) AT=605.025n

.meas tran vdout0_7ck1200 FIND v(dout0_7) AT=605.025n

.meas tran vdout0_8ck1200 FIND v(dout0_8) AT=605.025n

.meas tran vdout0_9ck1200 FIND v(dout0_9) AT=605.025n

.meas tran vdout0_10ck1200 FIND v(dout0_10) AT=605.025n

.meas tran vdout0_11ck1200 FIND v(dout0_11) AT=605.025n

.meas tran vdout0_12ck1200 FIND v(dout0_12) AT=605.025n

.meas tran vdout0_13ck1200 FIND v(dout0_13) AT=605.025n

.meas tran vdout0_14ck1200 FIND v(dout0_14) AT=605.025n

.meas tran vdout0_15ck1200 FIND v(dout0_15) AT=605.025n

.meas tran vdout0_16ck1200 FIND v(dout0_16) AT=605.025n

.meas tran vdout0_17ck1200 FIND v(dout0_17) AT=605.025n

.meas tran vdout0_18ck1200 FIND v(dout0_18) AT=605.025n

.meas tran vdout0_19ck1200 FIND v(dout0_19) AT=605.025n

.meas tran vdout0_20ck1200 FIND v(dout0_20) AT=605.025n

.meas tran vdout0_21ck1200 FIND v(dout0_21) AT=605.025n

.meas tran vdout0_22ck1200 FIND v(dout0_22) AT=605.025n

.meas tran vdout0_23ck1200 FIND v(dout0_23) AT=605.025n

.meas tran vdout0_24ck1200 FIND v(dout0_24) AT=605.025n

.meas tran vdout0_25ck1200 FIND v(dout0_25) AT=605.025n

.meas tran vdout0_26ck1200 FIND v(dout0_26) AT=605.025n

.meas tran vdout0_27ck1200 FIND v(dout0_27) AT=605.025n

.meas tran vdout0_28ck1200 FIND v(dout0_28) AT=605.025n

.meas tran vdout0_29ck1200 FIND v(dout0_29) AT=605.025n

.meas tran vdout0_30ck1200 FIND v(dout0_30) AT=605.025n

.meas tran vdout0_31ck1200 FIND v(dout0_31) AT=605.025n

.meas tran vdout0_32ck1200 FIND v(dout0_32) AT=605.025n

.meas tran vdout0_33ck1200 FIND v(dout0_33) AT=605.025n

.meas tran vdout0_34ck1200 FIND v(dout0_34) AT=605.025n

.meas tran vdout0_35ck1200 FIND v(dout0_35) AT=605.025n

.meas tran vdout0_36ck1200 FIND v(dout0_36) AT=605.025n

.meas tran vdout0_37ck1200 FIND v(dout0_37) AT=605.025n

.meas tran vdout0_38ck1200 FIND v(dout0_38) AT=605.025n

.meas tran vdout0_39ck1200 FIND v(dout0_39) AT=605.025n

.meas tran vdout0_40ck1200 FIND v(dout0_40) AT=605.025n

.meas tran vdout0_41ck1200 FIND v(dout0_41) AT=605.025n

.meas tran vdout0_42ck1200 FIND v(dout0_42) AT=605.025n

.meas tran vdout0_43ck1200 FIND v(dout0_43) AT=605.025n

.meas tran vdout0_44ck1200 FIND v(dout0_44) AT=605.025n

.meas tran vdout0_45ck1200 FIND v(dout0_45) AT=605.025n

.meas tran vdout0_46ck1200 FIND v(dout0_46) AT=605.025n

.meas tran vdout0_47ck1200 FIND v(dout0_47) AT=605.025n

.meas tran vdout0_48ck1200 FIND v(dout0_48) AT=605.025n

.meas tran vdout0_49ck1200 FIND v(dout0_49) AT=605.025n

.meas tran vdout0_50ck1200 FIND v(dout0_50) AT=605.025n

.meas tran vdout0_51ck1200 FIND v(dout0_51) AT=605.025n

.meas tran vdout0_52ck1200 FIND v(dout0_52) AT=605.025n

.meas tran vdout0_53ck1200 FIND v(dout0_53) AT=605.025n

.meas tran vdout0_54ck1200 FIND v(dout0_54) AT=605.025n

.meas tran vdout0_55ck1200 FIND v(dout0_55) AT=605.025n

.meas tran vdout0_56ck1200 FIND v(dout0_56) AT=605.025n

.meas tran vdout0_57ck1200 FIND v(dout0_57) AT=605.025n

.meas tran vdout0_58ck1200 FIND v(dout0_58) AT=605.025n

.meas tran vdout0_59ck1200 FIND v(dout0_59) AT=605.025n

.meas tran vdout0_60ck1200 FIND v(dout0_60) AT=605.025n

.meas tran vdout0_61ck1200 FIND v(dout0_61) AT=605.025n

.meas tran vdout0_62ck1200 FIND v(dout0_62) AT=605.025n

.meas tran vdout0_63ck1200 FIND v(dout0_63) AT=605.025n

.meas tran vdout0_0ck1230 FIND v(dout0_0) AT=620.025n

.meas tran vdout0_1ck1230 FIND v(dout0_1) AT=620.025n

.meas tran vdout0_2ck1230 FIND v(dout0_2) AT=620.025n

.meas tran vdout0_3ck1230 FIND v(dout0_3) AT=620.025n

.meas tran vdout0_4ck1230 FIND v(dout0_4) AT=620.025n

.meas tran vdout0_5ck1230 FIND v(dout0_5) AT=620.025n

.meas tran vdout0_6ck1230 FIND v(dout0_6) AT=620.025n

.meas tran vdout0_7ck1230 FIND v(dout0_7) AT=620.025n

.meas tran vdout0_8ck1230 FIND v(dout0_8) AT=620.025n

.meas tran vdout0_9ck1230 FIND v(dout0_9) AT=620.025n

.meas tran vdout0_10ck1230 FIND v(dout0_10) AT=620.025n

.meas tran vdout0_11ck1230 FIND v(dout0_11) AT=620.025n

.meas tran vdout0_12ck1230 FIND v(dout0_12) AT=620.025n

.meas tran vdout0_13ck1230 FIND v(dout0_13) AT=620.025n

.meas tran vdout0_14ck1230 FIND v(dout0_14) AT=620.025n

.meas tran vdout0_15ck1230 FIND v(dout0_15) AT=620.025n

.meas tran vdout0_16ck1230 FIND v(dout0_16) AT=620.025n

.meas tran vdout0_17ck1230 FIND v(dout0_17) AT=620.025n

.meas tran vdout0_18ck1230 FIND v(dout0_18) AT=620.025n

.meas tran vdout0_19ck1230 FIND v(dout0_19) AT=620.025n

.meas tran vdout0_20ck1230 FIND v(dout0_20) AT=620.025n

.meas tran vdout0_21ck1230 FIND v(dout0_21) AT=620.025n

.meas tran vdout0_22ck1230 FIND v(dout0_22) AT=620.025n

.meas tran vdout0_23ck1230 FIND v(dout0_23) AT=620.025n

.meas tran vdout0_24ck1230 FIND v(dout0_24) AT=620.025n

.meas tran vdout0_25ck1230 FIND v(dout0_25) AT=620.025n

.meas tran vdout0_26ck1230 FIND v(dout0_26) AT=620.025n

.meas tran vdout0_27ck1230 FIND v(dout0_27) AT=620.025n

.meas tran vdout0_28ck1230 FIND v(dout0_28) AT=620.025n

.meas tran vdout0_29ck1230 FIND v(dout0_29) AT=620.025n

.meas tran vdout0_30ck1230 FIND v(dout0_30) AT=620.025n

.meas tran vdout0_31ck1230 FIND v(dout0_31) AT=620.025n

.meas tran vdout0_32ck1230 FIND v(dout0_32) AT=620.025n

.meas tran vdout0_33ck1230 FIND v(dout0_33) AT=620.025n

.meas tran vdout0_34ck1230 FIND v(dout0_34) AT=620.025n

.meas tran vdout0_35ck1230 FIND v(dout0_35) AT=620.025n

.meas tran vdout0_36ck1230 FIND v(dout0_36) AT=620.025n

.meas tran vdout0_37ck1230 FIND v(dout0_37) AT=620.025n

.meas tran vdout0_38ck1230 FIND v(dout0_38) AT=620.025n

.meas tran vdout0_39ck1230 FIND v(dout0_39) AT=620.025n

.meas tran vdout0_40ck1230 FIND v(dout0_40) AT=620.025n

.meas tran vdout0_41ck1230 FIND v(dout0_41) AT=620.025n

.meas tran vdout0_42ck1230 FIND v(dout0_42) AT=620.025n

.meas tran vdout0_43ck1230 FIND v(dout0_43) AT=620.025n

.meas tran vdout0_44ck1230 FIND v(dout0_44) AT=620.025n

.meas tran vdout0_45ck1230 FIND v(dout0_45) AT=620.025n

.meas tran vdout0_46ck1230 FIND v(dout0_46) AT=620.025n

.meas tran vdout0_47ck1230 FIND v(dout0_47) AT=620.025n

.meas tran vdout0_48ck1230 FIND v(dout0_48) AT=620.025n

.meas tran vdout0_49ck1230 FIND v(dout0_49) AT=620.025n

.meas tran vdout0_50ck1230 FIND v(dout0_50) AT=620.025n

.meas tran vdout0_51ck1230 FIND v(dout0_51) AT=620.025n

.meas tran vdout0_52ck1230 FIND v(dout0_52) AT=620.025n

.meas tran vdout0_53ck1230 FIND v(dout0_53) AT=620.025n

.meas tran vdout0_54ck1230 FIND v(dout0_54) AT=620.025n

.meas tran vdout0_55ck1230 FIND v(dout0_55) AT=620.025n

.meas tran vdout0_56ck1230 FIND v(dout0_56) AT=620.025n

.meas tran vdout0_57ck1230 FIND v(dout0_57) AT=620.025n

.meas tran vdout0_58ck1230 FIND v(dout0_58) AT=620.025n

.meas tran vdout0_59ck1230 FIND v(dout0_59) AT=620.025n

.meas tran vdout0_60ck1230 FIND v(dout0_60) AT=620.025n

.meas tran vdout0_61ck1230 FIND v(dout0_61) AT=620.025n

.meas tran vdout0_62ck1230 FIND v(dout0_62) AT=620.025n

.meas tran vdout0_63ck1230 FIND v(dout0_63) AT=620.025n

.meas tran vdout0_0ck1240 FIND v(dout0_0) AT=625.025n

.meas tran vdout0_1ck1240 FIND v(dout0_1) AT=625.025n

.meas tran vdout0_2ck1240 FIND v(dout0_2) AT=625.025n

.meas tran vdout0_3ck1240 FIND v(dout0_3) AT=625.025n

.meas tran vdout0_4ck1240 FIND v(dout0_4) AT=625.025n

.meas tran vdout0_5ck1240 FIND v(dout0_5) AT=625.025n

.meas tran vdout0_6ck1240 FIND v(dout0_6) AT=625.025n

.meas tran vdout0_7ck1240 FIND v(dout0_7) AT=625.025n

.meas tran vdout0_8ck1240 FIND v(dout0_8) AT=625.025n

.meas tran vdout0_9ck1240 FIND v(dout0_9) AT=625.025n

.meas tran vdout0_10ck1240 FIND v(dout0_10) AT=625.025n

.meas tran vdout0_11ck1240 FIND v(dout0_11) AT=625.025n

.meas tran vdout0_12ck1240 FIND v(dout0_12) AT=625.025n

.meas tran vdout0_13ck1240 FIND v(dout0_13) AT=625.025n

.meas tran vdout0_14ck1240 FIND v(dout0_14) AT=625.025n

.meas tran vdout0_15ck1240 FIND v(dout0_15) AT=625.025n

.meas tran vdout0_16ck1240 FIND v(dout0_16) AT=625.025n

.meas tran vdout0_17ck1240 FIND v(dout0_17) AT=625.025n

.meas tran vdout0_18ck1240 FIND v(dout0_18) AT=625.025n

.meas tran vdout0_19ck1240 FIND v(dout0_19) AT=625.025n

.meas tran vdout0_20ck1240 FIND v(dout0_20) AT=625.025n

.meas tran vdout0_21ck1240 FIND v(dout0_21) AT=625.025n

.meas tran vdout0_22ck1240 FIND v(dout0_22) AT=625.025n

.meas tran vdout0_23ck1240 FIND v(dout0_23) AT=625.025n

.meas tran vdout0_24ck1240 FIND v(dout0_24) AT=625.025n

.meas tran vdout0_25ck1240 FIND v(dout0_25) AT=625.025n

.meas tran vdout0_26ck1240 FIND v(dout0_26) AT=625.025n

.meas tran vdout0_27ck1240 FIND v(dout0_27) AT=625.025n

.meas tran vdout0_28ck1240 FIND v(dout0_28) AT=625.025n

.meas tran vdout0_29ck1240 FIND v(dout0_29) AT=625.025n

.meas tran vdout0_30ck1240 FIND v(dout0_30) AT=625.025n

.meas tran vdout0_31ck1240 FIND v(dout0_31) AT=625.025n

.meas tran vdout0_32ck1240 FIND v(dout0_32) AT=625.025n

.meas tran vdout0_33ck1240 FIND v(dout0_33) AT=625.025n

.meas tran vdout0_34ck1240 FIND v(dout0_34) AT=625.025n

.meas tran vdout0_35ck1240 FIND v(dout0_35) AT=625.025n

.meas tran vdout0_36ck1240 FIND v(dout0_36) AT=625.025n

.meas tran vdout0_37ck1240 FIND v(dout0_37) AT=625.025n

.meas tran vdout0_38ck1240 FIND v(dout0_38) AT=625.025n

.meas tran vdout0_39ck1240 FIND v(dout0_39) AT=625.025n

.meas tran vdout0_40ck1240 FIND v(dout0_40) AT=625.025n

.meas tran vdout0_41ck1240 FIND v(dout0_41) AT=625.025n

.meas tran vdout0_42ck1240 FIND v(dout0_42) AT=625.025n

.meas tran vdout0_43ck1240 FIND v(dout0_43) AT=625.025n

.meas tran vdout0_44ck1240 FIND v(dout0_44) AT=625.025n

.meas tran vdout0_45ck1240 FIND v(dout0_45) AT=625.025n

.meas tran vdout0_46ck1240 FIND v(dout0_46) AT=625.025n

.meas tran vdout0_47ck1240 FIND v(dout0_47) AT=625.025n

.meas tran vdout0_48ck1240 FIND v(dout0_48) AT=625.025n

.meas tran vdout0_49ck1240 FIND v(dout0_49) AT=625.025n

.meas tran vdout0_50ck1240 FIND v(dout0_50) AT=625.025n

.meas tran vdout0_51ck1240 FIND v(dout0_51) AT=625.025n

.meas tran vdout0_52ck1240 FIND v(dout0_52) AT=625.025n

.meas tran vdout0_53ck1240 FIND v(dout0_53) AT=625.025n

.meas tran vdout0_54ck1240 FIND v(dout0_54) AT=625.025n

.meas tran vdout0_55ck1240 FIND v(dout0_55) AT=625.025n

.meas tran vdout0_56ck1240 FIND v(dout0_56) AT=625.025n

.meas tran vdout0_57ck1240 FIND v(dout0_57) AT=625.025n

.meas tran vdout0_58ck1240 FIND v(dout0_58) AT=625.025n

.meas tran vdout0_59ck1240 FIND v(dout0_59) AT=625.025n

.meas tran vdout0_60ck1240 FIND v(dout0_60) AT=625.025n

.meas tran vdout0_61ck1240 FIND v(dout0_61) AT=625.025n

.meas tran vdout0_62ck1240 FIND v(dout0_62) AT=625.025n

.meas tran vdout0_63ck1240 FIND v(dout0_63) AT=625.025n

.meas tran vdout0_0ck1250 FIND v(dout0_0) AT=630.025n

.meas tran vdout0_1ck1250 FIND v(dout0_1) AT=630.025n

.meas tran vdout0_2ck1250 FIND v(dout0_2) AT=630.025n

.meas tran vdout0_3ck1250 FIND v(dout0_3) AT=630.025n

.meas tran vdout0_4ck1250 FIND v(dout0_4) AT=630.025n

.meas tran vdout0_5ck1250 FIND v(dout0_5) AT=630.025n

.meas tran vdout0_6ck1250 FIND v(dout0_6) AT=630.025n

.meas tran vdout0_7ck1250 FIND v(dout0_7) AT=630.025n

.meas tran vdout0_8ck1250 FIND v(dout0_8) AT=630.025n

.meas tran vdout0_9ck1250 FIND v(dout0_9) AT=630.025n

.meas tran vdout0_10ck1250 FIND v(dout0_10) AT=630.025n

.meas tran vdout0_11ck1250 FIND v(dout0_11) AT=630.025n

.meas tran vdout0_12ck1250 FIND v(dout0_12) AT=630.025n

.meas tran vdout0_13ck1250 FIND v(dout0_13) AT=630.025n

.meas tran vdout0_14ck1250 FIND v(dout0_14) AT=630.025n

.meas tran vdout0_15ck1250 FIND v(dout0_15) AT=630.025n

.meas tran vdout0_16ck1250 FIND v(dout0_16) AT=630.025n

.meas tran vdout0_17ck1250 FIND v(dout0_17) AT=630.025n

.meas tran vdout0_18ck1250 FIND v(dout0_18) AT=630.025n

.meas tran vdout0_19ck1250 FIND v(dout0_19) AT=630.025n

.meas tran vdout0_20ck1250 FIND v(dout0_20) AT=630.025n

.meas tran vdout0_21ck1250 FIND v(dout0_21) AT=630.025n

.meas tran vdout0_22ck1250 FIND v(dout0_22) AT=630.025n

.meas tran vdout0_23ck1250 FIND v(dout0_23) AT=630.025n

.meas tran vdout0_24ck1250 FIND v(dout0_24) AT=630.025n

.meas tran vdout0_25ck1250 FIND v(dout0_25) AT=630.025n

.meas tran vdout0_26ck1250 FIND v(dout0_26) AT=630.025n

.meas tran vdout0_27ck1250 FIND v(dout0_27) AT=630.025n

.meas tran vdout0_28ck1250 FIND v(dout0_28) AT=630.025n

.meas tran vdout0_29ck1250 FIND v(dout0_29) AT=630.025n

.meas tran vdout0_30ck1250 FIND v(dout0_30) AT=630.025n

.meas tran vdout0_31ck1250 FIND v(dout0_31) AT=630.025n

.meas tran vdout0_32ck1250 FIND v(dout0_32) AT=630.025n

.meas tran vdout0_33ck1250 FIND v(dout0_33) AT=630.025n

.meas tran vdout0_34ck1250 FIND v(dout0_34) AT=630.025n

.meas tran vdout0_35ck1250 FIND v(dout0_35) AT=630.025n

.meas tran vdout0_36ck1250 FIND v(dout0_36) AT=630.025n

.meas tran vdout0_37ck1250 FIND v(dout0_37) AT=630.025n

.meas tran vdout0_38ck1250 FIND v(dout0_38) AT=630.025n

.meas tran vdout0_39ck1250 FIND v(dout0_39) AT=630.025n

.meas tran vdout0_40ck1250 FIND v(dout0_40) AT=630.025n

.meas tran vdout0_41ck1250 FIND v(dout0_41) AT=630.025n

.meas tran vdout0_42ck1250 FIND v(dout0_42) AT=630.025n

.meas tran vdout0_43ck1250 FIND v(dout0_43) AT=630.025n

.meas tran vdout0_44ck1250 FIND v(dout0_44) AT=630.025n

.meas tran vdout0_45ck1250 FIND v(dout0_45) AT=630.025n

.meas tran vdout0_46ck1250 FIND v(dout0_46) AT=630.025n

.meas tran vdout0_47ck1250 FIND v(dout0_47) AT=630.025n

.meas tran vdout0_48ck1250 FIND v(dout0_48) AT=630.025n

.meas tran vdout0_49ck1250 FIND v(dout0_49) AT=630.025n

.meas tran vdout0_50ck1250 FIND v(dout0_50) AT=630.025n

.meas tran vdout0_51ck1250 FIND v(dout0_51) AT=630.025n

.meas tran vdout0_52ck1250 FIND v(dout0_52) AT=630.025n

.meas tran vdout0_53ck1250 FIND v(dout0_53) AT=630.025n

.meas tran vdout0_54ck1250 FIND v(dout0_54) AT=630.025n

.meas tran vdout0_55ck1250 FIND v(dout0_55) AT=630.025n

.meas tran vdout0_56ck1250 FIND v(dout0_56) AT=630.025n

.meas tran vdout0_57ck1250 FIND v(dout0_57) AT=630.025n

.meas tran vdout0_58ck1250 FIND v(dout0_58) AT=630.025n

.meas tran vdout0_59ck1250 FIND v(dout0_59) AT=630.025n

.meas tran vdout0_60ck1250 FIND v(dout0_60) AT=630.025n

.meas tran vdout0_61ck1250 FIND v(dout0_61) AT=630.025n

.meas tran vdout0_62ck1250 FIND v(dout0_62) AT=630.025n

.meas tran vdout0_63ck1250 FIND v(dout0_63) AT=630.025n

.meas tran vdout0_0ck1270 FIND v(dout0_0) AT=640.025n

.meas tran vdout0_1ck1270 FIND v(dout0_1) AT=640.025n

.meas tran vdout0_2ck1270 FIND v(dout0_2) AT=640.025n

.meas tran vdout0_3ck1270 FIND v(dout0_3) AT=640.025n

.meas tran vdout0_4ck1270 FIND v(dout0_4) AT=640.025n

.meas tran vdout0_5ck1270 FIND v(dout0_5) AT=640.025n

.meas tran vdout0_6ck1270 FIND v(dout0_6) AT=640.025n

.meas tran vdout0_7ck1270 FIND v(dout0_7) AT=640.025n

.meas tran vdout0_8ck1270 FIND v(dout0_8) AT=640.025n

.meas tran vdout0_9ck1270 FIND v(dout0_9) AT=640.025n

.meas tran vdout0_10ck1270 FIND v(dout0_10) AT=640.025n

.meas tran vdout0_11ck1270 FIND v(dout0_11) AT=640.025n

.meas tran vdout0_12ck1270 FIND v(dout0_12) AT=640.025n

.meas tran vdout0_13ck1270 FIND v(dout0_13) AT=640.025n

.meas tran vdout0_14ck1270 FIND v(dout0_14) AT=640.025n

.meas tran vdout0_15ck1270 FIND v(dout0_15) AT=640.025n

.meas tran vdout0_16ck1270 FIND v(dout0_16) AT=640.025n

.meas tran vdout0_17ck1270 FIND v(dout0_17) AT=640.025n

.meas tran vdout0_18ck1270 FIND v(dout0_18) AT=640.025n

.meas tran vdout0_19ck1270 FIND v(dout0_19) AT=640.025n

.meas tran vdout0_20ck1270 FIND v(dout0_20) AT=640.025n

.meas tran vdout0_21ck1270 FIND v(dout0_21) AT=640.025n

.meas tran vdout0_22ck1270 FIND v(dout0_22) AT=640.025n

.meas tran vdout0_23ck1270 FIND v(dout0_23) AT=640.025n

.meas tran vdout0_24ck1270 FIND v(dout0_24) AT=640.025n

.meas tran vdout0_25ck1270 FIND v(dout0_25) AT=640.025n

.meas tran vdout0_26ck1270 FIND v(dout0_26) AT=640.025n

.meas tran vdout0_27ck1270 FIND v(dout0_27) AT=640.025n

.meas tran vdout0_28ck1270 FIND v(dout0_28) AT=640.025n

.meas tran vdout0_29ck1270 FIND v(dout0_29) AT=640.025n

.meas tran vdout0_30ck1270 FIND v(dout0_30) AT=640.025n

.meas tran vdout0_31ck1270 FIND v(dout0_31) AT=640.025n

.meas tran vdout0_32ck1270 FIND v(dout0_32) AT=640.025n

.meas tran vdout0_33ck1270 FIND v(dout0_33) AT=640.025n

.meas tran vdout0_34ck1270 FIND v(dout0_34) AT=640.025n

.meas tran vdout0_35ck1270 FIND v(dout0_35) AT=640.025n

.meas tran vdout0_36ck1270 FIND v(dout0_36) AT=640.025n

.meas tran vdout0_37ck1270 FIND v(dout0_37) AT=640.025n

.meas tran vdout0_38ck1270 FIND v(dout0_38) AT=640.025n

.meas tran vdout0_39ck1270 FIND v(dout0_39) AT=640.025n

.meas tran vdout0_40ck1270 FIND v(dout0_40) AT=640.025n

.meas tran vdout0_41ck1270 FIND v(dout0_41) AT=640.025n

.meas tran vdout0_42ck1270 FIND v(dout0_42) AT=640.025n

.meas tran vdout0_43ck1270 FIND v(dout0_43) AT=640.025n

.meas tran vdout0_44ck1270 FIND v(dout0_44) AT=640.025n

.meas tran vdout0_45ck1270 FIND v(dout0_45) AT=640.025n

.meas tran vdout0_46ck1270 FIND v(dout0_46) AT=640.025n

.meas tran vdout0_47ck1270 FIND v(dout0_47) AT=640.025n

.meas tran vdout0_48ck1270 FIND v(dout0_48) AT=640.025n

.meas tran vdout0_49ck1270 FIND v(dout0_49) AT=640.025n

.meas tran vdout0_50ck1270 FIND v(dout0_50) AT=640.025n

.meas tran vdout0_51ck1270 FIND v(dout0_51) AT=640.025n

.meas tran vdout0_52ck1270 FIND v(dout0_52) AT=640.025n

.meas tran vdout0_53ck1270 FIND v(dout0_53) AT=640.025n

.meas tran vdout0_54ck1270 FIND v(dout0_54) AT=640.025n

.meas tran vdout0_55ck1270 FIND v(dout0_55) AT=640.025n

.meas tran vdout0_56ck1270 FIND v(dout0_56) AT=640.025n

.meas tran vdout0_57ck1270 FIND v(dout0_57) AT=640.025n

.meas tran vdout0_58ck1270 FIND v(dout0_58) AT=640.025n

.meas tran vdout0_59ck1270 FIND v(dout0_59) AT=640.025n

.meas tran vdout0_60ck1270 FIND v(dout0_60) AT=640.025n

.meas tran vdout0_61ck1270 FIND v(dout0_61) AT=640.025n

.meas tran vdout0_62ck1270 FIND v(dout0_62) AT=640.025n

.meas tran vdout0_63ck1270 FIND v(dout0_63) AT=640.025n

.meas tran vdout0_0ck1320 FIND v(dout0_0) AT=665.025n

.meas tran vdout0_1ck1320 FIND v(dout0_1) AT=665.025n

.meas tran vdout0_2ck1320 FIND v(dout0_2) AT=665.025n

.meas tran vdout0_3ck1320 FIND v(dout0_3) AT=665.025n

.meas tran vdout0_4ck1320 FIND v(dout0_4) AT=665.025n

.meas tran vdout0_5ck1320 FIND v(dout0_5) AT=665.025n

.meas tran vdout0_6ck1320 FIND v(dout0_6) AT=665.025n

.meas tran vdout0_7ck1320 FIND v(dout0_7) AT=665.025n

.meas tran vdout0_8ck1320 FIND v(dout0_8) AT=665.025n

.meas tran vdout0_9ck1320 FIND v(dout0_9) AT=665.025n

.meas tran vdout0_10ck1320 FIND v(dout0_10) AT=665.025n

.meas tran vdout0_11ck1320 FIND v(dout0_11) AT=665.025n

.meas tran vdout0_12ck1320 FIND v(dout0_12) AT=665.025n

.meas tran vdout0_13ck1320 FIND v(dout0_13) AT=665.025n

.meas tran vdout0_14ck1320 FIND v(dout0_14) AT=665.025n

.meas tran vdout0_15ck1320 FIND v(dout0_15) AT=665.025n

.meas tran vdout0_16ck1320 FIND v(dout0_16) AT=665.025n

.meas tran vdout0_17ck1320 FIND v(dout0_17) AT=665.025n

.meas tran vdout0_18ck1320 FIND v(dout0_18) AT=665.025n

.meas tran vdout0_19ck1320 FIND v(dout0_19) AT=665.025n

.meas tran vdout0_20ck1320 FIND v(dout0_20) AT=665.025n

.meas tran vdout0_21ck1320 FIND v(dout0_21) AT=665.025n

.meas tran vdout0_22ck1320 FIND v(dout0_22) AT=665.025n

.meas tran vdout0_23ck1320 FIND v(dout0_23) AT=665.025n

.meas tran vdout0_24ck1320 FIND v(dout0_24) AT=665.025n

.meas tran vdout0_25ck1320 FIND v(dout0_25) AT=665.025n

.meas tran vdout0_26ck1320 FIND v(dout0_26) AT=665.025n

.meas tran vdout0_27ck1320 FIND v(dout0_27) AT=665.025n

.meas tran vdout0_28ck1320 FIND v(dout0_28) AT=665.025n

.meas tran vdout0_29ck1320 FIND v(dout0_29) AT=665.025n

.meas tran vdout0_30ck1320 FIND v(dout0_30) AT=665.025n

.meas tran vdout0_31ck1320 FIND v(dout0_31) AT=665.025n

.meas tran vdout0_32ck1320 FIND v(dout0_32) AT=665.025n

.meas tran vdout0_33ck1320 FIND v(dout0_33) AT=665.025n

.meas tran vdout0_34ck1320 FIND v(dout0_34) AT=665.025n

.meas tran vdout0_35ck1320 FIND v(dout0_35) AT=665.025n

.meas tran vdout0_36ck1320 FIND v(dout0_36) AT=665.025n

.meas tran vdout0_37ck1320 FIND v(dout0_37) AT=665.025n

.meas tran vdout0_38ck1320 FIND v(dout0_38) AT=665.025n

.meas tran vdout0_39ck1320 FIND v(dout0_39) AT=665.025n

.meas tran vdout0_40ck1320 FIND v(dout0_40) AT=665.025n

.meas tran vdout0_41ck1320 FIND v(dout0_41) AT=665.025n

.meas tran vdout0_42ck1320 FIND v(dout0_42) AT=665.025n

.meas tran vdout0_43ck1320 FIND v(dout0_43) AT=665.025n

.meas tran vdout0_44ck1320 FIND v(dout0_44) AT=665.025n

.meas tran vdout0_45ck1320 FIND v(dout0_45) AT=665.025n

.meas tran vdout0_46ck1320 FIND v(dout0_46) AT=665.025n

.meas tran vdout0_47ck1320 FIND v(dout0_47) AT=665.025n

.meas tran vdout0_48ck1320 FIND v(dout0_48) AT=665.025n

.meas tran vdout0_49ck1320 FIND v(dout0_49) AT=665.025n

.meas tran vdout0_50ck1320 FIND v(dout0_50) AT=665.025n

.meas tran vdout0_51ck1320 FIND v(dout0_51) AT=665.025n

.meas tran vdout0_52ck1320 FIND v(dout0_52) AT=665.025n

.meas tran vdout0_53ck1320 FIND v(dout0_53) AT=665.025n

.meas tran vdout0_54ck1320 FIND v(dout0_54) AT=665.025n

.meas tran vdout0_55ck1320 FIND v(dout0_55) AT=665.025n

.meas tran vdout0_56ck1320 FIND v(dout0_56) AT=665.025n

.meas tran vdout0_57ck1320 FIND v(dout0_57) AT=665.025n

.meas tran vdout0_58ck1320 FIND v(dout0_58) AT=665.025n

.meas tran vdout0_59ck1320 FIND v(dout0_59) AT=665.025n

.meas tran vdout0_60ck1320 FIND v(dout0_60) AT=665.025n

.meas tran vdout0_61ck1320 FIND v(dout0_61) AT=665.025n

.meas tran vdout0_62ck1320 FIND v(dout0_62) AT=665.025n

.meas tran vdout0_63ck1320 FIND v(dout0_63) AT=665.025n

.meas tran vdout0_0ck1330 FIND v(dout0_0) AT=670.025n

.meas tran vdout0_1ck1330 FIND v(dout0_1) AT=670.025n

.meas tran vdout0_2ck1330 FIND v(dout0_2) AT=670.025n

.meas tran vdout0_3ck1330 FIND v(dout0_3) AT=670.025n

.meas tran vdout0_4ck1330 FIND v(dout0_4) AT=670.025n

.meas tran vdout0_5ck1330 FIND v(dout0_5) AT=670.025n

.meas tran vdout0_6ck1330 FIND v(dout0_6) AT=670.025n

.meas tran vdout0_7ck1330 FIND v(dout0_7) AT=670.025n

.meas tran vdout0_8ck1330 FIND v(dout0_8) AT=670.025n

.meas tran vdout0_9ck1330 FIND v(dout0_9) AT=670.025n

.meas tran vdout0_10ck1330 FIND v(dout0_10) AT=670.025n

.meas tran vdout0_11ck1330 FIND v(dout0_11) AT=670.025n

.meas tran vdout0_12ck1330 FIND v(dout0_12) AT=670.025n

.meas tran vdout0_13ck1330 FIND v(dout0_13) AT=670.025n

.meas tran vdout0_14ck1330 FIND v(dout0_14) AT=670.025n

.meas tran vdout0_15ck1330 FIND v(dout0_15) AT=670.025n

.meas tran vdout0_16ck1330 FIND v(dout0_16) AT=670.025n

.meas tran vdout0_17ck1330 FIND v(dout0_17) AT=670.025n

.meas tran vdout0_18ck1330 FIND v(dout0_18) AT=670.025n

.meas tran vdout0_19ck1330 FIND v(dout0_19) AT=670.025n

.meas tran vdout0_20ck1330 FIND v(dout0_20) AT=670.025n

.meas tran vdout0_21ck1330 FIND v(dout0_21) AT=670.025n

.meas tran vdout0_22ck1330 FIND v(dout0_22) AT=670.025n

.meas tran vdout0_23ck1330 FIND v(dout0_23) AT=670.025n

.meas tran vdout0_24ck1330 FIND v(dout0_24) AT=670.025n

.meas tran vdout0_25ck1330 FIND v(dout0_25) AT=670.025n

.meas tran vdout0_26ck1330 FIND v(dout0_26) AT=670.025n

.meas tran vdout0_27ck1330 FIND v(dout0_27) AT=670.025n

.meas tran vdout0_28ck1330 FIND v(dout0_28) AT=670.025n

.meas tran vdout0_29ck1330 FIND v(dout0_29) AT=670.025n

.meas tran vdout0_30ck1330 FIND v(dout0_30) AT=670.025n

.meas tran vdout0_31ck1330 FIND v(dout0_31) AT=670.025n

.meas tran vdout0_32ck1330 FIND v(dout0_32) AT=670.025n

.meas tran vdout0_33ck1330 FIND v(dout0_33) AT=670.025n

.meas tran vdout0_34ck1330 FIND v(dout0_34) AT=670.025n

.meas tran vdout0_35ck1330 FIND v(dout0_35) AT=670.025n

.meas tran vdout0_36ck1330 FIND v(dout0_36) AT=670.025n

.meas tran vdout0_37ck1330 FIND v(dout0_37) AT=670.025n

.meas tran vdout0_38ck1330 FIND v(dout0_38) AT=670.025n

.meas tran vdout0_39ck1330 FIND v(dout0_39) AT=670.025n

.meas tran vdout0_40ck1330 FIND v(dout0_40) AT=670.025n

.meas tran vdout0_41ck1330 FIND v(dout0_41) AT=670.025n

.meas tran vdout0_42ck1330 FIND v(dout0_42) AT=670.025n

.meas tran vdout0_43ck1330 FIND v(dout0_43) AT=670.025n

.meas tran vdout0_44ck1330 FIND v(dout0_44) AT=670.025n

.meas tran vdout0_45ck1330 FIND v(dout0_45) AT=670.025n

.meas tran vdout0_46ck1330 FIND v(dout0_46) AT=670.025n

.meas tran vdout0_47ck1330 FIND v(dout0_47) AT=670.025n

.meas tran vdout0_48ck1330 FIND v(dout0_48) AT=670.025n

.meas tran vdout0_49ck1330 FIND v(dout0_49) AT=670.025n

.meas tran vdout0_50ck1330 FIND v(dout0_50) AT=670.025n

.meas tran vdout0_51ck1330 FIND v(dout0_51) AT=670.025n

.meas tran vdout0_52ck1330 FIND v(dout0_52) AT=670.025n

.meas tran vdout0_53ck1330 FIND v(dout0_53) AT=670.025n

.meas tran vdout0_54ck1330 FIND v(dout0_54) AT=670.025n

.meas tran vdout0_55ck1330 FIND v(dout0_55) AT=670.025n

.meas tran vdout0_56ck1330 FIND v(dout0_56) AT=670.025n

.meas tran vdout0_57ck1330 FIND v(dout0_57) AT=670.025n

.meas tran vdout0_58ck1330 FIND v(dout0_58) AT=670.025n

.meas tran vdout0_59ck1330 FIND v(dout0_59) AT=670.025n

.meas tran vdout0_60ck1330 FIND v(dout0_60) AT=670.025n

.meas tran vdout0_61ck1330 FIND v(dout0_61) AT=670.025n

.meas tran vdout0_62ck1330 FIND v(dout0_62) AT=670.025n

.meas tran vdout0_63ck1330 FIND v(dout0_63) AT=670.025n

.meas tran vdout0_0ck1350 FIND v(dout0_0) AT=680.025n

.meas tran vdout0_1ck1350 FIND v(dout0_1) AT=680.025n

.meas tran vdout0_2ck1350 FIND v(dout0_2) AT=680.025n

.meas tran vdout0_3ck1350 FIND v(dout0_3) AT=680.025n

.meas tran vdout0_4ck1350 FIND v(dout0_4) AT=680.025n

.meas tran vdout0_5ck1350 FIND v(dout0_5) AT=680.025n

.meas tran vdout0_6ck1350 FIND v(dout0_6) AT=680.025n

.meas tran vdout0_7ck1350 FIND v(dout0_7) AT=680.025n

.meas tran vdout0_8ck1350 FIND v(dout0_8) AT=680.025n

.meas tran vdout0_9ck1350 FIND v(dout0_9) AT=680.025n

.meas tran vdout0_10ck1350 FIND v(dout0_10) AT=680.025n

.meas tran vdout0_11ck1350 FIND v(dout0_11) AT=680.025n

.meas tran vdout0_12ck1350 FIND v(dout0_12) AT=680.025n

.meas tran vdout0_13ck1350 FIND v(dout0_13) AT=680.025n

.meas tran vdout0_14ck1350 FIND v(dout0_14) AT=680.025n

.meas tran vdout0_15ck1350 FIND v(dout0_15) AT=680.025n

.meas tran vdout0_16ck1350 FIND v(dout0_16) AT=680.025n

.meas tran vdout0_17ck1350 FIND v(dout0_17) AT=680.025n

.meas tran vdout0_18ck1350 FIND v(dout0_18) AT=680.025n

.meas tran vdout0_19ck1350 FIND v(dout0_19) AT=680.025n

.meas tran vdout0_20ck1350 FIND v(dout0_20) AT=680.025n

.meas tran vdout0_21ck1350 FIND v(dout0_21) AT=680.025n

.meas tran vdout0_22ck1350 FIND v(dout0_22) AT=680.025n

.meas tran vdout0_23ck1350 FIND v(dout0_23) AT=680.025n

.meas tran vdout0_24ck1350 FIND v(dout0_24) AT=680.025n

.meas tran vdout0_25ck1350 FIND v(dout0_25) AT=680.025n

.meas tran vdout0_26ck1350 FIND v(dout0_26) AT=680.025n

.meas tran vdout0_27ck1350 FIND v(dout0_27) AT=680.025n

.meas tran vdout0_28ck1350 FIND v(dout0_28) AT=680.025n

.meas tran vdout0_29ck1350 FIND v(dout0_29) AT=680.025n

.meas tran vdout0_30ck1350 FIND v(dout0_30) AT=680.025n

.meas tran vdout0_31ck1350 FIND v(dout0_31) AT=680.025n

.meas tran vdout0_32ck1350 FIND v(dout0_32) AT=680.025n

.meas tran vdout0_33ck1350 FIND v(dout0_33) AT=680.025n

.meas tran vdout0_34ck1350 FIND v(dout0_34) AT=680.025n

.meas tran vdout0_35ck1350 FIND v(dout0_35) AT=680.025n

.meas tran vdout0_36ck1350 FIND v(dout0_36) AT=680.025n

.meas tran vdout0_37ck1350 FIND v(dout0_37) AT=680.025n

.meas tran vdout0_38ck1350 FIND v(dout0_38) AT=680.025n

.meas tran vdout0_39ck1350 FIND v(dout0_39) AT=680.025n

.meas tran vdout0_40ck1350 FIND v(dout0_40) AT=680.025n

.meas tran vdout0_41ck1350 FIND v(dout0_41) AT=680.025n

.meas tran vdout0_42ck1350 FIND v(dout0_42) AT=680.025n

.meas tran vdout0_43ck1350 FIND v(dout0_43) AT=680.025n

.meas tran vdout0_44ck1350 FIND v(dout0_44) AT=680.025n

.meas tran vdout0_45ck1350 FIND v(dout0_45) AT=680.025n

.meas tran vdout0_46ck1350 FIND v(dout0_46) AT=680.025n

.meas tran vdout0_47ck1350 FIND v(dout0_47) AT=680.025n

.meas tran vdout0_48ck1350 FIND v(dout0_48) AT=680.025n

.meas tran vdout0_49ck1350 FIND v(dout0_49) AT=680.025n

.meas tran vdout0_50ck1350 FIND v(dout0_50) AT=680.025n

.meas tran vdout0_51ck1350 FIND v(dout0_51) AT=680.025n

.meas tran vdout0_52ck1350 FIND v(dout0_52) AT=680.025n

.meas tran vdout0_53ck1350 FIND v(dout0_53) AT=680.025n

.meas tran vdout0_54ck1350 FIND v(dout0_54) AT=680.025n

.meas tran vdout0_55ck1350 FIND v(dout0_55) AT=680.025n

.meas tran vdout0_56ck1350 FIND v(dout0_56) AT=680.025n

.meas tran vdout0_57ck1350 FIND v(dout0_57) AT=680.025n

.meas tran vdout0_58ck1350 FIND v(dout0_58) AT=680.025n

.meas tran vdout0_59ck1350 FIND v(dout0_59) AT=680.025n

.meas tran vdout0_60ck1350 FIND v(dout0_60) AT=680.025n

.meas tran vdout0_61ck1350 FIND v(dout0_61) AT=680.025n

.meas tran vdout0_62ck1350 FIND v(dout0_62) AT=680.025n

.meas tran vdout0_63ck1350 FIND v(dout0_63) AT=680.025n

.meas tran vdout0_0ck1360 FIND v(dout0_0) AT=685.025n

.meas tran vdout0_1ck1360 FIND v(dout0_1) AT=685.025n

.meas tran vdout0_2ck1360 FIND v(dout0_2) AT=685.025n

.meas tran vdout0_3ck1360 FIND v(dout0_3) AT=685.025n

.meas tran vdout0_4ck1360 FIND v(dout0_4) AT=685.025n

.meas tran vdout0_5ck1360 FIND v(dout0_5) AT=685.025n

.meas tran vdout0_6ck1360 FIND v(dout0_6) AT=685.025n

.meas tran vdout0_7ck1360 FIND v(dout0_7) AT=685.025n

.meas tran vdout0_8ck1360 FIND v(dout0_8) AT=685.025n

.meas tran vdout0_9ck1360 FIND v(dout0_9) AT=685.025n

.meas tran vdout0_10ck1360 FIND v(dout0_10) AT=685.025n

.meas tran vdout0_11ck1360 FIND v(dout0_11) AT=685.025n

.meas tran vdout0_12ck1360 FIND v(dout0_12) AT=685.025n

.meas tran vdout0_13ck1360 FIND v(dout0_13) AT=685.025n

.meas tran vdout0_14ck1360 FIND v(dout0_14) AT=685.025n

.meas tran vdout0_15ck1360 FIND v(dout0_15) AT=685.025n

.meas tran vdout0_16ck1360 FIND v(dout0_16) AT=685.025n

.meas tran vdout0_17ck1360 FIND v(dout0_17) AT=685.025n

.meas tran vdout0_18ck1360 FIND v(dout0_18) AT=685.025n

.meas tran vdout0_19ck1360 FIND v(dout0_19) AT=685.025n

.meas tran vdout0_20ck1360 FIND v(dout0_20) AT=685.025n

.meas tran vdout0_21ck1360 FIND v(dout0_21) AT=685.025n

.meas tran vdout0_22ck1360 FIND v(dout0_22) AT=685.025n

.meas tran vdout0_23ck1360 FIND v(dout0_23) AT=685.025n

.meas tran vdout0_24ck1360 FIND v(dout0_24) AT=685.025n

.meas tran vdout0_25ck1360 FIND v(dout0_25) AT=685.025n

.meas tran vdout0_26ck1360 FIND v(dout0_26) AT=685.025n

.meas tran vdout0_27ck1360 FIND v(dout0_27) AT=685.025n

.meas tran vdout0_28ck1360 FIND v(dout0_28) AT=685.025n

.meas tran vdout0_29ck1360 FIND v(dout0_29) AT=685.025n

.meas tran vdout0_30ck1360 FIND v(dout0_30) AT=685.025n

.meas tran vdout0_31ck1360 FIND v(dout0_31) AT=685.025n

.meas tran vdout0_32ck1360 FIND v(dout0_32) AT=685.025n

.meas tran vdout0_33ck1360 FIND v(dout0_33) AT=685.025n

.meas tran vdout0_34ck1360 FIND v(dout0_34) AT=685.025n

.meas tran vdout0_35ck1360 FIND v(dout0_35) AT=685.025n

.meas tran vdout0_36ck1360 FIND v(dout0_36) AT=685.025n

.meas tran vdout0_37ck1360 FIND v(dout0_37) AT=685.025n

.meas tran vdout0_38ck1360 FIND v(dout0_38) AT=685.025n

.meas tran vdout0_39ck1360 FIND v(dout0_39) AT=685.025n

.meas tran vdout0_40ck1360 FIND v(dout0_40) AT=685.025n

.meas tran vdout0_41ck1360 FIND v(dout0_41) AT=685.025n

.meas tran vdout0_42ck1360 FIND v(dout0_42) AT=685.025n

.meas tran vdout0_43ck1360 FIND v(dout0_43) AT=685.025n

.meas tran vdout0_44ck1360 FIND v(dout0_44) AT=685.025n

.meas tran vdout0_45ck1360 FIND v(dout0_45) AT=685.025n

.meas tran vdout0_46ck1360 FIND v(dout0_46) AT=685.025n

.meas tran vdout0_47ck1360 FIND v(dout0_47) AT=685.025n

.meas tran vdout0_48ck1360 FIND v(dout0_48) AT=685.025n

.meas tran vdout0_49ck1360 FIND v(dout0_49) AT=685.025n

.meas tran vdout0_50ck1360 FIND v(dout0_50) AT=685.025n

.meas tran vdout0_51ck1360 FIND v(dout0_51) AT=685.025n

.meas tran vdout0_52ck1360 FIND v(dout0_52) AT=685.025n

.meas tran vdout0_53ck1360 FIND v(dout0_53) AT=685.025n

.meas tran vdout0_54ck1360 FIND v(dout0_54) AT=685.025n

.meas tran vdout0_55ck1360 FIND v(dout0_55) AT=685.025n

.meas tran vdout0_56ck1360 FIND v(dout0_56) AT=685.025n

.meas tran vdout0_57ck1360 FIND v(dout0_57) AT=685.025n

.meas tran vdout0_58ck1360 FIND v(dout0_58) AT=685.025n

.meas tran vdout0_59ck1360 FIND v(dout0_59) AT=685.025n

.meas tran vdout0_60ck1360 FIND v(dout0_60) AT=685.025n

.meas tran vdout0_61ck1360 FIND v(dout0_61) AT=685.025n

.meas tran vdout0_62ck1360 FIND v(dout0_62) AT=685.025n

.meas tran vdout0_63ck1360 FIND v(dout0_63) AT=685.025n

.meas tran vdout0_0ck1370 FIND v(dout0_0) AT=690.025n

.meas tran vdout0_1ck1370 FIND v(dout0_1) AT=690.025n

.meas tran vdout0_2ck1370 FIND v(dout0_2) AT=690.025n

.meas tran vdout0_3ck1370 FIND v(dout0_3) AT=690.025n

.meas tran vdout0_4ck1370 FIND v(dout0_4) AT=690.025n

.meas tran vdout0_5ck1370 FIND v(dout0_5) AT=690.025n

.meas tran vdout0_6ck1370 FIND v(dout0_6) AT=690.025n

.meas tran vdout0_7ck1370 FIND v(dout0_7) AT=690.025n

.meas tran vdout0_8ck1370 FIND v(dout0_8) AT=690.025n

.meas tran vdout0_9ck1370 FIND v(dout0_9) AT=690.025n

.meas tran vdout0_10ck1370 FIND v(dout0_10) AT=690.025n

.meas tran vdout0_11ck1370 FIND v(dout0_11) AT=690.025n

.meas tran vdout0_12ck1370 FIND v(dout0_12) AT=690.025n

.meas tran vdout0_13ck1370 FIND v(dout0_13) AT=690.025n

.meas tran vdout0_14ck1370 FIND v(dout0_14) AT=690.025n

.meas tran vdout0_15ck1370 FIND v(dout0_15) AT=690.025n

.meas tran vdout0_16ck1370 FIND v(dout0_16) AT=690.025n

.meas tran vdout0_17ck1370 FIND v(dout0_17) AT=690.025n

.meas tran vdout0_18ck1370 FIND v(dout0_18) AT=690.025n

.meas tran vdout0_19ck1370 FIND v(dout0_19) AT=690.025n

.meas tran vdout0_20ck1370 FIND v(dout0_20) AT=690.025n

.meas tran vdout0_21ck1370 FIND v(dout0_21) AT=690.025n

.meas tran vdout0_22ck1370 FIND v(dout0_22) AT=690.025n

.meas tran vdout0_23ck1370 FIND v(dout0_23) AT=690.025n

.meas tran vdout0_24ck1370 FIND v(dout0_24) AT=690.025n

.meas tran vdout0_25ck1370 FIND v(dout0_25) AT=690.025n

.meas tran vdout0_26ck1370 FIND v(dout0_26) AT=690.025n

.meas tran vdout0_27ck1370 FIND v(dout0_27) AT=690.025n

.meas tran vdout0_28ck1370 FIND v(dout0_28) AT=690.025n

.meas tran vdout0_29ck1370 FIND v(dout0_29) AT=690.025n

.meas tran vdout0_30ck1370 FIND v(dout0_30) AT=690.025n

.meas tran vdout0_31ck1370 FIND v(dout0_31) AT=690.025n

.meas tran vdout0_32ck1370 FIND v(dout0_32) AT=690.025n

.meas tran vdout0_33ck1370 FIND v(dout0_33) AT=690.025n

.meas tran vdout0_34ck1370 FIND v(dout0_34) AT=690.025n

.meas tran vdout0_35ck1370 FIND v(dout0_35) AT=690.025n

.meas tran vdout0_36ck1370 FIND v(dout0_36) AT=690.025n

.meas tran vdout0_37ck1370 FIND v(dout0_37) AT=690.025n

.meas tran vdout0_38ck1370 FIND v(dout0_38) AT=690.025n

.meas tran vdout0_39ck1370 FIND v(dout0_39) AT=690.025n

.meas tran vdout0_40ck1370 FIND v(dout0_40) AT=690.025n

.meas tran vdout0_41ck1370 FIND v(dout0_41) AT=690.025n

.meas tran vdout0_42ck1370 FIND v(dout0_42) AT=690.025n

.meas tran vdout0_43ck1370 FIND v(dout0_43) AT=690.025n

.meas tran vdout0_44ck1370 FIND v(dout0_44) AT=690.025n

.meas tran vdout0_45ck1370 FIND v(dout0_45) AT=690.025n

.meas tran vdout0_46ck1370 FIND v(dout0_46) AT=690.025n

.meas tran vdout0_47ck1370 FIND v(dout0_47) AT=690.025n

.meas tran vdout0_48ck1370 FIND v(dout0_48) AT=690.025n

.meas tran vdout0_49ck1370 FIND v(dout0_49) AT=690.025n

.meas tran vdout0_50ck1370 FIND v(dout0_50) AT=690.025n

.meas tran vdout0_51ck1370 FIND v(dout0_51) AT=690.025n

.meas tran vdout0_52ck1370 FIND v(dout0_52) AT=690.025n

.meas tran vdout0_53ck1370 FIND v(dout0_53) AT=690.025n

.meas tran vdout0_54ck1370 FIND v(dout0_54) AT=690.025n

.meas tran vdout0_55ck1370 FIND v(dout0_55) AT=690.025n

.meas tran vdout0_56ck1370 FIND v(dout0_56) AT=690.025n

.meas tran vdout0_57ck1370 FIND v(dout0_57) AT=690.025n

.meas tran vdout0_58ck1370 FIND v(dout0_58) AT=690.025n

.meas tran vdout0_59ck1370 FIND v(dout0_59) AT=690.025n

.meas tran vdout0_60ck1370 FIND v(dout0_60) AT=690.025n

.meas tran vdout0_61ck1370 FIND v(dout0_61) AT=690.025n

.meas tran vdout0_62ck1370 FIND v(dout0_62) AT=690.025n

.meas tran vdout0_63ck1370 FIND v(dout0_63) AT=690.025n

.meas tran vdout0_0ck1390 FIND v(dout0_0) AT=700.025n

.meas tran vdout0_1ck1390 FIND v(dout0_1) AT=700.025n

.meas tran vdout0_2ck1390 FIND v(dout0_2) AT=700.025n

.meas tran vdout0_3ck1390 FIND v(dout0_3) AT=700.025n

.meas tran vdout0_4ck1390 FIND v(dout0_4) AT=700.025n

.meas tran vdout0_5ck1390 FIND v(dout0_5) AT=700.025n

.meas tran vdout0_6ck1390 FIND v(dout0_6) AT=700.025n

.meas tran vdout0_7ck1390 FIND v(dout0_7) AT=700.025n

.meas tran vdout0_8ck1390 FIND v(dout0_8) AT=700.025n

.meas tran vdout0_9ck1390 FIND v(dout0_9) AT=700.025n

.meas tran vdout0_10ck1390 FIND v(dout0_10) AT=700.025n

.meas tran vdout0_11ck1390 FIND v(dout0_11) AT=700.025n

.meas tran vdout0_12ck1390 FIND v(dout0_12) AT=700.025n

.meas tran vdout0_13ck1390 FIND v(dout0_13) AT=700.025n

.meas tran vdout0_14ck1390 FIND v(dout0_14) AT=700.025n

.meas tran vdout0_15ck1390 FIND v(dout0_15) AT=700.025n

.meas tran vdout0_16ck1390 FIND v(dout0_16) AT=700.025n

.meas tran vdout0_17ck1390 FIND v(dout0_17) AT=700.025n

.meas tran vdout0_18ck1390 FIND v(dout0_18) AT=700.025n

.meas tran vdout0_19ck1390 FIND v(dout0_19) AT=700.025n

.meas tran vdout0_20ck1390 FIND v(dout0_20) AT=700.025n

.meas tran vdout0_21ck1390 FIND v(dout0_21) AT=700.025n

.meas tran vdout0_22ck1390 FIND v(dout0_22) AT=700.025n

.meas tran vdout0_23ck1390 FIND v(dout0_23) AT=700.025n

.meas tran vdout0_24ck1390 FIND v(dout0_24) AT=700.025n

.meas tran vdout0_25ck1390 FIND v(dout0_25) AT=700.025n

.meas tran vdout0_26ck1390 FIND v(dout0_26) AT=700.025n

.meas tran vdout0_27ck1390 FIND v(dout0_27) AT=700.025n

.meas tran vdout0_28ck1390 FIND v(dout0_28) AT=700.025n

.meas tran vdout0_29ck1390 FIND v(dout0_29) AT=700.025n

.meas tran vdout0_30ck1390 FIND v(dout0_30) AT=700.025n

.meas tran vdout0_31ck1390 FIND v(dout0_31) AT=700.025n

.meas tran vdout0_32ck1390 FIND v(dout0_32) AT=700.025n

.meas tran vdout0_33ck1390 FIND v(dout0_33) AT=700.025n

.meas tran vdout0_34ck1390 FIND v(dout0_34) AT=700.025n

.meas tran vdout0_35ck1390 FIND v(dout0_35) AT=700.025n

.meas tran vdout0_36ck1390 FIND v(dout0_36) AT=700.025n

.meas tran vdout0_37ck1390 FIND v(dout0_37) AT=700.025n

.meas tran vdout0_38ck1390 FIND v(dout0_38) AT=700.025n

.meas tran vdout0_39ck1390 FIND v(dout0_39) AT=700.025n

.meas tran vdout0_40ck1390 FIND v(dout0_40) AT=700.025n

.meas tran vdout0_41ck1390 FIND v(dout0_41) AT=700.025n

.meas tran vdout0_42ck1390 FIND v(dout0_42) AT=700.025n

.meas tran vdout0_43ck1390 FIND v(dout0_43) AT=700.025n

.meas tran vdout0_44ck1390 FIND v(dout0_44) AT=700.025n

.meas tran vdout0_45ck1390 FIND v(dout0_45) AT=700.025n

.meas tran vdout0_46ck1390 FIND v(dout0_46) AT=700.025n

.meas tran vdout0_47ck1390 FIND v(dout0_47) AT=700.025n

.meas tran vdout0_48ck1390 FIND v(dout0_48) AT=700.025n

.meas tran vdout0_49ck1390 FIND v(dout0_49) AT=700.025n

.meas tran vdout0_50ck1390 FIND v(dout0_50) AT=700.025n

.meas tran vdout0_51ck1390 FIND v(dout0_51) AT=700.025n

.meas tran vdout0_52ck1390 FIND v(dout0_52) AT=700.025n

.meas tran vdout0_53ck1390 FIND v(dout0_53) AT=700.025n

.meas tran vdout0_54ck1390 FIND v(dout0_54) AT=700.025n

.meas tran vdout0_55ck1390 FIND v(dout0_55) AT=700.025n

.meas tran vdout0_56ck1390 FIND v(dout0_56) AT=700.025n

.meas tran vdout0_57ck1390 FIND v(dout0_57) AT=700.025n

.meas tran vdout0_58ck1390 FIND v(dout0_58) AT=700.025n

.meas tran vdout0_59ck1390 FIND v(dout0_59) AT=700.025n

.meas tran vdout0_60ck1390 FIND v(dout0_60) AT=700.025n

.meas tran vdout0_61ck1390 FIND v(dout0_61) AT=700.025n

.meas tran vdout0_62ck1390 FIND v(dout0_62) AT=700.025n

.meas tran vdout0_63ck1390 FIND v(dout0_63) AT=700.025n

.meas tran vdout0_0ck1400 FIND v(dout0_0) AT=705.025n

.meas tran vdout0_1ck1400 FIND v(dout0_1) AT=705.025n

.meas tran vdout0_2ck1400 FIND v(dout0_2) AT=705.025n

.meas tran vdout0_3ck1400 FIND v(dout0_3) AT=705.025n

.meas tran vdout0_4ck1400 FIND v(dout0_4) AT=705.025n

.meas tran vdout0_5ck1400 FIND v(dout0_5) AT=705.025n

.meas tran vdout0_6ck1400 FIND v(dout0_6) AT=705.025n

.meas tran vdout0_7ck1400 FIND v(dout0_7) AT=705.025n

.meas tran vdout0_8ck1400 FIND v(dout0_8) AT=705.025n

.meas tran vdout0_9ck1400 FIND v(dout0_9) AT=705.025n

.meas tran vdout0_10ck1400 FIND v(dout0_10) AT=705.025n

.meas tran vdout0_11ck1400 FIND v(dout0_11) AT=705.025n

.meas tran vdout0_12ck1400 FIND v(dout0_12) AT=705.025n

.meas tran vdout0_13ck1400 FIND v(dout0_13) AT=705.025n

.meas tran vdout0_14ck1400 FIND v(dout0_14) AT=705.025n

.meas tran vdout0_15ck1400 FIND v(dout0_15) AT=705.025n

.meas tran vdout0_16ck1400 FIND v(dout0_16) AT=705.025n

.meas tran vdout0_17ck1400 FIND v(dout0_17) AT=705.025n

.meas tran vdout0_18ck1400 FIND v(dout0_18) AT=705.025n

.meas tran vdout0_19ck1400 FIND v(dout0_19) AT=705.025n

.meas tran vdout0_20ck1400 FIND v(dout0_20) AT=705.025n

.meas tran vdout0_21ck1400 FIND v(dout0_21) AT=705.025n

.meas tran vdout0_22ck1400 FIND v(dout0_22) AT=705.025n

.meas tran vdout0_23ck1400 FIND v(dout0_23) AT=705.025n

.meas tran vdout0_24ck1400 FIND v(dout0_24) AT=705.025n

.meas tran vdout0_25ck1400 FIND v(dout0_25) AT=705.025n

.meas tran vdout0_26ck1400 FIND v(dout0_26) AT=705.025n

.meas tran vdout0_27ck1400 FIND v(dout0_27) AT=705.025n

.meas tran vdout0_28ck1400 FIND v(dout0_28) AT=705.025n

.meas tran vdout0_29ck1400 FIND v(dout0_29) AT=705.025n

.meas tran vdout0_30ck1400 FIND v(dout0_30) AT=705.025n

.meas tran vdout0_31ck1400 FIND v(dout0_31) AT=705.025n

.meas tran vdout0_32ck1400 FIND v(dout0_32) AT=705.025n

.meas tran vdout0_33ck1400 FIND v(dout0_33) AT=705.025n

.meas tran vdout0_34ck1400 FIND v(dout0_34) AT=705.025n

.meas tran vdout0_35ck1400 FIND v(dout0_35) AT=705.025n

.meas tran vdout0_36ck1400 FIND v(dout0_36) AT=705.025n

.meas tran vdout0_37ck1400 FIND v(dout0_37) AT=705.025n

.meas tran vdout0_38ck1400 FIND v(dout0_38) AT=705.025n

.meas tran vdout0_39ck1400 FIND v(dout0_39) AT=705.025n

.meas tran vdout0_40ck1400 FIND v(dout0_40) AT=705.025n

.meas tran vdout0_41ck1400 FIND v(dout0_41) AT=705.025n

.meas tran vdout0_42ck1400 FIND v(dout0_42) AT=705.025n

.meas tran vdout0_43ck1400 FIND v(dout0_43) AT=705.025n

.meas tran vdout0_44ck1400 FIND v(dout0_44) AT=705.025n

.meas tran vdout0_45ck1400 FIND v(dout0_45) AT=705.025n

.meas tran vdout0_46ck1400 FIND v(dout0_46) AT=705.025n

.meas tran vdout0_47ck1400 FIND v(dout0_47) AT=705.025n

.meas tran vdout0_48ck1400 FIND v(dout0_48) AT=705.025n

.meas tran vdout0_49ck1400 FIND v(dout0_49) AT=705.025n

.meas tran vdout0_50ck1400 FIND v(dout0_50) AT=705.025n

.meas tran vdout0_51ck1400 FIND v(dout0_51) AT=705.025n

.meas tran vdout0_52ck1400 FIND v(dout0_52) AT=705.025n

.meas tran vdout0_53ck1400 FIND v(dout0_53) AT=705.025n

.meas tran vdout0_54ck1400 FIND v(dout0_54) AT=705.025n

.meas tran vdout0_55ck1400 FIND v(dout0_55) AT=705.025n

.meas tran vdout0_56ck1400 FIND v(dout0_56) AT=705.025n

.meas tran vdout0_57ck1400 FIND v(dout0_57) AT=705.025n

.meas tran vdout0_58ck1400 FIND v(dout0_58) AT=705.025n

.meas tran vdout0_59ck1400 FIND v(dout0_59) AT=705.025n

.meas tran vdout0_60ck1400 FIND v(dout0_60) AT=705.025n

.meas tran vdout0_61ck1400 FIND v(dout0_61) AT=705.025n

.meas tran vdout0_62ck1400 FIND v(dout0_62) AT=705.025n

.meas tran vdout0_63ck1400 FIND v(dout0_63) AT=705.025n

.meas tran vdout0_0ck1440 FIND v(dout0_0) AT=725.025n

.meas tran vdout0_1ck1440 FIND v(dout0_1) AT=725.025n

.meas tran vdout0_2ck1440 FIND v(dout0_2) AT=725.025n

.meas tran vdout0_3ck1440 FIND v(dout0_3) AT=725.025n

.meas tran vdout0_4ck1440 FIND v(dout0_4) AT=725.025n

.meas tran vdout0_5ck1440 FIND v(dout0_5) AT=725.025n

.meas tran vdout0_6ck1440 FIND v(dout0_6) AT=725.025n

.meas tran vdout0_7ck1440 FIND v(dout0_7) AT=725.025n

.meas tran vdout0_8ck1440 FIND v(dout0_8) AT=725.025n

.meas tran vdout0_9ck1440 FIND v(dout0_9) AT=725.025n

.meas tran vdout0_10ck1440 FIND v(dout0_10) AT=725.025n

.meas tran vdout0_11ck1440 FIND v(dout0_11) AT=725.025n

.meas tran vdout0_12ck1440 FIND v(dout0_12) AT=725.025n

.meas tran vdout0_13ck1440 FIND v(dout0_13) AT=725.025n

.meas tran vdout0_14ck1440 FIND v(dout0_14) AT=725.025n

.meas tran vdout0_15ck1440 FIND v(dout0_15) AT=725.025n

.meas tran vdout0_16ck1440 FIND v(dout0_16) AT=725.025n

.meas tran vdout0_17ck1440 FIND v(dout0_17) AT=725.025n

.meas tran vdout0_18ck1440 FIND v(dout0_18) AT=725.025n

.meas tran vdout0_19ck1440 FIND v(dout0_19) AT=725.025n

.meas tran vdout0_20ck1440 FIND v(dout0_20) AT=725.025n

.meas tran vdout0_21ck1440 FIND v(dout0_21) AT=725.025n

.meas tran vdout0_22ck1440 FIND v(dout0_22) AT=725.025n

.meas tran vdout0_23ck1440 FIND v(dout0_23) AT=725.025n

.meas tran vdout0_24ck1440 FIND v(dout0_24) AT=725.025n

.meas tran vdout0_25ck1440 FIND v(dout0_25) AT=725.025n

.meas tran vdout0_26ck1440 FIND v(dout0_26) AT=725.025n

.meas tran vdout0_27ck1440 FIND v(dout0_27) AT=725.025n

.meas tran vdout0_28ck1440 FIND v(dout0_28) AT=725.025n

.meas tran vdout0_29ck1440 FIND v(dout0_29) AT=725.025n

.meas tran vdout0_30ck1440 FIND v(dout0_30) AT=725.025n

.meas tran vdout0_31ck1440 FIND v(dout0_31) AT=725.025n

.meas tran vdout0_32ck1440 FIND v(dout0_32) AT=725.025n

.meas tran vdout0_33ck1440 FIND v(dout0_33) AT=725.025n

.meas tran vdout0_34ck1440 FIND v(dout0_34) AT=725.025n

.meas tran vdout0_35ck1440 FIND v(dout0_35) AT=725.025n

.meas tran vdout0_36ck1440 FIND v(dout0_36) AT=725.025n

.meas tran vdout0_37ck1440 FIND v(dout0_37) AT=725.025n

.meas tran vdout0_38ck1440 FIND v(dout0_38) AT=725.025n

.meas tran vdout0_39ck1440 FIND v(dout0_39) AT=725.025n

.meas tran vdout0_40ck1440 FIND v(dout0_40) AT=725.025n

.meas tran vdout0_41ck1440 FIND v(dout0_41) AT=725.025n

.meas tran vdout0_42ck1440 FIND v(dout0_42) AT=725.025n

.meas tran vdout0_43ck1440 FIND v(dout0_43) AT=725.025n

.meas tran vdout0_44ck1440 FIND v(dout0_44) AT=725.025n

.meas tran vdout0_45ck1440 FIND v(dout0_45) AT=725.025n

.meas tran vdout0_46ck1440 FIND v(dout0_46) AT=725.025n

.meas tran vdout0_47ck1440 FIND v(dout0_47) AT=725.025n

.meas tran vdout0_48ck1440 FIND v(dout0_48) AT=725.025n

.meas tran vdout0_49ck1440 FIND v(dout0_49) AT=725.025n

.meas tran vdout0_50ck1440 FIND v(dout0_50) AT=725.025n

.meas tran vdout0_51ck1440 FIND v(dout0_51) AT=725.025n

.meas tran vdout0_52ck1440 FIND v(dout0_52) AT=725.025n

.meas tran vdout0_53ck1440 FIND v(dout0_53) AT=725.025n

.meas tran vdout0_54ck1440 FIND v(dout0_54) AT=725.025n

.meas tran vdout0_55ck1440 FIND v(dout0_55) AT=725.025n

.meas tran vdout0_56ck1440 FIND v(dout0_56) AT=725.025n

.meas tran vdout0_57ck1440 FIND v(dout0_57) AT=725.025n

.meas tran vdout0_58ck1440 FIND v(dout0_58) AT=725.025n

.meas tran vdout0_59ck1440 FIND v(dout0_59) AT=725.025n

.meas tran vdout0_60ck1440 FIND v(dout0_60) AT=725.025n

.meas tran vdout0_61ck1440 FIND v(dout0_61) AT=725.025n

.meas tran vdout0_62ck1440 FIND v(dout0_62) AT=725.025n

.meas tran vdout0_63ck1440 FIND v(dout0_63) AT=725.025n

.meas tran vdout0_0ck1450 FIND v(dout0_0) AT=730.025n

.meas tran vdout0_1ck1450 FIND v(dout0_1) AT=730.025n

.meas tran vdout0_2ck1450 FIND v(dout0_2) AT=730.025n

.meas tran vdout0_3ck1450 FIND v(dout0_3) AT=730.025n

.meas tran vdout0_4ck1450 FIND v(dout0_4) AT=730.025n

.meas tran vdout0_5ck1450 FIND v(dout0_5) AT=730.025n

.meas tran vdout0_6ck1450 FIND v(dout0_6) AT=730.025n

.meas tran vdout0_7ck1450 FIND v(dout0_7) AT=730.025n

.meas tran vdout0_8ck1450 FIND v(dout0_8) AT=730.025n

.meas tran vdout0_9ck1450 FIND v(dout0_9) AT=730.025n

.meas tran vdout0_10ck1450 FIND v(dout0_10) AT=730.025n

.meas tran vdout0_11ck1450 FIND v(dout0_11) AT=730.025n

.meas tran vdout0_12ck1450 FIND v(dout0_12) AT=730.025n

.meas tran vdout0_13ck1450 FIND v(dout0_13) AT=730.025n

.meas tran vdout0_14ck1450 FIND v(dout0_14) AT=730.025n

.meas tran vdout0_15ck1450 FIND v(dout0_15) AT=730.025n

.meas tran vdout0_16ck1450 FIND v(dout0_16) AT=730.025n

.meas tran vdout0_17ck1450 FIND v(dout0_17) AT=730.025n

.meas tran vdout0_18ck1450 FIND v(dout0_18) AT=730.025n

.meas tran vdout0_19ck1450 FIND v(dout0_19) AT=730.025n

.meas tran vdout0_20ck1450 FIND v(dout0_20) AT=730.025n

.meas tran vdout0_21ck1450 FIND v(dout0_21) AT=730.025n

.meas tran vdout0_22ck1450 FIND v(dout0_22) AT=730.025n

.meas tran vdout0_23ck1450 FIND v(dout0_23) AT=730.025n

.meas tran vdout0_24ck1450 FIND v(dout0_24) AT=730.025n

.meas tran vdout0_25ck1450 FIND v(dout0_25) AT=730.025n

.meas tran vdout0_26ck1450 FIND v(dout0_26) AT=730.025n

.meas tran vdout0_27ck1450 FIND v(dout0_27) AT=730.025n

.meas tran vdout0_28ck1450 FIND v(dout0_28) AT=730.025n

.meas tran vdout0_29ck1450 FIND v(dout0_29) AT=730.025n

.meas tran vdout0_30ck1450 FIND v(dout0_30) AT=730.025n

.meas tran vdout0_31ck1450 FIND v(dout0_31) AT=730.025n

.meas tran vdout0_32ck1450 FIND v(dout0_32) AT=730.025n

.meas tran vdout0_33ck1450 FIND v(dout0_33) AT=730.025n

.meas tran vdout0_34ck1450 FIND v(dout0_34) AT=730.025n

.meas tran vdout0_35ck1450 FIND v(dout0_35) AT=730.025n

.meas tran vdout0_36ck1450 FIND v(dout0_36) AT=730.025n

.meas tran vdout0_37ck1450 FIND v(dout0_37) AT=730.025n

.meas tran vdout0_38ck1450 FIND v(dout0_38) AT=730.025n

.meas tran vdout0_39ck1450 FIND v(dout0_39) AT=730.025n

.meas tran vdout0_40ck1450 FIND v(dout0_40) AT=730.025n

.meas tran vdout0_41ck1450 FIND v(dout0_41) AT=730.025n

.meas tran vdout0_42ck1450 FIND v(dout0_42) AT=730.025n

.meas tran vdout0_43ck1450 FIND v(dout0_43) AT=730.025n

.meas tran vdout0_44ck1450 FIND v(dout0_44) AT=730.025n

.meas tran vdout0_45ck1450 FIND v(dout0_45) AT=730.025n

.meas tran vdout0_46ck1450 FIND v(dout0_46) AT=730.025n

.meas tran vdout0_47ck1450 FIND v(dout0_47) AT=730.025n

.meas tran vdout0_48ck1450 FIND v(dout0_48) AT=730.025n

.meas tran vdout0_49ck1450 FIND v(dout0_49) AT=730.025n

.meas tran vdout0_50ck1450 FIND v(dout0_50) AT=730.025n

.meas tran vdout0_51ck1450 FIND v(dout0_51) AT=730.025n

.meas tran vdout0_52ck1450 FIND v(dout0_52) AT=730.025n

.meas tran vdout0_53ck1450 FIND v(dout0_53) AT=730.025n

.meas tran vdout0_54ck1450 FIND v(dout0_54) AT=730.025n

.meas tran vdout0_55ck1450 FIND v(dout0_55) AT=730.025n

.meas tran vdout0_56ck1450 FIND v(dout0_56) AT=730.025n

.meas tran vdout0_57ck1450 FIND v(dout0_57) AT=730.025n

.meas tran vdout0_58ck1450 FIND v(dout0_58) AT=730.025n

.meas tran vdout0_59ck1450 FIND v(dout0_59) AT=730.025n

.meas tran vdout0_60ck1450 FIND v(dout0_60) AT=730.025n

.meas tran vdout0_61ck1450 FIND v(dout0_61) AT=730.025n

.meas tran vdout0_62ck1450 FIND v(dout0_62) AT=730.025n

.meas tran vdout0_63ck1450 FIND v(dout0_63) AT=730.025n

.meas tran vdout0_0ck1480 FIND v(dout0_0) AT=745.025n

.meas tran vdout0_1ck1480 FIND v(dout0_1) AT=745.025n

.meas tran vdout0_2ck1480 FIND v(dout0_2) AT=745.025n

.meas tran vdout0_3ck1480 FIND v(dout0_3) AT=745.025n

.meas tran vdout0_4ck1480 FIND v(dout0_4) AT=745.025n

.meas tran vdout0_5ck1480 FIND v(dout0_5) AT=745.025n

.meas tran vdout0_6ck1480 FIND v(dout0_6) AT=745.025n

.meas tran vdout0_7ck1480 FIND v(dout0_7) AT=745.025n

.meas tran vdout0_8ck1480 FIND v(dout0_8) AT=745.025n

.meas tran vdout0_9ck1480 FIND v(dout0_9) AT=745.025n

.meas tran vdout0_10ck1480 FIND v(dout0_10) AT=745.025n

.meas tran vdout0_11ck1480 FIND v(dout0_11) AT=745.025n

.meas tran vdout0_12ck1480 FIND v(dout0_12) AT=745.025n

.meas tran vdout0_13ck1480 FIND v(dout0_13) AT=745.025n

.meas tran vdout0_14ck1480 FIND v(dout0_14) AT=745.025n

.meas tran vdout0_15ck1480 FIND v(dout0_15) AT=745.025n

.meas tran vdout0_16ck1480 FIND v(dout0_16) AT=745.025n

.meas tran vdout0_17ck1480 FIND v(dout0_17) AT=745.025n

.meas tran vdout0_18ck1480 FIND v(dout0_18) AT=745.025n

.meas tran vdout0_19ck1480 FIND v(dout0_19) AT=745.025n

.meas tran vdout0_20ck1480 FIND v(dout0_20) AT=745.025n

.meas tran vdout0_21ck1480 FIND v(dout0_21) AT=745.025n

.meas tran vdout0_22ck1480 FIND v(dout0_22) AT=745.025n

.meas tran vdout0_23ck1480 FIND v(dout0_23) AT=745.025n

.meas tran vdout0_24ck1480 FIND v(dout0_24) AT=745.025n

.meas tran vdout0_25ck1480 FIND v(dout0_25) AT=745.025n

.meas tran vdout0_26ck1480 FIND v(dout0_26) AT=745.025n

.meas tran vdout0_27ck1480 FIND v(dout0_27) AT=745.025n

.meas tran vdout0_28ck1480 FIND v(dout0_28) AT=745.025n

.meas tran vdout0_29ck1480 FIND v(dout0_29) AT=745.025n

.meas tran vdout0_30ck1480 FIND v(dout0_30) AT=745.025n

.meas tran vdout0_31ck1480 FIND v(dout0_31) AT=745.025n

.meas tran vdout0_32ck1480 FIND v(dout0_32) AT=745.025n

.meas tran vdout0_33ck1480 FIND v(dout0_33) AT=745.025n

.meas tran vdout0_34ck1480 FIND v(dout0_34) AT=745.025n

.meas tran vdout0_35ck1480 FIND v(dout0_35) AT=745.025n

.meas tran vdout0_36ck1480 FIND v(dout0_36) AT=745.025n

.meas tran vdout0_37ck1480 FIND v(dout0_37) AT=745.025n

.meas tran vdout0_38ck1480 FIND v(dout0_38) AT=745.025n

.meas tran vdout0_39ck1480 FIND v(dout0_39) AT=745.025n

.meas tran vdout0_40ck1480 FIND v(dout0_40) AT=745.025n

.meas tran vdout0_41ck1480 FIND v(dout0_41) AT=745.025n

.meas tran vdout0_42ck1480 FIND v(dout0_42) AT=745.025n

.meas tran vdout0_43ck1480 FIND v(dout0_43) AT=745.025n

.meas tran vdout0_44ck1480 FIND v(dout0_44) AT=745.025n

.meas tran vdout0_45ck1480 FIND v(dout0_45) AT=745.025n

.meas tran vdout0_46ck1480 FIND v(dout0_46) AT=745.025n

.meas tran vdout0_47ck1480 FIND v(dout0_47) AT=745.025n

.meas tran vdout0_48ck1480 FIND v(dout0_48) AT=745.025n

.meas tran vdout0_49ck1480 FIND v(dout0_49) AT=745.025n

.meas tran vdout0_50ck1480 FIND v(dout0_50) AT=745.025n

.meas tran vdout0_51ck1480 FIND v(dout0_51) AT=745.025n

.meas tran vdout0_52ck1480 FIND v(dout0_52) AT=745.025n

.meas tran vdout0_53ck1480 FIND v(dout0_53) AT=745.025n

.meas tran vdout0_54ck1480 FIND v(dout0_54) AT=745.025n

.meas tran vdout0_55ck1480 FIND v(dout0_55) AT=745.025n

.meas tran vdout0_56ck1480 FIND v(dout0_56) AT=745.025n

.meas tran vdout0_57ck1480 FIND v(dout0_57) AT=745.025n

.meas tran vdout0_58ck1480 FIND v(dout0_58) AT=745.025n

.meas tran vdout0_59ck1480 FIND v(dout0_59) AT=745.025n

.meas tran vdout0_60ck1480 FIND v(dout0_60) AT=745.025n

.meas tran vdout0_61ck1480 FIND v(dout0_61) AT=745.025n

.meas tran vdout0_62ck1480 FIND v(dout0_62) AT=745.025n

.meas tran vdout0_63ck1480 FIND v(dout0_63) AT=745.025n

.meas tran vdout0_0ck1490 FIND v(dout0_0) AT=750.025n

.meas tran vdout0_1ck1490 FIND v(dout0_1) AT=750.025n

.meas tran vdout0_2ck1490 FIND v(dout0_2) AT=750.025n

.meas tran vdout0_3ck1490 FIND v(dout0_3) AT=750.025n

.meas tran vdout0_4ck1490 FIND v(dout0_4) AT=750.025n

.meas tran vdout0_5ck1490 FIND v(dout0_5) AT=750.025n

.meas tran vdout0_6ck1490 FIND v(dout0_6) AT=750.025n

.meas tran vdout0_7ck1490 FIND v(dout0_7) AT=750.025n

.meas tran vdout0_8ck1490 FIND v(dout0_8) AT=750.025n

.meas tran vdout0_9ck1490 FIND v(dout0_9) AT=750.025n

.meas tran vdout0_10ck1490 FIND v(dout0_10) AT=750.025n

.meas tran vdout0_11ck1490 FIND v(dout0_11) AT=750.025n

.meas tran vdout0_12ck1490 FIND v(dout0_12) AT=750.025n

.meas tran vdout0_13ck1490 FIND v(dout0_13) AT=750.025n

.meas tran vdout0_14ck1490 FIND v(dout0_14) AT=750.025n

.meas tran vdout0_15ck1490 FIND v(dout0_15) AT=750.025n

.meas tran vdout0_16ck1490 FIND v(dout0_16) AT=750.025n

.meas tran vdout0_17ck1490 FIND v(dout0_17) AT=750.025n

.meas tran vdout0_18ck1490 FIND v(dout0_18) AT=750.025n

.meas tran vdout0_19ck1490 FIND v(dout0_19) AT=750.025n

.meas tran vdout0_20ck1490 FIND v(dout0_20) AT=750.025n

.meas tran vdout0_21ck1490 FIND v(dout0_21) AT=750.025n

.meas tran vdout0_22ck1490 FIND v(dout0_22) AT=750.025n

.meas tran vdout0_23ck1490 FIND v(dout0_23) AT=750.025n

.meas tran vdout0_24ck1490 FIND v(dout0_24) AT=750.025n

.meas tran vdout0_25ck1490 FIND v(dout0_25) AT=750.025n

.meas tran vdout0_26ck1490 FIND v(dout0_26) AT=750.025n

.meas tran vdout0_27ck1490 FIND v(dout0_27) AT=750.025n

.meas tran vdout0_28ck1490 FIND v(dout0_28) AT=750.025n

.meas tran vdout0_29ck1490 FIND v(dout0_29) AT=750.025n

.meas tran vdout0_30ck1490 FIND v(dout0_30) AT=750.025n

.meas tran vdout0_31ck1490 FIND v(dout0_31) AT=750.025n

.meas tran vdout0_32ck1490 FIND v(dout0_32) AT=750.025n

.meas tran vdout0_33ck1490 FIND v(dout0_33) AT=750.025n

.meas tran vdout0_34ck1490 FIND v(dout0_34) AT=750.025n

.meas tran vdout0_35ck1490 FIND v(dout0_35) AT=750.025n

.meas tran vdout0_36ck1490 FIND v(dout0_36) AT=750.025n

.meas tran vdout0_37ck1490 FIND v(dout0_37) AT=750.025n

.meas tran vdout0_38ck1490 FIND v(dout0_38) AT=750.025n

.meas tran vdout0_39ck1490 FIND v(dout0_39) AT=750.025n

.meas tran vdout0_40ck1490 FIND v(dout0_40) AT=750.025n

.meas tran vdout0_41ck1490 FIND v(dout0_41) AT=750.025n

.meas tran vdout0_42ck1490 FIND v(dout0_42) AT=750.025n

.meas tran vdout0_43ck1490 FIND v(dout0_43) AT=750.025n

.meas tran vdout0_44ck1490 FIND v(dout0_44) AT=750.025n

.meas tran vdout0_45ck1490 FIND v(dout0_45) AT=750.025n

.meas tran vdout0_46ck1490 FIND v(dout0_46) AT=750.025n

.meas tran vdout0_47ck1490 FIND v(dout0_47) AT=750.025n

.meas tran vdout0_48ck1490 FIND v(dout0_48) AT=750.025n

.meas tran vdout0_49ck1490 FIND v(dout0_49) AT=750.025n

.meas tran vdout0_50ck1490 FIND v(dout0_50) AT=750.025n

.meas tran vdout0_51ck1490 FIND v(dout0_51) AT=750.025n

.meas tran vdout0_52ck1490 FIND v(dout0_52) AT=750.025n

.meas tran vdout0_53ck1490 FIND v(dout0_53) AT=750.025n

.meas tran vdout0_54ck1490 FIND v(dout0_54) AT=750.025n

.meas tran vdout0_55ck1490 FIND v(dout0_55) AT=750.025n

.meas tran vdout0_56ck1490 FIND v(dout0_56) AT=750.025n

.meas tran vdout0_57ck1490 FIND v(dout0_57) AT=750.025n

.meas tran vdout0_58ck1490 FIND v(dout0_58) AT=750.025n

.meas tran vdout0_59ck1490 FIND v(dout0_59) AT=750.025n

.meas tran vdout0_60ck1490 FIND v(dout0_60) AT=750.025n

.meas tran vdout0_61ck1490 FIND v(dout0_61) AT=750.025n

.meas tran vdout0_62ck1490 FIND v(dout0_62) AT=750.025n

.meas tran vdout0_63ck1490 FIND v(dout0_63) AT=750.025n

.meas tran vdout0_0ck1500 FIND v(dout0_0) AT=755.025n

.meas tran vdout0_1ck1500 FIND v(dout0_1) AT=755.025n

.meas tran vdout0_2ck1500 FIND v(dout0_2) AT=755.025n

.meas tran vdout0_3ck1500 FIND v(dout0_3) AT=755.025n

.meas tran vdout0_4ck1500 FIND v(dout0_4) AT=755.025n

.meas tran vdout0_5ck1500 FIND v(dout0_5) AT=755.025n

.meas tran vdout0_6ck1500 FIND v(dout0_6) AT=755.025n

.meas tran vdout0_7ck1500 FIND v(dout0_7) AT=755.025n

.meas tran vdout0_8ck1500 FIND v(dout0_8) AT=755.025n

.meas tran vdout0_9ck1500 FIND v(dout0_9) AT=755.025n

.meas tran vdout0_10ck1500 FIND v(dout0_10) AT=755.025n

.meas tran vdout0_11ck1500 FIND v(dout0_11) AT=755.025n

.meas tran vdout0_12ck1500 FIND v(dout0_12) AT=755.025n

.meas tran vdout0_13ck1500 FIND v(dout0_13) AT=755.025n

.meas tran vdout0_14ck1500 FIND v(dout0_14) AT=755.025n

.meas tran vdout0_15ck1500 FIND v(dout0_15) AT=755.025n

.meas tran vdout0_16ck1500 FIND v(dout0_16) AT=755.025n

.meas tran vdout0_17ck1500 FIND v(dout0_17) AT=755.025n

.meas tran vdout0_18ck1500 FIND v(dout0_18) AT=755.025n

.meas tran vdout0_19ck1500 FIND v(dout0_19) AT=755.025n

.meas tran vdout0_20ck1500 FIND v(dout0_20) AT=755.025n

.meas tran vdout0_21ck1500 FIND v(dout0_21) AT=755.025n

.meas tran vdout0_22ck1500 FIND v(dout0_22) AT=755.025n

.meas tran vdout0_23ck1500 FIND v(dout0_23) AT=755.025n

.meas tran vdout0_24ck1500 FIND v(dout0_24) AT=755.025n

.meas tran vdout0_25ck1500 FIND v(dout0_25) AT=755.025n

.meas tran vdout0_26ck1500 FIND v(dout0_26) AT=755.025n

.meas tran vdout0_27ck1500 FIND v(dout0_27) AT=755.025n

.meas tran vdout0_28ck1500 FIND v(dout0_28) AT=755.025n

.meas tran vdout0_29ck1500 FIND v(dout0_29) AT=755.025n

.meas tran vdout0_30ck1500 FIND v(dout0_30) AT=755.025n

.meas tran vdout0_31ck1500 FIND v(dout0_31) AT=755.025n

.meas tran vdout0_32ck1500 FIND v(dout0_32) AT=755.025n

.meas tran vdout0_33ck1500 FIND v(dout0_33) AT=755.025n

.meas tran vdout0_34ck1500 FIND v(dout0_34) AT=755.025n

.meas tran vdout0_35ck1500 FIND v(dout0_35) AT=755.025n

.meas tran vdout0_36ck1500 FIND v(dout0_36) AT=755.025n

.meas tran vdout0_37ck1500 FIND v(dout0_37) AT=755.025n

.meas tran vdout0_38ck1500 FIND v(dout0_38) AT=755.025n

.meas tran vdout0_39ck1500 FIND v(dout0_39) AT=755.025n

.meas tran vdout0_40ck1500 FIND v(dout0_40) AT=755.025n

.meas tran vdout0_41ck1500 FIND v(dout0_41) AT=755.025n

.meas tran vdout0_42ck1500 FIND v(dout0_42) AT=755.025n

.meas tran vdout0_43ck1500 FIND v(dout0_43) AT=755.025n

.meas tran vdout0_44ck1500 FIND v(dout0_44) AT=755.025n

.meas tran vdout0_45ck1500 FIND v(dout0_45) AT=755.025n

.meas tran vdout0_46ck1500 FIND v(dout0_46) AT=755.025n

.meas tran vdout0_47ck1500 FIND v(dout0_47) AT=755.025n

.meas tran vdout0_48ck1500 FIND v(dout0_48) AT=755.025n

.meas tran vdout0_49ck1500 FIND v(dout0_49) AT=755.025n

.meas tran vdout0_50ck1500 FIND v(dout0_50) AT=755.025n

.meas tran vdout0_51ck1500 FIND v(dout0_51) AT=755.025n

.meas tran vdout0_52ck1500 FIND v(dout0_52) AT=755.025n

.meas tran vdout0_53ck1500 FIND v(dout0_53) AT=755.025n

.meas tran vdout0_54ck1500 FIND v(dout0_54) AT=755.025n

.meas tran vdout0_55ck1500 FIND v(dout0_55) AT=755.025n

.meas tran vdout0_56ck1500 FIND v(dout0_56) AT=755.025n

.meas tran vdout0_57ck1500 FIND v(dout0_57) AT=755.025n

.meas tran vdout0_58ck1500 FIND v(dout0_58) AT=755.025n

.meas tran vdout0_59ck1500 FIND v(dout0_59) AT=755.025n

.meas tran vdout0_60ck1500 FIND v(dout0_60) AT=755.025n

.meas tran vdout0_61ck1500 FIND v(dout0_61) AT=755.025n

.meas tran vdout0_62ck1500 FIND v(dout0_62) AT=755.025n

.meas tran vdout0_63ck1500 FIND v(dout0_63) AT=755.025n

.meas tran vdout0_0ck1540 FIND v(dout0_0) AT=775.025n

.meas tran vdout0_1ck1540 FIND v(dout0_1) AT=775.025n

.meas tran vdout0_2ck1540 FIND v(dout0_2) AT=775.025n

.meas tran vdout0_3ck1540 FIND v(dout0_3) AT=775.025n

.meas tran vdout0_4ck1540 FIND v(dout0_4) AT=775.025n

.meas tran vdout0_5ck1540 FIND v(dout0_5) AT=775.025n

.meas tran vdout0_6ck1540 FIND v(dout0_6) AT=775.025n

.meas tran vdout0_7ck1540 FIND v(dout0_7) AT=775.025n

.meas tran vdout0_8ck1540 FIND v(dout0_8) AT=775.025n

.meas tran vdout0_9ck1540 FIND v(dout0_9) AT=775.025n

.meas tran vdout0_10ck1540 FIND v(dout0_10) AT=775.025n

.meas tran vdout0_11ck1540 FIND v(dout0_11) AT=775.025n

.meas tran vdout0_12ck1540 FIND v(dout0_12) AT=775.025n

.meas tran vdout0_13ck1540 FIND v(dout0_13) AT=775.025n

.meas tran vdout0_14ck1540 FIND v(dout0_14) AT=775.025n

.meas tran vdout0_15ck1540 FIND v(dout0_15) AT=775.025n

.meas tran vdout0_16ck1540 FIND v(dout0_16) AT=775.025n

.meas tran vdout0_17ck1540 FIND v(dout0_17) AT=775.025n

.meas tran vdout0_18ck1540 FIND v(dout0_18) AT=775.025n

.meas tran vdout0_19ck1540 FIND v(dout0_19) AT=775.025n

.meas tran vdout0_20ck1540 FIND v(dout0_20) AT=775.025n

.meas tran vdout0_21ck1540 FIND v(dout0_21) AT=775.025n

.meas tran vdout0_22ck1540 FIND v(dout0_22) AT=775.025n

.meas tran vdout0_23ck1540 FIND v(dout0_23) AT=775.025n

.meas tran vdout0_24ck1540 FIND v(dout0_24) AT=775.025n

.meas tran vdout0_25ck1540 FIND v(dout0_25) AT=775.025n

.meas tran vdout0_26ck1540 FIND v(dout0_26) AT=775.025n

.meas tran vdout0_27ck1540 FIND v(dout0_27) AT=775.025n

.meas tran vdout0_28ck1540 FIND v(dout0_28) AT=775.025n

.meas tran vdout0_29ck1540 FIND v(dout0_29) AT=775.025n

.meas tran vdout0_30ck1540 FIND v(dout0_30) AT=775.025n

.meas tran vdout0_31ck1540 FIND v(dout0_31) AT=775.025n

.meas tran vdout0_32ck1540 FIND v(dout0_32) AT=775.025n

.meas tran vdout0_33ck1540 FIND v(dout0_33) AT=775.025n

.meas tran vdout0_34ck1540 FIND v(dout0_34) AT=775.025n

.meas tran vdout0_35ck1540 FIND v(dout0_35) AT=775.025n

.meas tran vdout0_36ck1540 FIND v(dout0_36) AT=775.025n

.meas tran vdout0_37ck1540 FIND v(dout0_37) AT=775.025n

.meas tran vdout0_38ck1540 FIND v(dout0_38) AT=775.025n

.meas tran vdout0_39ck1540 FIND v(dout0_39) AT=775.025n

.meas tran vdout0_40ck1540 FIND v(dout0_40) AT=775.025n

.meas tran vdout0_41ck1540 FIND v(dout0_41) AT=775.025n

.meas tran vdout0_42ck1540 FIND v(dout0_42) AT=775.025n

.meas tran vdout0_43ck1540 FIND v(dout0_43) AT=775.025n

.meas tran vdout0_44ck1540 FIND v(dout0_44) AT=775.025n

.meas tran vdout0_45ck1540 FIND v(dout0_45) AT=775.025n

.meas tran vdout0_46ck1540 FIND v(dout0_46) AT=775.025n

.meas tran vdout0_47ck1540 FIND v(dout0_47) AT=775.025n

.meas tran vdout0_48ck1540 FIND v(dout0_48) AT=775.025n

.meas tran vdout0_49ck1540 FIND v(dout0_49) AT=775.025n

.meas tran vdout0_50ck1540 FIND v(dout0_50) AT=775.025n

.meas tran vdout0_51ck1540 FIND v(dout0_51) AT=775.025n

.meas tran vdout0_52ck1540 FIND v(dout0_52) AT=775.025n

.meas tran vdout0_53ck1540 FIND v(dout0_53) AT=775.025n

.meas tran vdout0_54ck1540 FIND v(dout0_54) AT=775.025n

.meas tran vdout0_55ck1540 FIND v(dout0_55) AT=775.025n

.meas tran vdout0_56ck1540 FIND v(dout0_56) AT=775.025n

.meas tran vdout0_57ck1540 FIND v(dout0_57) AT=775.025n

.meas tran vdout0_58ck1540 FIND v(dout0_58) AT=775.025n

.meas tran vdout0_59ck1540 FIND v(dout0_59) AT=775.025n

.meas tran vdout0_60ck1540 FIND v(dout0_60) AT=775.025n

.meas tran vdout0_61ck1540 FIND v(dout0_61) AT=775.025n

.meas tran vdout0_62ck1540 FIND v(dout0_62) AT=775.025n

.meas tran vdout0_63ck1540 FIND v(dout0_63) AT=775.025n

.meas tran vdout0_0ck1550 FIND v(dout0_0) AT=780.025n

.meas tran vdout0_1ck1550 FIND v(dout0_1) AT=780.025n

.meas tran vdout0_2ck1550 FIND v(dout0_2) AT=780.025n

.meas tran vdout0_3ck1550 FIND v(dout0_3) AT=780.025n

.meas tran vdout0_4ck1550 FIND v(dout0_4) AT=780.025n

.meas tran vdout0_5ck1550 FIND v(dout0_5) AT=780.025n

.meas tran vdout0_6ck1550 FIND v(dout0_6) AT=780.025n

.meas tran vdout0_7ck1550 FIND v(dout0_7) AT=780.025n

.meas tran vdout0_8ck1550 FIND v(dout0_8) AT=780.025n

.meas tran vdout0_9ck1550 FIND v(dout0_9) AT=780.025n

.meas tran vdout0_10ck1550 FIND v(dout0_10) AT=780.025n

.meas tran vdout0_11ck1550 FIND v(dout0_11) AT=780.025n

.meas tran vdout0_12ck1550 FIND v(dout0_12) AT=780.025n

.meas tran vdout0_13ck1550 FIND v(dout0_13) AT=780.025n

.meas tran vdout0_14ck1550 FIND v(dout0_14) AT=780.025n

.meas tran vdout0_15ck1550 FIND v(dout0_15) AT=780.025n

.meas tran vdout0_16ck1550 FIND v(dout0_16) AT=780.025n

.meas tran vdout0_17ck1550 FIND v(dout0_17) AT=780.025n

.meas tran vdout0_18ck1550 FIND v(dout0_18) AT=780.025n

.meas tran vdout0_19ck1550 FIND v(dout0_19) AT=780.025n

.meas tran vdout0_20ck1550 FIND v(dout0_20) AT=780.025n

.meas tran vdout0_21ck1550 FIND v(dout0_21) AT=780.025n

.meas tran vdout0_22ck1550 FIND v(dout0_22) AT=780.025n

.meas tran vdout0_23ck1550 FIND v(dout0_23) AT=780.025n

.meas tran vdout0_24ck1550 FIND v(dout0_24) AT=780.025n

.meas tran vdout0_25ck1550 FIND v(dout0_25) AT=780.025n

.meas tran vdout0_26ck1550 FIND v(dout0_26) AT=780.025n

.meas tran vdout0_27ck1550 FIND v(dout0_27) AT=780.025n

.meas tran vdout0_28ck1550 FIND v(dout0_28) AT=780.025n

.meas tran vdout0_29ck1550 FIND v(dout0_29) AT=780.025n

.meas tran vdout0_30ck1550 FIND v(dout0_30) AT=780.025n

.meas tran vdout0_31ck1550 FIND v(dout0_31) AT=780.025n

.meas tran vdout0_32ck1550 FIND v(dout0_32) AT=780.025n

.meas tran vdout0_33ck1550 FIND v(dout0_33) AT=780.025n

.meas tran vdout0_34ck1550 FIND v(dout0_34) AT=780.025n

.meas tran vdout0_35ck1550 FIND v(dout0_35) AT=780.025n

.meas tran vdout0_36ck1550 FIND v(dout0_36) AT=780.025n

.meas tran vdout0_37ck1550 FIND v(dout0_37) AT=780.025n

.meas tran vdout0_38ck1550 FIND v(dout0_38) AT=780.025n

.meas tran vdout0_39ck1550 FIND v(dout0_39) AT=780.025n

.meas tran vdout0_40ck1550 FIND v(dout0_40) AT=780.025n

.meas tran vdout0_41ck1550 FIND v(dout0_41) AT=780.025n

.meas tran vdout0_42ck1550 FIND v(dout0_42) AT=780.025n

.meas tran vdout0_43ck1550 FIND v(dout0_43) AT=780.025n

.meas tran vdout0_44ck1550 FIND v(dout0_44) AT=780.025n

.meas tran vdout0_45ck1550 FIND v(dout0_45) AT=780.025n

.meas tran vdout0_46ck1550 FIND v(dout0_46) AT=780.025n

.meas tran vdout0_47ck1550 FIND v(dout0_47) AT=780.025n

.meas tran vdout0_48ck1550 FIND v(dout0_48) AT=780.025n

.meas tran vdout0_49ck1550 FIND v(dout0_49) AT=780.025n

.meas tran vdout0_50ck1550 FIND v(dout0_50) AT=780.025n

.meas tran vdout0_51ck1550 FIND v(dout0_51) AT=780.025n

.meas tran vdout0_52ck1550 FIND v(dout0_52) AT=780.025n

.meas tran vdout0_53ck1550 FIND v(dout0_53) AT=780.025n

.meas tran vdout0_54ck1550 FIND v(dout0_54) AT=780.025n

.meas tran vdout0_55ck1550 FIND v(dout0_55) AT=780.025n

.meas tran vdout0_56ck1550 FIND v(dout0_56) AT=780.025n

.meas tran vdout0_57ck1550 FIND v(dout0_57) AT=780.025n

.meas tran vdout0_58ck1550 FIND v(dout0_58) AT=780.025n

.meas tran vdout0_59ck1550 FIND v(dout0_59) AT=780.025n

.meas tran vdout0_60ck1550 FIND v(dout0_60) AT=780.025n

.meas tran vdout0_61ck1550 FIND v(dout0_61) AT=780.025n

.meas tran vdout0_62ck1550 FIND v(dout0_62) AT=780.025n

.meas tran vdout0_63ck1550 FIND v(dout0_63) AT=780.025n

.meas tran vdout0_0ck1570 FIND v(dout0_0) AT=790.025n

.meas tran vdout0_1ck1570 FIND v(dout0_1) AT=790.025n

.meas tran vdout0_2ck1570 FIND v(dout0_2) AT=790.025n

.meas tran vdout0_3ck1570 FIND v(dout0_3) AT=790.025n

.meas tran vdout0_4ck1570 FIND v(dout0_4) AT=790.025n

.meas tran vdout0_5ck1570 FIND v(dout0_5) AT=790.025n

.meas tran vdout0_6ck1570 FIND v(dout0_6) AT=790.025n

.meas tran vdout0_7ck1570 FIND v(dout0_7) AT=790.025n

.meas tran vdout0_8ck1570 FIND v(dout0_8) AT=790.025n

.meas tran vdout0_9ck1570 FIND v(dout0_9) AT=790.025n

.meas tran vdout0_10ck1570 FIND v(dout0_10) AT=790.025n

.meas tran vdout0_11ck1570 FIND v(dout0_11) AT=790.025n

.meas tran vdout0_12ck1570 FIND v(dout0_12) AT=790.025n

.meas tran vdout0_13ck1570 FIND v(dout0_13) AT=790.025n

.meas tran vdout0_14ck1570 FIND v(dout0_14) AT=790.025n

.meas tran vdout0_15ck1570 FIND v(dout0_15) AT=790.025n

.meas tran vdout0_16ck1570 FIND v(dout0_16) AT=790.025n

.meas tran vdout0_17ck1570 FIND v(dout0_17) AT=790.025n

.meas tran vdout0_18ck1570 FIND v(dout0_18) AT=790.025n

.meas tran vdout0_19ck1570 FIND v(dout0_19) AT=790.025n

.meas tran vdout0_20ck1570 FIND v(dout0_20) AT=790.025n

.meas tran vdout0_21ck1570 FIND v(dout0_21) AT=790.025n

.meas tran vdout0_22ck1570 FIND v(dout0_22) AT=790.025n

.meas tran vdout0_23ck1570 FIND v(dout0_23) AT=790.025n

.meas tran vdout0_24ck1570 FIND v(dout0_24) AT=790.025n

.meas tran vdout0_25ck1570 FIND v(dout0_25) AT=790.025n

.meas tran vdout0_26ck1570 FIND v(dout0_26) AT=790.025n

.meas tran vdout0_27ck1570 FIND v(dout0_27) AT=790.025n

.meas tran vdout0_28ck1570 FIND v(dout0_28) AT=790.025n

.meas tran vdout0_29ck1570 FIND v(dout0_29) AT=790.025n

.meas tran vdout0_30ck1570 FIND v(dout0_30) AT=790.025n

.meas tran vdout0_31ck1570 FIND v(dout0_31) AT=790.025n

.meas tran vdout0_32ck1570 FIND v(dout0_32) AT=790.025n

.meas tran vdout0_33ck1570 FIND v(dout0_33) AT=790.025n

.meas tran vdout0_34ck1570 FIND v(dout0_34) AT=790.025n

.meas tran vdout0_35ck1570 FIND v(dout0_35) AT=790.025n

.meas tran vdout0_36ck1570 FIND v(dout0_36) AT=790.025n

.meas tran vdout0_37ck1570 FIND v(dout0_37) AT=790.025n

.meas tran vdout0_38ck1570 FIND v(dout0_38) AT=790.025n

.meas tran vdout0_39ck1570 FIND v(dout0_39) AT=790.025n

.meas tran vdout0_40ck1570 FIND v(dout0_40) AT=790.025n

.meas tran vdout0_41ck1570 FIND v(dout0_41) AT=790.025n

.meas tran vdout0_42ck1570 FIND v(dout0_42) AT=790.025n

.meas tran vdout0_43ck1570 FIND v(dout0_43) AT=790.025n

.meas tran vdout0_44ck1570 FIND v(dout0_44) AT=790.025n

.meas tran vdout0_45ck1570 FIND v(dout0_45) AT=790.025n

.meas tran vdout0_46ck1570 FIND v(dout0_46) AT=790.025n

.meas tran vdout0_47ck1570 FIND v(dout0_47) AT=790.025n

.meas tran vdout0_48ck1570 FIND v(dout0_48) AT=790.025n

.meas tran vdout0_49ck1570 FIND v(dout0_49) AT=790.025n

.meas tran vdout0_50ck1570 FIND v(dout0_50) AT=790.025n

.meas tran vdout0_51ck1570 FIND v(dout0_51) AT=790.025n

.meas tran vdout0_52ck1570 FIND v(dout0_52) AT=790.025n

.meas tran vdout0_53ck1570 FIND v(dout0_53) AT=790.025n

.meas tran vdout0_54ck1570 FIND v(dout0_54) AT=790.025n

.meas tran vdout0_55ck1570 FIND v(dout0_55) AT=790.025n

.meas tran vdout0_56ck1570 FIND v(dout0_56) AT=790.025n

.meas tran vdout0_57ck1570 FIND v(dout0_57) AT=790.025n

.meas tran vdout0_58ck1570 FIND v(dout0_58) AT=790.025n

.meas tran vdout0_59ck1570 FIND v(dout0_59) AT=790.025n

.meas tran vdout0_60ck1570 FIND v(dout0_60) AT=790.025n

.meas tran vdout0_61ck1570 FIND v(dout0_61) AT=790.025n

.meas tran vdout0_62ck1570 FIND v(dout0_62) AT=790.025n

.meas tran vdout0_63ck1570 FIND v(dout0_63) AT=790.025n

.meas tran vdout0_0ck1620 FIND v(dout0_0) AT=815.025n

.meas tran vdout0_1ck1620 FIND v(dout0_1) AT=815.025n

.meas tran vdout0_2ck1620 FIND v(dout0_2) AT=815.025n

.meas tran vdout0_3ck1620 FIND v(dout0_3) AT=815.025n

.meas tran vdout0_4ck1620 FIND v(dout0_4) AT=815.025n

.meas tran vdout0_5ck1620 FIND v(dout0_5) AT=815.025n

.meas tran vdout0_6ck1620 FIND v(dout0_6) AT=815.025n

.meas tran vdout0_7ck1620 FIND v(dout0_7) AT=815.025n

.meas tran vdout0_8ck1620 FIND v(dout0_8) AT=815.025n

.meas tran vdout0_9ck1620 FIND v(dout0_9) AT=815.025n

.meas tran vdout0_10ck1620 FIND v(dout0_10) AT=815.025n

.meas tran vdout0_11ck1620 FIND v(dout0_11) AT=815.025n

.meas tran vdout0_12ck1620 FIND v(dout0_12) AT=815.025n

.meas tran vdout0_13ck1620 FIND v(dout0_13) AT=815.025n

.meas tran vdout0_14ck1620 FIND v(dout0_14) AT=815.025n

.meas tran vdout0_15ck1620 FIND v(dout0_15) AT=815.025n

.meas tran vdout0_16ck1620 FIND v(dout0_16) AT=815.025n

.meas tran vdout0_17ck1620 FIND v(dout0_17) AT=815.025n

.meas tran vdout0_18ck1620 FIND v(dout0_18) AT=815.025n

.meas tran vdout0_19ck1620 FIND v(dout0_19) AT=815.025n

.meas tran vdout0_20ck1620 FIND v(dout0_20) AT=815.025n

.meas tran vdout0_21ck1620 FIND v(dout0_21) AT=815.025n

.meas tran vdout0_22ck1620 FIND v(dout0_22) AT=815.025n

.meas tran vdout0_23ck1620 FIND v(dout0_23) AT=815.025n

.meas tran vdout0_24ck1620 FIND v(dout0_24) AT=815.025n

.meas tran vdout0_25ck1620 FIND v(dout0_25) AT=815.025n

.meas tran vdout0_26ck1620 FIND v(dout0_26) AT=815.025n

.meas tran vdout0_27ck1620 FIND v(dout0_27) AT=815.025n

.meas tran vdout0_28ck1620 FIND v(dout0_28) AT=815.025n

.meas tran vdout0_29ck1620 FIND v(dout0_29) AT=815.025n

.meas tran vdout0_30ck1620 FIND v(dout0_30) AT=815.025n

.meas tran vdout0_31ck1620 FIND v(dout0_31) AT=815.025n

.meas tran vdout0_32ck1620 FIND v(dout0_32) AT=815.025n

.meas tran vdout0_33ck1620 FIND v(dout0_33) AT=815.025n

.meas tran vdout0_34ck1620 FIND v(dout0_34) AT=815.025n

.meas tran vdout0_35ck1620 FIND v(dout0_35) AT=815.025n

.meas tran vdout0_36ck1620 FIND v(dout0_36) AT=815.025n

.meas tran vdout0_37ck1620 FIND v(dout0_37) AT=815.025n

.meas tran vdout0_38ck1620 FIND v(dout0_38) AT=815.025n

.meas tran vdout0_39ck1620 FIND v(dout0_39) AT=815.025n

.meas tran vdout0_40ck1620 FIND v(dout0_40) AT=815.025n

.meas tran vdout0_41ck1620 FIND v(dout0_41) AT=815.025n

.meas tran vdout0_42ck1620 FIND v(dout0_42) AT=815.025n

.meas tran vdout0_43ck1620 FIND v(dout0_43) AT=815.025n

.meas tran vdout0_44ck1620 FIND v(dout0_44) AT=815.025n

.meas tran vdout0_45ck1620 FIND v(dout0_45) AT=815.025n

.meas tran vdout0_46ck1620 FIND v(dout0_46) AT=815.025n

.meas tran vdout0_47ck1620 FIND v(dout0_47) AT=815.025n

.meas tran vdout0_48ck1620 FIND v(dout0_48) AT=815.025n

.meas tran vdout0_49ck1620 FIND v(dout0_49) AT=815.025n

.meas tran vdout0_50ck1620 FIND v(dout0_50) AT=815.025n

.meas tran vdout0_51ck1620 FIND v(dout0_51) AT=815.025n

.meas tran vdout0_52ck1620 FIND v(dout0_52) AT=815.025n

.meas tran vdout0_53ck1620 FIND v(dout0_53) AT=815.025n

.meas tran vdout0_54ck1620 FIND v(dout0_54) AT=815.025n

.meas tran vdout0_55ck1620 FIND v(dout0_55) AT=815.025n

.meas tran vdout0_56ck1620 FIND v(dout0_56) AT=815.025n

.meas tran vdout0_57ck1620 FIND v(dout0_57) AT=815.025n

.meas tran vdout0_58ck1620 FIND v(dout0_58) AT=815.025n

.meas tran vdout0_59ck1620 FIND v(dout0_59) AT=815.025n

.meas tran vdout0_60ck1620 FIND v(dout0_60) AT=815.025n

.meas tran vdout0_61ck1620 FIND v(dout0_61) AT=815.025n

.meas tran vdout0_62ck1620 FIND v(dout0_62) AT=815.025n

.meas tran vdout0_63ck1620 FIND v(dout0_63) AT=815.025n

.meas tran vdout0_0ck1640 FIND v(dout0_0) AT=825.025n

.meas tran vdout0_1ck1640 FIND v(dout0_1) AT=825.025n

.meas tran vdout0_2ck1640 FIND v(dout0_2) AT=825.025n

.meas tran vdout0_3ck1640 FIND v(dout0_3) AT=825.025n

.meas tran vdout0_4ck1640 FIND v(dout0_4) AT=825.025n

.meas tran vdout0_5ck1640 FIND v(dout0_5) AT=825.025n

.meas tran vdout0_6ck1640 FIND v(dout0_6) AT=825.025n

.meas tran vdout0_7ck1640 FIND v(dout0_7) AT=825.025n

.meas tran vdout0_8ck1640 FIND v(dout0_8) AT=825.025n

.meas tran vdout0_9ck1640 FIND v(dout0_9) AT=825.025n

.meas tran vdout0_10ck1640 FIND v(dout0_10) AT=825.025n

.meas tran vdout0_11ck1640 FIND v(dout0_11) AT=825.025n

.meas tran vdout0_12ck1640 FIND v(dout0_12) AT=825.025n

.meas tran vdout0_13ck1640 FIND v(dout0_13) AT=825.025n

.meas tran vdout0_14ck1640 FIND v(dout0_14) AT=825.025n

.meas tran vdout0_15ck1640 FIND v(dout0_15) AT=825.025n

.meas tran vdout0_16ck1640 FIND v(dout0_16) AT=825.025n

.meas tran vdout0_17ck1640 FIND v(dout0_17) AT=825.025n

.meas tran vdout0_18ck1640 FIND v(dout0_18) AT=825.025n

.meas tran vdout0_19ck1640 FIND v(dout0_19) AT=825.025n

.meas tran vdout0_20ck1640 FIND v(dout0_20) AT=825.025n

.meas tran vdout0_21ck1640 FIND v(dout0_21) AT=825.025n

.meas tran vdout0_22ck1640 FIND v(dout0_22) AT=825.025n

.meas tran vdout0_23ck1640 FIND v(dout0_23) AT=825.025n

.meas tran vdout0_24ck1640 FIND v(dout0_24) AT=825.025n

.meas tran vdout0_25ck1640 FIND v(dout0_25) AT=825.025n

.meas tran vdout0_26ck1640 FIND v(dout0_26) AT=825.025n

.meas tran vdout0_27ck1640 FIND v(dout0_27) AT=825.025n

.meas tran vdout0_28ck1640 FIND v(dout0_28) AT=825.025n

.meas tran vdout0_29ck1640 FIND v(dout0_29) AT=825.025n

.meas tran vdout0_30ck1640 FIND v(dout0_30) AT=825.025n

.meas tran vdout0_31ck1640 FIND v(dout0_31) AT=825.025n

.meas tran vdout0_32ck1640 FIND v(dout0_32) AT=825.025n

.meas tran vdout0_33ck1640 FIND v(dout0_33) AT=825.025n

.meas tran vdout0_34ck1640 FIND v(dout0_34) AT=825.025n

.meas tran vdout0_35ck1640 FIND v(dout0_35) AT=825.025n

.meas tran vdout0_36ck1640 FIND v(dout0_36) AT=825.025n

.meas tran vdout0_37ck1640 FIND v(dout0_37) AT=825.025n

.meas tran vdout0_38ck1640 FIND v(dout0_38) AT=825.025n

.meas tran vdout0_39ck1640 FIND v(dout0_39) AT=825.025n

.meas tran vdout0_40ck1640 FIND v(dout0_40) AT=825.025n

.meas tran vdout0_41ck1640 FIND v(dout0_41) AT=825.025n

.meas tran vdout0_42ck1640 FIND v(dout0_42) AT=825.025n

.meas tran vdout0_43ck1640 FIND v(dout0_43) AT=825.025n

.meas tran vdout0_44ck1640 FIND v(dout0_44) AT=825.025n

.meas tran vdout0_45ck1640 FIND v(dout0_45) AT=825.025n

.meas tran vdout0_46ck1640 FIND v(dout0_46) AT=825.025n

.meas tran vdout0_47ck1640 FIND v(dout0_47) AT=825.025n

.meas tran vdout0_48ck1640 FIND v(dout0_48) AT=825.025n

.meas tran vdout0_49ck1640 FIND v(dout0_49) AT=825.025n

.meas tran vdout0_50ck1640 FIND v(dout0_50) AT=825.025n

.meas tran vdout0_51ck1640 FIND v(dout0_51) AT=825.025n

.meas tran vdout0_52ck1640 FIND v(dout0_52) AT=825.025n

.meas tran vdout0_53ck1640 FIND v(dout0_53) AT=825.025n

.meas tran vdout0_54ck1640 FIND v(dout0_54) AT=825.025n

.meas tran vdout0_55ck1640 FIND v(dout0_55) AT=825.025n

.meas tran vdout0_56ck1640 FIND v(dout0_56) AT=825.025n

.meas tran vdout0_57ck1640 FIND v(dout0_57) AT=825.025n

.meas tran vdout0_58ck1640 FIND v(dout0_58) AT=825.025n

.meas tran vdout0_59ck1640 FIND v(dout0_59) AT=825.025n

.meas tran vdout0_60ck1640 FIND v(dout0_60) AT=825.025n

.meas tran vdout0_61ck1640 FIND v(dout0_61) AT=825.025n

.meas tran vdout0_62ck1640 FIND v(dout0_62) AT=825.025n

.meas tran vdout0_63ck1640 FIND v(dout0_63) AT=825.025n

.meas tran vdout0_0ck1710 FIND v(dout0_0) AT=860.025n

.meas tran vdout0_1ck1710 FIND v(dout0_1) AT=860.025n

.meas tran vdout0_2ck1710 FIND v(dout0_2) AT=860.025n

.meas tran vdout0_3ck1710 FIND v(dout0_3) AT=860.025n

.meas tran vdout0_4ck1710 FIND v(dout0_4) AT=860.025n

.meas tran vdout0_5ck1710 FIND v(dout0_5) AT=860.025n

.meas tran vdout0_6ck1710 FIND v(dout0_6) AT=860.025n

.meas tran vdout0_7ck1710 FIND v(dout0_7) AT=860.025n

.meas tran vdout0_8ck1710 FIND v(dout0_8) AT=860.025n

.meas tran vdout0_9ck1710 FIND v(dout0_9) AT=860.025n

.meas tran vdout0_10ck1710 FIND v(dout0_10) AT=860.025n

.meas tran vdout0_11ck1710 FIND v(dout0_11) AT=860.025n

.meas tran vdout0_12ck1710 FIND v(dout0_12) AT=860.025n

.meas tran vdout0_13ck1710 FIND v(dout0_13) AT=860.025n

.meas tran vdout0_14ck1710 FIND v(dout0_14) AT=860.025n

.meas tran vdout0_15ck1710 FIND v(dout0_15) AT=860.025n

.meas tran vdout0_16ck1710 FIND v(dout0_16) AT=860.025n

.meas tran vdout0_17ck1710 FIND v(dout0_17) AT=860.025n

.meas tran vdout0_18ck1710 FIND v(dout0_18) AT=860.025n

.meas tran vdout0_19ck1710 FIND v(dout0_19) AT=860.025n

.meas tran vdout0_20ck1710 FIND v(dout0_20) AT=860.025n

.meas tran vdout0_21ck1710 FIND v(dout0_21) AT=860.025n

.meas tran vdout0_22ck1710 FIND v(dout0_22) AT=860.025n

.meas tran vdout0_23ck1710 FIND v(dout0_23) AT=860.025n

.meas tran vdout0_24ck1710 FIND v(dout0_24) AT=860.025n

.meas tran vdout0_25ck1710 FIND v(dout0_25) AT=860.025n

.meas tran vdout0_26ck1710 FIND v(dout0_26) AT=860.025n

.meas tran vdout0_27ck1710 FIND v(dout0_27) AT=860.025n

.meas tran vdout0_28ck1710 FIND v(dout0_28) AT=860.025n

.meas tran vdout0_29ck1710 FIND v(dout0_29) AT=860.025n

.meas tran vdout0_30ck1710 FIND v(dout0_30) AT=860.025n

.meas tran vdout0_31ck1710 FIND v(dout0_31) AT=860.025n

.meas tran vdout0_32ck1710 FIND v(dout0_32) AT=860.025n

.meas tran vdout0_33ck1710 FIND v(dout0_33) AT=860.025n

.meas tran vdout0_34ck1710 FIND v(dout0_34) AT=860.025n

.meas tran vdout0_35ck1710 FIND v(dout0_35) AT=860.025n

.meas tran vdout0_36ck1710 FIND v(dout0_36) AT=860.025n

.meas tran vdout0_37ck1710 FIND v(dout0_37) AT=860.025n

.meas tran vdout0_38ck1710 FIND v(dout0_38) AT=860.025n

.meas tran vdout0_39ck1710 FIND v(dout0_39) AT=860.025n

.meas tran vdout0_40ck1710 FIND v(dout0_40) AT=860.025n

.meas tran vdout0_41ck1710 FIND v(dout0_41) AT=860.025n

.meas tran vdout0_42ck1710 FIND v(dout0_42) AT=860.025n

.meas tran vdout0_43ck1710 FIND v(dout0_43) AT=860.025n

.meas tran vdout0_44ck1710 FIND v(dout0_44) AT=860.025n

.meas tran vdout0_45ck1710 FIND v(dout0_45) AT=860.025n

.meas tran vdout0_46ck1710 FIND v(dout0_46) AT=860.025n

.meas tran vdout0_47ck1710 FIND v(dout0_47) AT=860.025n

.meas tran vdout0_48ck1710 FIND v(dout0_48) AT=860.025n

.meas tran vdout0_49ck1710 FIND v(dout0_49) AT=860.025n

.meas tran vdout0_50ck1710 FIND v(dout0_50) AT=860.025n

.meas tran vdout0_51ck1710 FIND v(dout0_51) AT=860.025n

.meas tran vdout0_52ck1710 FIND v(dout0_52) AT=860.025n

.meas tran vdout0_53ck1710 FIND v(dout0_53) AT=860.025n

.meas tran vdout0_54ck1710 FIND v(dout0_54) AT=860.025n

.meas tran vdout0_55ck1710 FIND v(dout0_55) AT=860.025n

.meas tran vdout0_56ck1710 FIND v(dout0_56) AT=860.025n

.meas tran vdout0_57ck1710 FIND v(dout0_57) AT=860.025n

.meas tran vdout0_58ck1710 FIND v(dout0_58) AT=860.025n

.meas tran vdout0_59ck1710 FIND v(dout0_59) AT=860.025n

.meas tran vdout0_60ck1710 FIND v(dout0_60) AT=860.025n

.meas tran vdout0_61ck1710 FIND v(dout0_61) AT=860.025n

.meas tran vdout0_62ck1710 FIND v(dout0_62) AT=860.025n

.meas tran vdout0_63ck1710 FIND v(dout0_63) AT=860.025n

.meas tran vdout0_0ck1740 FIND v(dout0_0) AT=875.025n

.meas tran vdout0_1ck1740 FIND v(dout0_1) AT=875.025n

.meas tran vdout0_2ck1740 FIND v(dout0_2) AT=875.025n

.meas tran vdout0_3ck1740 FIND v(dout0_3) AT=875.025n

.meas tran vdout0_4ck1740 FIND v(dout0_4) AT=875.025n

.meas tran vdout0_5ck1740 FIND v(dout0_5) AT=875.025n

.meas tran vdout0_6ck1740 FIND v(dout0_6) AT=875.025n

.meas tran vdout0_7ck1740 FIND v(dout0_7) AT=875.025n

.meas tran vdout0_8ck1740 FIND v(dout0_8) AT=875.025n

.meas tran vdout0_9ck1740 FIND v(dout0_9) AT=875.025n

.meas tran vdout0_10ck1740 FIND v(dout0_10) AT=875.025n

.meas tran vdout0_11ck1740 FIND v(dout0_11) AT=875.025n

.meas tran vdout0_12ck1740 FIND v(dout0_12) AT=875.025n

.meas tran vdout0_13ck1740 FIND v(dout0_13) AT=875.025n

.meas tran vdout0_14ck1740 FIND v(dout0_14) AT=875.025n

.meas tran vdout0_15ck1740 FIND v(dout0_15) AT=875.025n

.meas tran vdout0_16ck1740 FIND v(dout0_16) AT=875.025n

.meas tran vdout0_17ck1740 FIND v(dout0_17) AT=875.025n

.meas tran vdout0_18ck1740 FIND v(dout0_18) AT=875.025n

.meas tran vdout0_19ck1740 FIND v(dout0_19) AT=875.025n

.meas tran vdout0_20ck1740 FIND v(dout0_20) AT=875.025n

.meas tran vdout0_21ck1740 FIND v(dout0_21) AT=875.025n

.meas tran vdout0_22ck1740 FIND v(dout0_22) AT=875.025n

.meas tran vdout0_23ck1740 FIND v(dout0_23) AT=875.025n

.meas tran vdout0_24ck1740 FIND v(dout0_24) AT=875.025n

.meas tran vdout0_25ck1740 FIND v(dout0_25) AT=875.025n

.meas tran vdout0_26ck1740 FIND v(dout0_26) AT=875.025n

.meas tran vdout0_27ck1740 FIND v(dout0_27) AT=875.025n

.meas tran vdout0_28ck1740 FIND v(dout0_28) AT=875.025n

.meas tran vdout0_29ck1740 FIND v(dout0_29) AT=875.025n

.meas tran vdout0_30ck1740 FIND v(dout0_30) AT=875.025n

.meas tran vdout0_31ck1740 FIND v(dout0_31) AT=875.025n

.meas tran vdout0_32ck1740 FIND v(dout0_32) AT=875.025n

.meas tran vdout0_33ck1740 FIND v(dout0_33) AT=875.025n

.meas tran vdout0_34ck1740 FIND v(dout0_34) AT=875.025n

.meas tran vdout0_35ck1740 FIND v(dout0_35) AT=875.025n

.meas tran vdout0_36ck1740 FIND v(dout0_36) AT=875.025n

.meas tran vdout0_37ck1740 FIND v(dout0_37) AT=875.025n

.meas tran vdout0_38ck1740 FIND v(dout0_38) AT=875.025n

.meas tran vdout0_39ck1740 FIND v(dout0_39) AT=875.025n

.meas tran vdout0_40ck1740 FIND v(dout0_40) AT=875.025n

.meas tran vdout0_41ck1740 FIND v(dout0_41) AT=875.025n

.meas tran vdout0_42ck1740 FIND v(dout0_42) AT=875.025n

.meas tran vdout0_43ck1740 FIND v(dout0_43) AT=875.025n

.meas tran vdout0_44ck1740 FIND v(dout0_44) AT=875.025n

.meas tran vdout0_45ck1740 FIND v(dout0_45) AT=875.025n

.meas tran vdout0_46ck1740 FIND v(dout0_46) AT=875.025n

.meas tran vdout0_47ck1740 FIND v(dout0_47) AT=875.025n

.meas tran vdout0_48ck1740 FIND v(dout0_48) AT=875.025n

.meas tran vdout0_49ck1740 FIND v(dout0_49) AT=875.025n

.meas tran vdout0_50ck1740 FIND v(dout0_50) AT=875.025n

.meas tran vdout0_51ck1740 FIND v(dout0_51) AT=875.025n

.meas tran vdout0_52ck1740 FIND v(dout0_52) AT=875.025n

.meas tran vdout0_53ck1740 FIND v(dout0_53) AT=875.025n

.meas tran vdout0_54ck1740 FIND v(dout0_54) AT=875.025n

.meas tran vdout0_55ck1740 FIND v(dout0_55) AT=875.025n

.meas tran vdout0_56ck1740 FIND v(dout0_56) AT=875.025n

.meas tran vdout0_57ck1740 FIND v(dout0_57) AT=875.025n

.meas tran vdout0_58ck1740 FIND v(dout0_58) AT=875.025n

.meas tran vdout0_59ck1740 FIND v(dout0_59) AT=875.025n

.meas tran vdout0_60ck1740 FIND v(dout0_60) AT=875.025n

.meas tran vdout0_61ck1740 FIND v(dout0_61) AT=875.025n

.meas tran vdout0_62ck1740 FIND v(dout0_62) AT=875.025n

.meas tran vdout0_63ck1740 FIND v(dout0_63) AT=875.025n

.meas tran vdout0_0ck1760 FIND v(dout0_0) AT=885.025n

.meas tran vdout0_1ck1760 FIND v(dout0_1) AT=885.025n

.meas tran vdout0_2ck1760 FIND v(dout0_2) AT=885.025n

.meas tran vdout0_3ck1760 FIND v(dout0_3) AT=885.025n

.meas tran vdout0_4ck1760 FIND v(dout0_4) AT=885.025n

.meas tran vdout0_5ck1760 FIND v(dout0_5) AT=885.025n

.meas tran vdout0_6ck1760 FIND v(dout0_6) AT=885.025n

.meas tran vdout0_7ck1760 FIND v(dout0_7) AT=885.025n

.meas tran vdout0_8ck1760 FIND v(dout0_8) AT=885.025n

.meas tran vdout0_9ck1760 FIND v(dout0_9) AT=885.025n

.meas tran vdout0_10ck1760 FIND v(dout0_10) AT=885.025n

.meas tran vdout0_11ck1760 FIND v(dout0_11) AT=885.025n

.meas tran vdout0_12ck1760 FIND v(dout0_12) AT=885.025n

.meas tran vdout0_13ck1760 FIND v(dout0_13) AT=885.025n

.meas tran vdout0_14ck1760 FIND v(dout0_14) AT=885.025n

.meas tran vdout0_15ck1760 FIND v(dout0_15) AT=885.025n

.meas tran vdout0_16ck1760 FIND v(dout0_16) AT=885.025n

.meas tran vdout0_17ck1760 FIND v(dout0_17) AT=885.025n

.meas tran vdout0_18ck1760 FIND v(dout0_18) AT=885.025n

.meas tran vdout0_19ck1760 FIND v(dout0_19) AT=885.025n

.meas tran vdout0_20ck1760 FIND v(dout0_20) AT=885.025n

.meas tran vdout0_21ck1760 FIND v(dout0_21) AT=885.025n

.meas tran vdout0_22ck1760 FIND v(dout0_22) AT=885.025n

.meas tran vdout0_23ck1760 FIND v(dout0_23) AT=885.025n

.meas tran vdout0_24ck1760 FIND v(dout0_24) AT=885.025n

.meas tran vdout0_25ck1760 FIND v(dout0_25) AT=885.025n

.meas tran vdout0_26ck1760 FIND v(dout0_26) AT=885.025n

.meas tran vdout0_27ck1760 FIND v(dout0_27) AT=885.025n

.meas tran vdout0_28ck1760 FIND v(dout0_28) AT=885.025n

.meas tran vdout0_29ck1760 FIND v(dout0_29) AT=885.025n

.meas tran vdout0_30ck1760 FIND v(dout0_30) AT=885.025n

.meas tran vdout0_31ck1760 FIND v(dout0_31) AT=885.025n

.meas tran vdout0_32ck1760 FIND v(dout0_32) AT=885.025n

.meas tran vdout0_33ck1760 FIND v(dout0_33) AT=885.025n

.meas tran vdout0_34ck1760 FIND v(dout0_34) AT=885.025n

.meas tran vdout0_35ck1760 FIND v(dout0_35) AT=885.025n

.meas tran vdout0_36ck1760 FIND v(dout0_36) AT=885.025n

.meas tran vdout0_37ck1760 FIND v(dout0_37) AT=885.025n

.meas tran vdout0_38ck1760 FIND v(dout0_38) AT=885.025n

.meas tran vdout0_39ck1760 FIND v(dout0_39) AT=885.025n

.meas tran vdout0_40ck1760 FIND v(dout0_40) AT=885.025n

.meas tran vdout0_41ck1760 FIND v(dout0_41) AT=885.025n

.meas tran vdout0_42ck1760 FIND v(dout0_42) AT=885.025n

.meas tran vdout0_43ck1760 FIND v(dout0_43) AT=885.025n

.meas tran vdout0_44ck1760 FIND v(dout0_44) AT=885.025n

.meas tran vdout0_45ck1760 FIND v(dout0_45) AT=885.025n

.meas tran vdout0_46ck1760 FIND v(dout0_46) AT=885.025n

.meas tran vdout0_47ck1760 FIND v(dout0_47) AT=885.025n

.meas tran vdout0_48ck1760 FIND v(dout0_48) AT=885.025n

.meas tran vdout0_49ck1760 FIND v(dout0_49) AT=885.025n

.meas tran vdout0_50ck1760 FIND v(dout0_50) AT=885.025n

.meas tran vdout0_51ck1760 FIND v(dout0_51) AT=885.025n

.meas tran vdout0_52ck1760 FIND v(dout0_52) AT=885.025n

.meas tran vdout0_53ck1760 FIND v(dout0_53) AT=885.025n

.meas tran vdout0_54ck1760 FIND v(dout0_54) AT=885.025n

.meas tran vdout0_55ck1760 FIND v(dout0_55) AT=885.025n

.meas tran vdout0_56ck1760 FIND v(dout0_56) AT=885.025n

.meas tran vdout0_57ck1760 FIND v(dout0_57) AT=885.025n

.meas tran vdout0_58ck1760 FIND v(dout0_58) AT=885.025n

.meas tran vdout0_59ck1760 FIND v(dout0_59) AT=885.025n

.meas tran vdout0_60ck1760 FIND v(dout0_60) AT=885.025n

.meas tran vdout0_61ck1760 FIND v(dout0_61) AT=885.025n

.meas tran vdout0_62ck1760 FIND v(dout0_62) AT=885.025n

.meas tran vdout0_63ck1760 FIND v(dout0_63) AT=885.025n

.meas tran vdout0_0ck1780 FIND v(dout0_0) AT=895.025n

.meas tran vdout0_1ck1780 FIND v(dout0_1) AT=895.025n

.meas tran vdout0_2ck1780 FIND v(dout0_2) AT=895.025n

.meas tran vdout0_3ck1780 FIND v(dout0_3) AT=895.025n

.meas tran vdout0_4ck1780 FIND v(dout0_4) AT=895.025n

.meas tran vdout0_5ck1780 FIND v(dout0_5) AT=895.025n

.meas tran vdout0_6ck1780 FIND v(dout0_6) AT=895.025n

.meas tran vdout0_7ck1780 FIND v(dout0_7) AT=895.025n

.meas tran vdout0_8ck1780 FIND v(dout0_8) AT=895.025n

.meas tran vdout0_9ck1780 FIND v(dout0_9) AT=895.025n

.meas tran vdout0_10ck1780 FIND v(dout0_10) AT=895.025n

.meas tran vdout0_11ck1780 FIND v(dout0_11) AT=895.025n

.meas tran vdout0_12ck1780 FIND v(dout0_12) AT=895.025n

.meas tran vdout0_13ck1780 FIND v(dout0_13) AT=895.025n

.meas tran vdout0_14ck1780 FIND v(dout0_14) AT=895.025n

.meas tran vdout0_15ck1780 FIND v(dout0_15) AT=895.025n

.meas tran vdout0_16ck1780 FIND v(dout0_16) AT=895.025n

.meas tran vdout0_17ck1780 FIND v(dout0_17) AT=895.025n

.meas tran vdout0_18ck1780 FIND v(dout0_18) AT=895.025n

.meas tran vdout0_19ck1780 FIND v(dout0_19) AT=895.025n

.meas tran vdout0_20ck1780 FIND v(dout0_20) AT=895.025n

.meas tran vdout0_21ck1780 FIND v(dout0_21) AT=895.025n

.meas tran vdout0_22ck1780 FIND v(dout0_22) AT=895.025n

.meas tran vdout0_23ck1780 FIND v(dout0_23) AT=895.025n

.meas tran vdout0_24ck1780 FIND v(dout0_24) AT=895.025n

.meas tran vdout0_25ck1780 FIND v(dout0_25) AT=895.025n

.meas tran vdout0_26ck1780 FIND v(dout0_26) AT=895.025n

.meas tran vdout0_27ck1780 FIND v(dout0_27) AT=895.025n

.meas tran vdout0_28ck1780 FIND v(dout0_28) AT=895.025n

.meas tran vdout0_29ck1780 FIND v(dout0_29) AT=895.025n

.meas tran vdout0_30ck1780 FIND v(dout0_30) AT=895.025n

.meas tran vdout0_31ck1780 FIND v(dout0_31) AT=895.025n

.meas tran vdout0_32ck1780 FIND v(dout0_32) AT=895.025n

.meas tran vdout0_33ck1780 FIND v(dout0_33) AT=895.025n

.meas tran vdout0_34ck1780 FIND v(dout0_34) AT=895.025n

.meas tran vdout0_35ck1780 FIND v(dout0_35) AT=895.025n

.meas tran vdout0_36ck1780 FIND v(dout0_36) AT=895.025n

.meas tran vdout0_37ck1780 FIND v(dout0_37) AT=895.025n

.meas tran vdout0_38ck1780 FIND v(dout0_38) AT=895.025n

.meas tran vdout0_39ck1780 FIND v(dout0_39) AT=895.025n

.meas tran vdout0_40ck1780 FIND v(dout0_40) AT=895.025n

.meas tran vdout0_41ck1780 FIND v(dout0_41) AT=895.025n

.meas tran vdout0_42ck1780 FIND v(dout0_42) AT=895.025n

.meas tran vdout0_43ck1780 FIND v(dout0_43) AT=895.025n

.meas tran vdout0_44ck1780 FIND v(dout0_44) AT=895.025n

.meas tran vdout0_45ck1780 FIND v(dout0_45) AT=895.025n

.meas tran vdout0_46ck1780 FIND v(dout0_46) AT=895.025n

.meas tran vdout0_47ck1780 FIND v(dout0_47) AT=895.025n

.meas tran vdout0_48ck1780 FIND v(dout0_48) AT=895.025n

.meas tran vdout0_49ck1780 FIND v(dout0_49) AT=895.025n

.meas tran vdout0_50ck1780 FIND v(dout0_50) AT=895.025n

.meas tran vdout0_51ck1780 FIND v(dout0_51) AT=895.025n

.meas tran vdout0_52ck1780 FIND v(dout0_52) AT=895.025n

.meas tran vdout0_53ck1780 FIND v(dout0_53) AT=895.025n

.meas tran vdout0_54ck1780 FIND v(dout0_54) AT=895.025n

.meas tran vdout0_55ck1780 FIND v(dout0_55) AT=895.025n

.meas tran vdout0_56ck1780 FIND v(dout0_56) AT=895.025n

.meas tran vdout0_57ck1780 FIND v(dout0_57) AT=895.025n

.meas tran vdout0_58ck1780 FIND v(dout0_58) AT=895.025n

.meas tran vdout0_59ck1780 FIND v(dout0_59) AT=895.025n

.meas tran vdout0_60ck1780 FIND v(dout0_60) AT=895.025n

.meas tran vdout0_61ck1780 FIND v(dout0_61) AT=895.025n

.meas tran vdout0_62ck1780 FIND v(dout0_62) AT=895.025n

.meas tran vdout0_63ck1780 FIND v(dout0_63) AT=895.025n

.meas tran vdout0_0ck1820 FIND v(dout0_0) AT=915.025n

.meas tran vdout0_1ck1820 FIND v(dout0_1) AT=915.025n

.meas tran vdout0_2ck1820 FIND v(dout0_2) AT=915.025n

.meas tran vdout0_3ck1820 FIND v(dout0_3) AT=915.025n

.meas tran vdout0_4ck1820 FIND v(dout0_4) AT=915.025n

.meas tran vdout0_5ck1820 FIND v(dout0_5) AT=915.025n

.meas tran vdout0_6ck1820 FIND v(dout0_6) AT=915.025n

.meas tran vdout0_7ck1820 FIND v(dout0_7) AT=915.025n

.meas tran vdout0_8ck1820 FIND v(dout0_8) AT=915.025n

.meas tran vdout0_9ck1820 FIND v(dout0_9) AT=915.025n

.meas tran vdout0_10ck1820 FIND v(dout0_10) AT=915.025n

.meas tran vdout0_11ck1820 FIND v(dout0_11) AT=915.025n

.meas tran vdout0_12ck1820 FIND v(dout0_12) AT=915.025n

.meas tran vdout0_13ck1820 FIND v(dout0_13) AT=915.025n

.meas tran vdout0_14ck1820 FIND v(dout0_14) AT=915.025n

.meas tran vdout0_15ck1820 FIND v(dout0_15) AT=915.025n

.meas tran vdout0_16ck1820 FIND v(dout0_16) AT=915.025n

.meas tran vdout0_17ck1820 FIND v(dout0_17) AT=915.025n

.meas tran vdout0_18ck1820 FIND v(dout0_18) AT=915.025n

.meas tran vdout0_19ck1820 FIND v(dout0_19) AT=915.025n

.meas tran vdout0_20ck1820 FIND v(dout0_20) AT=915.025n

.meas tran vdout0_21ck1820 FIND v(dout0_21) AT=915.025n

.meas tran vdout0_22ck1820 FIND v(dout0_22) AT=915.025n

.meas tran vdout0_23ck1820 FIND v(dout0_23) AT=915.025n

.meas tran vdout0_24ck1820 FIND v(dout0_24) AT=915.025n

.meas tran vdout0_25ck1820 FIND v(dout0_25) AT=915.025n

.meas tran vdout0_26ck1820 FIND v(dout0_26) AT=915.025n

.meas tran vdout0_27ck1820 FIND v(dout0_27) AT=915.025n

.meas tran vdout0_28ck1820 FIND v(dout0_28) AT=915.025n

.meas tran vdout0_29ck1820 FIND v(dout0_29) AT=915.025n

.meas tran vdout0_30ck1820 FIND v(dout0_30) AT=915.025n

.meas tran vdout0_31ck1820 FIND v(dout0_31) AT=915.025n

.meas tran vdout0_32ck1820 FIND v(dout0_32) AT=915.025n

.meas tran vdout0_33ck1820 FIND v(dout0_33) AT=915.025n

.meas tran vdout0_34ck1820 FIND v(dout0_34) AT=915.025n

.meas tran vdout0_35ck1820 FIND v(dout0_35) AT=915.025n

.meas tran vdout0_36ck1820 FIND v(dout0_36) AT=915.025n

.meas tran vdout0_37ck1820 FIND v(dout0_37) AT=915.025n

.meas tran vdout0_38ck1820 FIND v(dout0_38) AT=915.025n

.meas tran vdout0_39ck1820 FIND v(dout0_39) AT=915.025n

.meas tran vdout0_40ck1820 FIND v(dout0_40) AT=915.025n

.meas tran vdout0_41ck1820 FIND v(dout0_41) AT=915.025n

.meas tran vdout0_42ck1820 FIND v(dout0_42) AT=915.025n

.meas tran vdout0_43ck1820 FIND v(dout0_43) AT=915.025n

.meas tran vdout0_44ck1820 FIND v(dout0_44) AT=915.025n

.meas tran vdout0_45ck1820 FIND v(dout0_45) AT=915.025n

.meas tran vdout0_46ck1820 FIND v(dout0_46) AT=915.025n

.meas tran vdout0_47ck1820 FIND v(dout0_47) AT=915.025n

.meas tran vdout0_48ck1820 FIND v(dout0_48) AT=915.025n

.meas tran vdout0_49ck1820 FIND v(dout0_49) AT=915.025n

.meas tran vdout0_50ck1820 FIND v(dout0_50) AT=915.025n

.meas tran vdout0_51ck1820 FIND v(dout0_51) AT=915.025n

.meas tran vdout0_52ck1820 FIND v(dout0_52) AT=915.025n

.meas tran vdout0_53ck1820 FIND v(dout0_53) AT=915.025n

.meas tran vdout0_54ck1820 FIND v(dout0_54) AT=915.025n

.meas tran vdout0_55ck1820 FIND v(dout0_55) AT=915.025n

.meas tran vdout0_56ck1820 FIND v(dout0_56) AT=915.025n

.meas tran vdout0_57ck1820 FIND v(dout0_57) AT=915.025n

.meas tran vdout0_58ck1820 FIND v(dout0_58) AT=915.025n

.meas tran vdout0_59ck1820 FIND v(dout0_59) AT=915.025n

.meas tran vdout0_60ck1820 FIND v(dout0_60) AT=915.025n

.meas tran vdout0_61ck1820 FIND v(dout0_61) AT=915.025n

.meas tran vdout0_62ck1820 FIND v(dout0_62) AT=915.025n

.meas tran vdout0_63ck1820 FIND v(dout0_63) AT=915.025n

.meas tran vdout0_0ck1840 FIND v(dout0_0) AT=925.025n

.meas tran vdout0_1ck1840 FIND v(dout0_1) AT=925.025n

.meas tran vdout0_2ck1840 FIND v(dout0_2) AT=925.025n

.meas tran vdout0_3ck1840 FIND v(dout0_3) AT=925.025n

.meas tran vdout0_4ck1840 FIND v(dout0_4) AT=925.025n

.meas tran vdout0_5ck1840 FIND v(dout0_5) AT=925.025n

.meas tran vdout0_6ck1840 FIND v(dout0_6) AT=925.025n

.meas tran vdout0_7ck1840 FIND v(dout0_7) AT=925.025n

.meas tran vdout0_8ck1840 FIND v(dout0_8) AT=925.025n

.meas tran vdout0_9ck1840 FIND v(dout0_9) AT=925.025n

.meas tran vdout0_10ck1840 FIND v(dout0_10) AT=925.025n

.meas tran vdout0_11ck1840 FIND v(dout0_11) AT=925.025n

.meas tran vdout0_12ck1840 FIND v(dout0_12) AT=925.025n

.meas tran vdout0_13ck1840 FIND v(dout0_13) AT=925.025n

.meas tran vdout0_14ck1840 FIND v(dout0_14) AT=925.025n

.meas tran vdout0_15ck1840 FIND v(dout0_15) AT=925.025n

.meas tran vdout0_16ck1840 FIND v(dout0_16) AT=925.025n

.meas tran vdout0_17ck1840 FIND v(dout0_17) AT=925.025n

.meas tran vdout0_18ck1840 FIND v(dout0_18) AT=925.025n

.meas tran vdout0_19ck1840 FIND v(dout0_19) AT=925.025n

.meas tran vdout0_20ck1840 FIND v(dout0_20) AT=925.025n

.meas tran vdout0_21ck1840 FIND v(dout0_21) AT=925.025n

.meas tran vdout0_22ck1840 FIND v(dout0_22) AT=925.025n

.meas tran vdout0_23ck1840 FIND v(dout0_23) AT=925.025n

.meas tran vdout0_24ck1840 FIND v(dout0_24) AT=925.025n

.meas tran vdout0_25ck1840 FIND v(dout0_25) AT=925.025n

.meas tran vdout0_26ck1840 FIND v(dout0_26) AT=925.025n

.meas tran vdout0_27ck1840 FIND v(dout0_27) AT=925.025n

.meas tran vdout0_28ck1840 FIND v(dout0_28) AT=925.025n

.meas tran vdout0_29ck1840 FIND v(dout0_29) AT=925.025n

.meas tran vdout0_30ck1840 FIND v(dout0_30) AT=925.025n

.meas tran vdout0_31ck1840 FIND v(dout0_31) AT=925.025n

.meas tran vdout0_32ck1840 FIND v(dout0_32) AT=925.025n

.meas tran vdout0_33ck1840 FIND v(dout0_33) AT=925.025n

.meas tran vdout0_34ck1840 FIND v(dout0_34) AT=925.025n

.meas tran vdout0_35ck1840 FIND v(dout0_35) AT=925.025n

.meas tran vdout0_36ck1840 FIND v(dout0_36) AT=925.025n

.meas tran vdout0_37ck1840 FIND v(dout0_37) AT=925.025n

.meas tran vdout0_38ck1840 FIND v(dout0_38) AT=925.025n

.meas tran vdout0_39ck1840 FIND v(dout0_39) AT=925.025n

.meas tran vdout0_40ck1840 FIND v(dout0_40) AT=925.025n

.meas tran vdout0_41ck1840 FIND v(dout0_41) AT=925.025n

.meas tran vdout0_42ck1840 FIND v(dout0_42) AT=925.025n

.meas tran vdout0_43ck1840 FIND v(dout0_43) AT=925.025n

.meas tran vdout0_44ck1840 FIND v(dout0_44) AT=925.025n

.meas tran vdout0_45ck1840 FIND v(dout0_45) AT=925.025n

.meas tran vdout0_46ck1840 FIND v(dout0_46) AT=925.025n

.meas tran vdout0_47ck1840 FIND v(dout0_47) AT=925.025n

.meas tran vdout0_48ck1840 FIND v(dout0_48) AT=925.025n

.meas tran vdout0_49ck1840 FIND v(dout0_49) AT=925.025n

.meas tran vdout0_50ck1840 FIND v(dout0_50) AT=925.025n

.meas tran vdout0_51ck1840 FIND v(dout0_51) AT=925.025n

.meas tran vdout0_52ck1840 FIND v(dout0_52) AT=925.025n

.meas tran vdout0_53ck1840 FIND v(dout0_53) AT=925.025n

.meas tran vdout0_54ck1840 FIND v(dout0_54) AT=925.025n

.meas tran vdout0_55ck1840 FIND v(dout0_55) AT=925.025n

.meas tran vdout0_56ck1840 FIND v(dout0_56) AT=925.025n

.meas tran vdout0_57ck1840 FIND v(dout0_57) AT=925.025n

.meas tran vdout0_58ck1840 FIND v(dout0_58) AT=925.025n

.meas tran vdout0_59ck1840 FIND v(dout0_59) AT=925.025n

.meas tran vdout0_60ck1840 FIND v(dout0_60) AT=925.025n

.meas tran vdout0_61ck1840 FIND v(dout0_61) AT=925.025n

.meas tran vdout0_62ck1840 FIND v(dout0_62) AT=925.025n

.meas tran vdout0_63ck1840 FIND v(dout0_63) AT=925.025n

.meas tran vdout0_0ck1850 FIND v(dout0_0) AT=930.025n

.meas tran vdout0_1ck1850 FIND v(dout0_1) AT=930.025n

.meas tran vdout0_2ck1850 FIND v(dout0_2) AT=930.025n

.meas tran vdout0_3ck1850 FIND v(dout0_3) AT=930.025n

.meas tran vdout0_4ck1850 FIND v(dout0_4) AT=930.025n

.meas tran vdout0_5ck1850 FIND v(dout0_5) AT=930.025n

.meas tran vdout0_6ck1850 FIND v(dout0_6) AT=930.025n

.meas tran vdout0_7ck1850 FIND v(dout0_7) AT=930.025n

.meas tran vdout0_8ck1850 FIND v(dout0_8) AT=930.025n

.meas tran vdout0_9ck1850 FIND v(dout0_9) AT=930.025n

.meas tran vdout0_10ck1850 FIND v(dout0_10) AT=930.025n

.meas tran vdout0_11ck1850 FIND v(dout0_11) AT=930.025n

.meas tran vdout0_12ck1850 FIND v(dout0_12) AT=930.025n

.meas tran vdout0_13ck1850 FIND v(dout0_13) AT=930.025n

.meas tran vdout0_14ck1850 FIND v(dout0_14) AT=930.025n

.meas tran vdout0_15ck1850 FIND v(dout0_15) AT=930.025n

.meas tran vdout0_16ck1850 FIND v(dout0_16) AT=930.025n

.meas tran vdout0_17ck1850 FIND v(dout0_17) AT=930.025n

.meas tran vdout0_18ck1850 FIND v(dout0_18) AT=930.025n

.meas tran vdout0_19ck1850 FIND v(dout0_19) AT=930.025n

.meas tran vdout0_20ck1850 FIND v(dout0_20) AT=930.025n

.meas tran vdout0_21ck1850 FIND v(dout0_21) AT=930.025n

.meas tran vdout0_22ck1850 FIND v(dout0_22) AT=930.025n

.meas tran vdout0_23ck1850 FIND v(dout0_23) AT=930.025n

.meas tran vdout0_24ck1850 FIND v(dout0_24) AT=930.025n

.meas tran vdout0_25ck1850 FIND v(dout0_25) AT=930.025n

.meas tran vdout0_26ck1850 FIND v(dout0_26) AT=930.025n

.meas tran vdout0_27ck1850 FIND v(dout0_27) AT=930.025n

.meas tran vdout0_28ck1850 FIND v(dout0_28) AT=930.025n

.meas tran vdout0_29ck1850 FIND v(dout0_29) AT=930.025n

.meas tran vdout0_30ck1850 FIND v(dout0_30) AT=930.025n

.meas tran vdout0_31ck1850 FIND v(dout0_31) AT=930.025n

.meas tran vdout0_32ck1850 FIND v(dout0_32) AT=930.025n

.meas tran vdout0_33ck1850 FIND v(dout0_33) AT=930.025n

.meas tran vdout0_34ck1850 FIND v(dout0_34) AT=930.025n

.meas tran vdout0_35ck1850 FIND v(dout0_35) AT=930.025n

.meas tran vdout0_36ck1850 FIND v(dout0_36) AT=930.025n

.meas tran vdout0_37ck1850 FIND v(dout0_37) AT=930.025n

.meas tran vdout0_38ck1850 FIND v(dout0_38) AT=930.025n

.meas tran vdout0_39ck1850 FIND v(dout0_39) AT=930.025n

.meas tran vdout0_40ck1850 FIND v(dout0_40) AT=930.025n

.meas tran vdout0_41ck1850 FIND v(dout0_41) AT=930.025n

.meas tran vdout0_42ck1850 FIND v(dout0_42) AT=930.025n

.meas tran vdout0_43ck1850 FIND v(dout0_43) AT=930.025n

.meas tran vdout0_44ck1850 FIND v(dout0_44) AT=930.025n

.meas tran vdout0_45ck1850 FIND v(dout0_45) AT=930.025n

.meas tran vdout0_46ck1850 FIND v(dout0_46) AT=930.025n

.meas tran vdout0_47ck1850 FIND v(dout0_47) AT=930.025n

.meas tran vdout0_48ck1850 FIND v(dout0_48) AT=930.025n

.meas tran vdout0_49ck1850 FIND v(dout0_49) AT=930.025n

.meas tran vdout0_50ck1850 FIND v(dout0_50) AT=930.025n

.meas tran vdout0_51ck1850 FIND v(dout0_51) AT=930.025n

.meas tran vdout0_52ck1850 FIND v(dout0_52) AT=930.025n

.meas tran vdout0_53ck1850 FIND v(dout0_53) AT=930.025n

.meas tran vdout0_54ck1850 FIND v(dout0_54) AT=930.025n

.meas tran vdout0_55ck1850 FIND v(dout0_55) AT=930.025n

.meas tran vdout0_56ck1850 FIND v(dout0_56) AT=930.025n

.meas tran vdout0_57ck1850 FIND v(dout0_57) AT=930.025n

.meas tran vdout0_58ck1850 FIND v(dout0_58) AT=930.025n

.meas tran vdout0_59ck1850 FIND v(dout0_59) AT=930.025n

.meas tran vdout0_60ck1850 FIND v(dout0_60) AT=930.025n

.meas tran vdout0_61ck1850 FIND v(dout0_61) AT=930.025n

.meas tran vdout0_62ck1850 FIND v(dout0_62) AT=930.025n

.meas tran vdout0_63ck1850 FIND v(dout0_63) AT=930.025n

.meas tran vdout0_0ck1870 FIND v(dout0_0) AT=940.025n

.meas tran vdout0_1ck1870 FIND v(dout0_1) AT=940.025n

.meas tran vdout0_2ck1870 FIND v(dout0_2) AT=940.025n

.meas tran vdout0_3ck1870 FIND v(dout0_3) AT=940.025n

.meas tran vdout0_4ck1870 FIND v(dout0_4) AT=940.025n

.meas tran vdout0_5ck1870 FIND v(dout0_5) AT=940.025n

.meas tran vdout0_6ck1870 FIND v(dout0_6) AT=940.025n

.meas tran vdout0_7ck1870 FIND v(dout0_7) AT=940.025n

.meas tran vdout0_8ck1870 FIND v(dout0_8) AT=940.025n

.meas tran vdout0_9ck1870 FIND v(dout0_9) AT=940.025n

.meas tran vdout0_10ck1870 FIND v(dout0_10) AT=940.025n

.meas tran vdout0_11ck1870 FIND v(dout0_11) AT=940.025n

.meas tran vdout0_12ck1870 FIND v(dout0_12) AT=940.025n

.meas tran vdout0_13ck1870 FIND v(dout0_13) AT=940.025n

.meas tran vdout0_14ck1870 FIND v(dout0_14) AT=940.025n

.meas tran vdout0_15ck1870 FIND v(dout0_15) AT=940.025n

.meas tran vdout0_16ck1870 FIND v(dout0_16) AT=940.025n

.meas tran vdout0_17ck1870 FIND v(dout0_17) AT=940.025n

.meas tran vdout0_18ck1870 FIND v(dout0_18) AT=940.025n

.meas tran vdout0_19ck1870 FIND v(dout0_19) AT=940.025n

.meas tran vdout0_20ck1870 FIND v(dout0_20) AT=940.025n

.meas tran vdout0_21ck1870 FIND v(dout0_21) AT=940.025n

.meas tran vdout0_22ck1870 FIND v(dout0_22) AT=940.025n

.meas tran vdout0_23ck1870 FIND v(dout0_23) AT=940.025n

.meas tran vdout0_24ck1870 FIND v(dout0_24) AT=940.025n

.meas tran vdout0_25ck1870 FIND v(dout0_25) AT=940.025n

.meas tran vdout0_26ck1870 FIND v(dout0_26) AT=940.025n

.meas tran vdout0_27ck1870 FIND v(dout0_27) AT=940.025n

.meas tran vdout0_28ck1870 FIND v(dout0_28) AT=940.025n

.meas tran vdout0_29ck1870 FIND v(dout0_29) AT=940.025n

.meas tran vdout0_30ck1870 FIND v(dout0_30) AT=940.025n

.meas tran vdout0_31ck1870 FIND v(dout0_31) AT=940.025n

.meas tran vdout0_32ck1870 FIND v(dout0_32) AT=940.025n

.meas tran vdout0_33ck1870 FIND v(dout0_33) AT=940.025n

.meas tran vdout0_34ck1870 FIND v(dout0_34) AT=940.025n

.meas tran vdout0_35ck1870 FIND v(dout0_35) AT=940.025n

.meas tran vdout0_36ck1870 FIND v(dout0_36) AT=940.025n

.meas tran vdout0_37ck1870 FIND v(dout0_37) AT=940.025n

.meas tran vdout0_38ck1870 FIND v(dout0_38) AT=940.025n

.meas tran vdout0_39ck1870 FIND v(dout0_39) AT=940.025n

.meas tran vdout0_40ck1870 FIND v(dout0_40) AT=940.025n

.meas tran vdout0_41ck1870 FIND v(dout0_41) AT=940.025n

.meas tran vdout0_42ck1870 FIND v(dout0_42) AT=940.025n

.meas tran vdout0_43ck1870 FIND v(dout0_43) AT=940.025n

.meas tran vdout0_44ck1870 FIND v(dout0_44) AT=940.025n

.meas tran vdout0_45ck1870 FIND v(dout0_45) AT=940.025n

.meas tran vdout0_46ck1870 FIND v(dout0_46) AT=940.025n

.meas tran vdout0_47ck1870 FIND v(dout0_47) AT=940.025n

.meas tran vdout0_48ck1870 FIND v(dout0_48) AT=940.025n

.meas tran vdout0_49ck1870 FIND v(dout0_49) AT=940.025n

.meas tran vdout0_50ck1870 FIND v(dout0_50) AT=940.025n

.meas tran vdout0_51ck1870 FIND v(dout0_51) AT=940.025n

.meas tran vdout0_52ck1870 FIND v(dout0_52) AT=940.025n

.meas tran vdout0_53ck1870 FIND v(dout0_53) AT=940.025n

.meas tran vdout0_54ck1870 FIND v(dout0_54) AT=940.025n

.meas tran vdout0_55ck1870 FIND v(dout0_55) AT=940.025n

.meas tran vdout0_56ck1870 FIND v(dout0_56) AT=940.025n

.meas tran vdout0_57ck1870 FIND v(dout0_57) AT=940.025n

.meas tran vdout0_58ck1870 FIND v(dout0_58) AT=940.025n

.meas tran vdout0_59ck1870 FIND v(dout0_59) AT=940.025n

.meas tran vdout0_60ck1870 FIND v(dout0_60) AT=940.025n

.meas tran vdout0_61ck1870 FIND v(dout0_61) AT=940.025n

.meas tran vdout0_62ck1870 FIND v(dout0_62) AT=940.025n

.meas tran vdout0_63ck1870 FIND v(dout0_63) AT=940.025n

.meas tran vdout0_0ck1910 FIND v(dout0_0) AT=960.025n

.meas tran vdout0_1ck1910 FIND v(dout0_1) AT=960.025n

.meas tran vdout0_2ck1910 FIND v(dout0_2) AT=960.025n

.meas tran vdout0_3ck1910 FIND v(dout0_3) AT=960.025n

.meas tran vdout0_4ck1910 FIND v(dout0_4) AT=960.025n

.meas tran vdout0_5ck1910 FIND v(dout0_5) AT=960.025n

.meas tran vdout0_6ck1910 FIND v(dout0_6) AT=960.025n

.meas tran vdout0_7ck1910 FIND v(dout0_7) AT=960.025n

.meas tran vdout0_8ck1910 FIND v(dout0_8) AT=960.025n

.meas tran vdout0_9ck1910 FIND v(dout0_9) AT=960.025n

.meas tran vdout0_10ck1910 FIND v(dout0_10) AT=960.025n

.meas tran vdout0_11ck1910 FIND v(dout0_11) AT=960.025n

.meas tran vdout0_12ck1910 FIND v(dout0_12) AT=960.025n

.meas tran vdout0_13ck1910 FIND v(dout0_13) AT=960.025n

.meas tran vdout0_14ck1910 FIND v(dout0_14) AT=960.025n

.meas tran vdout0_15ck1910 FIND v(dout0_15) AT=960.025n

.meas tran vdout0_16ck1910 FIND v(dout0_16) AT=960.025n

.meas tran vdout0_17ck1910 FIND v(dout0_17) AT=960.025n

.meas tran vdout0_18ck1910 FIND v(dout0_18) AT=960.025n

.meas tran vdout0_19ck1910 FIND v(dout0_19) AT=960.025n

.meas tran vdout0_20ck1910 FIND v(dout0_20) AT=960.025n

.meas tran vdout0_21ck1910 FIND v(dout0_21) AT=960.025n

.meas tran vdout0_22ck1910 FIND v(dout0_22) AT=960.025n

.meas tran vdout0_23ck1910 FIND v(dout0_23) AT=960.025n

.meas tran vdout0_24ck1910 FIND v(dout0_24) AT=960.025n

.meas tran vdout0_25ck1910 FIND v(dout0_25) AT=960.025n

.meas tran vdout0_26ck1910 FIND v(dout0_26) AT=960.025n

.meas tran vdout0_27ck1910 FIND v(dout0_27) AT=960.025n

.meas tran vdout0_28ck1910 FIND v(dout0_28) AT=960.025n

.meas tran vdout0_29ck1910 FIND v(dout0_29) AT=960.025n

.meas tran vdout0_30ck1910 FIND v(dout0_30) AT=960.025n

.meas tran vdout0_31ck1910 FIND v(dout0_31) AT=960.025n

.meas tran vdout0_32ck1910 FIND v(dout0_32) AT=960.025n

.meas tran vdout0_33ck1910 FIND v(dout0_33) AT=960.025n

.meas tran vdout0_34ck1910 FIND v(dout0_34) AT=960.025n

.meas tran vdout0_35ck1910 FIND v(dout0_35) AT=960.025n

.meas tran vdout0_36ck1910 FIND v(dout0_36) AT=960.025n

.meas tran vdout0_37ck1910 FIND v(dout0_37) AT=960.025n

.meas tran vdout0_38ck1910 FIND v(dout0_38) AT=960.025n

.meas tran vdout0_39ck1910 FIND v(dout0_39) AT=960.025n

.meas tran vdout0_40ck1910 FIND v(dout0_40) AT=960.025n

.meas tran vdout0_41ck1910 FIND v(dout0_41) AT=960.025n

.meas tran vdout0_42ck1910 FIND v(dout0_42) AT=960.025n

.meas tran vdout0_43ck1910 FIND v(dout0_43) AT=960.025n

.meas tran vdout0_44ck1910 FIND v(dout0_44) AT=960.025n

.meas tran vdout0_45ck1910 FIND v(dout0_45) AT=960.025n

.meas tran vdout0_46ck1910 FIND v(dout0_46) AT=960.025n

.meas tran vdout0_47ck1910 FIND v(dout0_47) AT=960.025n

.meas tran vdout0_48ck1910 FIND v(dout0_48) AT=960.025n

.meas tran vdout0_49ck1910 FIND v(dout0_49) AT=960.025n

.meas tran vdout0_50ck1910 FIND v(dout0_50) AT=960.025n

.meas tran vdout0_51ck1910 FIND v(dout0_51) AT=960.025n

.meas tran vdout0_52ck1910 FIND v(dout0_52) AT=960.025n

.meas tran vdout0_53ck1910 FIND v(dout0_53) AT=960.025n

.meas tran vdout0_54ck1910 FIND v(dout0_54) AT=960.025n

.meas tran vdout0_55ck1910 FIND v(dout0_55) AT=960.025n

.meas tran vdout0_56ck1910 FIND v(dout0_56) AT=960.025n

.meas tran vdout0_57ck1910 FIND v(dout0_57) AT=960.025n

.meas tran vdout0_58ck1910 FIND v(dout0_58) AT=960.025n

.meas tran vdout0_59ck1910 FIND v(dout0_59) AT=960.025n

.meas tran vdout0_60ck1910 FIND v(dout0_60) AT=960.025n

.meas tran vdout0_61ck1910 FIND v(dout0_61) AT=960.025n

.meas tran vdout0_62ck1910 FIND v(dout0_62) AT=960.025n

.meas tran vdout0_63ck1910 FIND v(dout0_63) AT=960.025n

.meas tran vdout0_0ck1930 FIND v(dout0_0) AT=970.025n

.meas tran vdout0_1ck1930 FIND v(dout0_1) AT=970.025n

.meas tran vdout0_2ck1930 FIND v(dout0_2) AT=970.025n

.meas tran vdout0_3ck1930 FIND v(dout0_3) AT=970.025n

.meas tran vdout0_4ck1930 FIND v(dout0_4) AT=970.025n

.meas tran vdout0_5ck1930 FIND v(dout0_5) AT=970.025n

.meas tran vdout0_6ck1930 FIND v(dout0_6) AT=970.025n

.meas tran vdout0_7ck1930 FIND v(dout0_7) AT=970.025n

.meas tran vdout0_8ck1930 FIND v(dout0_8) AT=970.025n

.meas tran vdout0_9ck1930 FIND v(dout0_9) AT=970.025n

.meas tran vdout0_10ck1930 FIND v(dout0_10) AT=970.025n

.meas tran vdout0_11ck1930 FIND v(dout0_11) AT=970.025n

.meas tran vdout0_12ck1930 FIND v(dout0_12) AT=970.025n

.meas tran vdout0_13ck1930 FIND v(dout0_13) AT=970.025n

.meas tran vdout0_14ck1930 FIND v(dout0_14) AT=970.025n

.meas tran vdout0_15ck1930 FIND v(dout0_15) AT=970.025n

.meas tran vdout0_16ck1930 FIND v(dout0_16) AT=970.025n

.meas tran vdout0_17ck1930 FIND v(dout0_17) AT=970.025n

.meas tran vdout0_18ck1930 FIND v(dout0_18) AT=970.025n

.meas tran vdout0_19ck1930 FIND v(dout0_19) AT=970.025n

.meas tran vdout0_20ck1930 FIND v(dout0_20) AT=970.025n

.meas tran vdout0_21ck1930 FIND v(dout0_21) AT=970.025n

.meas tran vdout0_22ck1930 FIND v(dout0_22) AT=970.025n

.meas tran vdout0_23ck1930 FIND v(dout0_23) AT=970.025n

.meas tran vdout0_24ck1930 FIND v(dout0_24) AT=970.025n

.meas tran vdout0_25ck1930 FIND v(dout0_25) AT=970.025n

.meas tran vdout0_26ck1930 FIND v(dout0_26) AT=970.025n

.meas tran vdout0_27ck1930 FIND v(dout0_27) AT=970.025n

.meas tran vdout0_28ck1930 FIND v(dout0_28) AT=970.025n

.meas tran vdout0_29ck1930 FIND v(dout0_29) AT=970.025n

.meas tran vdout0_30ck1930 FIND v(dout0_30) AT=970.025n

.meas tran vdout0_31ck1930 FIND v(dout0_31) AT=970.025n

.meas tran vdout0_32ck1930 FIND v(dout0_32) AT=970.025n

.meas tran vdout0_33ck1930 FIND v(dout0_33) AT=970.025n

.meas tran vdout0_34ck1930 FIND v(dout0_34) AT=970.025n

.meas tran vdout0_35ck1930 FIND v(dout0_35) AT=970.025n

.meas tran vdout0_36ck1930 FIND v(dout0_36) AT=970.025n

.meas tran vdout0_37ck1930 FIND v(dout0_37) AT=970.025n

.meas tran vdout0_38ck1930 FIND v(dout0_38) AT=970.025n

.meas tran vdout0_39ck1930 FIND v(dout0_39) AT=970.025n

.meas tran vdout0_40ck1930 FIND v(dout0_40) AT=970.025n

.meas tran vdout0_41ck1930 FIND v(dout0_41) AT=970.025n

.meas tran vdout0_42ck1930 FIND v(dout0_42) AT=970.025n

.meas tran vdout0_43ck1930 FIND v(dout0_43) AT=970.025n

.meas tran vdout0_44ck1930 FIND v(dout0_44) AT=970.025n

.meas tran vdout0_45ck1930 FIND v(dout0_45) AT=970.025n

.meas tran vdout0_46ck1930 FIND v(dout0_46) AT=970.025n

.meas tran vdout0_47ck1930 FIND v(dout0_47) AT=970.025n

.meas tran vdout0_48ck1930 FIND v(dout0_48) AT=970.025n

.meas tran vdout0_49ck1930 FIND v(dout0_49) AT=970.025n

.meas tran vdout0_50ck1930 FIND v(dout0_50) AT=970.025n

.meas tran vdout0_51ck1930 FIND v(dout0_51) AT=970.025n

.meas tran vdout0_52ck1930 FIND v(dout0_52) AT=970.025n

.meas tran vdout0_53ck1930 FIND v(dout0_53) AT=970.025n

.meas tran vdout0_54ck1930 FIND v(dout0_54) AT=970.025n

.meas tran vdout0_55ck1930 FIND v(dout0_55) AT=970.025n

.meas tran vdout0_56ck1930 FIND v(dout0_56) AT=970.025n

.meas tran vdout0_57ck1930 FIND v(dout0_57) AT=970.025n

.meas tran vdout0_58ck1930 FIND v(dout0_58) AT=970.025n

.meas tran vdout0_59ck1930 FIND v(dout0_59) AT=970.025n

.meas tran vdout0_60ck1930 FIND v(dout0_60) AT=970.025n

.meas tran vdout0_61ck1930 FIND v(dout0_61) AT=970.025n

.meas tran vdout0_62ck1930 FIND v(dout0_62) AT=970.025n

.meas tran vdout0_63ck1930 FIND v(dout0_63) AT=970.025n

.meas tran vdout0_0ck1990 FIND v(dout0_0) AT=1000.025n

.meas tran vdout0_1ck1990 FIND v(dout0_1) AT=1000.025n

.meas tran vdout0_2ck1990 FIND v(dout0_2) AT=1000.025n

.meas tran vdout0_3ck1990 FIND v(dout0_3) AT=1000.025n

.meas tran vdout0_4ck1990 FIND v(dout0_4) AT=1000.025n

.meas tran vdout0_5ck1990 FIND v(dout0_5) AT=1000.025n

.meas tran vdout0_6ck1990 FIND v(dout0_6) AT=1000.025n

.meas tran vdout0_7ck1990 FIND v(dout0_7) AT=1000.025n

.meas tran vdout0_8ck1990 FIND v(dout0_8) AT=1000.025n

.meas tran vdout0_9ck1990 FIND v(dout0_9) AT=1000.025n

.meas tran vdout0_10ck1990 FIND v(dout0_10) AT=1000.025n

.meas tran vdout0_11ck1990 FIND v(dout0_11) AT=1000.025n

.meas tran vdout0_12ck1990 FIND v(dout0_12) AT=1000.025n

.meas tran vdout0_13ck1990 FIND v(dout0_13) AT=1000.025n

.meas tran vdout0_14ck1990 FIND v(dout0_14) AT=1000.025n

.meas tran vdout0_15ck1990 FIND v(dout0_15) AT=1000.025n

.meas tran vdout0_16ck1990 FIND v(dout0_16) AT=1000.025n

.meas tran vdout0_17ck1990 FIND v(dout0_17) AT=1000.025n

.meas tran vdout0_18ck1990 FIND v(dout0_18) AT=1000.025n

.meas tran vdout0_19ck1990 FIND v(dout0_19) AT=1000.025n

.meas tran vdout0_20ck1990 FIND v(dout0_20) AT=1000.025n

.meas tran vdout0_21ck1990 FIND v(dout0_21) AT=1000.025n

.meas tran vdout0_22ck1990 FIND v(dout0_22) AT=1000.025n

.meas tran vdout0_23ck1990 FIND v(dout0_23) AT=1000.025n

.meas tran vdout0_24ck1990 FIND v(dout0_24) AT=1000.025n

.meas tran vdout0_25ck1990 FIND v(dout0_25) AT=1000.025n

.meas tran vdout0_26ck1990 FIND v(dout0_26) AT=1000.025n

.meas tran vdout0_27ck1990 FIND v(dout0_27) AT=1000.025n

.meas tran vdout0_28ck1990 FIND v(dout0_28) AT=1000.025n

.meas tran vdout0_29ck1990 FIND v(dout0_29) AT=1000.025n

.meas tran vdout0_30ck1990 FIND v(dout0_30) AT=1000.025n

.meas tran vdout0_31ck1990 FIND v(dout0_31) AT=1000.025n

.meas tran vdout0_32ck1990 FIND v(dout0_32) AT=1000.025n

.meas tran vdout0_33ck1990 FIND v(dout0_33) AT=1000.025n

.meas tran vdout0_34ck1990 FIND v(dout0_34) AT=1000.025n

.meas tran vdout0_35ck1990 FIND v(dout0_35) AT=1000.025n

.meas tran vdout0_36ck1990 FIND v(dout0_36) AT=1000.025n

.meas tran vdout0_37ck1990 FIND v(dout0_37) AT=1000.025n

.meas tran vdout0_38ck1990 FIND v(dout0_38) AT=1000.025n

.meas tran vdout0_39ck1990 FIND v(dout0_39) AT=1000.025n

.meas tran vdout0_40ck1990 FIND v(dout0_40) AT=1000.025n

.meas tran vdout0_41ck1990 FIND v(dout0_41) AT=1000.025n

.meas tran vdout0_42ck1990 FIND v(dout0_42) AT=1000.025n

.meas tran vdout0_43ck1990 FIND v(dout0_43) AT=1000.025n

.meas tran vdout0_44ck1990 FIND v(dout0_44) AT=1000.025n

.meas tran vdout0_45ck1990 FIND v(dout0_45) AT=1000.025n

.meas tran vdout0_46ck1990 FIND v(dout0_46) AT=1000.025n

.meas tran vdout0_47ck1990 FIND v(dout0_47) AT=1000.025n

.meas tran vdout0_48ck1990 FIND v(dout0_48) AT=1000.025n

.meas tran vdout0_49ck1990 FIND v(dout0_49) AT=1000.025n

.meas tran vdout0_50ck1990 FIND v(dout0_50) AT=1000.025n

.meas tran vdout0_51ck1990 FIND v(dout0_51) AT=1000.025n

.meas tran vdout0_52ck1990 FIND v(dout0_52) AT=1000.025n

.meas tran vdout0_53ck1990 FIND v(dout0_53) AT=1000.025n

.meas tran vdout0_54ck1990 FIND v(dout0_54) AT=1000.025n

.meas tran vdout0_55ck1990 FIND v(dout0_55) AT=1000.025n

.meas tran vdout0_56ck1990 FIND v(dout0_56) AT=1000.025n

.meas tran vdout0_57ck1990 FIND v(dout0_57) AT=1000.025n

.meas tran vdout0_58ck1990 FIND v(dout0_58) AT=1000.025n

.meas tran vdout0_59ck1990 FIND v(dout0_59) AT=1000.025n

.meas tran vdout0_60ck1990 FIND v(dout0_60) AT=1000.025n

.meas tran vdout0_61ck1990 FIND v(dout0_61) AT=1000.025n

.meas tran vdout0_62ck1990 FIND v(dout0_62) AT=1000.025n

.meas tran vdout0_63ck1990 FIND v(dout0_63) AT=1000.025n

.meas tran vdout0_0ck2020 FIND v(dout0_0) AT=1015.025n

.meas tran vdout0_1ck2020 FIND v(dout0_1) AT=1015.025n

.meas tran vdout0_2ck2020 FIND v(dout0_2) AT=1015.025n

.meas tran vdout0_3ck2020 FIND v(dout0_3) AT=1015.025n

.meas tran vdout0_4ck2020 FIND v(dout0_4) AT=1015.025n

.meas tran vdout0_5ck2020 FIND v(dout0_5) AT=1015.025n

.meas tran vdout0_6ck2020 FIND v(dout0_6) AT=1015.025n

.meas tran vdout0_7ck2020 FIND v(dout0_7) AT=1015.025n

.meas tran vdout0_8ck2020 FIND v(dout0_8) AT=1015.025n

.meas tran vdout0_9ck2020 FIND v(dout0_9) AT=1015.025n

.meas tran vdout0_10ck2020 FIND v(dout0_10) AT=1015.025n

.meas tran vdout0_11ck2020 FIND v(dout0_11) AT=1015.025n

.meas tran vdout0_12ck2020 FIND v(dout0_12) AT=1015.025n

.meas tran vdout0_13ck2020 FIND v(dout0_13) AT=1015.025n

.meas tran vdout0_14ck2020 FIND v(dout0_14) AT=1015.025n

.meas tran vdout0_15ck2020 FIND v(dout0_15) AT=1015.025n

.meas tran vdout0_16ck2020 FIND v(dout0_16) AT=1015.025n

.meas tran vdout0_17ck2020 FIND v(dout0_17) AT=1015.025n

.meas tran vdout0_18ck2020 FIND v(dout0_18) AT=1015.025n

.meas tran vdout0_19ck2020 FIND v(dout0_19) AT=1015.025n

.meas tran vdout0_20ck2020 FIND v(dout0_20) AT=1015.025n

.meas tran vdout0_21ck2020 FIND v(dout0_21) AT=1015.025n

.meas tran vdout0_22ck2020 FIND v(dout0_22) AT=1015.025n

.meas tran vdout0_23ck2020 FIND v(dout0_23) AT=1015.025n

.meas tran vdout0_24ck2020 FIND v(dout0_24) AT=1015.025n

.meas tran vdout0_25ck2020 FIND v(dout0_25) AT=1015.025n

.meas tran vdout0_26ck2020 FIND v(dout0_26) AT=1015.025n

.meas tran vdout0_27ck2020 FIND v(dout0_27) AT=1015.025n

.meas tran vdout0_28ck2020 FIND v(dout0_28) AT=1015.025n

.meas tran vdout0_29ck2020 FIND v(dout0_29) AT=1015.025n

.meas tran vdout0_30ck2020 FIND v(dout0_30) AT=1015.025n

.meas tran vdout0_31ck2020 FIND v(dout0_31) AT=1015.025n

.meas tran vdout0_32ck2020 FIND v(dout0_32) AT=1015.025n

.meas tran vdout0_33ck2020 FIND v(dout0_33) AT=1015.025n

.meas tran vdout0_34ck2020 FIND v(dout0_34) AT=1015.025n

.meas tran vdout0_35ck2020 FIND v(dout0_35) AT=1015.025n

.meas tran vdout0_36ck2020 FIND v(dout0_36) AT=1015.025n

.meas tran vdout0_37ck2020 FIND v(dout0_37) AT=1015.025n

.meas tran vdout0_38ck2020 FIND v(dout0_38) AT=1015.025n

.meas tran vdout0_39ck2020 FIND v(dout0_39) AT=1015.025n

.meas tran vdout0_40ck2020 FIND v(dout0_40) AT=1015.025n

.meas tran vdout0_41ck2020 FIND v(dout0_41) AT=1015.025n

.meas tran vdout0_42ck2020 FIND v(dout0_42) AT=1015.025n

.meas tran vdout0_43ck2020 FIND v(dout0_43) AT=1015.025n

.meas tran vdout0_44ck2020 FIND v(dout0_44) AT=1015.025n

.meas tran vdout0_45ck2020 FIND v(dout0_45) AT=1015.025n

.meas tran vdout0_46ck2020 FIND v(dout0_46) AT=1015.025n

.meas tran vdout0_47ck2020 FIND v(dout0_47) AT=1015.025n

.meas tran vdout0_48ck2020 FIND v(dout0_48) AT=1015.025n

.meas tran vdout0_49ck2020 FIND v(dout0_49) AT=1015.025n

.meas tran vdout0_50ck2020 FIND v(dout0_50) AT=1015.025n

.meas tran vdout0_51ck2020 FIND v(dout0_51) AT=1015.025n

.meas tran vdout0_52ck2020 FIND v(dout0_52) AT=1015.025n

.meas tran vdout0_53ck2020 FIND v(dout0_53) AT=1015.025n

.meas tran vdout0_54ck2020 FIND v(dout0_54) AT=1015.025n

.meas tran vdout0_55ck2020 FIND v(dout0_55) AT=1015.025n

.meas tran vdout0_56ck2020 FIND v(dout0_56) AT=1015.025n

.meas tran vdout0_57ck2020 FIND v(dout0_57) AT=1015.025n

.meas tran vdout0_58ck2020 FIND v(dout0_58) AT=1015.025n

.meas tran vdout0_59ck2020 FIND v(dout0_59) AT=1015.025n

.meas tran vdout0_60ck2020 FIND v(dout0_60) AT=1015.025n

.meas tran vdout0_61ck2020 FIND v(dout0_61) AT=1015.025n

.meas tran vdout0_62ck2020 FIND v(dout0_62) AT=1015.025n

.meas tran vdout0_63ck2020 FIND v(dout0_63) AT=1015.025n

.meas tran vdout0_0ck2030 FIND v(dout0_0) AT=1020.025n

.meas tran vdout0_1ck2030 FIND v(dout0_1) AT=1020.025n

.meas tran vdout0_2ck2030 FIND v(dout0_2) AT=1020.025n

.meas tran vdout0_3ck2030 FIND v(dout0_3) AT=1020.025n

.meas tran vdout0_4ck2030 FIND v(dout0_4) AT=1020.025n

.meas tran vdout0_5ck2030 FIND v(dout0_5) AT=1020.025n

.meas tran vdout0_6ck2030 FIND v(dout0_6) AT=1020.025n

.meas tran vdout0_7ck2030 FIND v(dout0_7) AT=1020.025n

.meas tran vdout0_8ck2030 FIND v(dout0_8) AT=1020.025n

.meas tran vdout0_9ck2030 FIND v(dout0_9) AT=1020.025n

.meas tran vdout0_10ck2030 FIND v(dout0_10) AT=1020.025n

.meas tran vdout0_11ck2030 FIND v(dout0_11) AT=1020.025n

.meas tran vdout0_12ck2030 FIND v(dout0_12) AT=1020.025n

.meas tran vdout0_13ck2030 FIND v(dout0_13) AT=1020.025n

.meas tran vdout0_14ck2030 FIND v(dout0_14) AT=1020.025n

.meas tran vdout0_15ck2030 FIND v(dout0_15) AT=1020.025n

.meas tran vdout0_16ck2030 FIND v(dout0_16) AT=1020.025n

.meas tran vdout0_17ck2030 FIND v(dout0_17) AT=1020.025n

.meas tran vdout0_18ck2030 FIND v(dout0_18) AT=1020.025n

.meas tran vdout0_19ck2030 FIND v(dout0_19) AT=1020.025n

.meas tran vdout0_20ck2030 FIND v(dout0_20) AT=1020.025n

.meas tran vdout0_21ck2030 FIND v(dout0_21) AT=1020.025n

.meas tran vdout0_22ck2030 FIND v(dout0_22) AT=1020.025n

.meas tran vdout0_23ck2030 FIND v(dout0_23) AT=1020.025n

.meas tran vdout0_24ck2030 FIND v(dout0_24) AT=1020.025n

.meas tran vdout0_25ck2030 FIND v(dout0_25) AT=1020.025n

.meas tran vdout0_26ck2030 FIND v(dout0_26) AT=1020.025n

.meas tran vdout0_27ck2030 FIND v(dout0_27) AT=1020.025n

.meas tran vdout0_28ck2030 FIND v(dout0_28) AT=1020.025n

.meas tran vdout0_29ck2030 FIND v(dout0_29) AT=1020.025n

.meas tran vdout0_30ck2030 FIND v(dout0_30) AT=1020.025n

.meas tran vdout0_31ck2030 FIND v(dout0_31) AT=1020.025n

.meas tran vdout0_32ck2030 FIND v(dout0_32) AT=1020.025n

.meas tran vdout0_33ck2030 FIND v(dout0_33) AT=1020.025n

.meas tran vdout0_34ck2030 FIND v(dout0_34) AT=1020.025n

.meas tran vdout0_35ck2030 FIND v(dout0_35) AT=1020.025n

.meas tran vdout0_36ck2030 FIND v(dout0_36) AT=1020.025n

.meas tran vdout0_37ck2030 FIND v(dout0_37) AT=1020.025n

.meas tran vdout0_38ck2030 FIND v(dout0_38) AT=1020.025n

.meas tran vdout0_39ck2030 FIND v(dout0_39) AT=1020.025n

.meas tran vdout0_40ck2030 FIND v(dout0_40) AT=1020.025n

.meas tran vdout0_41ck2030 FIND v(dout0_41) AT=1020.025n

.meas tran vdout0_42ck2030 FIND v(dout0_42) AT=1020.025n

.meas tran vdout0_43ck2030 FIND v(dout0_43) AT=1020.025n

.meas tran vdout0_44ck2030 FIND v(dout0_44) AT=1020.025n

.meas tran vdout0_45ck2030 FIND v(dout0_45) AT=1020.025n

.meas tran vdout0_46ck2030 FIND v(dout0_46) AT=1020.025n

.meas tran vdout0_47ck2030 FIND v(dout0_47) AT=1020.025n

.meas tran vdout0_48ck2030 FIND v(dout0_48) AT=1020.025n

.meas tran vdout0_49ck2030 FIND v(dout0_49) AT=1020.025n

.meas tran vdout0_50ck2030 FIND v(dout0_50) AT=1020.025n

.meas tran vdout0_51ck2030 FIND v(dout0_51) AT=1020.025n

.meas tran vdout0_52ck2030 FIND v(dout0_52) AT=1020.025n

.meas tran vdout0_53ck2030 FIND v(dout0_53) AT=1020.025n

.meas tran vdout0_54ck2030 FIND v(dout0_54) AT=1020.025n

.meas tran vdout0_55ck2030 FIND v(dout0_55) AT=1020.025n

.meas tran vdout0_56ck2030 FIND v(dout0_56) AT=1020.025n

.meas tran vdout0_57ck2030 FIND v(dout0_57) AT=1020.025n

.meas tran vdout0_58ck2030 FIND v(dout0_58) AT=1020.025n

.meas tran vdout0_59ck2030 FIND v(dout0_59) AT=1020.025n

.meas tran vdout0_60ck2030 FIND v(dout0_60) AT=1020.025n

.meas tran vdout0_61ck2030 FIND v(dout0_61) AT=1020.025n

.meas tran vdout0_62ck2030 FIND v(dout0_62) AT=1020.025n

.meas tran vdout0_63ck2030 FIND v(dout0_63) AT=1020.025n
