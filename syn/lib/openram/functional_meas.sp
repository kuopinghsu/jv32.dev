.meas tran vdout0_0ck40 FIND v(dout0_0) AT=25.025n

.meas tran vdout0_1ck40 FIND v(dout0_1) AT=25.025n

.meas tran vdout0_2ck40 FIND v(dout0_2) AT=25.025n

.meas tran vdout0_3ck40 FIND v(dout0_3) AT=25.025n

.meas tran vdout0_4ck40 FIND v(dout0_4) AT=25.025n

.meas tran vdout0_5ck40 FIND v(dout0_5) AT=25.025n

.meas tran vdout0_6ck40 FIND v(dout0_6) AT=25.025n

.meas tran vdout0_7ck40 FIND v(dout0_7) AT=25.025n

.meas tran vdout0_8ck40 FIND v(dout0_8) AT=25.025n

.meas tran vdout0_9ck40 FIND v(dout0_9) AT=25.025n

.meas tran vdout0_10ck40 FIND v(dout0_10) AT=25.025n

.meas tran vdout0_11ck40 FIND v(dout0_11) AT=25.025n

.meas tran vdout0_12ck40 FIND v(dout0_12) AT=25.025n

.meas tran vdout0_13ck40 FIND v(dout0_13) AT=25.025n

.meas tran vdout0_14ck40 FIND v(dout0_14) AT=25.025n

.meas tran vdout0_15ck40 FIND v(dout0_15) AT=25.025n

.meas tran vdout0_16ck40 FIND v(dout0_16) AT=25.025n

.meas tran vdout0_17ck40 FIND v(dout0_17) AT=25.025n

.meas tran vdout0_18ck40 FIND v(dout0_18) AT=25.025n

.meas tran vdout0_19ck40 FIND v(dout0_19) AT=25.025n

.meas tran vdout0_20ck40 FIND v(dout0_20) AT=25.025n

.meas tran vdout0_21ck40 FIND v(dout0_21) AT=25.025n

.meas tran vdout0_22ck40 FIND v(dout0_22) AT=25.025n

.meas tran vdout0_23ck40 FIND v(dout0_23) AT=25.025n

.meas tran vdout0_24ck40 FIND v(dout0_24) AT=25.025n

.meas tran vdout0_25ck40 FIND v(dout0_25) AT=25.025n

.meas tran vdout0_26ck40 FIND v(dout0_26) AT=25.025n

.meas tran vdout0_27ck40 FIND v(dout0_27) AT=25.025n

.meas tran vdout0_28ck40 FIND v(dout0_28) AT=25.025n

.meas tran vdout0_29ck40 FIND v(dout0_29) AT=25.025n

.meas tran vdout0_30ck40 FIND v(dout0_30) AT=25.025n

.meas tran vdout0_31ck40 FIND v(dout0_31) AT=25.025n

.meas tran vdout0_32ck40 FIND v(dout0_32) AT=25.025n

.meas tran vdout0_33ck40 FIND v(dout0_33) AT=25.025n

.meas tran vdout0_34ck40 FIND v(dout0_34) AT=25.025n

.meas tran vdout0_35ck40 FIND v(dout0_35) AT=25.025n

.meas tran vdout0_36ck40 FIND v(dout0_36) AT=25.025n

.meas tran vdout0_37ck40 FIND v(dout0_37) AT=25.025n

.meas tran vdout0_38ck40 FIND v(dout0_38) AT=25.025n

.meas tran vdout0_39ck40 FIND v(dout0_39) AT=25.025n

.meas tran vdout0_40ck40 FIND v(dout0_40) AT=25.025n

.meas tran vdout0_41ck40 FIND v(dout0_41) AT=25.025n

.meas tran vdout0_42ck40 FIND v(dout0_42) AT=25.025n

.meas tran vdout0_43ck40 FIND v(dout0_43) AT=25.025n

.meas tran vdout0_44ck40 FIND v(dout0_44) AT=25.025n

.meas tran vdout0_45ck40 FIND v(dout0_45) AT=25.025n

.meas tran vdout0_46ck40 FIND v(dout0_46) AT=25.025n

.meas tran vdout0_47ck40 FIND v(dout0_47) AT=25.025n

.meas tran vdout0_48ck40 FIND v(dout0_48) AT=25.025n

.meas tran vdout0_49ck40 FIND v(dout0_49) AT=25.025n

.meas tran vdout0_50ck40 FIND v(dout0_50) AT=25.025n

.meas tran vdout0_51ck40 FIND v(dout0_51) AT=25.025n

.meas tran vdout0_52ck40 FIND v(dout0_52) AT=25.025n

.meas tran vdout0_53ck40 FIND v(dout0_53) AT=25.025n

.meas tran vdout0_54ck40 FIND v(dout0_54) AT=25.025n

.meas tran vdout0_55ck40 FIND v(dout0_55) AT=25.025n

.meas tran vdout0_56ck40 FIND v(dout0_56) AT=25.025n

.meas tran vdout0_57ck40 FIND v(dout0_57) AT=25.025n

.meas tran vdout0_58ck40 FIND v(dout0_58) AT=25.025n

.meas tran vdout0_59ck40 FIND v(dout0_59) AT=25.025n

.meas tran vdout0_60ck40 FIND v(dout0_60) AT=25.025n

.meas tran vdout0_61ck40 FIND v(dout0_61) AT=25.025n

.meas tran vdout0_62ck40 FIND v(dout0_62) AT=25.025n

.meas tran vdout0_63ck40 FIND v(dout0_63) AT=25.025n

.meas tran vdout0_0ck100 FIND v(dout0_0) AT=55.025n

.meas tran vdout0_1ck100 FIND v(dout0_1) AT=55.025n

.meas tran vdout0_2ck100 FIND v(dout0_2) AT=55.025n

.meas tran vdout0_3ck100 FIND v(dout0_3) AT=55.025n

.meas tran vdout0_4ck100 FIND v(dout0_4) AT=55.025n

.meas tran vdout0_5ck100 FIND v(dout0_5) AT=55.025n

.meas tran vdout0_6ck100 FIND v(dout0_6) AT=55.025n

.meas tran vdout0_7ck100 FIND v(dout0_7) AT=55.025n

.meas tran vdout0_8ck100 FIND v(dout0_8) AT=55.025n

.meas tran vdout0_9ck100 FIND v(dout0_9) AT=55.025n

.meas tran vdout0_10ck100 FIND v(dout0_10) AT=55.025n

.meas tran vdout0_11ck100 FIND v(dout0_11) AT=55.025n

.meas tran vdout0_12ck100 FIND v(dout0_12) AT=55.025n

.meas tran vdout0_13ck100 FIND v(dout0_13) AT=55.025n

.meas tran vdout0_14ck100 FIND v(dout0_14) AT=55.025n

.meas tran vdout0_15ck100 FIND v(dout0_15) AT=55.025n

.meas tran vdout0_16ck100 FIND v(dout0_16) AT=55.025n

.meas tran vdout0_17ck100 FIND v(dout0_17) AT=55.025n

.meas tran vdout0_18ck100 FIND v(dout0_18) AT=55.025n

.meas tran vdout0_19ck100 FIND v(dout0_19) AT=55.025n

.meas tran vdout0_20ck100 FIND v(dout0_20) AT=55.025n

.meas tran vdout0_21ck100 FIND v(dout0_21) AT=55.025n

.meas tran vdout0_22ck100 FIND v(dout0_22) AT=55.025n

.meas tran vdout0_23ck100 FIND v(dout0_23) AT=55.025n

.meas tran vdout0_24ck100 FIND v(dout0_24) AT=55.025n

.meas tran vdout0_25ck100 FIND v(dout0_25) AT=55.025n

.meas tran vdout0_26ck100 FIND v(dout0_26) AT=55.025n

.meas tran vdout0_27ck100 FIND v(dout0_27) AT=55.025n

.meas tran vdout0_28ck100 FIND v(dout0_28) AT=55.025n

.meas tran vdout0_29ck100 FIND v(dout0_29) AT=55.025n

.meas tran vdout0_30ck100 FIND v(dout0_30) AT=55.025n

.meas tran vdout0_31ck100 FIND v(dout0_31) AT=55.025n

.meas tran vdout0_32ck100 FIND v(dout0_32) AT=55.025n

.meas tran vdout0_33ck100 FIND v(dout0_33) AT=55.025n

.meas tran vdout0_34ck100 FIND v(dout0_34) AT=55.025n

.meas tran vdout0_35ck100 FIND v(dout0_35) AT=55.025n

.meas tran vdout0_36ck100 FIND v(dout0_36) AT=55.025n

.meas tran vdout0_37ck100 FIND v(dout0_37) AT=55.025n

.meas tran vdout0_38ck100 FIND v(dout0_38) AT=55.025n

.meas tran vdout0_39ck100 FIND v(dout0_39) AT=55.025n

.meas tran vdout0_40ck100 FIND v(dout0_40) AT=55.025n

.meas tran vdout0_41ck100 FIND v(dout0_41) AT=55.025n

.meas tran vdout0_42ck100 FIND v(dout0_42) AT=55.025n

.meas tran vdout0_43ck100 FIND v(dout0_43) AT=55.025n

.meas tran vdout0_44ck100 FIND v(dout0_44) AT=55.025n

.meas tran vdout0_45ck100 FIND v(dout0_45) AT=55.025n

.meas tran vdout0_46ck100 FIND v(dout0_46) AT=55.025n

.meas tran vdout0_47ck100 FIND v(dout0_47) AT=55.025n

.meas tran vdout0_48ck100 FIND v(dout0_48) AT=55.025n

.meas tran vdout0_49ck100 FIND v(dout0_49) AT=55.025n

.meas tran vdout0_50ck100 FIND v(dout0_50) AT=55.025n

.meas tran vdout0_51ck100 FIND v(dout0_51) AT=55.025n

.meas tran vdout0_52ck100 FIND v(dout0_52) AT=55.025n

.meas tran vdout0_53ck100 FIND v(dout0_53) AT=55.025n

.meas tran vdout0_54ck100 FIND v(dout0_54) AT=55.025n

.meas tran vdout0_55ck100 FIND v(dout0_55) AT=55.025n

.meas tran vdout0_56ck100 FIND v(dout0_56) AT=55.025n

.meas tran vdout0_57ck100 FIND v(dout0_57) AT=55.025n

.meas tran vdout0_58ck100 FIND v(dout0_58) AT=55.025n

.meas tran vdout0_59ck100 FIND v(dout0_59) AT=55.025n

.meas tran vdout0_60ck100 FIND v(dout0_60) AT=55.025n

.meas tran vdout0_61ck100 FIND v(dout0_61) AT=55.025n

.meas tran vdout0_62ck100 FIND v(dout0_62) AT=55.025n

.meas tran vdout0_63ck100 FIND v(dout0_63) AT=55.025n

.meas tran vdout0_0ck110 FIND v(dout0_0) AT=60.025n

.meas tran vdout0_1ck110 FIND v(dout0_1) AT=60.025n

.meas tran vdout0_2ck110 FIND v(dout0_2) AT=60.025n

.meas tran vdout0_3ck110 FIND v(dout0_3) AT=60.025n

.meas tran vdout0_4ck110 FIND v(dout0_4) AT=60.025n

.meas tran vdout0_5ck110 FIND v(dout0_5) AT=60.025n

.meas tran vdout0_6ck110 FIND v(dout0_6) AT=60.025n

.meas tran vdout0_7ck110 FIND v(dout0_7) AT=60.025n

.meas tran vdout0_8ck110 FIND v(dout0_8) AT=60.025n

.meas tran vdout0_9ck110 FIND v(dout0_9) AT=60.025n

.meas tran vdout0_10ck110 FIND v(dout0_10) AT=60.025n

.meas tran vdout0_11ck110 FIND v(dout0_11) AT=60.025n

.meas tran vdout0_12ck110 FIND v(dout0_12) AT=60.025n

.meas tran vdout0_13ck110 FIND v(dout0_13) AT=60.025n

.meas tran vdout0_14ck110 FIND v(dout0_14) AT=60.025n

.meas tran vdout0_15ck110 FIND v(dout0_15) AT=60.025n

.meas tran vdout0_16ck110 FIND v(dout0_16) AT=60.025n

.meas tran vdout0_17ck110 FIND v(dout0_17) AT=60.025n

.meas tran vdout0_18ck110 FIND v(dout0_18) AT=60.025n

.meas tran vdout0_19ck110 FIND v(dout0_19) AT=60.025n

.meas tran vdout0_20ck110 FIND v(dout0_20) AT=60.025n

.meas tran vdout0_21ck110 FIND v(dout0_21) AT=60.025n

.meas tran vdout0_22ck110 FIND v(dout0_22) AT=60.025n

.meas tran vdout0_23ck110 FIND v(dout0_23) AT=60.025n

.meas tran vdout0_24ck110 FIND v(dout0_24) AT=60.025n

.meas tran vdout0_25ck110 FIND v(dout0_25) AT=60.025n

.meas tran vdout0_26ck110 FIND v(dout0_26) AT=60.025n

.meas tran vdout0_27ck110 FIND v(dout0_27) AT=60.025n

.meas tran vdout0_28ck110 FIND v(dout0_28) AT=60.025n

.meas tran vdout0_29ck110 FIND v(dout0_29) AT=60.025n

.meas tran vdout0_30ck110 FIND v(dout0_30) AT=60.025n

.meas tran vdout0_31ck110 FIND v(dout0_31) AT=60.025n

.meas tran vdout0_32ck110 FIND v(dout0_32) AT=60.025n

.meas tran vdout0_33ck110 FIND v(dout0_33) AT=60.025n

.meas tran vdout0_34ck110 FIND v(dout0_34) AT=60.025n

.meas tran vdout0_35ck110 FIND v(dout0_35) AT=60.025n

.meas tran vdout0_36ck110 FIND v(dout0_36) AT=60.025n

.meas tran vdout0_37ck110 FIND v(dout0_37) AT=60.025n

.meas tran vdout0_38ck110 FIND v(dout0_38) AT=60.025n

.meas tran vdout0_39ck110 FIND v(dout0_39) AT=60.025n

.meas tran vdout0_40ck110 FIND v(dout0_40) AT=60.025n

.meas tran vdout0_41ck110 FIND v(dout0_41) AT=60.025n

.meas tran vdout0_42ck110 FIND v(dout0_42) AT=60.025n

.meas tran vdout0_43ck110 FIND v(dout0_43) AT=60.025n

.meas tran vdout0_44ck110 FIND v(dout0_44) AT=60.025n

.meas tran vdout0_45ck110 FIND v(dout0_45) AT=60.025n

.meas tran vdout0_46ck110 FIND v(dout0_46) AT=60.025n

.meas tran vdout0_47ck110 FIND v(dout0_47) AT=60.025n

.meas tran vdout0_48ck110 FIND v(dout0_48) AT=60.025n

.meas tran vdout0_49ck110 FIND v(dout0_49) AT=60.025n

.meas tran vdout0_50ck110 FIND v(dout0_50) AT=60.025n

.meas tran vdout0_51ck110 FIND v(dout0_51) AT=60.025n

.meas tran vdout0_52ck110 FIND v(dout0_52) AT=60.025n

.meas tran vdout0_53ck110 FIND v(dout0_53) AT=60.025n

.meas tran vdout0_54ck110 FIND v(dout0_54) AT=60.025n

.meas tran vdout0_55ck110 FIND v(dout0_55) AT=60.025n

.meas tran vdout0_56ck110 FIND v(dout0_56) AT=60.025n

.meas tran vdout0_57ck110 FIND v(dout0_57) AT=60.025n

.meas tran vdout0_58ck110 FIND v(dout0_58) AT=60.025n

.meas tran vdout0_59ck110 FIND v(dout0_59) AT=60.025n

.meas tran vdout0_60ck110 FIND v(dout0_60) AT=60.025n

.meas tran vdout0_61ck110 FIND v(dout0_61) AT=60.025n

.meas tran vdout0_62ck110 FIND v(dout0_62) AT=60.025n

.meas tran vdout0_63ck110 FIND v(dout0_63) AT=60.025n

.meas tran vdout0_0ck140 FIND v(dout0_0) AT=75.025n

.meas tran vdout0_1ck140 FIND v(dout0_1) AT=75.025n

.meas tran vdout0_2ck140 FIND v(dout0_2) AT=75.025n

.meas tran vdout0_3ck140 FIND v(dout0_3) AT=75.025n

.meas tran vdout0_4ck140 FIND v(dout0_4) AT=75.025n

.meas tran vdout0_5ck140 FIND v(dout0_5) AT=75.025n

.meas tran vdout0_6ck140 FIND v(dout0_6) AT=75.025n

.meas tran vdout0_7ck140 FIND v(dout0_7) AT=75.025n

.meas tran vdout0_8ck140 FIND v(dout0_8) AT=75.025n

.meas tran vdout0_9ck140 FIND v(dout0_9) AT=75.025n

.meas tran vdout0_10ck140 FIND v(dout0_10) AT=75.025n

.meas tran vdout0_11ck140 FIND v(dout0_11) AT=75.025n

.meas tran vdout0_12ck140 FIND v(dout0_12) AT=75.025n

.meas tran vdout0_13ck140 FIND v(dout0_13) AT=75.025n

.meas tran vdout0_14ck140 FIND v(dout0_14) AT=75.025n

.meas tran vdout0_15ck140 FIND v(dout0_15) AT=75.025n

.meas tran vdout0_16ck140 FIND v(dout0_16) AT=75.025n

.meas tran vdout0_17ck140 FIND v(dout0_17) AT=75.025n

.meas tran vdout0_18ck140 FIND v(dout0_18) AT=75.025n

.meas tran vdout0_19ck140 FIND v(dout0_19) AT=75.025n

.meas tran vdout0_20ck140 FIND v(dout0_20) AT=75.025n

.meas tran vdout0_21ck140 FIND v(dout0_21) AT=75.025n

.meas tran vdout0_22ck140 FIND v(dout0_22) AT=75.025n

.meas tran vdout0_23ck140 FIND v(dout0_23) AT=75.025n

.meas tran vdout0_24ck140 FIND v(dout0_24) AT=75.025n

.meas tran vdout0_25ck140 FIND v(dout0_25) AT=75.025n

.meas tran vdout0_26ck140 FIND v(dout0_26) AT=75.025n

.meas tran vdout0_27ck140 FIND v(dout0_27) AT=75.025n

.meas tran vdout0_28ck140 FIND v(dout0_28) AT=75.025n

.meas tran vdout0_29ck140 FIND v(dout0_29) AT=75.025n

.meas tran vdout0_30ck140 FIND v(dout0_30) AT=75.025n

.meas tran vdout0_31ck140 FIND v(dout0_31) AT=75.025n

.meas tran vdout0_32ck140 FIND v(dout0_32) AT=75.025n

.meas tran vdout0_33ck140 FIND v(dout0_33) AT=75.025n

.meas tran vdout0_34ck140 FIND v(dout0_34) AT=75.025n

.meas tran vdout0_35ck140 FIND v(dout0_35) AT=75.025n

.meas tran vdout0_36ck140 FIND v(dout0_36) AT=75.025n

.meas tran vdout0_37ck140 FIND v(dout0_37) AT=75.025n

.meas tran vdout0_38ck140 FIND v(dout0_38) AT=75.025n

.meas tran vdout0_39ck140 FIND v(dout0_39) AT=75.025n

.meas tran vdout0_40ck140 FIND v(dout0_40) AT=75.025n

.meas tran vdout0_41ck140 FIND v(dout0_41) AT=75.025n

.meas tran vdout0_42ck140 FIND v(dout0_42) AT=75.025n

.meas tran vdout0_43ck140 FIND v(dout0_43) AT=75.025n

.meas tran vdout0_44ck140 FIND v(dout0_44) AT=75.025n

.meas tran vdout0_45ck140 FIND v(dout0_45) AT=75.025n

.meas tran vdout0_46ck140 FIND v(dout0_46) AT=75.025n

.meas tran vdout0_47ck140 FIND v(dout0_47) AT=75.025n

.meas tran vdout0_48ck140 FIND v(dout0_48) AT=75.025n

.meas tran vdout0_49ck140 FIND v(dout0_49) AT=75.025n

.meas tran vdout0_50ck140 FIND v(dout0_50) AT=75.025n

.meas tran vdout0_51ck140 FIND v(dout0_51) AT=75.025n

.meas tran vdout0_52ck140 FIND v(dout0_52) AT=75.025n

.meas tran vdout0_53ck140 FIND v(dout0_53) AT=75.025n

.meas tran vdout0_54ck140 FIND v(dout0_54) AT=75.025n

.meas tran vdout0_55ck140 FIND v(dout0_55) AT=75.025n

.meas tran vdout0_56ck140 FIND v(dout0_56) AT=75.025n

.meas tran vdout0_57ck140 FIND v(dout0_57) AT=75.025n

.meas tran vdout0_58ck140 FIND v(dout0_58) AT=75.025n

.meas tran vdout0_59ck140 FIND v(dout0_59) AT=75.025n

.meas tran vdout0_60ck140 FIND v(dout0_60) AT=75.025n

.meas tran vdout0_61ck140 FIND v(dout0_61) AT=75.025n

.meas tran vdout0_62ck140 FIND v(dout0_62) AT=75.025n

.meas tran vdout0_63ck140 FIND v(dout0_63) AT=75.025n

.meas tran vdout0_0ck150 FIND v(dout0_0) AT=80.025n

.meas tran vdout0_1ck150 FIND v(dout0_1) AT=80.025n

.meas tran vdout0_2ck150 FIND v(dout0_2) AT=80.025n

.meas tran vdout0_3ck150 FIND v(dout0_3) AT=80.025n

.meas tran vdout0_4ck150 FIND v(dout0_4) AT=80.025n

.meas tran vdout0_5ck150 FIND v(dout0_5) AT=80.025n

.meas tran vdout0_6ck150 FIND v(dout0_6) AT=80.025n

.meas tran vdout0_7ck150 FIND v(dout0_7) AT=80.025n

.meas tran vdout0_8ck150 FIND v(dout0_8) AT=80.025n

.meas tran vdout0_9ck150 FIND v(dout0_9) AT=80.025n

.meas tran vdout0_10ck150 FIND v(dout0_10) AT=80.025n

.meas tran vdout0_11ck150 FIND v(dout0_11) AT=80.025n

.meas tran vdout0_12ck150 FIND v(dout0_12) AT=80.025n

.meas tran vdout0_13ck150 FIND v(dout0_13) AT=80.025n

.meas tran vdout0_14ck150 FIND v(dout0_14) AT=80.025n

.meas tran vdout0_15ck150 FIND v(dout0_15) AT=80.025n

.meas tran vdout0_16ck150 FIND v(dout0_16) AT=80.025n

.meas tran vdout0_17ck150 FIND v(dout0_17) AT=80.025n

.meas tran vdout0_18ck150 FIND v(dout0_18) AT=80.025n

.meas tran vdout0_19ck150 FIND v(dout0_19) AT=80.025n

.meas tran vdout0_20ck150 FIND v(dout0_20) AT=80.025n

.meas tran vdout0_21ck150 FIND v(dout0_21) AT=80.025n

.meas tran vdout0_22ck150 FIND v(dout0_22) AT=80.025n

.meas tran vdout0_23ck150 FIND v(dout0_23) AT=80.025n

.meas tran vdout0_24ck150 FIND v(dout0_24) AT=80.025n

.meas tran vdout0_25ck150 FIND v(dout0_25) AT=80.025n

.meas tran vdout0_26ck150 FIND v(dout0_26) AT=80.025n

.meas tran vdout0_27ck150 FIND v(dout0_27) AT=80.025n

.meas tran vdout0_28ck150 FIND v(dout0_28) AT=80.025n

.meas tran vdout0_29ck150 FIND v(dout0_29) AT=80.025n

.meas tran vdout0_30ck150 FIND v(dout0_30) AT=80.025n

.meas tran vdout0_31ck150 FIND v(dout0_31) AT=80.025n

.meas tran vdout0_32ck150 FIND v(dout0_32) AT=80.025n

.meas tran vdout0_33ck150 FIND v(dout0_33) AT=80.025n

.meas tran vdout0_34ck150 FIND v(dout0_34) AT=80.025n

.meas tran vdout0_35ck150 FIND v(dout0_35) AT=80.025n

.meas tran vdout0_36ck150 FIND v(dout0_36) AT=80.025n

.meas tran vdout0_37ck150 FIND v(dout0_37) AT=80.025n

.meas tran vdout0_38ck150 FIND v(dout0_38) AT=80.025n

.meas tran vdout0_39ck150 FIND v(dout0_39) AT=80.025n

.meas tran vdout0_40ck150 FIND v(dout0_40) AT=80.025n

.meas tran vdout0_41ck150 FIND v(dout0_41) AT=80.025n

.meas tran vdout0_42ck150 FIND v(dout0_42) AT=80.025n

.meas tran vdout0_43ck150 FIND v(dout0_43) AT=80.025n

.meas tran vdout0_44ck150 FIND v(dout0_44) AT=80.025n

.meas tran vdout0_45ck150 FIND v(dout0_45) AT=80.025n

.meas tran vdout0_46ck150 FIND v(dout0_46) AT=80.025n

.meas tran vdout0_47ck150 FIND v(dout0_47) AT=80.025n

.meas tran vdout0_48ck150 FIND v(dout0_48) AT=80.025n

.meas tran vdout0_49ck150 FIND v(dout0_49) AT=80.025n

.meas tran vdout0_50ck150 FIND v(dout0_50) AT=80.025n

.meas tran vdout0_51ck150 FIND v(dout0_51) AT=80.025n

.meas tran vdout0_52ck150 FIND v(dout0_52) AT=80.025n

.meas tran vdout0_53ck150 FIND v(dout0_53) AT=80.025n

.meas tran vdout0_54ck150 FIND v(dout0_54) AT=80.025n

.meas tran vdout0_55ck150 FIND v(dout0_55) AT=80.025n

.meas tran vdout0_56ck150 FIND v(dout0_56) AT=80.025n

.meas tran vdout0_57ck150 FIND v(dout0_57) AT=80.025n

.meas tran vdout0_58ck150 FIND v(dout0_58) AT=80.025n

.meas tran vdout0_59ck150 FIND v(dout0_59) AT=80.025n

.meas tran vdout0_60ck150 FIND v(dout0_60) AT=80.025n

.meas tran vdout0_61ck150 FIND v(dout0_61) AT=80.025n

.meas tran vdout0_62ck150 FIND v(dout0_62) AT=80.025n

.meas tran vdout0_63ck150 FIND v(dout0_63) AT=80.025n

.meas tran vdout0_0ck220 FIND v(dout0_0) AT=115.025n

.meas tran vdout0_1ck220 FIND v(dout0_1) AT=115.025n

.meas tran vdout0_2ck220 FIND v(dout0_2) AT=115.025n

.meas tran vdout0_3ck220 FIND v(dout0_3) AT=115.025n

.meas tran vdout0_4ck220 FIND v(dout0_4) AT=115.025n

.meas tran vdout0_5ck220 FIND v(dout0_5) AT=115.025n

.meas tran vdout0_6ck220 FIND v(dout0_6) AT=115.025n

.meas tran vdout0_7ck220 FIND v(dout0_7) AT=115.025n

.meas tran vdout0_8ck220 FIND v(dout0_8) AT=115.025n

.meas tran vdout0_9ck220 FIND v(dout0_9) AT=115.025n

.meas tran vdout0_10ck220 FIND v(dout0_10) AT=115.025n

.meas tran vdout0_11ck220 FIND v(dout0_11) AT=115.025n

.meas tran vdout0_12ck220 FIND v(dout0_12) AT=115.025n

.meas tran vdout0_13ck220 FIND v(dout0_13) AT=115.025n

.meas tran vdout0_14ck220 FIND v(dout0_14) AT=115.025n

.meas tran vdout0_15ck220 FIND v(dout0_15) AT=115.025n

.meas tran vdout0_16ck220 FIND v(dout0_16) AT=115.025n

.meas tran vdout0_17ck220 FIND v(dout0_17) AT=115.025n

.meas tran vdout0_18ck220 FIND v(dout0_18) AT=115.025n

.meas tran vdout0_19ck220 FIND v(dout0_19) AT=115.025n

.meas tran vdout0_20ck220 FIND v(dout0_20) AT=115.025n

.meas tran vdout0_21ck220 FIND v(dout0_21) AT=115.025n

.meas tran vdout0_22ck220 FIND v(dout0_22) AT=115.025n

.meas tran vdout0_23ck220 FIND v(dout0_23) AT=115.025n

.meas tran vdout0_24ck220 FIND v(dout0_24) AT=115.025n

.meas tran vdout0_25ck220 FIND v(dout0_25) AT=115.025n

.meas tran vdout0_26ck220 FIND v(dout0_26) AT=115.025n

.meas tran vdout0_27ck220 FIND v(dout0_27) AT=115.025n

.meas tran vdout0_28ck220 FIND v(dout0_28) AT=115.025n

.meas tran vdout0_29ck220 FIND v(dout0_29) AT=115.025n

.meas tran vdout0_30ck220 FIND v(dout0_30) AT=115.025n

.meas tran vdout0_31ck220 FIND v(dout0_31) AT=115.025n

.meas tran vdout0_32ck220 FIND v(dout0_32) AT=115.025n

.meas tran vdout0_33ck220 FIND v(dout0_33) AT=115.025n

.meas tran vdout0_34ck220 FIND v(dout0_34) AT=115.025n

.meas tran vdout0_35ck220 FIND v(dout0_35) AT=115.025n

.meas tran vdout0_36ck220 FIND v(dout0_36) AT=115.025n

.meas tran vdout0_37ck220 FIND v(dout0_37) AT=115.025n

.meas tran vdout0_38ck220 FIND v(dout0_38) AT=115.025n

.meas tran vdout0_39ck220 FIND v(dout0_39) AT=115.025n

.meas tran vdout0_40ck220 FIND v(dout0_40) AT=115.025n

.meas tran vdout0_41ck220 FIND v(dout0_41) AT=115.025n

.meas tran vdout0_42ck220 FIND v(dout0_42) AT=115.025n

.meas tran vdout0_43ck220 FIND v(dout0_43) AT=115.025n

.meas tran vdout0_44ck220 FIND v(dout0_44) AT=115.025n

.meas tran vdout0_45ck220 FIND v(dout0_45) AT=115.025n

.meas tran vdout0_46ck220 FIND v(dout0_46) AT=115.025n

.meas tran vdout0_47ck220 FIND v(dout0_47) AT=115.025n

.meas tran vdout0_48ck220 FIND v(dout0_48) AT=115.025n

.meas tran vdout0_49ck220 FIND v(dout0_49) AT=115.025n

.meas tran vdout0_50ck220 FIND v(dout0_50) AT=115.025n

.meas tran vdout0_51ck220 FIND v(dout0_51) AT=115.025n

.meas tran vdout0_52ck220 FIND v(dout0_52) AT=115.025n

.meas tran vdout0_53ck220 FIND v(dout0_53) AT=115.025n

.meas tran vdout0_54ck220 FIND v(dout0_54) AT=115.025n

.meas tran vdout0_55ck220 FIND v(dout0_55) AT=115.025n

.meas tran vdout0_56ck220 FIND v(dout0_56) AT=115.025n

.meas tran vdout0_57ck220 FIND v(dout0_57) AT=115.025n

.meas tran vdout0_58ck220 FIND v(dout0_58) AT=115.025n

.meas tran vdout0_59ck220 FIND v(dout0_59) AT=115.025n

.meas tran vdout0_60ck220 FIND v(dout0_60) AT=115.025n

.meas tran vdout0_61ck220 FIND v(dout0_61) AT=115.025n

.meas tran vdout0_62ck220 FIND v(dout0_62) AT=115.025n

.meas tran vdout0_63ck220 FIND v(dout0_63) AT=115.025n

.meas tran vdout0_0ck250 FIND v(dout0_0) AT=130.025n

.meas tran vdout0_1ck250 FIND v(dout0_1) AT=130.025n

.meas tran vdout0_2ck250 FIND v(dout0_2) AT=130.025n

.meas tran vdout0_3ck250 FIND v(dout0_3) AT=130.025n

.meas tran vdout0_4ck250 FIND v(dout0_4) AT=130.025n

.meas tran vdout0_5ck250 FIND v(dout0_5) AT=130.025n

.meas tran vdout0_6ck250 FIND v(dout0_6) AT=130.025n

.meas tran vdout0_7ck250 FIND v(dout0_7) AT=130.025n

.meas tran vdout0_8ck250 FIND v(dout0_8) AT=130.025n

.meas tran vdout0_9ck250 FIND v(dout0_9) AT=130.025n

.meas tran vdout0_10ck250 FIND v(dout0_10) AT=130.025n

.meas tran vdout0_11ck250 FIND v(dout0_11) AT=130.025n

.meas tran vdout0_12ck250 FIND v(dout0_12) AT=130.025n

.meas tran vdout0_13ck250 FIND v(dout0_13) AT=130.025n

.meas tran vdout0_14ck250 FIND v(dout0_14) AT=130.025n

.meas tran vdout0_15ck250 FIND v(dout0_15) AT=130.025n

.meas tran vdout0_16ck250 FIND v(dout0_16) AT=130.025n

.meas tran vdout0_17ck250 FIND v(dout0_17) AT=130.025n

.meas tran vdout0_18ck250 FIND v(dout0_18) AT=130.025n

.meas tran vdout0_19ck250 FIND v(dout0_19) AT=130.025n

.meas tran vdout0_20ck250 FIND v(dout0_20) AT=130.025n

.meas tran vdout0_21ck250 FIND v(dout0_21) AT=130.025n

.meas tran vdout0_22ck250 FIND v(dout0_22) AT=130.025n

.meas tran vdout0_23ck250 FIND v(dout0_23) AT=130.025n

.meas tran vdout0_24ck250 FIND v(dout0_24) AT=130.025n

.meas tran vdout0_25ck250 FIND v(dout0_25) AT=130.025n

.meas tran vdout0_26ck250 FIND v(dout0_26) AT=130.025n

.meas tran vdout0_27ck250 FIND v(dout0_27) AT=130.025n

.meas tran vdout0_28ck250 FIND v(dout0_28) AT=130.025n

.meas tran vdout0_29ck250 FIND v(dout0_29) AT=130.025n

.meas tran vdout0_30ck250 FIND v(dout0_30) AT=130.025n

.meas tran vdout0_31ck250 FIND v(dout0_31) AT=130.025n

.meas tran vdout0_32ck250 FIND v(dout0_32) AT=130.025n

.meas tran vdout0_33ck250 FIND v(dout0_33) AT=130.025n

.meas tran vdout0_34ck250 FIND v(dout0_34) AT=130.025n

.meas tran vdout0_35ck250 FIND v(dout0_35) AT=130.025n

.meas tran vdout0_36ck250 FIND v(dout0_36) AT=130.025n

.meas tran vdout0_37ck250 FIND v(dout0_37) AT=130.025n

.meas tran vdout0_38ck250 FIND v(dout0_38) AT=130.025n

.meas tran vdout0_39ck250 FIND v(dout0_39) AT=130.025n

.meas tran vdout0_40ck250 FIND v(dout0_40) AT=130.025n

.meas tran vdout0_41ck250 FIND v(dout0_41) AT=130.025n

.meas tran vdout0_42ck250 FIND v(dout0_42) AT=130.025n

.meas tran vdout0_43ck250 FIND v(dout0_43) AT=130.025n

.meas tran vdout0_44ck250 FIND v(dout0_44) AT=130.025n

.meas tran vdout0_45ck250 FIND v(dout0_45) AT=130.025n

.meas tran vdout0_46ck250 FIND v(dout0_46) AT=130.025n

.meas tran vdout0_47ck250 FIND v(dout0_47) AT=130.025n

.meas tran vdout0_48ck250 FIND v(dout0_48) AT=130.025n

.meas tran vdout0_49ck250 FIND v(dout0_49) AT=130.025n

.meas tran vdout0_50ck250 FIND v(dout0_50) AT=130.025n

.meas tran vdout0_51ck250 FIND v(dout0_51) AT=130.025n

.meas tran vdout0_52ck250 FIND v(dout0_52) AT=130.025n

.meas tran vdout0_53ck250 FIND v(dout0_53) AT=130.025n

.meas tran vdout0_54ck250 FIND v(dout0_54) AT=130.025n

.meas tran vdout0_55ck250 FIND v(dout0_55) AT=130.025n

.meas tran vdout0_56ck250 FIND v(dout0_56) AT=130.025n

.meas tran vdout0_57ck250 FIND v(dout0_57) AT=130.025n

.meas tran vdout0_58ck250 FIND v(dout0_58) AT=130.025n

.meas tran vdout0_59ck250 FIND v(dout0_59) AT=130.025n

.meas tran vdout0_60ck250 FIND v(dout0_60) AT=130.025n

.meas tran vdout0_61ck250 FIND v(dout0_61) AT=130.025n

.meas tran vdout0_62ck250 FIND v(dout0_62) AT=130.025n

.meas tran vdout0_63ck250 FIND v(dout0_63) AT=130.025n

.meas tran vdout0_0ck260 FIND v(dout0_0) AT=135.025n

.meas tran vdout0_1ck260 FIND v(dout0_1) AT=135.025n

.meas tran vdout0_2ck260 FIND v(dout0_2) AT=135.025n

.meas tran vdout0_3ck260 FIND v(dout0_3) AT=135.025n

.meas tran vdout0_4ck260 FIND v(dout0_4) AT=135.025n

.meas tran vdout0_5ck260 FIND v(dout0_5) AT=135.025n

.meas tran vdout0_6ck260 FIND v(dout0_6) AT=135.025n

.meas tran vdout0_7ck260 FIND v(dout0_7) AT=135.025n

.meas tran vdout0_8ck260 FIND v(dout0_8) AT=135.025n

.meas tran vdout0_9ck260 FIND v(dout0_9) AT=135.025n

.meas tran vdout0_10ck260 FIND v(dout0_10) AT=135.025n

.meas tran vdout0_11ck260 FIND v(dout0_11) AT=135.025n

.meas tran vdout0_12ck260 FIND v(dout0_12) AT=135.025n

.meas tran vdout0_13ck260 FIND v(dout0_13) AT=135.025n

.meas tran vdout0_14ck260 FIND v(dout0_14) AT=135.025n

.meas tran vdout0_15ck260 FIND v(dout0_15) AT=135.025n

.meas tran vdout0_16ck260 FIND v(dout0_16) AT=135.025n

.meas tran vdout0_17ck260 FIND v(dout0_17) AT=135.025n

.meas tran vdout0_18ck260 FIND v(dout0_18) AT=135.025n

.meas tran vdout0_19ck260 FIND v(dout0_19) AT=135.025n

.meas tran vdout0_20ck260 FIND v(dout0_20) AT=135.025n

.meas tran vdout0_21ck260 FIND v(dout0_21) AT=135.025n

.meas tran vdout0_22ck260 FIND v(dout0_22) AT=135.025n

.meas tran vdout0_23ck260 FIND v(dout0_23) AT=135.025n

.meas tran vdout0_24ck260 FIND v(dout0_24) AT=135.025n

.meas tran vdout0_25ck260 FIND v(dout0_25) AT=135.025n

.meas tran vdout0_26ck260 FIND v(dout0_26) AT=135.025n

.meas tran vdout0_27ck260 FIND v(dout0_27) AT=135.025n

.meas tran vdout0_28ck260 FIND v(dout0_28) AT=135.025n

.meas tran vdout0_29ck260 FIND v(dout0_29) AT=135.025n

.meas tran vdout0_30ck260 FIND v(dout0_30) AT=135.025n

.meas tran vdout0_31ck260 FIND v(dout0_31) AT=135.025n

.meas tran vdout0_32ck260 FIND v(dout0_32) AT=135.025n

.meas tran vdout0_33ck260 FIND v(dout0_33) AT=135.025n

.meas tran vdout0_34ck260 FIND v(dout0_34) AT=135.025n

.meas tran vdout0_35ck260 FIND v(dout0_35) AT=135.025n

.meas tran vdout0_36ck260 FIND v(dout0_36) AT=135.025n

.meas tran vdout0_37ck260 FIND v(dout0_37) AT=135.025n

.meas tran vdout0_38ck260 FIND v(dout0_38) AT=135.025n

.meas tran vdout0_39ck260 FIND v(dout0_39) AT=135.025n

.meas tran vdout0_40ck260 FIND v(dout0_40) AT=135.025n

.meas tran vdout0_41ck260 FIND v(dout0_41) AT=135.025n

.meas tran vdout0_42ck260 FIND v(dout0_42) AT=135.025n

.meas tran vdout0_43ck260 FIND v(dout0_43) AT=135.025n

.meas tran vdout0_44ck260 FIND v(dout0_44) AT=135.025n

.meas tran vdout0_45ck260 FIND v(dout0_45) AT=135.025n

.meas tran vdout0_46ck260 FIND v(dout0_46) AT=135.025n

.meas tran vdout0_47ck260 FIND v(dout0_47) AT=135.025n

.meas tran vdout0_48ck260 FIND v(dout0_48) AT=135.025n

.meas tran vdout0_49ck260 FIND v(dout0_49) AT=135.025n

.meas tran vdout0_50ck260 FIND v(dout0_50) AT=135.025n

.meas tran vdout0_51ck260 FIND v(dout0_51) AT=135.025n

.meas tran vdout0_52ck260 FIND v(dout0_52) AT=135.025n

.meas tran vdout0_53ck260 FIND v(dout0_53) AT=135.025n

.meas tran vdout0_54ck260 FIND v(dout0_54) AT=135.025n

.meas tran vdout0_55ck260 FIND v(dout0_55) AT=135.025n

.meas tran vdout0_56ck260 FIND v(dout0_56) AT=135.025n

.meas tran vdout0_57ck260 FIND v(dout0_57) AT=135.025n

.meas tran vdout0_58ck260 FIND v(dout0_58) AT=135.025n

.meas tran vdout0_59ck260 FIND v(dout0_59) AT=135.025n

.meas tran vdout0_60ck260 FIND v(dout0_60) AT=135.025n

.meas tran vdout0_61ck260 FIND v(dout0_61) AT=135.025n

.meas tran vdout0_62ck260 FIND v(dout0_62) AT=135.025n

.meas tran vdout0_63ck260 FIND v(dout0_63) AT=135.025n

.meas tran vdout0_0ck300 FIND v(dout0_0) AT=155.025n

.meas tran vdout0_1ck300 FIND v(dout0_1) AT=155.025n

.meas tran vdout0_2ck300 FIND v(dout0_2) AT=155.025n

.meas tran vdout0_3ck300 FIND v(dout0_3) AT=155.025n

.meas tran vdout0_4ck300 FIND v(dout0_4) AT=155.025n

.meas tran vdout0_5ck300 FIND v(dout0_5) AT=155.025n

.meas tran vdout0_6ck300 FIND v(dout0_6) AT=155.025n

.meas tran vdout0_7ck300 FIND v(dout0_7) AT=155.025n

.meas tran vdout0_8ck300 FIND v(dout0_8) AT=155.025n

.meas tran vdout0_9ck300 FIND v(dout0_9) AT=155.025n

.meas tran vdout0_10ck300 FIND v(dout0_10) AT=155.025n

.meas tran vdout0_11ck300 FIND v(dout0_11) AT=155.025n

.meas tran vdout0_12ck300 FIND v(dout0_12) AT=155.025n

.meas tran vdout0_13ck300 FIND v(dout0_13) AT=155.025n

.meas tran vdout0_14ck300 FIND v(dout0_14) AT=155.025n

.meas tran vdout0_15ck300 FIND v(dout0_15) AT=155.025n

.meas tran vdout0_16ck300 FIND v(dout0_16) AT=155.025n

.meas tran vdout0_17ck300 FIND v(dout0_17) AT=155.025n

.meas tran vdout0_18ck300 FIND v(dout0_18) AT=155.025n

.meas tran vdout0_19ck300 FIND v(dout0_19) AT=155.025n

.meas tran vdout0_20ck300 FIND v(dout0_20) AT=155.025n

.meas tran vdout0_21ck300 FIND v(dout0_21) AT=155.025n

.meas tran vdout0_22ck300 FIND v(dout0_22) AT=155.025n

.meas tran vdout0_23ck300 FIND v(dout0_23) AT=155.025n

.meas tran vdout0_24ck300 FIND v(dout0_24) AT=155.025n

.meas tran vdout0_25ck300 FIND v(dout0_25) AT=155.025n

.meas tran vdout0_26ck300 FIND v(dout0_26) AT=155.025n

.meas tran vdout0_27ck300 FIND v(dout0_27) AT=155.025n

.meas tran vdout0_28ck300 FIND v(dout0_28) AT=155.025n

.meas tran vdout0_29ck300 FIND v(dout0_29) AT=155.025n

.meas tran vdout0_30ck300 FIND v(dout0_30) AT=155.025n

.meas tran vdout0_31ck300 FIND v(dout0_31) AT=155.025n

.meas tran vdout0_32ck300 FIND v(dout0_32) AT=155.025n

.meas tran vdout0_33ck300 FIND v(dout0_33) AT=155.025n

.meas tran vdout0_34ck300 FIND v(dout0_34) AT=155.025n

.meas tran vdout0_35ck300 FIND v(dout0_35) AT=155.025n

.meas tran vdout0_36ck300 FIND v(dout0_36) AT=155.025n

.meas tran vdout0_37ck300 FIND v(dout0_37) AT=155.025n

.meas tran vdout0_38ck300 FIND v(dout0_38) AT=155.025n

.meas tran vdout0_39ck300 FIND v(dout0_39) AT=155.025n

.meas tran vdout0_40ck300 FIND v(dout0_40) AT=155.025n

.meas tran vdout0_41ck300 FIND v(dout0_41) AT=155.025n

.meas tran vdout0_42ck300 FIND v(dout0_42) AT=155.025n

.meas tran vdout0_43ck300 FIND v(dout0_43) AT=155.025n

.meas tran vdout0_44ck300 FIND v(dout0_44) AT=155.025n

.meas tran vdout0_45ck300 FIND v(dout0_45) AT=155.025n

.meas tran vdout0_46ck300 FIND v(dout0_46) AT=155.025n

.meas tran vdout0_47ck300 FIND v(dout0_47) AT=155.025n

.meas tran vdout0_48ck300 FIND v(dout0_48) AT=155.025n

.meas tran vdout0_49ck300 FIND v(dout0_49) AT=155.025n

.meas tran vdout0_50ck300 FIND v(dout0_50) AT=155.025n

.meas tran vdout0_51ck300 FIND v(dout0_51) AT=155.025n

.meas tran vdout0_52ck300 FIND v(dout0_52) AT=155.025n

.meas tran vdout0_53ck300 FIND v(dout0_53) AT=155.025n

.meas tran vdout0_54ck300 FIND v(dout0_54) AT=155.025n

.meas tran vdout0_55ck300 FIND v(dout0_55) AT=155.025n

.meas tran vdout0_56ck300 FIND v(dout0_56) AT=155.025n

.meas tran vdout0_57ck300 FIND v(dout0_57) AT=155.025n

.meas tran vdout0_58ck300 FIND v(dout0_58) AT=155.025n

.meas tran vdout0_59ck300 FIND v(dout0_59) AT=155.025n

.meas tran vdout0_60ck300 FIND v(dout0_60) AT=155.025n

.meas tran vdout0_61ck300 FIND v(dout0_61) AT=155.025n

.meas tran vdout0_62ck300 FIND v(dout0_62) AT=155.025n

.meas tran vdout0_63ck300 FIND v(dout0_63) AT=155.025n

.meas tran vdout0_0ck310 FIND v(dout0_0) AT=160.025n

.meas tran vdout0_1ck310 FIND v(dout0_1) AT=160.025n

.meas tran vdout0_2ck310 FIND v(dout0_2) AT=160.025n

.meas tran vdout0_3ck310 FIND v(dout0_3) AT=160.025n

.meas tran vdout0_4ck310 FIND v(dout0_4) AT=160.025n

.meas tran vdout0_5ck310 FIND v(dout0_5) AT=160.025n

.meas tran vdout0_6ck310 FIND v(dout0_6) AT=160.025n

.meas tran vdout0_7ck310 FIND v(dout0_7) AT=160.025n

.meas tran vdout0_8ck310 FIND v(dout0_8) AT=160.025n

.meas tran vdout0_9ck310 FIND v(dout0_9) AT=160.025n

.meas tran vdout0_10ck310 FIND v(dout0_10) AT=160.025n

.meas tran vdout0_11ck310 FIND v(dout0_11) AT=160.025n

.meas tran vdout0_12ck310 FIND v(dout0_12) AT=160.025n

.meas tran vdout0_13ck310 FIND v(dout0_13) AT=160.025n

.meas tran vdout0_14ck310 FIND v(dout0_14) AT=160.025n

.meas tran vdout0_15ck310 FIND v(dout0_15) AT=160.025n

.meas tran vdout0_16ck310 FIND v(dout0_16) AT=160.025n

.meas tran vdout0_17ck310 FIND v(dout0_17) AT=160.025n

.meas tran vdout0_18ck310 FIND v(dout0_18) AT=160.025n

.meas tran vdout0_19ck310 FIND v(dout0_19) AT=160.025n

.meas tran vdout0_20ck310 FIND v(dout0_20) AT=160.025n

.meas tran vdout0_21ck310 FIND v(dout0_21) AT=160.025n

.meas tran vdout0_22ck310 FIND v(dout0_22) AT=160.025n

.meas tran vdout0_23ck310 FIND v(dout0_23) AT=160.025n

.meas tran vdout0_24ck310 FIND v(dout0_24) AT=160.025n

.meas tran vdout0_25ck310 FIND v(dout0_25) AT=160.025n

.meas tran vdout0_26ck310 FIND v(dout0_26) AT=160.025n

.meas tran vdout0_27ck310 FIND v(dout0_27) AT=160.025n

.meas tran vdout0_28ck310 FIND v(dout0_28) AT=160.025n

.meas tran vdout0_29ck310 FIND v(dout0_29) AT=160.025n

.meas tran vdout0_30ck310 FIND v(dout0_30) AT=160.025n

.meas tran vdout0_31ck310 FIND v(dout0_31) AT=160.025n

.meas tran vdout0_32ck310 FIND v(dout0_32) AT=160.025n

.meas tran vdout0_33ck310 FIND v(dout0_33) AT=160.025n

.meas tran vdout0_34ck310 FIND v(dout0_34) AT=160.025n

.meas tran vdout0_35ck310 FIND v(dout0_35) AT=160.025n

.meas tran vdout0_36ck310 FIND v(dout0_36) AT=160.025n

.meas tran vdout0_37ck310 FIND v(dout0_37) AT=160.025n

.meas tran vdout0_38ck310 FIND v(dout0_38) AT=160.025n

.meas tran vdout0_39ck310 FIND v(dout0_39) AT=160.025n

.meas tran vdout0_40ck310 FIND v(dout0_40) AT=160.025n

.meas tran vdout0_41ck310 FIND v(dout0_41) AT=160.025n

.meas tran vdout0_42ck310 FIND v(dout0_42) AT=160.025n

.meas tran vdout0_43ck310 FIND v(dout0_43) AT=160.025n

.meas tran vdout0_44ck310 FIND v(dout0_44) AT=160.025n

.meas tran vdout0_45ck310 FIND v(dout0_45) AT=160.025n

.meas tran vdout0_46ck310 FIND v(dout0_46) AT=160.025n

.meas tran vdout0_47ck310 FIND v(dout0_47) AT=160.025n

.meas tran vdout0_48ck310 FIND v(dout0_48) AT=160.025n

.meas tran vdout0_49ck310 FIND v(dout0_49) AT=160.025n

.meas tran vdout0_50ck310 FIND v(dout0_50) AT=160.025n

.meas tran vdout0_51ck310 FIND v(dout0_51) AT=160.025n

.meas tran vdout0_52ck310 FIND v(dout0_52) AT=160.025n

.meas tran vdout0_53ck310 FIND v(dout0_53) AT=160.025n

.meas tran vdout0_54ck310 FIND v(dout0_54) AT=160.025n

.meas tran vdout0_55ck310 FIND v(dout0_55) AT=160.025n

.meas tran vdout0_56ck310 FIND v(dout0_56) AT=160.025n

.meas tran vdout0_57ck310 FIND v(dout0_57) AT=160.025n

.meas tran vdout0_58ck310 FIND v(dout0_58) AT=160.025n

.meas tran vdout0_59ck310 FIND v(dout0_59) AT=160.025n

.meas tran vdout0_60ck310 FIND v(dout0_60) AT=160.025n

.meas tran vdout0_61ck310 FIND v(dout0_61) AT=160.025n

.meas tran vdout0_62ck310 FIND v(dout0_62) AT=160.025n

.meas tran vdout0_63ck310 FIND v(dout0_63) AT=160.025n

.meas tran vdout0_0ck320 FIND v(dout0_0) AT=165.025n

.meas tran vdout0_1ck320 FIND v(dout0_1) AT=165.025n

.meas tran vdout0_2ck320 FIND v(dout0_2) AT=165.025n

.meas tran vdout0_3ck320 FIND v(dout0_3) AT=165.025n

.meas tran vdout0_4ck320 FIND v(dout0_4) AT=165.025n

.meas tran vdout0_5ck320 FIND v(dout0_5) AT=165.025n

.meas tran vdout0_6ck320 FIND v(dout0_6) AT=165.025n

.meas tran vdout0_7ck320 FIND v(dout0_7) AT=165.025n

.meas tran vdout0_8ck320 FIND v(dout0_8) AT=165.025n

.meas tran vdout0_9ck320 FIND v(dout0_9) AT=165.025n

.meas tran vdout0_10ck320 FIND v(dout0_10) AT=165.025n

.meas tran vdout0_11ck320 FIND v(dout0_11) AT=165.025n

.meas tran vdout0_12ck320 FIND v(dout0_12) AT=165.025n

.meas tran vdout0_13ck320 FIND v(dout0_13) AT=165.025n

.meas tran vdout0_14ck320 FIND v(dout0_14) AT=165.025n

.meas tran vdout0_15ck320 FIND v(dout0_15) AT=165.025n

.meas tran vdout0_16ck320 FIND v(dout0_16) AT=165.025n

.meas tran vdout0_17ck320 FIND v(dout0_17) AT=165.025n

.meas tran vdout0_18ck320 FIND v(dout0_18) AT=165.025n

.meas tran vdout0_19ck320 FIND v(dout0_19) AT=165.025n

.meas tran vdout0_20ck320 FIND v(dout0_20) AT=165.025n

.meas tran vdout0_21ck320 FIND v(dout0_21) AT=165.025n

.meas tran vdout0_22ck320 FIND v(dout0_22) AT=165.025n

.meas tran vdout0_23ck320 FIND v(dout0_23) AT=165.025n

.meas tran vdout0_24ck320 FIND v(dout0_24) AT=165.025n

.meas tran vdout0_25ck320 FIND v(dout0_25) AT=165.025n

.meas tran vdout0_26ck320 FIND v(dout0_26) AT=165.025n

.meas tran vdout0_27ck320 FIND v(dout0_27) AT=165.025n

.meas tran vdout0_28ck320 FIND v(dout0_28) AT=165.025n

.meas tran vdout0_29ck320 FIND v(dout0_29) AT=165.025n

.meas tran vdout0_30ck320 FIND v(dout0_30) AT=165.025n

.meas tran vdout0_31ck320 FIND v(dout0_31) AT=165.025n

.meas tran vdout0_32ck320 FIND v(dout0_32) AT=165.025n

.meas tran vdout0_33ck320 FIND v(dout0_33) AT=165.025n

.meas tran vdout0_34ck320 FIND v(dout0_34) AT=165.025n

.meas tran vdout0_35ck320 FIND v(dout0_35) AT=165.025n

.meas tran vdout0_36ck320 FIND v(dout0_36) AT=165.025n

.meas tran vdout0_37ck320 FIND v(dout0_37) AT=165.025n

.meas tran vdout0_38ck320 FIND v(dout0_38) AT=165.025n

.meas tran vdout0_39ck320 FIND v(dout0_39) AT=165.025n

.meas tran vdout0_40ck320 FIND v(dout0_40) AT=165.025n

.meas tran vdout0_41ck320 FIND v(dout0_41) AT=165.025n

.meas tran vdout0_42ck320 FIND v(dout0_42) AT=165.025n

.meas tran vdout0_43ck320 FIND v(dout0_43) AT=165.025n

.meas tran vdout0_44ck320 FIND v(dout0_44) AT=165.025n

.meas tran vdout0_45ck320 FIND v(dout0_45) AT=165.025n

.meas tran vdout0_46ck320 FIND v(dout0_46) AT=165.025n

.meas tran vdout0_47ck320 FIND v(dout0_47) AT=165.025n

.meas tran vdout0_48ck320 FIND v(dout0_48) AT=165.025n

.meas tran vdout0_49ck320 FIND v(dout0_49) AT=165.025n

.meas tran vdout0_50ck320 FIND v(dout0_50) AT=165.025n

.meas tran vdout0_51ck320 FIND v(dout0_51) AT=165.025n

.meas tran vdout0_52ck320 FIND v(dout0_52) AT=165.025n

.meas tran vdout0_53ck320 FIND v(dout0_53) AT=165.025n

.meas tran vdout0_54ck320 FIND v(dout0_54) AT=165.025n

.meas tran vdout0_55ck320 FIND v(dout0_55) AT=165.025n

.meas tran vdout0_56ck320 FIND v(dout0_56) AT=165.025n

.meas tran vdout0_57ck320 FIND v(dout0_57) AT=165.025n

.meas tran vdout0_58ck320 FIND v(dout0_58) AT=165.025n

.meas tran vdout0_59ck320 FIND v(dout0_59) AT=165.025n

.meas tran vdout0_60ck320 FIND v(dout0_60) AT=165.025n

.meas tran vdout0_61ck320 FIND v(dout0_61) AT=165.025n

.meas tran vdout0_62ck320 FIND v(dout0_62) AT=165.025n

.meas tran vdout0_63ck320 FIND v(dout0_63) AT=165.025n

.meas tran vdout0_0ck330 FIND v(dout0_0) AT=170.025n

.meas tran vdout0_1ck330 FIND v(dout0_1) AT=170.025n

.meas tran vdout0_2ck330 FIND v(dout0_2) AT=170.025n

.meas tran vdout0_3ck330 FIND v(dout0_3) AT=170.025n

.meas tran vdout0_4ck330 FIND v(dout0_4) AT=170.025n

.meas tran vdout0_5ck330 FIND v(dout0_5) AT=170.025n

.meas tran vdout0_6ck330 FIND v(dout0_6) AT=170.025n

.meas tran vdout0_7ck330 FIND v(dout0_7) AT=170.025n

.meas tran vdout0_8ck330 FIND v(dout0_8) AT=170.025n

.meas tran vdout0_9ck330 FIND v(dout0_9) AT=170.025n

.meas tran vdout0_10ck330 FIND v(dout0_10) AT=170.025n

.meas tran vdout0_11ck330 FIND v(dout0_11) AT=170.025n

.meas tran vdout0_12ck330 FIND v(dout0_12) AT=170.025n

.meas tran vdout0_13ck330 FIND v(dout0_13) AT=170.025n

.meas tran vdout0_14ck330 FIND v(dout0_14) AT=170.025n

.meas tran vdout0_15ck330 FIND v(dout0_15) AT=170.025n

.meas tran vdout0_16ck330 FIND v(dout0_16) AT=170.025n

.meas tran vdout0_17ck330 FIND v(dout0_17) AT=170.025n

.meas tran vdout0_18ck330 FIND v(dout0_18) AT=170.025n

.meas tran vdout0_19ck330 FIND v(dout0_19) AT=170.025n

.meas tran vdout0_20ck330 FIND v(dout0_20) AT=170.025n

.meas tran vdout0_21ck330 FIND v(dout0_21) AT=170.025n

.meas tran vdout0_22ck330 FIND v(dout0_22) AT=170.025n

.meas tran vdout0_23ck330 FIND v(dout0_23) AT=170.025n

.meas tran vdout0_24ck330 FIND v(dout0_24) AT=170.025n

.meas tran vdout0_25ck330 FIND v(dout0_25) AT=170.025n

.meas tran vdout0_26ck330 FIND v(dout0_26) AT=170.025n

.meas tran vdout0_27ck330 FIND v(dout0_27) AT=170.025n

.meas tran vdout0_28ck330 FIND v(dout0_28) AT=170.025n

.meas tran vdout0_29ck330 FIND v(dout0_29) AT=170.025n

.meas tran vdout0_30ck330 FIND v(dout0_30) AT=170.025n

.meas tran vdout0_31ck330 FIND v(dout0_31) AT=170.025n

.meas tran vdout0_32ck330 FIND v(dout0_32) AT=170.025n

.meas tran vdout0_33ck330 FIND v(dout0_33) AT=170.025n

.meas tran vdout0_34ck330 FIND v(dout0_34) AT=170.025n

.meas tran vdout0_35ck330 FIND v(dout0_35) AT=170.025n

.meas tran vdout0_36ck330 FIND v(dout0_36) AT=170.025n

.meas tran vdout0_37ck330 FIND v(dout0_37) AT=170.025n

.meas tran vdout0_38ck330 FIND v(dout0_38) AT=170.025n

.meas tran vdout0_39ck330 FIND v(dout0_39) AT=170.025n

.meas tran vdout0_40ck330 FIND v(dout0_40) AT=170.025n

.meas tran vdout0_41ck330 FIND v(dout0_41) AT=170.025n

.meas tran vdout0_42ck330 FIND v(dout0_42) AT=170.025n

.meas tran vdout0_43ck330 FIND v(dout0_43) AT=170.025n

.meas tran vdout0_44ck330 FIND v(dout0_44) AT=170.025n

.meas tran vdout0_45ck330 FIND v(dout0_45) AT=170.025n

.meas tran vdout0_46ck330 FIND v(dout0_46) AT=170.025n

.meas tran vdout0_47ck330 FIND v(dout0_47) AT=170.025n

.meas tran vdout0_48ck330 FIND v(dout0_48) AT=170.025n

.meas tran vdout0_49ck330 FIND v(dout0_49) AT=170.025n

.meas tran vdout0_50ck330 FIND v(dout0_50) AT=170.025n

.meas tran vdout0_51ck330 FIND v(dout0_51) AT=170.025n

.meas tran vdout0_52ck330 FIND v(dout0_52) AT=170.025n

.meas tran vdout0_53ck330 FIND v(dout0_53) AT=170.025n

.meas tran vdout0_54ck330 FIND v(dout0_54) AT=170.025n

.meas tran vdout0_55ck330 FIND v(dout0_55) AT=170.025n

.meas tran vdout0_56ck330 FIND v(dout0_56) AT=170.025n

.meas tran vdout0_57ck330 FIND v(dout0_57) AT=170.025n

.meas tran vdout0_58ck330 FIND v(dout0_58) AT=170.025n

.meas tran vdout0_59ck330 FIND v(dout0_59) AT=170.025n

.meas tran vdout0_60ck330 FIND v(dout0_60) AT=170.025n

.meas tran vdout0_61ck330 FIND v(dout0_61) AT=170.025n

.meas tran vdout0_62ck330 FIND v(dout0_62) AT=170.025n

.meas tran vdout0_63ck330 FIND v(dout0_63) AT=170.025n

.meas tran vdout0_0ck360 FIND v(dout0_0) AT=185.025n

.meas tran vdout0_1ck360 FIND v(dout0_1) AT=185.025n

.meas tran vdout0_2ck360 FIND v(dout0_2) AT=185.025n

.meas tran vdout0_3ck360 FIND v(dout0_3) AT=185.025n

.meas tran vdout0_4ck360 FIND v(dout0_4) AT=185.025n

.meas tran vdout0_5ck360 FIND v(dout0_5) AT=185.025n

.meas tran vdout0_6ck360 FIND v(dout0_6) AT=185.025n

.meas tran vdout0_7ck360 FIND v(dout0_7) AT=185.025n

.meas tran vdout0_8ck360 FIND v(dout0_8) AT=185.025n

.meas tran vdout0_9ck360 FIND v(dout0_9) AT=185.025n

.meas tran vdout0_10ck360 FIND v(dout0_10) AT=185.025n

.meas tran vdout0_11ck360 FIND v(dout0_11) AT=185.025n

.meas tran vdout0_12ck360 FIND v(dout0_12) AT=185.025n

.meas tran vdout0_13ck360 FIND v(dout0_13) AT=185.025n

.meas tran vdout0_14ck360 FIND v(dout0_14) AT=185.025n

.meas tran vdout0_15ck360 FIND v(dout0_15) AT=185.025n

.meas tran vdout0_16ck360 FIND v(dout0_16) AT=185.025n

.meas tran vdout0_17ck360 FIND v(dout0_17) AT=185.025n

.meas tran vdout0_18ck360 FIND v(dout0_18) AT=185.025n

.meas tran vdout0_19ck360 FIND v(dout0_19) AT=185.025n

.meas tran vdout0_20ck360 FIND v(dout0_20) AT=185.025n

.meas tran vdout0_21ck360 FIND v(dout0_21) AT=185.025n

.meas tran vdout0_22ck360 FIND v(dout0_22) AT=185.025n

.meas tran vdout0_23ck360 FIND v(dout0_23) AT=185.025n

.meas tran vdout0_24ck360 FIND v(dout0_24) AT=185.025n

.meas tran vdout0_25ck360 FIND v(dout0_25) AT=185.025n

.meas tran vdout0_26ck360 FIND v(dout0_26) AT=185.025n

.meas tran vdout0_27ck360 FIND v(dout0_27) AT=185.025n

.meas tran vdout0_28ck360 FIND v(dout0_28) AT=185.025n

.meas tran vdout0_29ck360 FIND v(dout0_29) AT=185.025n

.meas tran vdout0_30ck360 FIND v(dout0_30) AT=185.025n

.meas tran vdout0_31ck360 FIND v(dout0_31) AT=185.025n

.meas tran vdout0_32ck360 FIND v(dout0_32) AT=185.025n

.meas tran vdout0_33ck360 FIND v(dout0_33) AT=185.025n

.meas tran vdout0_34ck360 FIND v(dout0_34) AT=185.025n

.meas tran vdout0_35ck360 FIND v(dout0_35) AT=185.025n

.meas tran vdout0_36ck360 FIND v(dout0_36) AT=185.025n

.meas tran vdout0_37ck360 FIND v(dout0_37) AT=185.025n

.meas tran vdout0_38ck360 FIND v(dout0_38) AT=185.025n

.meas tran vdout0_39ck360 FIND v(dout0_39) AT=185.025n

.meas tran vdout0_40ck360 FIND v(dout0_40) AT=185.025n

.meas tran vdout0_41ck360 FIND v(dout0_41) AT=185.025n

.meas tran vdout0_42ck360 FIND v(dout0_42) AT=185.025n

.meas tran vdout0_43ck360 FIND v(dout0_43) AT=185.025n

.meas tran vdout0_44ck360 FIND v(dout0_44) AT=185.025n

.meas tran vdout0_45ck360 FIND v(dout0_45) AT=185.025n

.meas tran vdout0_46ck360 FIND v(dout0_46) AT=185.025n

.meas tran vdout0_47ck360 FIND v(dout0_47) AT=185.025n

.meas tran vdout0_48ck360 FIND v(dout0_48) AT=185.025n

.meas tran vdout0_49ck360 FIND v(dout0_49) AT=185.025n

.meas tran vdout0_50ck360 FIND v(dout0_50) AT=185.025n

.meas tran vdout0_51ck360 FIND v(dout0_51) AT=185.025n

.meas tran vdout0_52ck360 FIND v(dout0_52) AT=185.025n

.meas tran vdout0_53ck360 FIND v(dout0_53) AT=185.025n

.meas tran vdout0_54ck360 FIND v(dout0_54) AT=185.025n

.meas tran vdout0_55ck360 FIND v(dout0_55) AT=185.025n

.meas tran vdout0_56ck360 FIND v(dout0_56) AT=185.025n

.meas tran vdout0_57ck360 FIND v(dout0_57) AT=185.025n

.meas tran vdout0_58ck360 FIND v(dout0_58) AT=185.025n

.meas tran vdout0_59ck360 FIND v(dout0_59) AT=185.025n

.meas tran vdout0_60ck360 FIND v(dout0_60) AT=185.025n

.meas tran vdout0_61ck360 FIND v(dout0_61) AT=185.025n

.meas tran vdout0_62ck360 FIND v(dout0_62) AT=185.025n

.meas tran vdout0_63ck360 FIND v(dout0_63) AT=185.025n

.meas tran vdout0_0ck380 FIND v(dout0_0) AT=195.025n

.meas tran vdout0_1ck380 FIND v(dout0_1) AT=195.025n

.meas tran vdout0_2ck380 FIND v(dout0_2) AT=195.025n

.meas tran vdout0_3ck380 FIND v(dout0_3) AT=195.025n

.meas tran vdout0_4ck380 FIND v(dout0_4) AT=195.025n

.meas tran vdout0_5ck380 FIND v(dout0_5) AT=195.025n

.meas tran vdout0_6ck380 FIND v(dout0_6) AT=195.025n

.meas tran vdout0_7ck380 FIND v(dout0_7) AT=195.025n

.meas tran vdout0_8ck380 FIND v(dout0_8) AT=195.025n

.meas tran vdout0_9ck380 FIND v(dout0_9) AT=195.025n

.meas tran vdout0_10ck380 FIND v(dout0_10) AT=195.025n

.meas tran vdout0_11ck380 FIND v(dout0_11) AT=195.025n

.meas tran vdout0_12ck380 FIND v(dout0_12) AT=195.025n

.meas tran vdout0_13ck380 FIND v(dout0_13) AT=195.025n

.meas tran vdout0_14ck380 FIND v(dout0_14) AT=195.025n

.meas tran vdout0_15ck380 FIND v(dout0_15) AT=195.025n

.meas tran vdout0_16ck380 FIND v(dout0_16) AT=195.025n

.meas tran vdout0_17ck380 FIND v(dout0_17) AT=195.025n

.meas tran vdout0_18ck380 FIND v(dout0_18) AT=195.025n

.meas tran vdout0_19ck380 FIND v(dout0_19) AT=195.025n

.meas tran vdout0_20ck380 FIND v(dout0_20) AT=195.025n

.meas tran vdout0_21ck380 FIND v(dout0_21) AT=195.025n

.meas tran vdout0_22ck380 FIND v(dout0_22) AT=195.025n

.meas tran vdout0_23ck380 FIND v(dout0_23) AT=195.025n

.meas tran vdout0_24ck380 FIND v(dout0_24) AT=195.025n

.meas tran vdout0_25ck380 FIND v(dout0_25) AT=195.025n

.meas tran vdout0_26ck380 FIND v(dout0_26) AT=195.025n

.meas tran vdout0_27ck380 FIND v(dout0_27) AT=195.025n

.meas tran vdout0_28ck380 FIND v(dout0_28) AT=195.025n

.meas tran vdout0_29ck380 FIND v(dout0_29) AT=195.025n

.meas tran vdout0_30ck380 FIND v(dout0_30) AT=195.025n

.meas tran vdout0_31ck380 FIND v(dout0_31) AT=195.025n

.meas tran vdout0_32ck380 FIND v(dout0_32) AT=195.025n

.meas tran vdout0_33ck380 FIND v(dout0_33) AT=195.025n

.meas tran vdout0_34ck380 FIND v(dout0_34) AT=195.025n

.meas tran vdout0_35ck380 FIND v(dout0_35) AT=195.025n

.meas tran vdout0_36ck380 FIND v(dout0_36) AT=195.025n

.meas tran vdout0_37ck380 FIND v(dout0_37) AT=195.025n

.meas tran vdout0_38ck380 FIND v(dout0_38) AT=195.025n

.meas tran vdout0_39ck380 FIND v(dout0_39) AT=195.025n

.meas tran vdout0_40ck380 FIND v(dout0_40) AT=195.025n

.meas tran vdout0_41ck380 FIND v(dout0_41) AT=195.025n

.meas tran vdout0_42ck380 FIND v(dout0_42) AT=195.025n

.meas tran vdout0_43ck380 FIND v(dout0_43) AT=195.025n

.meas tran vdout0_44ck380 FIND v(dout0_44) AT=195.025n

.meas tran vdout0_45ck380 FIND v(dout0_45) AT=195.025n

.meas tran vdout0_46ck380 FIND v(dout0_46) AT=195.025n

.meas tran vdout0_47ck380 FIND v(dout0_47) AT=195.025n

.meas tran vdout0_48ck380 FIND v(dout0_48) AT=195.025n

.meas tran vdout0_49ck380 FIND v(dout0_49) AT=195.025n

.meas tran vdout0_50ck380 FIND v(dout0_50) AT=195.025n

.meas tran vdout0_51ck380 FIND v(dout0_51) AT=195.025n

.meas tran vdout0_52ck380 FIND v(dout0_52) AT=195.025n

.meas tran vdout0_53ck380 FIND v(dout0_53) AT=195.025n

.meas tran vdout0_54ck380 FIND v(dout0_54) AT=195.025n

.meas tran vdout0_55ck380 FIND v(dout0_55) AT=195.025n

.meas tran vdout0_56ck380 FIND v(dout0_56) AT=195.025n

.meas tran vdout0_57ck380 FIND v(dout0_57) AT=195.025n

.meas tran vdout0_58ck380 FIND v(dout0_58) AT=195.025n

.meas tran vdout0_59ck380 FIND v(dout0_59) AT=195.025n

.meas tran vdout0_60ck380 FIND v(dout0_60) AT=195.025n

.meas tran vdout0_61ck380 FIND v(dout0_61) AT=195.025n

.meas tran vdout0_62ck380 FIND v(dout0_62) AT=195.025n

.meas tran vdout0_63ck380 FIND v(dout0_63) AT=195.025n

.meas tran vdout0_0ck390 FIND v(dout0_0) AT=200.025n

.meas tran vdout0_1ck390 FIND v(dout0_1) AT=200.025n

.meas tran vdout0_2ck390 FIND v(dout0_2) AT=200.025n

.meas tran vdout0_3ck390 FIND v(dout0_3) AT=200.025n

.meas tran vdout0_4ck390 FIND v(dout0_4) AT=200.025n

.meas tran vdout0_5ck390 FIND v(dout0_5) AT=200.025n

.meas tran vdout0_6ck390 FIND v(dout0_6) AT=200.025n

.meas tran vdout0_7ck390 FIND v(dout0_7) AT=200.025n

.meas tran vdout0_8ck390 FIND v(dout0_8) AT=200.025n

.meas tran vdout0_9ck390 FIND v(dout0_9) AT=200.025n

.meas tran vdout0_10ck390 FIND v(dout0_10) AT=200.025n

.meas tran vdout0_11ck390 FIND v(dout0_11) AT=200.025n

.meas tran vdout0_12ck390 FIND v(dout0_12) AT=200.025n

.meas tran vdout0_13ck390 FIND v(dout0_13) AT=200.025n

.meas tran vdout0_14ck390 FIND v(dout0_14) AT=200.025n

.meas tran vdout0_15ck390 FIND v(dout0_15) AT=200.025n

.meas tran vdout0_16ck390 FIND v(dout0_16) AT=200.025n

.meas tran vdout0_17ck390 FIND v(dout0_17) AT=200.025n

.meas tran vdout0_18ck390 FIND v(dout0_18) AT=200.025n

.meas tran vdout0_19ck390 FIND v(dout0_19) AT=200.025n

.meas tran vdout0_20ck390 FIND v(dout0_20) AT=200.025n

.meas tran vdout0_21ck390 FIND v(dout0_21) AT=200.025n

.meas tran vdout0_22ck390 FIND v(dout0_22) AT=200.025n

.meas tran vdout0_23ck390 FIND v(dout0_23) AT=200.025n

.meas tran vdout0_24ck390 FIND v(dout0_24) AT=200.025n

.meas tran vdout0_25ck390 FIND v(dout0_25) AT=200.025n

.meas tran vdout0_26ck390 FIND v(dout0_26) AT=200.025n

.meas tran vdout0_27ck390 FIND v(dout0_27) AT=200.025n

.meas tran vdout0_28ck390 FIND v(dout0_28) AT=200.025n

.meas tran vdout0_29ck390 FIND v(dout0_29) AT=200.025n

.meas tran vdout0_30ck390 FIND v(dout0_30) AT=200.025n

.meas tran vdout0_31ck390 FIND v(dout0_31) AT=200.025n

.meas tran vdout0_32ck390 FIND v(dout0_32) AT=200.025n

.meas tran vdout0_33ck390 FIND v(dout0_33) AT=200.025n

.meas tran vdout0_34ck390 FIND v(dout0_34) AT=200.025n

.meas tran vdout0_35ck390 FIND v(dout0_35) AT=200.025n

.meas tran vdout0_36ck390 FIND v(dout0_36) AT=200.025n

.meas tran vdout0_37ck390 FIND v(dout0_37) AT=200.025n

.meas tran vdout0_38ck390 FIND v(dout0_38) AT=200.025n

.meas tran vdout0_39ck390 FIND v(dout0_39) AT=200.025n

.meas tran vdout0_40ck390 FIND v(dout0_40) AT=200.025n

.meas tran vdout0_41ck390 FIND v(dout0_41) AT=200.025n

.meas tran vdout0_42ck390 FIND v(dout0_42) AT=200.025n

.meas tran vdout0_43ck390 FIND v(dout0_43) AT=200.025n

.meas tran vdout0_44ck390 FIND v(dout0_44) AT=200.025n

.meas tran vdout0_45ck390 FIND v(dout0_45) AT=200.025n

.meas tran vdout0_46ck390 FIND v(dout0_46) AT=200.025n

.meas tran vdout0_47ck390 FIND v(dout0_47) AT=200.025n

.meas tran vdout0_48ck390 FIND v(dout0_48) AT=200.025n

.meas tran vdout0_49ck390 FIND v(dout0_49) AT=200.025n

.meas tran vdout0_50ck390 FIND v(dout0_50) AT=200.025n

.meas tran vdout0_51ck390 FIND v(dout0_51) AT=200.025n

.meas tran vdout0_52ck390 FIND v(dout0_52) AT=200.025n

.meas tran vdout0_53ck390 FIND v(dout0_53) AT=200.025n

.meas tran vdout0_54ck390 FIND v(dout0_54) AT=200.025n

.meas tran vdout0_55ck390 FIND v(dout0_55) AT=200.025n

.meas tran vdout0_56ck390 FIND v(dout0_56) AT=200.025n

.meas tran vdout0_57ck390 FIND v(dout0_57) AT=200.025n

.meas tran vdout0_58ck390 FIND v(dout0_58) AT=200.025n

.meas tran vdout0_59ck390 FIND v(dout0_59) AT=200.025n

.meas tran vdout0_60ck390 FIND v(dout0_60) AT=200.025n

.meas tran vdout0_61ck390 FIND v(dout0_61) AT=200.025n

.meas tran vdout0_62ck390 FIND v(dout0_62) AT=200.025n

.meas tran vdout0_63ck390 FIND v(dout0_63) AT=200.025n

.meas tran vdout0_0ck430 FIND v(dout0_0) AT=220.025n

.meas tran vdout0_1ck430 FIND v(dout0_1) AT=220.025n

.meas tran vdout0_2ck430 FIND v(dout0_2) AT=220.025n

.meas tran vdout0_3ck430 FIND v(dout0_3) AT=220.025n

.meas tran vdout0_4ck430 FIND v(dout0_4) AT=220.025n

.meas tran vdout0_5ck430 FIND v(dout0_5) AT=220.025n

.meas tran vdout0_6ck430 FIND v(dout0_6) AT=220.025n

.meas tran vdout0_7ck430 FIND v(dout0_7) AT=220.025n

.meas tran vdout0_8ck430 FIND v(dout0_8) AT=220.025n

.meas tran vdout0_9ck430 FIND v(dout0_9) AT=220.025n

.meas tran vdout0_10ck430 FIND v(dout0_10) AT=220.025n

.meas tran vdout0_11ck430 FIND v(dout0_11) AT=220.025n

.meas tran vdout0_12ck430 FIND v(dout0_12) AT=220.025n

.meas tran vdout0_13ck430 FIND v(dout0_13) AT=220.025n

.meas tran vdout0_14ck430 FIND v(dout0_14) AT=220.025n

.meas tran vdout0_15ck430 FIND v(dout0_15) AT=220.025n

.meas tran vdout0_16ck430 FIND v(dout0_16) AT=220.025n

.meas tran vdout0_17ck430 FIND v(dout0_17) AT=220.025n

.meas tran vdout0_18ck430 FIND v(dout0_18) AT=220.025n

.meas tran vdout0_19ck430 FIND v(dout0_19) AT=220.025n

.meas tran vdout0_20ck430 FIND v(dout0_20) AT=220.025n

.meas tran vdout0_21ck430 FIND v(dout0_21) AT=220.025n

.meas tran vdout0_22ck430 FIND v(dout0_22) AT=220.025n

.meas tran vdout0_23ck430 FIND v(dout0_23) AT=220.025n

.meas tran vdout0_24ck430 FIND v(dout0_24) AT=220.025n

.meas tran vdout0_25ck430 FIND v(dout0_25) AT=220.025n

.meas tran vdout0_26ck430 FIND v(dout0_26) AT=220.025n

.meas tran vdout0_27ck430 FIND v(dout0_27) AT=220.025n

.meas tran vdout0_28ck430 FIND v(dout0_28) AT=220.025n

.meas tran vdout0_29ck430 FIND v(dout0_29) AT=220.025n

.meas tran vdout0_30ck430 FIND v(dout0_30) AT=220.025n

.meas tran vdout0_31ck430 FIND v(dout0_31) AT=220.025n

.meas tran vdout0_32ck430 FIND v(dout0_32) AT=220.025n

.meas tran vdout0_33ck430 FIND v(dout0_33) AT=220.025n

.meas tran vdout0_34ck430 FIND v(dout0_34) AT=220.025n

.meas tran vdout0_35ck430 FIND v(dout0_35) AT=220.025n

.meas tran vdout0_36ck430 FIND v(dout0_36) AT=220.025n

.meas tran vdout0_37ck430 FIND v(dout0_37) AT=220.025n

.meas tran vdout0_38ck430 FIND v(dout0_38) AT=220.025n

.meas tran vdout0_39ck430 FIND v(dout0_39) AT=220.025n

.meas tran vdout0_40ck430 FIND v(dout0_40) AT=220.025n

.meas tran vdout0_41ck430 FIND v(dout0_41) AT=220.025n

.meas tran vdout0_42ck430 FIND v(dout0_42) AT=220.025n

.meas tran vdout0_43ck430 FIND v(dout0_43) AT=220.025n

.meas tran vdout0_44ck430 FIND v(dout0_44) AT=220.025n

.meas tran vdout0_45ck430 FIND v(dout0_45) AT=220.025n

.meas tran vdout0_46ck430 FIND v(dout0_46) AT=220.025n

.meas tran vdout0_47ck430 FIND v(dout0_47) AT=220.025n

.meas tran vdout0_48ck430 FIND v(dout0_48) AT=220.025n

.meas tran vdout0_49ck430 FIND v(dout0_49) AT=220.025n

.meas tran vdout0_50ck430 FIND v(dout0_50) AT=220.025n

.meas tran vdout0_51ck430 FIND v(dout0_51) AT=220.025n

.meas tran vdout0_52ck430 FIND v(dout0_52) AT=220.025n

.meas tran vdout0_53ck430 FIND v(dout0_53) AT=220.025n

.meas tran vdout0_54ck430 FIND v(dout0_54) AT=220.025n

.meas tran vdout0_55ck430 FIND v(dout0_55) AT=220.025n

.meas tran vdout0_56ck430 FIND v(dout0_56) AT=220.025n

.meas tran vdout0_57ck430 FIND v(dout0_57) AT=220.025n

.meas tran vdout0_58ck430 FIND v(dout0_58) AT=220.025n

.meas tran vdout0_59ck430 FIND v(dout0_59) AT=220.025n

.meas tran vdout0_60ck430 FIND v(dout0_60) AT=220.025n

.meas tran vdout0_61ck430 FIND v(dout0_61) AT=220.025n

.meas tran vdout0_62ck430 FIND v(dout0_62) AT=220.025n

.meas tran vdout0_63ck430 FIND v(dout0_63) AT=220.025n

.meas tran vdout0_0ck450 FIND v(dout0_0) AT=230.025n

.meas tran vdout0_1ck450 FIND v(dout0_1) AT=230.025n

.meas tran vdout0_2ck450 FIND v(dout0_2) AT=230.025n

.meas tran vdout0_3ck450 FIND v(dout0_3) AT=230.025n

.meas tran vdout0_4ck450 FIND v(dout0_4) AT=230.025n

.meas tran vdout0_5ck450 FIND v(dout0_5) AT=230.025n

.meas tran vdout0_6ck450 FIND v(dout0_6) AT=230.025n

.meas tran vdout0_7ck450 FIND v(dout0_7) AT=230.025n

.meas tran vdout0_8ck450 FIND v(dout0_8) AT=230.025n

.meas tran vdout0_9ck450 FIND v(dout0_9) AT=230.025n

.meas tran vdout0_10ck450 FIND v(dout0_10) AT=230.025n

.meas tran vdout0_11ck450 FIND v(dout0_11) AT=230.025n

.meas tran vdout0_12ck450 FIND v(dout0_12) AT=230.025n

.meas tran vdout0_13ck450 FIND v(dout0_13) AT=230.025n

.meas tran vdout0_14ck450 FIND v(dout0_14) AT=230.025n

.meas tran vdout0_15ck450 FIND v(dout0_15) AT=230.025n

.meas tran vdout0_16ck450 FIND v(dout0_16) AT=230.025n

.meas tran vdout0_17ck450 FIND v(dout0_17) AT=230.025n

.meas tran vdout0_18ck450 FIND v(dout0_18) AT=230.025n

.meas tran vdout0_19ck450 FIND v(dout0_19) AT=230.025n

.meas tran vdout0_20ck450 FIND v(dout0_20) AT=230.025n

.meas tran vdout0_21ck450 FIND v(dout0_21) AT=230.025n

.meas tran vdout0_22ck450 FIND v(dout0_22) AT=230.025n

.meas tran vdout0_23ck450 FIND v(dout0_23) AT=230.025n

.meas tran vdout0_24ck450 FIND v(dout0_24) AT=230.025n

.meas tran vdout0_25ck450 FIND v(dout0_25) AT=230.025n

.meas tran vdout0_26ck450 FIND v(dout0_26) AT=230.025n

.meas tran vdout0_27ck450 FIND v(dout0_27) AT=230.025n

.meas tran vdout0_28ck450 FIND v(dout0_28) AT=230.025n

.meas tran vdout0_29ck450 FIND v(dout0_29) AT=230.025n

.meas tran vdout0_30ck450 FIND v(dout0_30) AT=230.025n

.meas tran vdout0_31ck450 FIND v(dout0_31) AT=230.025n

.meas tran vdout0_32ck450 FIND v(dout0_32) AT=230.025n

.meas tran vdout0_33ck450 FIND v(dout0_33) AT=230.025n

.meas tran vdout0_34ck450 FIND v(dout0_34) AT=230.025n

.meas tran vdout0_35ck450 FIND v(dout0_35) AT=230.025n

.meas tran vdout0_36ck450 FIND v(dout0_36) AT=230.025n

.meas tran vdout0_37ck450 FIND v(dout0_37) AT=230.025n

.meas tran vdout0_38ck450 FIND v(dout0_38) AT=230.025n

.meas tran vdout0_39ck450 FIND v(dout0_39) AT=230.025n

.meas tran vdout0_40ck450 FIND v(dout0_40) AT=230.025n

.meas tran vdout0_41ck450 FIND v(dout0_41) AT=230.025n

.meas tran vdout0_42ck450 FIND v(dout0_42) AT=230.025n

.meas tran vdout0_43ck450 FIND v(dout0_43) AT=230.025n

.meas tran vdout0_44ck450 FIND v(dout0_44) AT=230.025n

.meas tran vdout0_45ck450 FIND v(dout0_45) AT=230.025n

.meas tran vdout0_46ck450 FIND v(dout0_46) AT=230.025n

.meas tran vdout0_47ck450 FIND v(dout0_47) AT=230.025n

.meas tran vdout0_48ck450 FIND v(dout0_48) AT=230.025n

.meas tran vdout0_49ck450 FIND v(dout0_49) AT=230.025n

.meas tran vdout0_50ck450 FIND v(dout0_50) AT=230.025n

.meas tran vdout0_51ck450 FIND v(dout0_51) AT=230.025n

.meas tran vdout0_52ck450 FIND v(dout0_52) AT=230.025n

.meas tran vdout0_53ck450 FIND v(dout0_53) AT=230.025n

.meas tran vdout0_54ck450 FIND v(dout0_54) AT=230.025n

.meas tran vdout0_55ck450 FIND v(dout0_55) AT=230.025n

.meas tran vdout0_56ck450 FIND v(dout0_56) AT=230.025n

.meas tran vdout0_57ck450 FIND v(dout0_57) AT=230.025n

.meas tran vdout0_58ck450 FIND v(dout0_58) AT=230.025n

.meas tran vdout0_59ck450 FIND v(dout0_59) AT=230.025n

.meas tran vdout0_60ck450 FIND v(dout0_60) AT=230.025n

.meas tran vdout0_61ck450 FIND v(dout0_61) AT=230.025n

.meas tran vdout0_62ck450 FIND v(dout0_62) AT=230.025n

.meas tran vdout0_63ck450 FIND v(dout0_63) AT=230.025n

.meas tran vdout0_0ck470 FIND v(dout0_0) AT=240.025n

.meas tran vdout0_1ck470 FIND v(dout0_1) AT=240.025n

.meas tran vdout0_2ck470 FIND v(dout0_2) AT=240.025n

.meas tran vdout0_3ck470 FIND v(dout0_3) AT=240.025n

.meas tran vdout0_4ck470 FIND v(dout0_4) AT=240.025n

.meas tran vdout0_5ck470 FIND v(dout0_5) AT=240.025n

.meas tran vdout0_6ck470 FIND v(dout0_6) AT=240.025n

.meas tran vdout0_7ck470 FIND v(dout0_7) AT=240.025n

.meas tran vdout0_8ck470 FIND v(dout0_8) AT=240.025n

.meas tran vdout0_9ck470 FIND v(dout0_9) AT=240.025n

.meas tran vdout0_10ck470 FIND v(dout0_10) AT=240.025n

.meas tran vdout0_11ck470 FIND v(dout0_11) AT=240.025n

.meas tran vdout0_12ck470 FIND v(dout0_12) AT=240.025n

.meas tran vdout0_13ck470 FIND v(dout0_13) AT=240.025n

.meas tran vdout0_14ck470 FIND v(dout0_14) AT=240.025n

.meas tran vdout0_15ck470 FIND v(dout0_15) AT=240.025n

.meas tran vdout0_16ck470 FIND v(dout0_16) AT=240.025n

.meas tran vdout0_17ck470 FIND v(dout0_17) AT=240.025n

.meas tran vdout0_18ck470 FIND v(dout0_18) AT=240.025n

.meas tran vdout0_19ck470 FIND v(dout0_19) AT=240.025n

.meas tran vdout0_20ck470 FIND v(dout0_20) AT=240.025n

.meas tran vdout0_21ck470 FIND v(dout0_21) AT=240.025n

.meas tran vdout0_22ck470 FIND v(dout0_22) AT=240.025n

.meas tran vdout0_23ck470 FIND v(dout0_23) AT=240.025n

.meas tran vdout0_24ck470 FIND v(dout0_24) AT=240.025n

.meas tran vdout0_25ck470 FIND v(dout0_25) AT=240.025n

.meas tran vdout0_26ck470 FIND v(dout0_26) AT=240.025n

.meas tran vdout0_27ck470 FIND v(dout0_27) AT=240.025n

.meas tran vdout0_28ck470 FIND v(dout0_28) AT=240.025n

.meas tran vdout0_29ck470 FIND v(dout0_29) AT=240.025n

.meas tran vdout0_30ck470 FIND v(dout0_30) AT=240.025n

.meas tran vdout0_31ck470 FIND v(dout0_31) AT=240.025n

.meas tran vdout0_32ck470 FIND v(dout0_32) AT=240.025n

.meas tran vdout0_33ck470 FIND v(dout0_33) AT=240.025n

.meas tran vdout0_34ck470 FIND v(dout0_34) AT=240.025n

.meas tran vdout0_35ck470 FIND v(dout0_35) AT=240.025n

.meas tran vdout0_36ck470 FIND v(dout0_36) AT=240.025n

.meas tran vdout0_37ck470 FIND v(dout0_37) AT=240.025n

.meas tran vdout0_38ck470 FIND v(dout0_38) AT=240.025n

.meas tran vdout0_39ck470 FIND v(dout0_39) AT=240.025n

.meas tran vdout0_40ck470 FIND v(dout0_40) AT=240.025n

.meas tran vdout0_41ck470 FIND v(dout0_41) AT=240.025n

.meas tran vdout0_42ck470 FIND v(dout0_42) AT=240.025n

.meas tran vdout0_43ck470 FIND v(dout0_43) AT=240.025n

.meas tran vdout0_44ck470 FIND v(dout0_44) AT=240.025n

.meas tran vdout0_45ck470 FIND v(dout0_45) AT=240.025n

.meas tran vdout0_46ck470 FIND v(dout0_46) AT=240.025n

.meas tran vdout0_47ck470 FIND v(dout0_47) AT=240.025n

.meas tran vdout0_48ck470 FIND v(dout0_48) AT=240.025n

.meas tran vdout0_49ck470 FIND v(dout0_49) AT=240.025n

.meas tran vdout0_50ck470 FIND v(dout0_50) AT=240.025n

.meas tran vdout0_51ck470 FIND v(dout0_51) AT=240.025n

.meas tran vdout0_52ck470 FIND v(dout0_52) AT=240.025n

.meas tran vdout0_53ck470 FIND v(dout0_53) AT=240.025n

.meas tran vdout0_54ck470 FIND v(dout0_54) AT=240.025n

.meas tran vdout0_55ck470 FIND v(dout0_55) AT=240.025n

.meas tran vdout0_56ck470 FIND v(dout0_56) AT=240.025n

.meas tran vdout0_57ck470 FIND v(dout0_57) AT=240.025n

.meas tran vdout0_58ck470 FIND v(dout0_58) AT=240.025n

.meas tran vdout0_59ck470 FIND v(dout0_59) AT=240.025n

.meas tran vdout0_60ck470 FIND v(dout0_60) AT=240.025n

.meas tran vdout0_61ck470 FIND v(dout0_61) AT=240.025n

.meas tran vdout0_62ck470 FIND v(dout0_62) AT=240.025n

.meas tran vdout0_63ck470 FIND v(dout0_63) AT=240.025n

.meas tran vdout0_0ck490 FIND v(dout0_0) AT=250.025n

.meas tran vdout0_1ck490 FIND v(dout0_1) AT=250.025n

.meas tran vdout0_2ck490 FIND v(dout0_2) AT=250.025n

.meas tran vdout0_3ck490 FIND v(dout0_3) AT=250.025n

.meas tran vdout0_4ck490 FIND v(dout0_4) AT=250.025n

.meas tran vdout0_5ck490 FIND v(dout0_5) AT=250.025n

.meas tran vdout0_6ck490 FIND v(dout0_6) AT=250.025n

.meas tran vdout0_7ck490 FIND v(dout0_7) AT=250.025n

.meas tran vdout0_8ck490 FIND v(dout0_8) AT=250.025n

.meas tran vdout0_9ck490 FIND v(dout0_9) AT=250.025n

.meas tran vdout0_10ck490 FIND v(dout0_10) AT=250.025n

.meas tran vdout0_11ck490 FIND v(dout0_11) AT=250.025n

.meas tran vdout0_12ck490 FIND v(dout0_12) AT=250.025n

.meas tran vdout0_13ck490 FIND v(dout0_13) AT=250.025n

.meas tran vdout0_14ck490 FIND v(dout0_14) AT=250.025n

.meas tran vdout0_15ck490 FIND v(dout0_15) AT=250.025n

.meas tran vdout0_16ck490 FIND v(dout0_16) AT=250.025n

.meas tran vdout0_17ck490 FIND v(dout0_17) AT=250.025n

.meas tran vdout0_18ck490 FIND v(dout0_18) AT=250.025n

.meas tran vdout0_19ck490 FIND v(dout0_19) AT=250.025n

.meas tran vdout0_20ck490 FIND v(dout0_20) AT=250.025n

.meas tran vdout0_21ck490 FIND v(dout0_21) AT=250.025n

.meas tran vdout0_22ck490 FIND v(dout0_22) AT=250.025n

.meas tran vdout0_23ck490 FIND v(dout0_23) AT=250.025n

.meas tran vdout0_24ck490 FIND v(dout0_24) AT=250.025n

.meas tran vdout0_25ck490 FIND v(dout0_25) AT=250.025n

.meas tran vdout0_26ck490 FIND v(dout0_26) AT=250.025n

.meas tran vdout0_27ck490 FIND v(dout0_27) AT=250.025n

.meas tran vdout0_28ck490 FIND v(dout0_28) AT=250.025n

.meas tran vdout0_29ck490 FIND v(dout0_29) AT=250.025n

.meas tran vdout0_30ck490 FIND v(dout0_30) AT=250.025n

.meas tran vdout0_31ck490 FIND v(dout0_31) AT=250.025n

.meas tran vdout0_32ck490 FIND v(dout0_32) AT=250.025n

.meas tran vdout0_33ck490 FIND v(dout0_33) AT=250.025n

.meas tran vdout0_34ck490 FIND v(dout0_34) AT=250.025n

.meas tran vdout0_35ck490 FIND v(dout0_35) AT=250.025n

.meas tran vdout0_36ck490 FIND v(dout0_36) AT=250.025n

.meas tran vdout0_37ck490 FIND v(dout0_37) AT=250.025n

.meas tran vdout0_38ck490 FIND v(dout0_38) AT=250.025n

.meas tran vdout0_39ck490 FIND v(dout0_39) AT=250.025n

.meas tran vdout0_40ck490 FIND v(dout0_40) AT=250.025n

.meas tran vdout0_41ck490 FIND v(dout0_41) AT=250.025n

.meas tran vdout0_42ck490 FIND v(dout0_42) AT=250.025n

.meas tran vdout0_43ck490 FIND v(dout0_43) AT=250.025n

.meas tran vdout0_44ck490 FIND v(dout0_44) AT=250.025n

.meas tran vdout0_45ck490 FIND v(dout0_45) AT=250.025n

.meas tran vdout0_46ck490 FIND v(dout0_46) AT=250.025n

.meas tran vdout0_47ck490 FIND v(dout0_47) AT=250.025n

.meas tran vdout0_48ck490 FIND v(dout0_48) AT=250.025n

.meas tran vdout0_49ck490 FIND v(dout0_49) AT=250.025n

.meas tran vdout0_50ck490 FIND v(dout0_50) AT=250.025n

.meas tran vdout0_51ck490 FIND v(dout0_51) AT=250.025n

.meas tran vdout0_52ck490 FIND v(dout0_52) AT=250.025n

.meas tran vdout0_53ck490 FIND v(dout0_53) AT=250.025n

.meas tran vdout0_54ck490 FIND v(dout0_54) AT=250.025n

.meas tran vdout0_55ck490 FIND v(dout0_55) AT=250.025n

.meas tran vdout0_56ck490 FIND v(dout0_56) AT=250.025n

.meas tran vdout0_57ck490 FIND v(dout0_57) AT=250.025n

.meas tran vdout0_58ck490 FIND v(dout0_58) AT=250.025n

.meas tran vdout0_59ck490 FIND v(dout0_59) AT=250.025n

.meas tran vdout0_60ck490 FIND v(dout0_60) AT=250.025n

.meas tran vdout0_61ck490 FIND v(dout0_61) AT=250.025n

.meas tran vdout0_62ck490 FIND v(dout0_62) AT=250.025n

.meas tran vdout0_63ck490 FIND v(dout0_63) AT=250.025n

.meas tran vdout0_0ck500 FIND v(dout0_0) AT=255.025n

.meas tran vdout0_1ck500 FIND v(dout0_1) AT=255.025n

.meas tran vdout0_2ck500 FIND v(dout0_2) AT=255.025n

.meas tran vdout0_3ck500 FIND v(dout0_3) AT=255.025n

.meas tran vdout0_4ck500 FIND v(dout0_4) AT=255.025n

.meas tran vdout0_5ck500 FIND v(dout0_5) AT=255.025n

.meas tran vdout0_6ck500 FIND v(dout0_6) AT=255.025n

.meas tran vdout0_7ck500 FIND v(dout0_7) AT=255.025n

.meas tran vdout0_8ck500 FIND v(dout0_8) AT=255.025n

.meas tran vdout0_9ck500 FIND v(dout0_9) AT=255.025n

.meas tran vdout0_10ck500 FIND v(dout0_10) AT=255.025n

.meas tran vdout0_11ck500 FIND v(dout0_11) AT=255.025n

.meas tran vdout0_12ck500 FIND v(dout0_12) AT=255.025n

.meas tran vdout0_13ck500 FIND v(dout0_13) AT=255.025n

.meas tran vdout0_14ck500 FIND v(dout0_14) AT=255.025n

.meas tran vdout0_15ck500 FIND v(dout0_15) AT=255.025n

.meas tran vdout0_16ck500 FIND v(dout0_16) AT=255.025n

.meas tran vdout0_17ck500 FIND v(dout0_17) AT=255.025n

.meas tran vdout0_18ck500 FIND v(dout0_18) AT=255.025n

.meas tran vdout0_19ck500 FIND v(dout0_19) AT=255.025n

.meas tran vdout0_20ck500 FIND v(dout0_20) AT=255.025n

.meas tran vdout0_21ck500 FIND v(dout0_21) AT=255.025n

.meas tran vdout0_22ck500 FIND v(dout0_22) AT=255.025n

.meas tran vdout0_23ck500 FIND v(dout0_23) AT=255.025n

.meas tran vdout0_24ck500 FIND v(dout0_24) AT=255.025n

.meas tran vdout0_25ck500 FIND v(dout0_25) AT=255.025n

.meas tran vdout0_26ck500 FIND v(dout0_26) AT=255.025n

.meas tran vdout0_27ck500 FIND v(dout0_27) AT=255.025n

.meas tran vdout0_28ck500 FIND v(dout0_28) AT=255.025n

.meas tran vdout0_29ck500 FIND v(dout0_29) AT=255.025n

.meas tran vdout0_30ck500 FIND v(dout0_30) AT=255.025n

.meas tran vdout0_31ck500 FIND v(dout0_31) AT=255.025n

.meas tran vdout0_32ck500 FIND v(dout0_32) AT=255.025n

.meas tran vdout0_33ck500 FIND v(dout0_33) AT=255.025n

.meas tran vdout0_34ck500 FIND v(dout0_34) AT=255.025n

.meas tran vdout0_35ck500 FIND v(dout0_35) AT=255.025n

.meas tran vdout0_36ck500 FIND v(dout0_36) AT=255.025n

.meas tran vdout0_37ck500 FIND v(dout0_37) AT=255.025n

.meas tran vdout0_38ck500 FIND v(dout0_38) AT=255.025n

.meas tran vdout0_39ck500 FIND v(dout0_39) AT=255.025n

.meas tran vdout0_40ck500 FIND v(dout0_40) AT=255.025n

.meas tran vdout0_41ck500 FIND v(dout0_41) AT=255.025n

.meas tran vdout0_42ck500 FIND v(dout0_42) AT=255.025n

.meas tran vdout0_43ck500 FIND v(dout0_43) AT=255.025n

.meas tran vdout0_44ck500 FIND v(dout0_44) AT=255.025n

.meas tran vdout0_45ck500 FIND v(dout0_45) AT=255.025n

.meas tran vdout0_46ck500 FIND v(dout0_46) AT=255.025n

.meas tran vdout0_47ck500 FIND v(dout0_47) AT=255.025n

.meas tran vdout0_48ck500 FIND v(dout0_48) AT=255.025n

.meas tran vdout0_49ck500 FIND v(dout0_49) AT=255.025n

.meas tran vdout0_50ck500 FIND v(dout0_50) AT=255.025n

.meas tran vdout0_51ck500 FIND v(dout0_51) AT=255.025n

.meas tran vdout0_52ck500 FIND v(dout0_52) AT=255.025n

.meas tran vdout0_53ck500 FIND v(dout0_53) AT=255.025n

.meas tran vdout0_54ck500 FIND v(dout0_54) AT=255.025n

.meas tran vdout0_55ck500 FIND v(dout0_55) AT=255.025n

.meas tran vdout0_56ck500 FIND v(dout0_56) AT=255.025n

.meas tran vdout0_57ck500 FIND v(dout0_57) AT=255.025n

.meas tran vdout0_58ck500 FIND v(dout0_58) AT=255.025n

.meas tran vdout0_59ck500 FIND v(dout0_59) AT=255.025n

.meas tran vdout0_60ck500 FIND v(dout0_60) AT=255.025n

.meas tran vdout0_61ck500 FIND v(dout0_61) AT=255.025n

.meas tran vdout0_62ck500 FIND v(dout0_62) AT=255.025n

.meas tran vdout0_63ck500 FIND v(dout0_63) AT=255.025n

.meas tran vdout0_0ck550 FIND v(dout0_0) AT=280.025n

.meas tran vdout0_1ck550 FIND v(dout0_1) AT=280.025n

.meas tran vdout0_2ck550 FIND v(dout0_2) AT=280.025n

.meas tran vdout0_3ck550 FIND v(dout0_3) AT=280.025n

.meas tran vdout0_4ck550 FIND v(dout0_4) AT=280.025n

.meas tran vdout0_5ck550 FIND v(dout0_5) AT=280.025n

.meas tran vdout0_6ck550 FIND v(dout0_6) AT=280.025n

.meas tran vdout0_7ck550 FIND v(dout0_7) AT=280.025n

.meas tran vdout0_8ck550 FIND v(dout0_8) AT=280.025n

.meas tran vdout0_9ck550 FIND v(dout0_9) AT=280.025n

.meas tran vdout0_10ck550 FIND v(dout0_10) AT=280.025n

.meas tran vdout0_11ck550 FIND v(dout0_11) AT=280.025n

.meas tran vdout0_12ck550 FIND v(dout0_12) AT=280.025n

.meas tran vdout0_13ck550 FIND v(dout0_13) AT=280.025n

.meas tran vdout0_14ck550 FIND v(dout0_14) AT=280.025n

.meas tran vdout0_15ck550 FIND v(dout0_15) AT=280.025n

.meas tran vdout0_16ck550 FIND v(dout0_16) AT=280.025n

.meas tran vdout0_17ck550 FIND v(dout0_17) AT=280.025n

.meas tran vdout0_18ck550 FIND v(dout0_18) AT=280.025n

.meas tran vdout0_19ck550 FIND v(dout0_19) AT=280.025n

.meas tran vdout0_20ck550 FIND v(dout0_20) AT=280.025n

.meas tran vdout0_21ck550 FIND v(dout0_21) AT=280.025n

.meas tran vdout0_22ck550 FIND v(dout0_22) AT=280.025n

.meas tran vdout0_23ck550 FIND v(dout0_23) AT=280.025n

.meas tran vdout0_24ck550 FIND v(dout0_24) AT=280.025n

.meas tran vdout0_25ck550 FIND v(dout0_25) AT=280.025n

.meas tran vdout0_26ck550 FIND v(dout0_26) AT=280.025n

.meas tran vdout0_27ck550 FIND v(dout0_27) AT=280.025n

.meas tran vdout0_28ck550 FIND v(dout0_28) AT=280.025n

.meas tran vdout0_29ck550 FIND v(dout0_29) AT=280.025n

.meas tran vdout0_30ck550 FIND v(dout0_30) AT=280.025n

.meas tran vdout0_31ck550 FIND v(dout0_31) AT=280.025n

.meas tran vdout0_32ck550 FIND v(dout0_32) AT=280.025n

.meas tran vdout0_33ck550 FIND v(dout0_33) AT=280.025n

.meas tran vdout0_34ck550 FIND v(dout0_34) AT=280.025n

.meas tran vdout0_35ck550 FIND v(dout0_35) AT=280.025n

.meas tran vdout0_36ck550 FIND v(dout0_36) AT=280.025n

.meas tran vdout0_37ck550 FIND v(dout0_37) AT=280.025n

.meas tran vdout0_38ck550 FIND v(dout0_38) AT=280.025n

.meas tran vdout0_39ck550 FIND v(dout0_39) AT=280.025n

.meas tran vdout0_40ck550 FIND v(dout0_40) AT=280.025n

.meas tran vdout0_41ck550 FIND v(dout0_41) AT=280.025n

.meas tran vdout0_42ck550 FIND v(dout0_42) AT=280.025n

.meas tran vdout0_43ck550 FIND v(dout0_43) AT=280.025n

.meas tran vdout0_44ck550 FIND v(dout0_44) AT=280.025n

.meas tran vdout0_45ck550 FIND v(dout0_45) AT=280.025n

.meas tran vdout0_46ck550 FIND v(dout0_46) AT=280.025n

.meas tran vdout0_47ck550 FIND v(dout0_47) AT=280.025n

.meas tran vdout0_48ck550 FIND v(dout0_48) AT=280.025n

.meas tran vdout0_49ck550 FIND v(dout0_49) AT=280.025n

.meas tran vdout0_50ck550 FIND v(dout0_50) AT=280.025n

.meas tran vdout0_51ck550 FIND v(dout0_51) AT=280.025n

.meas tran vdout0_52ck550 FIND v(dout0_52) AT=280.025n

.meas tran vdout0_53ck550 FIND v(dout0_53) AT=280.025n

.meas tran vdout0_54ck550 FIND v(dout0_54) AT=280.025n

.meas tran vdout0_55ck550 FIND v(dout0_55) AT=280.025n

.meas tran vdout0_56ck550 FIND v(dout0_56) AT=280.025n

.meas tran vdout0_57ck550 FIND v(dout0_57) AT=280.025n

.meas tran vdout0_58ck550 FIND v(dout0_58) AT=280.025n

.meas tran vdout0_59ck550 FIND v(dout0_59) AT=280.025n

.meas tran vdout0_60ck550 FIND v(dout0_60) AT=280.025n

.meas tran vdout0_61ck550 FIND v(dout0_61) AT=280.025n

.meas tran vdout0_62ck550 FIND v(dout0_62) AT=280.025n

.meas tran vdout0_63ck550 FIND v(dout0_63) AT=280.025n

.meas tran vdout0_0ck570 FIND v(dout0_0) AT=290.025n

.meas tran vdout0_1ck570 FIND v(dout0_1) AT=290.025n

.meas tran vdout0_2ck570 FIND v(dout0_2) AT=290.025n

.meas tran vdout0_3ck570 FIND v(dout0_3) AT=290.025n

.meas tran vdout0_4ck570 FIND v(dout0_4) AT=290.025n

.meas tran vdout0_5ck570 FIND v(dout0_5) AT=290.025n

.meas tran vdout0_6ck570 FIND v(dout0_6) AT=290.025n

.meas tran vdout0_7ck570 FIND v(dout0_7) AT=290.025n

.meas tran vdout0_8ck570 FIND v(dout0_8) AT=290.025n

.meas tran vdout0_9ck570 FIND v(dout0_9) AT=290.025n

.meas tran vdout0_10ck570 FIND v(dout0_10) AT=290.025n

.meas tran vdout0_11ck570 FIND v(dout0_11) AT=290.025n

.meas tran vdout0_12ck570 FIND v(dout0_12) AT=290.025n

.meas tran vdout0_13ck570 FIND v(dout0_13) AT=290.025n

.meas tran vdout0_14ck570 FIND v(dout0_14) AT=290.025n

.meas tran vdout0_15ck570 FIND v(dout0_15) AT=290.025n

.meas tran vdout0_16ck570 FIND v(dout0_16) AT=290.025n

.meas tran vdout0_17ck570 FIND v(dout0_17) AT=290.025n

.meas tran vdout0_18ck570 FIND v(dout0_18) AT=290.025n

.meas tran vdout0_19ck570 FIND v(dout0_19) AT=290.025n

.meas tran vdout0_20ck570 FIND v(dout0_20) AT=290.025n

.meas tran vdout0_21ck570 FIND v(dout0_21) AT=290.025n

.meas tran vdout0_22ck570 FIND v(dout0_22) AT=290.025n

.meas tran vdout0_23ck570 FIND v(dout0_23) AT=290.025n

.meas tran vdout0_24ck570 FIND v(dout0_24) AT=290.025n

.meas tran vdout0_25ck570 FIND v(dout0_25) AT=290.025n

.meas tran vdout0_26ck570 FIND v(dout0_26) AT=290.025n

.meas tran vdout0_27ck570 FIND v(dout0_27) AT=290.025n

.meas tran vdout0_28ck570 FIND v(dout0_28) AT=290.025n

.meas tran vdout0_29ck570 FIND v(dout0_29) AT=290.025n

.meas tran vdout0_30ck570 FIND v(dout0_30) AT=290.025n

.meas tran vdout0_31ck570 FIND v(dout0_31) AT=290.025n

.meas tran vdout0_32ck570 FIND v(dout0_32) AT=290.025n

.meas tran vdout0_33ck570 FIND v(dout0_33) AT=290.025n

.meas tran vdout0_34ck570 FIND v(dout0_34) AT=290.025n

.meas tran vdout0_35ck570 FIND v(dout0_35) AT=290.025n

.meas tran vdout0_36ck570 FIND v(dout0_36) AT=290.025n

.meas tran vdout0_37ck570 FIND v(dout0_37) AT=290.025n

.meas tran vdout0_38ck570 FIND v(dout0_38) AT=290.025n

.meas tran vdout0_39ck570 FIND v(dout0_39) AT=290.025n

.meas tran vdout0_40ck570 FIND v(dout0_40) AT=290.025n

.meas tran vdout0_41ck570 FIND v(dout0_41) AT=290.025n

.meas tran vdout0_42ck570 FIND v(dout0_42) AT=290.025n

.meas tran vdout0_43ck570 FIND v(dout0_43) AT=290.025n

.meas tran vdout0_44ck570 FIND v(dout0_44) AT=290.025n

.meas tran vdout0_45ck570 FIND v(dout0_45) AT=290.025n

.meas tran vdout0_46ck570 FIND v(dout0_46) AT=290.025n

.meas tran vdout0_47ck570 FIND v(dout0_47) AT=290.025n

.meas tran vdout0_48ck570 FIND v(dout0_48) AT=290.025n

.meas tran vdout0_49ck570 FIND v(dout0_49) AT=290.025n

.meas tran vdout0_50ck570 FIND v(dout0_50) AT=290.025n

.meas tran vdout0_51ck570 FIND v(dout0_51) AT=290.025n

.meas tran vdout0_52ck570 FIND v(dout0_52) AT=290.025n

.meas tran vdout0_53ck570 FIND v(dout0_53) AT=290.025n

.meas tran vdout0_54ck570 FIND v(dout0_54) AT=290.025n

.meas tran vdout0_55ck570 FIND v(dout0_55) AT=290.025n

.meas tran vdout0_56ck570 FIND v(dout0_56) AT=290.025n

.meas tran vdout0_57ck570 FIND v(dout0_57) AT=290.025n

.meas tran vdout0_58ck570 FIND v(dout0_58) AT=290.025n

.meas tran vdout0_59ck570 FIND v(dout0_59) AT=290.025n

.meas tran vdout0_60ck570 FIND v(dout0_60) AT=290.025n

.meas tran vdout0_61ck570 FIND v(dout0_61) AT=290.025n

.meas tran vdout0_62ck570 FIND v(dout0_62) AT=290.025n

.meas tran vdout0_63ck570 FIND v(dout0_63) AT=290.025n

.meas tran vdout0_0ck590 FIND v(dout0_0) AT=300.025n

.meas tran vdout0_1ck590 FIND v(dout0_1) AT=300.025n

.meas tran vdout0_2ck590 FIND v(dout0_2) AT=300.025n

.meas tran vdout0_3ck590 FIND v(dout0_3) AT=300.025n

.meas tran vdout0_4ck590 FIND v(dout0_4) AT=300.025n

.meas tran vdout0_5ck590 FIND v(dout0_5) AT=300.025n

.meas tran vdout0_6ck590 FIND v(dout0_6) AT=300.025n

.meas tran vdout0_7ck590 FIND v(dout0_7) AT=300.025n

.meas tran vdout0_8ck590 FIND v(dout0_8) AT=300.025n

.meas tran vdout0_9ck590 FIND v(dout0_9) AT=300.025n

.meas tran vdout0_10ck590 FIND v(dout0_10) AT=300.025n

.meas tran vdout0_11ck590 FIND v(dout0_11) AT=300.025n

.meas tran vdout0_12ck590 FIND v(dout0_12) AT=300.025n

.meas tran vdout0_13ck590 FIND v(dout0_13) AT=300.025n

.meas tran vdout0_14ck590 FIND v(dout0_14) AT=300.025n

.meas tran vdout0_15ck590 FIND v(dout0_15) AT=300.025n

.meas tran vdout0_16ck590 FIND v(dout0_16) AT=300.025n

.meas tran vdout0_17ck590 FIND v(dout0_17) AT=300.025n

.meas tran vdout0_18ck590 FIND v(dout0_18) AT=300.025n

.meas tran vdout0_19ck590 FIND v(dout0_19) AT=300.025n

.meas tran vdout0_20ck590 FIND v(dout0_20) AT=300.025n

.meas tran vdout0_21ck590 FIND v(dout0_21) AT=300.025n

.meas tran vdout0_22ck590 FIND v(dout0_22) AT=300.025n

.meas tran vdout0_23ck590 FIND v(dout0_23) AT=300.025n

.meas tran vdout0_24ck590 FIND v(dout0_24) AT=300.025n

.meas tran vdout0_25ck590 FIND v(dout0_25) AT=300.025n

.meas tran vdout0_26ck590 FIND v(dout0_26) AT=300.025n

.meas tran vdout0_27ck590 FIND v(dout0_27) AT=300.025n

.meas tran vdout0_28ck590 FIND v(dout0_28) AT=300.025n

.meas tran vdout0_29ck590 FIND v(dout0_29) AT=300.025n

.meas tran vdout0_30ck590 FIND v(dout0_30) AT=300.025n

.meas tran vdout0_31ck590 FIND v(dout0_31) AT=300.025n

.meas tran vdout0_32ck590 FIND v(dout0_32) AT=300.025n

.meas tran vdout0_33ck590 FIND v(dout0_33) AT=300.025n

.meas tran vdout0_34ck590 FIND v(dout0_34) AT=300.025n

.meas tran vdout0_35ck590 FIND v(dout0_35) AT=300.025n

.meas tran vdout0_36ck590 FIND v(dout0_36) AT=300.025n

.meas tran vdout0_37ck590 FIND v(dout0_37) AT=300.025n

.meas tran vdout0_38ck590 FIND v(dout0_38) AT=300.025n

.meas tran vdout0_39ck590 FIND v(dout0_39) AT=300.025n

.meas tran vdout0_40ck590 FIND v(dout0_40) AT=300.025n

.meas tran vdout0_41ck590 FIND v(dout0_41) AT=300.025n

.meas tran vdout0_42ck590 FIND v(dout0_42) AT=300.025n

.meas tran vdout0_43ck590 FIND v(dout0_43) AT=300.025n

.meas tran vdout0_44ck590 FIND v(dout0_44) AT=300.025n

.meas tran vdout0_45ck590 FIND v(dout0_45) AT=300.025n

.meas tran vdout0_46ck590 FIND v(dout0_46) AT=300.025n

.meas tran vdout0_47ck590 FIND v(dout0_47) AT=300.025n

.meas tran vdout0_48ck590 FIND v(dout0_48) AT=300.025n

.meas tran vdout0_49ck590 FIND v(dout0_49) AT=300.025n

.meas tran vdout0_50ck590 FIND v(dout0_50) AT=300.025n

.meas tran vdout0_51ck590 FIND v(dout0_51) AT=300.025n

.meas tran vdout0_52ck590 FIND v(dout0_52) AT=300.025n

.meas tran vdout0_53ck590 FIND v(dout0_53) AT=300.025n

.meas tran vdout0_54ck590 FIND v(dout0_54) AT=300.025n

.meas tran vdout0_55ck590 FIND v(dout0_55) AT=300.025n

.meas tran vdout0_56ck590 FIND v(dout0_56) AT=300.025n

.meas tran vdout0_57ck590 FIND v(dout0_57) AT=300.025n

.meas tran vdout0_58ck590 FIND v(dout0_58) AT=300.025n

.meas tran vdout0_59ck590 FIND v(dout0_59) AT=300.025n

.meas tran vdout0_60ck590 FIND v(dout0_60) AT=300.025n

.meas tran vdout0_61ck590 FIND v(dout0_61) AT=300.025n

.meas tran vdout0_62ck590 FIND v(dout0_62) AT=300.025n

.meas tran vdout0_63ck590 FIND v(dout0_63) AT=300.025n

.meas tran vdout0_0ck640 FIND v(dout0_0) AT=325.025n

.meas tran vdout0_1ck640 FIND v(dout0_1) AT=325.025n

.meas tran vdout0_2ck640 FIND v(dout0_2) AT=325.025n

.meas tran vdout0_3ck640 FIND v(dout0_3) AT=325.025n

.meas tran vdout0_4ck640 FIND v(dout0_4) AT=325.025n

.meas tran vdout0_5ck640 FIND v(dout0_5) AT=325.025n

.meas tran vdout0_6ck640 FIND v(dout0_6) AT=325.025n

.meas tran vdout0_7ck640 FIND v(dout0_7) AT=325.025n

.meas tran vdout0_8ck640 FIND v(dout0_8) AT=325.025n

.meas tran vdout0_9ck640 FIND v(dout0_9) AT=325.025n

.meas tran vdout0_10ck640 FIND v(dout0_10) AT=325.025n

.meas tran vdout0_11ck640 FIND v(dout0_11) AT=325.025n

.meas tran vdout0_12ck640 FIND v(dout0_12) AT=325.025n

.meas tran vdout0_13ck640 FIND v(dout0_13) AT=325.025n

.meas tran vdout0_14ck640 FIND v(dout0_14) AT=325.025n

.meas tran vdout0_15ck640 FIND v(dout0_15) AT=325.025n

.meas tran vdout0_16ck640 FIND v(dout0_16) AT=325.025n

.meas tran vdout0_17ck640 FIND v(dout0_17) AT=325.025n

.meas tran vdout0_18ck640 FIND v(dout0_18) AT=325.025n

.meas tran vdout0_19ck640 FIND v(dout0_19) AT=325.025n

.meas tran vdout0_20ck640 FIND v(dout0_20) AT=325.025n

.meas tran vdout0_21ck640 FIND v(dout0_21) AT=325.025n

.meas tran vdout0_22ck640 FIND v(dout0_22) AT=325.025n

.meas tran vdout0_23ck640 FIND v(dout0_23) AT=325.025n

.meas tran vdout0_24ck640 FIND v(dout0_24) AT=325.025n

.meas tran vdout0_25ck640 FIND v(dout0_25) AT=325.025n

.meas tran vdout0_26ck640 FIND v(dout0_26) AT=325.025n

.meas tran vdout0_27ck640 FIND v(dout0_27) AT=325.025n

.meas tran vdout0_28ck640 FIND v(dout0_28) AT=325.025n

.meas tran vdout0_29ck640 FIND v(dout0_29) AT=325.025n

.meas tran vdout0_30ck640 FIND v(dout0_30) AT=325.025n

.meas tran vdout0_31ck640 FIND v(dout0_31) AT=325.025n

.meas tran vdout0_32ck640 FIND v(dout0_32) AT=325.025n

.meas tran vdout0_33ck640 FIND v(dout0_33) AT=325.025n

.meas tran vdout0_34ck640 FIND v(dout0_34) AT=325.025n

.meas tran vdout0_35ck640 FIND v(dout0_35) AT=325.025n

.meas tran vdout0_36ck640 FIND v(dout0_36) AT=325.025n

.meas tran vdout0_37ck640 FIND v(dout0_37) AT=325.025n

.meas tran vdout0_38ck640 FIND v(dout0_38) AT=325.025n

.meas tran vdout0_39ck640 FIND v(dout0_39) AT=325.025n

.meas tran vdout0_40ck640 FIND v(dout0_40) AT=325.025n

.meas tran vdout0_41ck640 FIND v(dout0_41) AT=325.025n

.meas tran vdout0_42ck640 FIND v(dout0_42) AT=325.025n

.meas tran vdout0_43ck640 FIND v(dout0_43) AT=325.025n

.meas tran vdout0_44ck640 FIND v(dout0_44) AT=325.025n

.meas tran vdout0_45ck640 FIND v(dout0_45) AT=325.025n

.meas tran vdout0_46ck640 FIND v(dout0_46) AT=325.025n

.meas tran vdout0_47ck640 FIND v(dout0_47) AT=325.025n

.meas tran vdout0_48ck640 FIND v(dout0_48) AT=325.025n

.meas tran vdout0_49ck640 FIND v(dout0_49) AT=325.025n

.meas tran vdout0_50ck640 FIND v(dout0_50) AT=325.025n

.meas tran vdout0_51ck640 FIND v(dout0_51) AT=325.025n

.meas tran vdout0_52ck640 FIND v(dout0_52) AT=325.025n

.meas tran vdout0_53ck640 FIND v(dout0_53) AT=325.025n

.meas tran vdout0_54ck640 FIND v(dout0_54) AT=325.025n

.meas tran vdout0_55ck640 FIND v(dout0_55) AT=325.025n

.meas tran vdout0_56ck640 FIND v(dout0_56) AT=325.025n

.meas tran vdout0_57ck640 FIND v(dout0_57) AT=325.025n

.meas tran vdout0_58ck640 FIND v(dout0_58) AT=325.025n

.meas tran vdout0_59ck640 FIND v(dout0_59) AT=325.025n

.meas tran vdout0_60ck640 FIND v(dout0_60) AT=325.025n

.meas tran vdout0_61ck640 FIND v(dout0_61) AT=325.025n

.meas tran vdout0_62ck640 FIND v(dout0_62) AT=325.025n

.meas tran vdout0_63ck640 FIND v(dout0_63) AT=325.025n

.meas tran vdout0_0ck710 FIND v(dout0_0) AT=360.025n

.meas tran vdout0_1ck710 FIND v(dout0_1) AT=360.025n

.meas tran vdout0_2ck710 FIND v(dout0_2) AT=360.025n

.meas tran vdout0_3ck710 FIND v(dout0_3) AT=360.025n

.meas tran vdout0_4ck710 FIND v(dout0_4) AT=360.025n

.meas tran vdout0_5ck710 FIND v(dout0_5) AT=360.025n

.meas tran vdout0_6ck710 FIND v(dout0_6) AT=360.025n

.meas tran vdout0_7ck710 FIND v(dout0_7) AT=360.025n

.meas tran vdout0_8ck710 FIND v(dout0_8) AT=360.025n

.meas tran vdout0_9ck710 FIND v(dout0_9) AT=360.025n

.meas tran vdout0_10ck710 FIND v(dout0_10) AT=360.025n

.meas tran vdout0_11ck710 FIND v(dout0_11) AT=360.025n

.meas tran vdout0_12ck710 FIND v(dout0_12) AT=360.025n

.meas tran vdout0_13ck710 FIND v(dout0_13) AT=360.025n

.meas tran vdout0_14ck710 FIND v(dout0_14) AT=360.025n

.meas tran vdout0_15ck710 FIND v(dout0_15) AT=360.025n

.meas tran vdout0_16ck710 FIND v(dout0_16) AT=360.025n

.meas tran vdout0_17ck710 FIND v(dout0_17) AT=360.025n

.meas tran vdout0_18ck710 FIND v(dout0_18) AT=360.025n

.meas tran vdout0_19ck710 FIND v(dout0_19) AT=360.025n

.meas tran vdout0_20ck710 FIND v(dout0_20) AT=360.025n

.meas tran vdout0_21ck710 FIND v(dout0_21) AT=360.025n

.meas tran vdout0_22ck710 FIND v(dout0_22) AT=360.025n

.meas tran vdout0_23ck710 FIND v(dout0_23) AT=360.025n

.meas tran vdout0_24ck710 FIND v(dout0_24) AT=360.025n

.meas tran vdout0_25ck710 FIND v(dout0_25) AT=360.025n

.meas tran vdout0_26ck710 FIND v(dout0_26) AT=360.025n

.meas tran vdout0_27ck710 FIND v(dout0_27) AT=360.025n

.meas tran vdout0_28ck710 FIND v(dout0_28) AT=360.025n

.meas tran vdout0_29ck710 FIND v(dout0_29) AT=360.025n

.meas tran vdout0_30ck710 FIND v(dout0_30) AT=360.025n

.meas tran vdout0_31ck710 FIND v(dout0_31) AT=360.025n

.meas tran vdout0_32ck710 FIND v(dout0_32) AT=360.025n

.meas tran vdout0_33ck710 FIND v(dout0_33) AT=360.025n

.meas tran vdout0_34ck710 FIND v(dout0_34) AT=360.025n

.meas tran vdout0_35ck710 FIND v(dout0_35) AT=360.025n

.meas tran vdout0_36ck710 FIND v(dout0_36) AT=360.025n

.meas tran vdout0_37ck710 FIND v(dout0_37) AT=360.025n

.meas tran vdout0_38ck710 FIND v(dout0_38) AT=360.025n

.meas tran vdout0_39ck710 FIND v(dout0_39) AT=360.025n

.meas tran vdout0_40ck710 FIND v(dout0_40) AT=360.025n

.meas tran vdout0_41ck710 FIND v(dout0_41) AT=360.025n

.meas tran vdout0_42ck710 FIND v(dout0_42) AT=360.025n

.meas tran vdout0_43ck710 FIND v(dout0_43) AT=360.025n

.meas tran vdout0_44ck710 FIND v(dout0_44) AT=360.025n

.meas tran vdout0_45ck710 FIND v(dout0_45) AT=360.025n

.meas tran vdout0_46ck710 FIND v(dout0_46) AT=360.025n

.meas tran vdout0_47ck710 FIND v(dout0_47) AT=360.025n

.meas tran vdout0_48ck710 FIND v(dout0_48) AT=360.025n

.meas tran vdout0_49ck710 FIND v(dout0_49) AT=360.025n

.meas tran vdout0_50ck710 FIND v(dout0_50) AT=360.025n

.meas tran vdout0_51ck710 FIND v(dout0_51) AT=360.025n

.meas tran vdout0_52ck710 FIND v(dout0_52) AT=360.025n

.meas tran vdout0_53ck710 FIND v(dout0_53) AT=360.025n

.meas tran vdout0_54ck710 FIND v(dout0_54) AT=360.025n

.meas tran vdout0_55ck710 FIND v(dout0_55) AT=360.025n

.meas tran vdout0_56ck710 FIND v(dout0_56) AT=360.025n

.meas tran vdout0_57ck710 FIND v(dout0_57) AT=360.025n

.meas tran vdout0_58ck710 FIND v(dout0_58) AT=360.025n

.meas tran vdout0_59ck710 FIND v(dout0_59) AT=360.025n

.meas tran vdout0_60ck710 FIND v(dout0_60) AT=360.025n

.meas tran vdout0_61ck710 FIND v(dout0_61) AT=360.025n

.meas tran vdout0_62ck710 FIND v(dout0_62) AT=360.025n

.meas tran vdout0_63ck710 FIND v(dout0_63) AT=360.025n

.meas tran vdout0_0ck730 FIND v(dout0_0) AT=370.025n

.meas tran vdout0_1ck730 FIND v(dout0_1) AT=370.025n

.meas tran vdout0_2ck730 FIND v(dout0_2) AT=370.025n

.meas tran vdout0_3ck730 FIND v(dout0_3) AT=370.025n

.meas tran vdout0_4ck730 FIND v(dout0_4) AT=370.025n

.meas tran vdout0_5ck730 FIND v(dout0_5) AT=370.025n

.meas tran vdout0_6ck730 FIND v(dout0_6) AT=370.025n

.meas tran vdout0_7ck730 FIND v(dout0_7) AT=370.025n

.meas tran vdout0_8ck730 FIND v(dout0_8) AT=370.025n

.meas tran vdout0_9ck730 FIND v(dout0_9) AT=370.025n

.meas tran vdout0_10ck730 FIND v(dout0_10) AT=370.025n

.meas tran vdout0_11ck730 FIND v(dout0_11) AT=370.025n

.meas tran vdout0_12ck730 FIND v(dout0_12) AT=370.025n

.meas tran vdout0_13ck730 FIND v(dout0_13) AT=370.025n

.meas tran vdout0_14ck730 FIND v(dout0_14) AT=370.025n

.meas tran vdout0_15ck730 FIND v(dout0_15) AT=370.025n

.meas tran vdout0_16ck730 FIND v(dout0_16) AT=370.025n

.meas tran vdout0_17ck730 FIND v(dout0_17) AT=370.025n

.meas tran vdout0_18ck730 FIND v(dout0_18) AT=370.025n

.meas tran vdout0_19ck730 FIND v(dout0_19) AT=370.025n

.meas tran vdout0_20ck730 FIND v(dout0_20) AT=370.025n

.meas tran vdout0_21ck730 FIND v(dout0_21) AT=370.025n

.meas tran vdout0_22ck730 FIND v(dout0_22) AT=370.025n

.meas tran vdout0_23ck730 FIND v(dout0_23) AT=370.025n

.meas tran vdout0_24ck730 FIND v(dout0_24) AT=370.025n

.meas tran vdout0_25ck730 FIND v(dout0_25) AT=370.025n

.meas tran vdout0_26ck730 FIND v(dout0_26) AT=370.025n

.meas tran vdout0_27ck730 FIND v(dout0_27) AT=370.025n

.meas tran vdout0_28ck730 FIND v(dout0_28) AT=370.025n

.meas tran vdout0_29ck730 FIND v(dout0_29) AT=370.025n

.meas tran vdout0_30ck730 FIND v(dout0_30) AT=370.025n

.meas tran vdout0_31ck730 FIND v(dout0_31) AT=370.025n

.meas tran vdout0_32ck730 FIND v(dout0_32) AT=370.025n

.meas tran vdout0_33ck730 FIND v(dout0_33) AT=370.025n

.meas tran vdout0_34ck730 FIND v(dout0_34) AT=370.025n

.meas tran vdout0_35ck730 FIND v(dout0_35) AT=370.025n

.meas tran vdout0_36ck730 FIND v(dout0_36) AT=370.025n

.meas tran vdout0_37ck730 FIND v(dout0_37) AT=370.025n

.meas tran vdout0_38ck730 FIND v(dout0_38) AT=370.025n

.meas tran vdout0_39ck730 FIND v(dout0_39) AT=370.025n

.meas tran vdout0_40ck730 FIND v(dout0_40) AT=370.025n

.meas tran vdout0_41ck730 FIND v(dout0_41) AT=370.025n

.meas tran vdout0_42ck730 FIND v(dout0_42) AT=370.025n

.meas tran vdout0_43ck730 FIND v(dout0_43) AT=370.025n

.meas tran vdout0_44ck730 FIND v(dout0_44) AT=370.025n

.meas tran vdout0_45ck730 FIND v(dout0_45) AT=370.025n

.meas tran vdout0_46ck730 FIND v(dout0_46) AT=370.025n

.meas tran vdout0_47ck730 FIND v(dout0_47) AT=370.025n

.meas tran vdout0_48ck730 FIND v(dout0_48) AT=370.025n

.meas tran vdout0_49ck730 FIND v(dout0_49) AT=370.025n

.meas tran vdout0_50ck730 FIND v(dout0_50) AT=370.025n

.meas tran vdout0_51ck730 FIND v(dout0_51) AT=370.025n

.meas tran vdout0_52ck730 FIND v(dout0_52) AT=370.025n

.meas tran vdout0_53ck730 FIND v(dout0_53) AT=370.025n

.meas tran vdout0_54ck730 FIND v(dout0_54) AT=370.025n

.meas tran vdout0_55ck730 FIND v(dout0_55) AT=370.025n

.meas tran vdout0_56ck730 FIND v(dout0_56) AT=370.025n

.meas tran vdout0_57ck730 FIND v(dout0_57) AT=370.025n

.meas tran vdout0_58ck730 FIND v(dout0_58) AT=370.025n

.meas tran vdout0_59ck730 FIND v(dout0_59) AT=370.025n

.meas tran vdout0_60ck730 FIND v(dout0_60) AT=370.025n

.meas tran vdout0_61ck730 FIND v(dout0_61) AT=370.025n

.meas tran vdout0_62ck730 FIND v(dout0_62) AT=370.025n

.meas tran vdout0_63ck730 FIND v(dout0_63) AT=370.025n

.meas tran vdout0_0ck740 FIND v(dout0_0) AT=375.025n

.meas tran vdout0_1ck740 FIND v(dout0_1) AT=375.025n

.meas tran vdout0_2ck740 FIND v(dout0_2) AT=375.025n

.meas tran vdout0_3ck740 FIND v(dout0_3) AT=375.025n

.meas tran vdout0_4ck740 FIND v(dout0_4) AT=375.025n

.meas tran vdout0_5ck740 FIND v(dout0_5) AT=375.025n

.meas tran vdout0_6ck740 FIND v(dout0_6) AT=375.025n

.meas tran vdout0_7ck740 FIND v(dout0_7) AT=375.025n

.meas tran vdout0_8ck740 FIND v(dout0_8) AT=375.025n

.meas tran vdout0_9ck740 FIND v(dout0_9) AT=375.025n

.meas tran vdout0_10ck740 FIND v(dout0_10) AT=375.025n

.meas tran vdout0_11ck740 FIND v(dout0_11) AT=375.025n

.meas tran vdout0_12ck740 FIND v(dout0_12) AT=375.025n

.meas tran vdout0_13ck740 FIND v(dout0_13) AT=375.025n

.meas tran vdout0_14ck740 FIND v(dout0_14) AT=375.025n

.meas tran vdout0_15ck740 FIND v(dout0_15) AT=375.025n

.meas tran vdout0_16ck740 FIND v(dout0_16) AT=375.025n

.meas tran vdout0_17ck740 FIND v(dout0_17) AT=375.025n

.meas tran vdout0_18ck740 FIND v(dout0_18) AT=375.025n

.meas tran vdout0_19ck740 FIND v(dout0_19) AT=375.025n

.meas tran vdout0_20ck740 FIND v(dout0_20) AT=375.025n

.meas tran vdout0_21ck740 FIND v(dout0_21) AT=375.025n

.meas tran vdout0_22ck740 FIND v(dout0_22) AT=375.025n

.meas tran vdout0_23ck740 FIND v(dout0_23) AT=375.025n

.meas tran vdout0_24ck740 FIND v(dout0_24) AT=375.025n

.meas tran vdout0_25ck740 FIND v(dout0_25) AT=375.025n

.meas tran vdout0_26ck740 FIND v(dout0_26) AT=375.025n

.meas tran vdout0_27ck740 FIND v(dout0_27) AT=375.025n

.meas tran vdout0_28ck740 FIND v(dout0_28) AT=375.025n

.meas tran vdout0_29ck740 FIND v(dout0_29) AT=375.025n

.meas tran vdout0_30ck740 FIND v(dout0_30) AT=375.025n

.meas tran vdout0_31ck740 FIND v(dout0_31) AT=375.025n

.meas tran vdout0_32ck740 FIND v(dout0_32) AT=375.025n

.meas tran vdout0_33ck740 FIND v(dout0_33) AT=375.025n

.meas tran vdout0_34ck740 FIND v(dout0_34) AT=375.025n

.meas tran vdout0_35ck740 FIND v(dout0_35) AT=375.025n

.meas tran vdout0_36ck740 FIND v(dout0_36) AT=375.025n

.meas tran vdout0_37ck740 FIND v(dout0_37) AT=375.025n

.meas tran vdout0_38ck740 FIND v(dout0_38) AT=375.025n

.meas tran vdout0_39ck740 FIND v(dout0_39) AT=375.025n

.meas tran vdout0_40ck740 FIND v(dout0_40) AT=375.025n

.meas tran vdout0_41ck740 FIND v(dout0_41) AT=375.025n

.meas tran vdout0_42ck740 FIND v(dout0_42) AT=375.025n

.meas tran vdout0_43ck740 FIND v(dout0_43) AT=375.025n

.meas tran vdout0_44ck740 FIND v(dout0_44) AT=375.025n

.meas tran vdout0_45ck740 FIND v(dout0_45) AT=375.025n

.meas tran vdout0_46ck740 FIND v(dout0_46) AT=375.025n

.meas tran vdout0_47ck740 FIND v(dout0_47) AT=375.025n

.meas tran vdout0_48ck740 FIND v(dout0_48) AT=375.025n

.meas tran vdout0_49ck740 FIND v(dout0_49) AT=375.025n

.meas tran vdout0_50ck740 FIND v(dout0_50) AT=375.025n

.meas tran vdout0_51ck740 FIND v(dout0_51) AT=375.025n

.meas tran vdout0_52ck740 FIND v(dout0_52) AT=375.025n

.meas tran vdout0_53ck740 FIND v(dout0_53) AT=375.025n

.meas tran vdout0_54ck740 FIND v(dout0_54) AT=375.025n

.meas tran vdout0_55ck740 FIND v(dout0_55) AT=375.025n

.meas tran vdout0_56ck740 FIND v(dout0_56) AT=375.025n

.meas tran vdout0_57ck740 FIND v(dout0_57) AT=375.025n

.meas tran vdout0_58ck740 FIND v(dout0_58) AT=375.025n

.meas tran vdout0_59ck740 FIND v(dout0_59) AT=375.025n

.meas tran vdout0_60ck740 FIND v(dout0_60) AT=375.025n

.meas tran vdout0_61ck740 FIND v(dout0_61) AT=375.025n

.meas tran vdout0_62ck740 FIND v(dout0_62) AT=375.025n

.meas tran vdout0_63ck740 FIND v(dout0_63) AT=375.025n

.meas tran vdout0_0ck760 FIND v(dout0_0) AT=385.025n

.meas tran vdout0_1ck760 FIND v(dout0_1) AT=385.025n

.meas tran vdout0_2ck760 FIND v(dout0_2) AT=385.025n

.meas tran vdout0_3ck760 FIND v(dout0_3) AT=385.025n

.meas tran vdout0_4ck760 FIND v(dout0_4) AT=385.025n

.meas tran vdout0_5ck760 FIND v(dout0_5) AT=385.025n

.meas tran vdout0_6ck760 FIND v(dout0_6) AT=385.025n

.meas tran vdout0_7ck760 FIND v(dout0_7) AT=385.025n

.meas tran vdout0_8ck760 FIND v(dout0_8) AT=385.025n

.meas tran vdout0_9ck760 FIND v(dout0_9) AT=385.025n

.meas tran vdout0_10ck760 FIND v(dout0_10) AT=385.025n

.meas tran vdout0_11ck760 FIND v(dout0_11) AT=385.025n

.meas tran vdout0_12ck760 FIND v(dout0_12) AT=385.025n

.meas tran vdout0_13ck760 FIND v(dout0_13) AT=385.025n

.meas tran vdout0_14ck760 FIND v(dout0_14) AT=385.025n

.meas tran vdout0_15ck760 FIND v(dout0_15) AT=385.025n

.meas tran vdout0_16ck760 FIND v(dout0_16) AT=385.025n

.meas tran vdout0_17ck760 FIND v(dout0_17) AT=385.025n

.meas tran vdout0_18ck760 FIND v(dout0_18) AT=385.025n

.meas tran vdout0_19ck760 FIND v(dout0_19) AT=385.025n

.meas tran vdout0_20ck760 FIND v(dout0_20) AT=385.025n

.meas tran vdout0_21ck760 FIND v(dout0_21) AT=385.025n

.meas tran vdout0_22ck760 FIND v(dout0_22) AT=385.025n

.meas tran vdout0_23ck760 FIND v(dout0_23) AT=385.025n

.meas tran vdout0_24ck760 FIND v(dout0_24) AT=385.025n

.meas tran vdout0_25ck760 FIND v(dout0_25) AT=385.025n

.meas tran vdout0_26ck760 FIND v(dout0_26) AT=385.025n

.meas tran vdout0_27ck760 FIND v(dout0_27) AT=385.025n

.meas tran vdout0_28ck760 FIND v(dout0_28) AT=385.025n

.meas tran vdout0_29ck760 FIND v(dout0_29) AT=385.025n

.meas tran vdout0_30ck760 FIND v(dout0_30) AT=385.025n

.meas tran vdout0_31ck760 FIND v(dout0_31) AT=385.025n

.meas tran vdout0_32ck760 FIND v(dout0_32) AT=385.025n

.meas tran vdout0_33ck760 FIND v(dout0_33) AT=385.025n

.meas tran vdout0_34ck760 FIND v(dout0_34) AT=385.025n

.meas tran vdout0_35ck760 FIND v(dout0_35) AT=385.025n

.meas tran vdout0_36ck760 FIND v(dout0_36) AT=385.025n

.meas tran vdout0_37ck760 FIND v(dout0_37) AT=385.025n

.meas tran vdout0_38ck760 FIND v(dout0_38) AT=385.025n

.meas tran vdout0_39ck760 FIND v(dout0_39) AT=385.025n

.meas tran vdout0_40ck760 FIND v(dout0_40) AT=385.025n

.meas tran vdout0_41ck760 FIND v(dout0_41) AT=385.025n

.meas tran vdout0_42ck760 FIND v(dout0_42) AT=385.025n

.meas tran vdout0_43ck760 FIND v(dout0_43) AT=385.025n

.meas tran vdout0_44ck760 FIND v(dout0_44) AT=385.025n

.meas tran vdout0_45ck760 FIND v(dout0_45) AT=385.025n

.meas tran vdout0_46ck760 FIND v(dout0_46) AT=385.025n

.meas tran vdout0_47ck760 FIND v(dout0_47) AT=385.025n

.meas tran vdout0_48ck760 FIND v(dout0_48) AT=385.025n

.meas tran vdout0_49ck760 FIND v(dout0_49) AT=385.025n

.meas tran vdout0_50ck760 FIND v(dout0_50) AT=385.025n

.meas tran vdout0_51ck760 FIND v(dout0_51) AT=385.025n

.meas tran vdout0_52ck760 FIND v(dout0_52) AT=385.025n

.meas tran vdout0_53ck760 FIND v(dout0_53) AT=385.025n

.meas tran vdout0_54ck760 FIND v(dout0_54) AT=385.025n

.meas tran vdout0_55ck760 FIND v(dout0_55) AT=385.025n

.meas tran vdout0_56ck760 FIND v(dout0_56) AT=385.025n

.meas tran vdout0_57ck760 FIND v(dout0_57) AT=385.025n

.meas tran vdout0_58ck760 FIND v(dout0_58) AT=385.025n

.meas tran vdout0_59ck760 FIND v(dout0_59) AT=385.025n

.meas tran vdout0_60ck760 FIND v(dout0_60) AT=385.025n

.meas tran vdout0_61ck760 FIND v(dout0_61) AT=385.025n

.meas tran vdout0_62ck760 FIND v(dout0_62) AT=385.025n

.meas tran vdout0_63ck760 FIND v(dout0_63) AT=385.025n

.meas tran vdout0_0ck780 FIND v(dout0_0) AT=395.025n

.meas tran vdout0_1ck780 FIND v(dout0_1) AT=395.025n

.meas tran vdout0_2ck780 FIND v(dout0_2) AT=395.025n

.meas tran vdout0_3ck780 FIND v(dout0_3) AT=395.025n

.meas tran vdout0_4ck780 FIND v(dout0_4) AT=395.025n

.meas tran vdout0_5ck780 FIND v(dout0_5) AT=395.025n

.meas tran vdout0_6ck780 FIND v(dout0_6) AT=395.025n

.meas tran vdout0_7ck780 FIND v(dout0_7) AT=395.025n

.meas tran vdout0_8ck780 FIND v(dout0_8) AT=395.025n

.meas tran vdout0_9ck780 FIND v(dout0_9) AT=395.025n

.meas tran vdout0_10ck780 FIND v(dout0_10) AT=395.025n

.meas tran vdout0_11ck780 FIND v(dout0_11) AT=395.025n

.meas tran vdout0_12ck780 FIND v(dout0_12) AT=395.025n

.meas tran vdout0_13ck780 FIND v(dout0_13) AT=395.025n

.meas tran vdout0_14ck780 FIND v(dout0_14) AT=395.025n

.meas tran vdout0_15ck780 FIND v(dout0_15) AT=395.025n

.meas tran vdout0_16ck780 FIND v(dout0_16) AT=395.025n

.meas tran vdout0_17ck780 FIND v(dout0_17) AT=395.025n

.meas tran vdout0_18ck780 FIND v(dout0_18) AT=395.025n

.meas tran vdout0_19ck780 FIND v(dout0_19) AT=395.025n

.meas tran vdout0_20ck780 FIND v(dout0_20) AT=395.025n

.meas tran vdout0_21ck780 FIND v(dout0_21) AT=395.025n

.meas tran vdout0_22ck780 FIND v(dout0_22) AT=395.025n

.meas tran vdout0_23ck780 FIND v(dout0_23) AT=395.025n

.meas tran vdout0_24ck780 FIND v(dout0_24) AT=395.025n

.meas tran vdout0_25ck780 FIND v(dout0_25) AT=395.025n

.meas tran vdout0_26ck780 FIND v(dout0_26) AT=395.025n

.meas tran vdout0_27ck780 FIND v(dout0_27) AT=395.025n

.meas tran vdout0_28ck780 FIND v(dout0_28) AT=395.025n

.meas tran vdout0_29ck780 FIND v(dout0_29) AT=395.025n

.meas tran vdout0_30ck780 FIND v(dout0_30) AT=395.025n

.meas tran vdout0_31ck780 FIND v(dout0_31) AT=395.025n

.meas tran vdout0_32ck780 FIND v(dout0_32) AT=395.025n

.meas tran vdout0_33ck780 FIND v(dout0_33) AT=395.025n

.meas tran vdout0_34ck780 FIND v(dout0_34) AT=395.025n

.meas tran vdout0_35ck780 FIND v(dout0_35) AT=395.025n

.meas tran vdout0_36ck780 FIND v(dout0_36) AT=395.025n

.meas tran vdout0_37ck780 FIND v(dout0_37) AT=395.025n

.meas tran vdout0_38ck780 FIND v(dout0_38) AT=395.025n

.meas tran vdout0_39ck780 FIND v(dout0_39) AT=395.025n

.meas tran vdout0_40ck780 FIND v(dout0_40) AT=395.025n

.meas tran vdout0_41ck780 FIND v(dout0_41) AT=395.025n

.meas tran vdout0_42ck780 FIND v(dout0_42) AT=395.025n

.meas tran vdout0_43ck780 FIND v(dout0_43) AT=395.025n

.meas tran vdout0_44ck780 FIND v(dout0_44) AT=395.025n

.meas tran vdout0_45ck780 FIND v(dout0_45) AT=395.025n

.meas tran vdout0_46ck780 FIND v(dout0_46) AT=395.025n

.meas tran vdout0_47ck780 FIND v(dout0_47) AT=395.025n

.meas tran vdout0_48ck780 FIND v(dout0_48) AT=395.025n

.meas tran vdout0_49ck780 FIND v(dout0_49) AT=395.025n

.meas tran vdout0_50ck780 FIND v(dout0_50) AT=395.025n

.meas tran vdout0_51ck780 FIND v(dout0_51) AT=395.025n

.meas tran vdout0_52ck780 FIND v(dout0_52) AT=395.025n

.meas tran vdout0_53ck780 FIND v(dout0_53) AT=395.025n

.meas tran vdout0_54ck780 FIND v(dout0_54) AT=395.025n

.meas tran vdout0_55ck780 FIND v(dout0_55) AT=395.025n

.meas tran vdout0_56ck780 FIND v(dout0_56) AT=395.025n

.meas tran vdout0_57ck780 FIND v(dout0_57) AT=395.025n

.meas tran vdout0_58ck780 FIND v(dout0_58) AT=395.025n

.meas tran vdout0_59ck780 FIND v(dout0_59) AT=395.025n

.meas tran vdout0_60ck780 FIND v(dout0_60) AT=395.025n

.meas tran vdout0_61ck780 FIND v(dout0_61) AT=395.025n

.meas tran vdout0_62ck780 FIND v(dout0_62) AT=395.025n

.meas tran vdout0_63ck780 FIND v(dout0_63) AT=395.025n

.meas tran vdout0_0ck810 FIND v(dout0_0) AT=410.025n

.meas tran vdout0_1ck810 FIND v(dout0_1) AT=410.025n

.meas tran vdout0_2ck810 FIND v(dout0_2) AT=410.025n

.meas tran vdout0_3ck810 FIND v(dout0_3) AT=410.025n

.meas tran vdout0_4ck810 FIND v(dout0_4) AT=410.025n

.meas tran vdout0_5ck810 FIND v(dout0_5) AT=410.025n

.meas tran vdout0_6ck810 FIND v(dout0_6) AT=410.025n

.meas tran vdout0_7ck810 FIND v(dout0_7) AT=410.025n

.meas tran vdout0_8ck810 FIND v(dout0_8) AT=410.025n

.meas tran vdout0_9ck810 FIND v(dout0_9) AT=410.025n

.meas tran vdout0_10ck810 FIND v(dout0_10) AT=410.025n

.meas tran vdout0_11ck810 FIND v(dout0_11) AT=410.025n

.meas tran vdout0_12ck810 FIND v(dout0_12) AT=410.025n

.meas tran vdout0_13ck810 FIND v(dout0_13) AT=410.025n

.meas tran vdout0_14ck810 FIND v(dout0_14) AT=410.025n

.meas tran vdout0_15ck810 FIND v(dout0_15) AT=410.025n

.meas tran vdout0_16ck810 FIND v(dout0_16) AT=410.025n

.meas tran vdout0_17ck810 FIND v(dout0_17) AT=410.025n

.meas tran vdout0_18ck810 FIND v(dout0_18) AT=410.025n

.meas tran vdout0_19ck810 FIND v(dout0_19) AT=410.025n

.meas tran vdout0_20ck810 FIND v(dout0_20) AT=410.025n

.meas tran vdout0_21ck810 FIND v(dout0_21) AT=410.025n

.meas tran vdout0_22ck810 FIND v(dout0_22) AT=410.025n

.meas tran vdout0_23ck810 FIND v(dout0_23) AT=410.025n

.meas tran vdout0_24ck810 FIND v(dout0_24) AT=410.025n

.meas tran vdout0_25ck810 FIND v(dout0_25) AT=410.025n

.meas tran vdout0_26ck810 FIND v(dout0_26) AT=410.025n

.meas tran vdout0_27ck810 FIND v(dout0_27) AT=410.025n

.meas tran vdout0_28ck810 FIND v(dout0_28) AT=410.025n

.meas tran vdout0_29ck810 FIND v(dout0_29) AT=410.025n

.meas tran vdout0_30ck810 FIND v(dout0_30) AT=410.025n

.meas tran vdout0_31ck810 FIND v(dout0_31) AT=410.025n

.meas tran vdout0_32ck810 FIND v(dout0_32) AT=410.025n

.meas tran vdout0_33ck810 FIND v(dout0_33) AT=410.025n

.meas tran vdout0_34ck810 FIND v(dout0_34) AT=410.025n

.meas tran vdout0_35ck810 FIND v(dout0_35) AT=410.025n

.meas tran vdout0_36ck810 FIND v(dout0_36) AT=410.025n

.meas tran vdout0_37ck810 FIND v(dout0_37) AT=410.025n

.meas tran vdout0_38ck810 FIND v(dout0_38) AT=410.025n

.meas tran vdout0_39ck810 FIND v(dout0_39) AT=410.025n

.meas tran vdout0_40ck810 FIND v(dout0_40) AT=410.025n

.meas tran vdout0_41ck810 FIND v(dout0_41) AT=410.025n

.meas tran vdout0_42ck810 FIND v(dout0_42) AT=410.025n

.meas tran vdout0_43ck810 FIND v(dout0_43) AT=410.025n

.meas tran vdout0_44ck810 FIND v(dout0_44) AT=410.025n

.meas tran vdout0_45ck810 FIND v(dout0_45) AT=410.025n

.meas tran vdout0_46ck810 FIND v(dout0_46) AT=410.025n

.meas tran vdout0_47ck810 FIND v(dout0_47) AT=410.025n

.meas tran vdout0_48ck810 FIND v(dout0_48) AT=410.025n

.meas tran vdout0_49ck810 FIND v(dout0_49) AT=410.025n

.meas tran vdout0_50ck810 FIND v(dout0_50) AT=410.025n

.meas tran vdout0_51ck810 FIND v(dout0_51) AT=410.025n

.meas tran vdout0_52ck810 FIND v(dout0_52) AT=410.025n

.meas tran vdout0_53ck810 FIND v(dout0_53) AT=410.025n

.meas tran vdout0_54ck810 FIND v(dout0_54) AT=410.025n

.meas tran vdout0_55ck810 FIND v(dout0_55) AT=410.025n

.meas tran vdout0_56ck810 FIND v(dout0_56) AT=410.025n

.meas tran vdout0_57ck810 FIND v(dout0_57) AT=410.025n

.meas tran vdout0_58ck810 FIND v(dout0_58) AT=410.025n

.meas tran vdout0_59ck810 FIND v(dout0_59) AT=410.025n

.meas tran vdout0_60ck810 FIND v(dout0_60) AT=410.025n

.meas tran vdout0_61ck810 FIND v(dout0_61) AT=410.025n

.meas tran vdout0_62ck810 FIND v(dout0_62) AT=410.025n

.meas tran vdout0_63ck810 FIND v(dout0_63) AT=410.025n

.meas tran vdout0_0ck910 FIND v(dout0_0) AT=460.025n

.meas tran vdout0_1ck910 FIND v(dout0_1) AT=460.025n

.meas tran vdout0_2ck910 FIND v(dout0_2) AT=460.025n

.meas tran vdout0_3ck910 FIND v(dout0_3) AT=460.025n

.meas tran vdout0_4ck910 FIND v(dout0_4) AT=460.025n

.meas tran vdout0_5ck910 FIND v(dout0_5) AT=460.025n

.meas tran vdout0_6ck910 FIND v(dout0_6) AT=460.025n

.meas tran vdout0_7ck910 FIND v(dout0_7) AT=460.025n

.meas tran vdout0_8ck910 FIND v(dout0_8) AT=460.025n

.meas tran vdout0_9ck910 FIND v(dout0_9) AT=460.025n

.meas tran vdout0_10ck910 FIND v(dout0_10) AT=460.025n

.meas tran vdout0_11ck910 FIND v(dout0_11) AT=460.025n

.meas tran vdout0_12ck910 FIND v(dout0_12) AT=460.025n

.meas tran vdout0_13ck910 FIND v(dout0_13) AT=460.025n

.meas tran vdout0_14ck910 FIND v(dout0_14) AT=460.025n

.meas tran vdout0_15ck910 FIND v(dout0_15) AT=460.025n

.meas tran vdout0_16ck910 FIND v(dout0_16) AT=460.025n

.meas tran vdout0_17ck910 FIND v(dout0_17) AT=460.025n

.meas tran vdout0_18ck910 FIND v(dout0_18) AT=460.025n

.meas tran vdout0_19ck910 FIND v(dout0_19) AT=460.025n

.meas tran vdout0_20ck910 FIND v(dout0_20) AT=460.025n

.meas tran vdout0_21ck910 FIND v(dout0_21) AT=460.025n

.meas tran vdout0_22ck910 FIND v(dout0_22) AT=460.025n

.meas tran vdout0_23ck910 FIND v(dout0_23) AT=460.025n

.meas tran vdout0_24ck910 FIND v(dout0_24) AT=460.025n

.meas tran vdout0_25ck910 FIND v(dout0_25) AT=460.025n

.meas tran vdout0_26ck910 FIND v(dout0_26) AT=460.025n

.meas tran vdout0_27ck910 FIND v(dout0_27) AT=460.025n

.meas tran vdout0_28ck910 FIND v(dout0_28) AT=460.025n

.meas tran vdout0_29ck910 FIND v(dout0_29) AT=460.025n

.meas tran vdout0_30ck910 FIND v(dout0_30) AT=460.025n

.meas tran vdout0_31ck910 FIND v(dout0_31) AT=460.025n

.meas tran vdout0_32ck910 FIND v(dout0_32) AT=460.025n

.meas tran vdout0_33ck910 FIND v(dout0_33) AT=460.025n

.meas tran vdout0_34ck910 FIND v(dout0_34) AT=460.025n

.meas tran vdout0_35ck910 FIND v(dout0_35) AT=460.025n

.meas tran vdout0_36ck910 FIND v(dout0_36) AT=460.025n

.meas tran vdout0_37ck910 FIND v(dout0_37) AT=460.025n

.meas tran vdout0_38ck910 FIND v(dout0_38) AT=460.025n

.meas tran vdout0_39ck910 FIND v(dout0_39) AT=460.025n

.meas tran vdout0_40ck910 FIND v(dout0_40) AT=460.025n

.meas tran vdout0_41ck910 FIND v(dout0_41) AT=460.025n

.meas tran vdout0_42ck910 FIND v(dout0_42) AT=460.025n

.meas tran vdout0_43ck910 FIND v(dout0_43) AT=460.025n

.meas tran vdout0_44ck910 FIND v(dout0_44) AT=460.025n

.meas tran vdout0_45ck910 FIND v(dout0_45) AT=460.025n

.meas tran vdout0_46ck910 FIND v(dout0_46) AT=460.025n

.meas tran vdout0_47ck910 FIND v(dout0_47) AT=460.025n

.meas tran vdout0_48ck910 FIND v(dout0_48) AT=460.025n

.meas tran vdout0_49ck910 FIND v(dout0_49) AT=460.025n

.meas tran vdout0_50ck910 FIND v(dout0_50) AT=460.025n

.meas tran vdout0_51ck910 FIND v(dout0_51) AT=460.025n

.meas tran vdout0_52ck910 FIND v(dout0_52) AT=460.025n

.meas tran vdout0_53ck910 FIND v(dout0_53) AT=460.025n

.meas tran vdout0_54ck910 FIND v(dout0_54) AT=460.025n

.meas tran vdout0_55ck910 FIND v(dout0_55) AT=460.025n

.meas tran vdout0_56ck910 FIND v(dout0_56) AT=460.025n

.meas tran vdout0_57ck910 FIND v(dout0_57) AT=460.025n

.meas tran vdout0_58ck910 FIND v(dout0_58) AT=460.025n

.meas tran vdout0_59ck910 FIND v(dout0_59) AT=460.025n

.meas tran vdout0_60ck910 FIND v(dout0_60) AT=460.025n

.meas tran vdout0_61ck910 FIND v(dout0_61) AT=460.025n

.meas tran vdout0_62ck910 FIND v(dout0_62) AT=460.025n

.meas tran vdout0_63ck910 FIND v(dout0_63) AT=460.025n

.meas tran vdout0_0ck980 FIND v(dout0_0) AT=495.025n

.meas tran vdout0_1ck980 FIND v(dout0_1) AT=495.025n

.meas tran vdout0_2ck980 FIND v(dout0_2) AT=495.025n

.meas tran vdout0_3ck980 FIND v(dout0_3) AT=495.025n

.meas tran vdout0_4ck980 FIND v(dout0_4) AT=495.025n

.meas tran vdout0_5ck980 FIND v(dout0_5) AT=495.025n

.meas tran vdout0_6ck980 FIND v(dout0_6) AT=495.025n

.meas tran vdout0_7ck980 FIND v(dout0_7) AT=495.025n

.meas tran vdout0_8ck980 FIND v(dout0_8) AT=495.025n

.meas tran vdout0_9ck980 FIND v(dout0_9) AT=495.025n

.meas tran vdout0_10ck980 FIND v(dout0_10) AT=495.025n

.meas tran vdout0_11ck980 FIND v(dout0_11) AT=495.025n

.meas tran vdout0_12ck980 FIND v(dout0_12) AT=495.025n

.meas tran vdout0_13ck980 FIND v(dout0_13) AT=495.025n

.meas tran vdout0_14ck980 FIND v(dout0_14) AT=495.025n

.meas tran vdout0_15ck980 FIND v(dout0_15) AT=495.025n

.meas tran vdout0_16ck980 FIND v(dout0_16) AT=495.025n

.meas tran vdout0_17ck980 FIND v(dout0_17) AT=495.025n

.meas tran vdout0_18ck980 FIND v(dout0_18) AT=495.025n

.meas tran vdout0_19ck980 FIND v(dout0_19) AT=495.025n

.meas tran vdout0_20ck980 FIND v(dout0_20) AT=495.025n

.meas tran vdout0_21ck980 FIND v(dout0_21) AT=495.025n

.meas tran vdout0_22ck980 FIND v(dout0_22) AT=495.025n

.meas tran vdout0_23ck980 FIND v(dout0_23) AT=495.025n

.meas tran vdout0_24ck980 FIND v(dout0_24) AT=495.025n

.meas tran vdout0_25ck980 FIND v(dout0_25) AT=495.025n

.meas tran vdout0_26ck980 FIND v(dout0_26) AT=495.025n

.meas tran vdout0_27ck980 FIND v(dout0_27) AT=495.025n

.meas tran vdout0_28ck980 FIND v(dout0_28) AT=495.025n

.meas tran vdout0_29ck980 FIND v(dout0_29) AT=495.025n

.meas tran vdout0_30ck980 FIND v(dout0_30) AT=495.025n

.meas tran vdout0_31ck980 FIND v(dout0_31) AT=495.025n

.meas tran vdout0_32ck980 FIND v(dout0_32) AT=495.025n

.meas tran vdout0_33ck980 FIND v(dout0_33) AT=495.025n

.meas tran vdout0_34ck980 FIND v(dout0_34) AT=495.025n

.meas tran vdout0_35ck980 FIND v(dout0_35) AT=495.025n

.meas tran vdout0_36ck980 FIND v(dout0_36) AT=495.025n

.meas tran vdout0_37ck980 FIND v(dout0_37) AT=495.025n

.meas tran vdout0_38ck980 FIND v(dout0_38) AT=495.025n

.meas tran vdout0_39ck980 FIND v(dout0_39) AT=495.025n

.meas tran vdout0_40ck980 FIND v(dout0_40) AT=495.025n

.meas tran vdout0_41ck980 FIND v(dout0_41) AT=495.025n

.meas tran vdout0_42ck980 FIND v(dout0_42) AT=495.025n

.meas tran vdout0_43ck980 FIND v(dout0_43) AT=495.025n

.meas tran vdout0_44ck980 FIND v(dout0_44) AT=495.025n

.meas tran vdout0_45ck980 FIND v(dout0_45) AT=495.025n

.meas tran vdout0_46ck980 FIND v(dout0_46) AT=495.025n

.meas tran vdout0_47ck980 FIND v(dout0_47) AT=495.025n

.meas tran vdout0_48ck980 FIND v(dout0_48) AT=495.025n

.meas tran vdout0_49ck980 FIND v(dout0_49) AT=495.025n

.meas tran vdout0_50ck980 FIND v(dout0_50) AT=495.025n

.meas tran vdout0_51ck980 FIND v(dout0_51) AT=495.025n

.meas tran vdout0_52ck980 FIND v(dout0_52) AT=495.025n

.meas tran vdout0_53ck980 FIND v(dout0_53) AT=495.025n

.meas tran vdout0_54ck980 FIND v(dout0_54) AT=495.025n

.meas tran vdout0_55ck980 FIND v(dout0_55) AT=495.025n

.meas tran vdout0_56ck980 FIND v(dout0_56) AT=495.025n

.meas tran vdout0_57ck980 FIND v(dout0_57) AT=495.025n

.meas tran vdout0_58ck980 FIND v(dout0_58) AT=495.025n

.meas tran vdout0_59ck980 FIND v(dout0_59) AT=495.025n

.meas tran vdout0_60ck980 FIND v(dout0_60) AT=495.025n

.meas tran vdout0_61ck980 FIND v(dout0_61) AT=495.025n

.meas tran vdout0_62ck980 FIND v(dout0_62) AT=495.025n

.meas tran vdout0_63ck980 FIND v(dout0_63) AT=495.025n

.meas tran vdout0_0ck1040 FIND v(dout0_0) AT=525.025n

.meas tran vdout0_1ck1040 FIND v(dout0_1) AT=525.025n

.meas tran vdout0_2ck1040 FIND v(dout0_2) AT=525.025n

.meas tran vdout0_3ck1040 FIND v(dout0_3) AT=525.025n

.meas tran vdout0_4ck1040 FIND v(dout0_4) AT=525.025n

.meas tran vdout0_5ck1040 FIND v(dout0_5) AT=525.025n

.meas tran vdout0_6ck1040 FIND v(dout0_6) AT=525.025n

.meas tran vdout0_7ck1040 FIND v(dout0_7) AT=525.025n

.meas tran vdout0_8ck1040 FIND v(dout0_8) AT=525.025n

.meas tran vdout0_9ck1040 FIND v(dout0_9) AT=525.025n

.meas tran vdout0_10ck1040 FIND v(dout0_10) AT=525.025n

.meas tran vdout0_11ck1040 FIND v(dout0_11) AT=525.025n

.meas tran vdout0_12ck1040 FIND v(dout0_12) AT=525.025n

.meas tran vdout0_13ck1040 FIND v(dout0_13) AT=525.025n

.meas tran vdout0_14ck1040 FIND v(dout0_14) AT=525.025n

.meas tran vdout0_15ck1040 FIND v(dout0_15) AT=525.025n

.meas tran vdout0_16ck1040 FIND v(dout0_16) AT=525.025n

.meas tran vdout0_17ck1040 FIND v(dout0_17) AT=525.025n

.meas tran vdout0_18ck1040 FIND v(dout0_18) AT=525.025n

.meas tran vdout0_19ck1040 FIND v(dout0_19) AT=525.025n

.meas tran vdout0_20ck1040 FIND v(dout0_20) AT=525.025n

.meas tran vdout0_21ck1040 FIND v(dout0_21) AT=525.025n

.meas tran vdout0_22ck1040 FIND v(dout0_22) AT=525.025n

.meas tran vdout0_23ck1040 FIND v(dout0_23) AT=525.025n

.meas tran vdout0_24ck1040 FIND v(dout0_24) AT=525.025n

.meas tran vdout0_25ck1040 FIND v(dout0_25) AT=525.025n

.meas tran vdout0_26ck1040 FIND v(dout0_26) AT=525.025n

.meas tran vdout0_27ck1040 FIND v(dout0_27) AT=525.025n

.meas tran vdout0_28ck1040 FIND v(dout0_28) AT=525.025n

.meas tran vdout0_29ck1040 FIND v(dout0_29) AT=525.025n

.meas tran vdout0_30ck1040 FIND v(dout0_30) AT=525.025n

.meas tran vdout0_31ck1040 FIND v(dout0_31) AT=525.025n

.meas tran vdout0_32ck1040 FIND v(dout0_32) AT=525.025n

.meas tran vdout0_33ck1040 FIND v(dout0_33) AT=525.025n

.meas tran vdout0_34ck1040 FIND v(dout0_34) AT=525.025n

.meas tran vdout0_35ck1040 FIND v(dout0_35) AT=525.025n

.meas tran vdout0_36ck1040 FIND v(dout0_36) AT=525.025n

.meas tran vdout0_37ck1040 FIND v(dout0_37) AT=525.025n

.meas tran vdout0_38ck1040 FIND v(dout0_38) AT=525.025n

.meas tran vdout0_39ck1040 FIND v(dout0_39) AT=525.025n

.meas tran vdout0_40ck1040 FIND v(dout0_40) AT=525.025n

.meas tran vdout0_41ck1040 FIND v(dout0_41) AT=525.025n

.meas tran vdout0_42ck1040 FIND v(dout0_42) AT=525.025n

.meas tran vdout0_43ck1040 FIND v(dout0_43) AT=525.025n

.meas tran vdout0_44ck1040 FIND v(dout0_44) AT=525.025n

.meas tran vdout0_45ck1040 FIND v(dout0_45) AT=525.025n

.meas tran vdout0_46ck1040 FIND v(dout0_46) AT=525.025n

.meas tran vdout0_47ck1040 FIND v(dout0_47) AT=525.025n

.meas tran vdout0_48ck1040 FIND v(dout0_48) AT=525.025n

.meas tran vdout0_49ck1040 FIND v(dout0_49) AT=525.025n

.meas tran vdout0_50ck1040 FIND v(dout0_50) AT=525.025n

.meas tran vdout0_51ck1040 FIND v(dout0_51) AT=525.025n

.meas tran vdout0_52ck1040 FIND v(dout0_52) AT=525.025n

.meas tran vdout0_53ck1040 FIND v(dout0_53) AT=525.025n

.meas tran vdout0_54ck1040 FIND v(dout0_54) AT=525.025n

.meas tran vdout0_55ck1040 FIND v(dout0_55) AT=525.025n

.meas tran vdout0_56ck1040 FIND v(dout0_56) AT=525.025n

.meas tran vdout0_57ck1040 FIND v(dout0_57) AT=525.025n

.meas tran vdout0_58ck1040 FIND v(dout0_58) AT=525.025n

.meas tran vdout0_59ck1040 FIND v(dout0_59) AT=525.025n

.meas tran vdout0_60ck1040 FIND v(dout0_60) AT=525.025n

.meas tran vdout0_61ck1040 FIND v(dout0_61) AT=525.025n

.meas tran vdout0_62ck1040 FIND v(dout0_62) AT=525.025n

.meas tran vdout0_63ck1040 FIND v(dout0_63) AT=525.025n

.meas tran vdout0_0ck1060 FIND v(dout0_0) AT=535.025n

.meas tran vdout0_1ck1060 FIND v(dout0_1) AT=535.025n

.meas tran vdout0_2ck1060 FIND v(dout0_2) AT=535.025n

.meas tran vdout0_3ck1060 FIND v(dout0_3) AT=535.025n

.meas tran vdout0_4ck1060 FIND v(dout0_4) AT=535.025n

.meas tran vdout0_5ck1060 FIND v(dout0_5) AT=535.025n

.meas tran vdout0_6ck1060 FIND v(dout0_6) AT=535.025n

.meas tran vdout0_7ck1060 FIND v(dout0_7) AT=535.025n

.meas tran vdout0_8ck1060 FIND v(dout0_8) AT=535.025n

.meas tran vdout0_9ck1060 FIND v(dout0_9) AT=535.025n

.meas tran vdout0_10ck1060 FIND v(dout0_10) AT=535.025n

.meas tran vdout0_11ck1060 FIND v(dout0_11) AT=535.025n

.meas tran vdout0_12ck1060 FIND v(dout0_12) AT=535.025n

.meas tran vdout0_13ck1060 FIND v(dout0_13) AT=535.025n

.meas tran vdout0_14ck1060 FIND v(dout0_14) AT=535.025n

.meas tran vdout0_15ck1060 FIND v(dout0_15) AT=535.025n

.meas tran vdout0_16ck1060 FIND v(dout0_16) AT=535.025n

.meas tran vdout0_17ck1060 FIND v(dout0_17) AT=535.025n

.meas tran vdout0_18ck1060 FIND v(dout0_18) AT=535.025n

.meas tran vdout0_19ck1060 FIND v(dout0_19) AT=535.025n

.meas tran vdout0_20ck1060 FIND v(dout0_20) AT=535.025n

.meas tran vdout0_21ck1060 FIND v(dout0_21) AT=535.025n

.meas tran vdout0_22ck1060 FIND v(dout0_22) AT=535.025n

.meas tran vdout0_23ck1060 FIND v(dout0_23) AT=535.025n

.meas tran vdout0_24ck1060 FIND v(dout0_24) AT=535.025n

.meas tran vdout0_25ck1060 FIND v(dout0_25) AT=535.025n

.meas tran vdout0_26ck1060 FIND v(dout0_26) AT=535.025n

.meas tran vdout0_27ck1060 FIND v(dout0_27) AT=535.025n

.meas tran vdout0_28ck1060 FIND v(dout0_28) AT=535.025n

.meas tran vdout0_29ck1060 FIND v(dout0_29) AT=535.025n

.meas tran vdout0_30ck1060 FIND v(dout0_30) AT=535.025n

.meas tran vdout0_31ck1060 FIND v(dout0_31) AT=535.025n

.meas tran vdout0_32ck1060 FIND v(dout0_32) AT=535.025n

.meas tran vdout0_33ck1060 FIND v(dout0_33) AT=535.025n

.meas tran vdout0_34ck1060 FIND v(dout0_34) AT=535.025n

.meas tran vdout0_35ck1060 FIND v(dout0_35) AT=535.025n

.meas tran vdout0_36ck1060 FIND v(dout0_36) AT=535.025n

.meas tran vdout0_37ck1060 FIND v(dout0_37) AT=535.025n

.meas tran vdout0_38ck1060 FIND v(dout0_38) AT=535.025n

.meas tran vdout0_39ck1060 FIND v(dout0_39) AT=535.025n

.meas tran vdout0_40ck1060 FIND v(dout0_40) AT=535.025n

.meas tran vdout0_41ck1060 FIND v(dout0_41) AT=535.025n

.meas tran vdout0_42ck1060 FIND v(dout0_42) AT=535.025n

.meas tran vdout0_43ck1060 FIND v(dout0_43) AT=535.025n

.meas tran vdout0_44ck1060 FIND v(dout0_44) AT=535.025n

.meas tran vdout0_45ck1060 FIND v(dout0_45) AT=535.025n

.meas tran vdout0_46ck1060 FIND v(dout0_46) AT=535.025n

.meas tran vdout0_47ck1060 FIND v(dout0_47) AT=535.025n

.meas tran vdout0_48ck1060 FIND v(dout0_48) AT=535.025n

.meas tran vdout0_49ck1060 FIND v(dout0_49) AT=535.025n

.meas tran vdout0_50ck1060 FIND v(dout0_50) AT=535.025n

.meas tran vdout0_51ck1060 FIND v(dout0_51) AT=535.025n

.meas tran vdout0_52ck1060 FIND v(dout0_52) AT=535.025n

.meas tran vdout0_53ck1060 FIND v(dout0_53) AT=535.025n

.meas tran vdout0_54ck1060 FIND v(dout0_54) AT=535.025n

.meas tran vdout0_55ck1060 FIND v(dout0_55) AT=535.025n

.meas tran vdout0_56ck1060 FIND v(dout0_56) AT=535.025n

.meas tran vdout0_57ck1060 FIND v(dout0_57) AT=535.025n

.meas tran vdout0_58ck1060 FIND v(dout0_58) AT=535.025n

.meas tran vdout0_59ck1060 FIND v(dout0_59) AT=535.025n

.meas tran vdout0_60ck1060 FIND v(dout0_60) AT=535.025n

.meas tran vdout0_61ck1060 FIND v(dout0_61) AT=535.025n

.meas tran vdout0_62ck1060 FIND v(dout0_62) AT=535.025n

.meas tran vdout0_63ck1060 FIND v(dout0_63) AT=535.025n

.meas tran vdout0_0ck1100 FIND v(dout0_0) AT=555.025n

.meas tran vdout0_1ck1100 FIND v(dout0_1) AT=555.025n

.meas tran vdout0_2ck1100 FIND v(dout0_2) AT=555.025n

.meas tran vdout0_3ck1100 FIND v(dout0_3) AT=555.025n

.meas tran vdout0_4ck1100 FIND v(dout0_4) AT=555.025n

.meas tran vdout0_5ck1100 FIND v(dout0_5) AT=555.025n

.meas tran vdout0_6ck1100 FIND v(dout0_6) AT=555.025n

.meas tran vdout0_7ck1100 FIND v(dout0_7) AT=555.025n

.meas tran vdout0_8ck1100 FIND v(dout0_8) AT=555.025n

.meas tran vdout0_9ck1100 FIND v(dout0_9) AT=555.025n

.meas tran vdout0_10ck1100 FIND v(dout0_10) AT=555.025n

.meas tran vdout0_11ck1100 FIND v(dout0_11) AT=555.025n

.meas tran vdout0_12ck1100 FIND v(dout0_12) AT=555.025n

.meas tran vdout0_13ck1100 FIND v(dout0_13) AT=555.025n

.meas tran vdout0_14ck1100 FIND v(dout0_14) AT=555.025n

.meas tran vdout0_15ck1100 FIND v(dout0_15) AT=555.025n

.meas tran vdout0_16ck1100 FIND v(dout0_16) AT=555.025n

.meas tran vdout0_17ck1100 FIND v(dout0_17) AT=555.025n

.meas tran vdout0_18ck1100 FIND v(dout0_18) AT=555.025n

.meas tran vdout0_19ck1100 FIND v(dout0_19) AT=555.025n

.meas tran vdout0_20ck1100 FIND v(dout0_20) AT=555.025n

.meas tran vdout0_21ck1100 FIND v(dout0_21) AT=555.025n

.meas tran vdout0_22ck1100 FIND v(dout0_22) AT=555.025n

.meas tran vdout0_23ck1100 FIND v(dout0_23) AT=555.025n

.meas tran vdout0_24ck1100 FIND v(dout0_24) AT=555.025n

.meas tran vdout0_25ck1100 FIND v(dout0_25) AT=555.025n

.meas tran vdout0_26ck1100 FIND v(dout0_26) AT=555.025n

.meas tran vdout0_27ck1100 FIND v(dout0_27) AT=555.025n

.meas tran vdout0_28ck1100 FIND v(dout0_28) AT=555.025n

.meas tran vdout0_29ck1100 FIND v(dout0_29) AT=555.025n

.meas tran vdout0_30ck1100 FIND v(dout0_30) AT=555.025n

.meas tran vdout0_31ck1100 FIND v(dout0_31) AT=555.025n

.meas tran vdout0_32ck1100 FIND v(dout0_32) AT=555.025n

.meas tran vdout0_33ck1100 FIND v(dout0_33) AT=555.025n

.meas tran vdout0_34ck1100 FIND v(dout0_34) AT=555.025n

.meas tran vdout0_35ck1100 FIND v(dout0_35) AT=555.025n

.meas tran vdout0_36ck1100 FIND v(dout0_36) AT=555.025n

.meas tran vdout0_37ck1100 FIND v(dout0_37) AT=555.025n

.meas tran vdout0_38ck1100 FIND v(dout0_38) AT=555.025n

.meas tran vdout0_39ck1100 FIND v(dout0_39) AT=555.025n

.meas tran vdout0_40ck1100 FIND v(dout0_40) AT=555.025n

.meas tran vdout0_41ck1100 FIND v(dout0_41) AT=555.025n

.meas tran vdout0_42ck1100 FIND v(dout0_42) AT=555.025n

.meas tran vdout0_43ck1100 FIND v(dout0_43) AT=555.025n

.meas tran vdout0_44ck1100 FIND v(dout0_44) AT=555.025n

.meas tran vdout0_45ck1100 FIND v(dout0_45) AT=555.025n

.meas tran vdout0_46ck1100 FIND v(dout0_46) AT=555.025n

.meas tran vdout0_47ck1100 FIND v(dout0_47) AT=555.025n

.meas tran vdout0_48ck1100 FIND v(dout0_48) AT=555.025n

.meas tran vdout0_49ck1100 FIND v(dout0_49) AT=555.025n

.meas tran vdout0_50ck1100 FIND v(dout0_50) AT=555.025n

.meas tran vdout0_51ck1100 FIND v(dout0_51) AT=555.025n

.meas tran vdout0_52ck1100 FIND v(dout0_52) AT=555.025n

.meas tran vdout0_53ck1100 FIND v(dout0_53) AT=555.025n

.meas tran vdout0_54ck1100 FIND v(dout0_54) AT=555.025n

.meas tran vdout0_55ck1100 FIND v(dout0_55) AT=555.025n

.meas tran vdout0_56ck1100 FIND v(dout0_56) AT=555.025n

.meas tran vdout0_57ck1100 FIND v(dout0_57) AT=555.025n

.meas tran vdout0_58ck1100 FIND v(dout0_58) AT=555.025n

.meas tran vdout0_59ck1100 FIND v(dout0_59) AT=555.025n

.meas tran vdout0_60ck1100 FIND v(dout0_60) AT=555.025n

.meas tran vdout0_61ck1100 FIND v(dout0_61) AT=555.025n

.meas tran vdout0_62ck1100 FIND v(dout0_62) AT=555.025n

.meas tran vdout0_63ck1100 FIND v(dout0_63) AT=555.025n

.meas tran vdout0_0ck1120 FIND v(dout0_0) AT=565.025n

.meas tran vdout0_1ck1120 FIND v(dout0_1) AT=565.025n

.meas tran vdout0_2ck1120 FIND v(dout0_2) AT=565.025n

.meas tran vdout0_3ck1120 FIND v(dout0_3) AT=565.025n

.meas tran vdout0_4ck1120 FIND v(dout0_4) AT=565.025n

.meas tran vdout0_5ck1120 FIND v(dout0_5) AT=565.025n

.meas tran vdout0_6ck1120 FIND v(dout0_6) AT=565.025n

.meas tran vdout0_7ck1120 FIND v(dout0_7) AT=565.025n

.meas tran vdout0_8ck1120 FIND v(dout0_8) AT=565.025n

.meas tran vdout0_9ck1120 FIND v(dout0_9) AT=565.025n

.meas tran vdout0_10ck1120 FIND v(dout0_10) AT=565.025n

.meas tran vdout0_11ck1120 FIND v(dout0_11) AT=565.025n

.meas tran vdout0_12ck1120 FIND v(dout0_12) AT=565.025n

.meas tran vdout0_13ck1120 FIND v(dout0_13) AT=565.025n

.meas tran vdout0_14ck1120 FIND v(dout0_14) AT=565.025n

.meas tran vdout0_15ck1120 FIND v(dout0_15) AT=565.025n

.meas tran vdout0_16ck1120 FIND v(dout0_16) AT=565.025n

.meas tran vdout0_17ck1120 FIND v(dout0_17) AT=565.025n

.meas tran vdout0_18ck1120 FIND v(dout0_18) AT=565.025n

.meas tran vdout0_19ck1120 FIND v(dout0_19) AT=565.025n

.meas tran vdout0_20ck1120 FIND v(dout0_20) AT=565.025n

.meas tran vdout0_21ck1120 FIND v(dout0_21) AT=565.025n

.meas tran vdout0_22ck1120 FIND v(dout0_22) AT=565.025n

.meas tran vdout0_23ck1120 FIND v(dout0_23) AT=565.025n

.meas tran vdout0_24ck1120 FIND v(dout0_24) AT=565.025n

.meas tran vdout0_25ck1120 FIND v(dout0_25) AT=565.025n

.meas tran vdout0_26ck1120 FIND v(dout0_26) AT=565.025n

.meas tran vdout0_27ck1120 FIND v(dout0_27) AT=565.025n

.meas tran vdout0_28ck1120 FIND v(dout0_28) AT=565.025n

.meas tran vdout0_29ck1120 FIND v(dout0_29) AT=565.025n

.meas tran vdout0_30ck1120 FIND v(dout0_30) AT=565.025n

.meas tran vdout0_31ck1120 FIND v(dout0_31) AT=565.025n

.meas tran vdout0_32ck1120 FIND v(dout0_32) AT=565.025n

.meas tran vdout0_33ck1120 FIND v(dout0_33) AT=565.025n

.meas tran vdout0_34ck1120 FIND v(dout0_34) AT=565.025n

.meas tran vdout0_35ck1120 FIND v(dout0_35) AT=565.025n

.meas tran vdout0_36ck1120 FIND v(dout0_36) AT=565.025n

.meas tran vdout0_37ck1120 FIND v(dout0_37) AT=565.025n

.meas tran vdout0_38ck1120 FIND v(dout0_38) AT=565.025n

.meas tran vdout0_39ck1120 FIND v(dout0_39) AT=565.025n

.meas tran vdout0_40ck1120 FIND v(dout0_40) AT=565.025n

.meas tran vdout0_41ck1120 FIND v(dout0_41) AT=565.025n

.meas tran vdout0_42ck1120 FIND v(dout0_42) AT=565.025n

.meas tran vdout0_43ck1120 FIND v(dout0_43) AT=565.025n

.meas tran vdout0_44ck1120 FIND v(dout0_44) AT=565.025n

.meas tran vdout0_45ck1120 FIND v(dout0_45) AT=565.025n

.meas tran vdout0_46ck1120 FIND v(dout0_46) AT=565.025n

.meas tran vdout0_47ck1120 FIND v(dout0_47) AT=565.025n

.meas tran vdout0_48ck1120 FIND v(dout0_48) AT=565.025n

.meas tran vdout0_49ck1120 FIND v(dout0_49) AT=565.025n

.meas tran vdout0_50ck1120 FIND v(dout0_50) AT=565.025n

.meas tran vdout0_51ck1120 FIND v(dout0_51) AT=565.025n

.meas tran vdout0_52ck1120 FIND v(dout0_52) AT=565.025n

.meas tran vdout0_53ck1120 FIND v(dout0_53) AT=565.025n

.meas tran vdout0_54ck1120 FIND v(dout0_54) AT=565.025n

.meas tran vdout0_55ck1120 FIND v(dout0_55) AT=565.025n

.meas tran vdout0_56ck1120 FIND v(dout0_56) AT=565.025n

.meas tran vdout0_57ck1120 FIND v(dout0_57) AT=565.025n

.meas tran vdout0_58ck1120 FIND v(dout0_58) AT=565.025n

.meas tran vdout0_59ck1120 FIND v(dout0_59) AT=565.025n

.meas tran vdout0_60ck1120 FIND v(dout0_60) AT=565.025n

.meas tran vdout0_61ck1120 FIND v(dout0_61) AT=565.025n

.meas tran vdout0_62ck1120 FIND v(dout0_62) AT=565.025n

.meas tran vdout0_63ck1120 FIND v(dout0_63) AT=565.025n

.meas tran vdout0_0ck1130 FIND v(dout0_0) AT=570.025n

.meas tran vdout0_1ck1130 FIND v(dout0_1) AT=570.025n

.meas tran vdout0_2ck1130 FIND v(dout0_2) AT=570.025n

.meas tran vdout0_3ck1130 FIND v(dout0_3) AT=570.025n

.meas tran vdout0_4ck1130 FIND v(dout0_4) AT=570.025n

.meas tran vdout0_5ck1130 FIND v(dout0_5) AT=570.025n

.meas tran vdout0_6ck1130 FIND v(dout0_6) AT=570.025n

.meas tran vdout0_7ck1130 FIND v(dout0_7) AT=570.025n

.meas tran vdout0_8ck1130 FIND v(dout0_8) AT=570.025n

.meas tran vdout0_9ck1130 FIND v(dout0_9) AT=570.025n

.meas tran vdout0_10ck1130 FIND v(dout0_10) AT=570.025n

.meas tran vdout0_11ck1130 FIND v(dout0_11) AT=570.025n

.meas tran vdout0_12ck1130 FIND v(dout0_12) AT=570.025n

.meas tran vdout0_13ck1130 FIND v(dout0_13) AT=570.025n

.meas tran vdout0_14ck1130 FIND v(dout0_14) AT=570.025n

.meas tran vdout0_15ck1130 FIND v(dout0_15) AT=570.025n

.meas tran vdout0_16ck1130 FIND v(dout0_16) AT=570.025n

.meas tran vdout0_17ck1130 FIND v(dout0_17) AT=570.025n

.meas tran vdout0_18ck1130 FIND v(dout0_18) AT=570.025n

.meas tran vdout0_19ck1130 FIND v(dout0_19) AT=570.025n

.meas tran vdout0_20ck1130 FIND v(dout0_20) AT=570.025n

.meas tran vdout0_21ck1130 FIND v(dout0_21) AT=570.025n

.meas tran vdout0_22ck1130 FIND v(dout0_22) AT=570.025n

.meas tran vdout0_23ck1130 FIND v(dout0_23) AT=570.025n

.meas tran vdout0_24ck1130 FIND v(dout0_24) AT=570.025n

.meas tran vdout0_25ck1130 FIND v(dout0_25) AT=570.025n

.meas tran vdout0_26ck1130 FIND v(dout0_26) AT=570.025n

.meas tran vdout0_27ck1130 FIND v(dout0_27) AT=570.025n

.meas tran vdout0_28ck1130 FIND v(dout0_28) AT=570.025n

.meas tran vdout0_29ck1130 FIND v(dout0_29) AT=570.025n

.meas tran vdout0_30ck1130 FIND v(dout0_30) AT=570.025n

.meas tran vdout0_31ck1130 FIND v(dout0_31) AT=570.025n

.meas tran vdout0_32ck1130 FIND v(dout0_32) AT=570.025n

.meas tran vdout0_33ck1130 FIND v(dout0_33) AT=570.025n

.meas tran vdout0_34ck1130 FIND v(dout0_34) AT=570.025n

.meas tran vdout0_35ck1130 FIND v(dout0_35) AT=570.025n

.meas tran vdout0_36ck1130 FIND v(dout0_36) AT=570.025n

.meas tran vdout0_37ck1130 FIND v(dout0_37) AT=570.025n

.meas tran vdout0_38ck1130 FIND v(dout0_38) AT=570.025n

.meas tran vdout0_39ck1130 FIND v(dout0_39) AT=570.025n

.meas tran vdout0_40ck1130 FIND v(dout0_40) AT=570.025n

.meas tran vdout0_41ck1130 FIND v(dout0_41) AT=570.025n

.meas tran vdout0_42ck1130 FIND v(dout0_42) AT=570.025n

.meas tran vdout0_43ck1130 FIND v(dout0_43) AT=570.025n

.meas tran vdout0_44ck1130 FIND v(dout0_44) AT=570.025n

.meas tran vdout0_45ck1130 FIND v(dout0_45) AT=570.025n

.meas tran vdout0_46ck1130 FIND v(dout0_46) AT=570.025n

.meas tran vdout0_47ck1130 FIND v(dout0_47) AT=570.025n

.meas tran vdout0_48ck1130 FIND v(dout0_48) AT=570.025n

.meas tran vdout0_49ck1130 FIND v(dout0_49) AT=570.025n

.meas tran vdout0_50ck1130 FIND v(dout0_50) AT=570.025n

.meas tran vdout0_51ck1130 FIND v(dout0_51) AT=570.025n

.meas tran vdout0_52ck1130 FIND v(dout0_52) AT=570.025n

.meas tran vdout0_53ck1130 FIND v(dout0_53) AT=570.025n

.meas tran vdout0_54ck1130 FIND v(dout0_54) AT=570.025n

.meas tran vdout0_55ck1130 FIND v(dout0_55) AT=570.025n

.meas tran vdout0_56ck1130 FIND v(dout0_56) AT=570.025n

.meas tran vdout0_57ck1130 FIND v(dout0_57) AT=570.025n

.meas tran vdout0_58ck1130 FIND v(dout0_58) AT=570.025n

.meas tran vdout0_59ck1130 FIND v(dout0_59) AT=570.025n

.meas tran vdout0_60ck1130 FIND v(dout0_60) AT=570.025n

.meas tran vdout0_61ck1130 FIND v(dout0_61) AT=570.025n

.meas tran vdout0_62ck1130 FIND v(dout0_62) AT=570.025n

.meas tran vdout0_63ck1130 FIND v(dout0_63) AT=570.025n

.meas tran vdout0_0ck1160 FIND v(dout0_0) AT=585.025n

.meas tran vdout0_1ck1160 FIND v(dout0_1) AT=585.025n

.meas tran vdout0_2ck1160 FIND v(dout0_2) AT=585.025n

.meas tran vdout0_3ck1160 FIND v(dout0_3) AT=585.025n

.meas tran vdout0_4ck1160 FIND v(dout0_4) AT=585.025n

.meas tran vdout0_5ck1160 FIND v(dout0_5) AT=585.025n

.meas tran vdout0_6ck1160 FIND v(dout0_6) AT=585.025n

.meas tran vdout0_7ck1160 FIND v(dout0_7) AT=585.025n

.meas tran vdout0_8ck1160 FIND v(dout0_8) AT=585.025n

.meas tran vdout0_9ck1160 FIND v(dout0_9) AT=585.025n

.meas tran vdout0_10ck1160 FIND v(dout0_10) AT=585.025n

.meas tran vdout0_11ck1160 FIND v(dout0_11) AT=585.025n

.meas tran vdout0_12ck1160 FIND v(dout0_12) AT=585.025n

.meas tran vdout0_13ck1160 FIND v(dout0_13) AT=585.025n

.meas tran vdout0_14ck1160 FIND v(dout0_14) AT=585.025n

.meas tran vdout0_15ck1160 FIND v(dout0_15) AT=585.025n

.meas tran vdout0_16ck1160 FIND v(dout0_16) AT=585.025n

.meas tran vdout0_17ck1160 FIND v(dout0_17) AT=585.025n

.meas tran vdout0_18ck1160 FIND v(dout0_18) AT=585.025n

.meas tran vdout0_19ck1160 FIND v(dout0_19) AT=585.025n

.meas tran vdout0_20ck1160 FIND v(dout0_20) AT=585.025n

.meas tran vdout0_21ck1160 FIND v(dout0_21) AT=585.025n

.meas tran vdout0_22ck1160 FIND v(dout0_22) AT=585.025n

.meas tran vdout0_23ck1160 FIND v(dout0_23) AT=585.025n

.meas tran vdout0_24ck1160 FIND v(dout0_24) AT=585.025n

.meas tran vdout0_25ck1160 FIND v(dout0_25) AT=585.025n

.meas tran vdout0_26ck1160 FIND v(dout0_26) AT=585.025n

.meas tran vdout0_27ck1160 FIND v(dout0_27) AT=585.025n

.meas tran vdout0_28ck1160 FIND v(dout0_28) AT=585.025n

.meas tran vdout0_29ck1160 FIND v(dout0_29) AT=585.025n

.meas tran vdout0_30ck1160 FIND v(dout0_30) AT=585.025n

.meas tran vdout0_31ck1160 FIND v(dout0_31) AT=585.025n

.meas tran vdout0_32ck1160 FIND v(dout0_32) AT=585.025n

.meas tran vdout0_33ck1160 FIND v(dout0_33) AT=585.025n

.meas tran vdout0_34ck1160 FIND v(dout0_34) AT=585.025n

.meas tran vdout0_35ck1160 FIND v(dout0_35) AT=585.025n

.meas tran vdout0_36ck1160 FIND v(dout0_36) AT=585.025n

.meas tran vdout0_37ck1160 FIND v(dout0_37) AT=585.025n

.meas tran vdout0_38ck1160 FIND v(dout0_38) AT=585.025n

.meas tran vdout0_39ck1160 FIND v(dout0_39) AT=585.025n

.meas tran vdout0_40ck1160 FIND v(dout0_40) AT=585.025n

.meas tran vdout0_41ck1160 FIND v(dout0_41) AT=585.025n

.meas tran vdout0_42ck1160 FIND v(dout0_42) AT=585.025n

.meas tran vdout0_43ck1160 FIND v(dout0_43) AT=585.025n

.meas tran vdout0_44ck1160 FIND v(dout0_44) AT=585.025n

.meas tran vdout0_45ck1160 FIND v(dout0_45) AT=585.025n

.meas tran vdout0_46ck1160 FIND v(dout0_46) AT=585.025n

.meas tran vdout0_47ck1160 FIND v(dout0_47) AT=585.025n

.meas tran vdout0_48ck1160 FIND v(dout0_48) AT=585.025n

.meas tran vdout0_49ck1160 FIND v(dout0_49) AT=585.025n

.meas tran vdout0_50ck1160 FIND v(dout0_50) AT=585.025n

.meas tran vdout0_51ck1160 FIND v(dout0_51) AT=585.025n

.meas tran vdout0_52ck1160 FIND v(dout0_52) AT=585.025n

.meas tran vdout0_53ck1160 FIND v(dout0_53) AT=585.025n

.meas tran vdout0_54ck1160 FIND v(dout0_54) AT=585.025n

.meas tran vdout0_55ck1160 FIND v(dout0_55) AT=585.025n

.meas tran vdout0_56ck1160 FIND v(dout0_56) AT=585.025n

.meas tran vdout0_57ck1160 FIND v(dout0_57) AT=585.025n

.meas tran vdout0_58ck1160 FIND v(dout0_58) AT=585.025n

.meas tran vdout0_59ck1160 FIND v(dout0_59) AT=585.025n

.meas tran vdout0_60ck1160 FIND v(dout0_60) AT=585.025n

.meas tran vdout0_61ck1160 FIND v(dout0_61) AT=585.025n

.meas tran vdout0_62ck1160 FIND v(dout0_62) AT=585.025n

.meas tran vdout0_63ck1160 FIND v(dout0_63) AT=585.025n

.meas tran vdout0_0ck1170 FIND v(dout0_0) AT=590.025n

.meas tran vdout0_1ck1170 FIND v(dout0_1) AT=590.025n

.meas tran vdout0_2ck1170 FIND v(dout0_2) AT=590.025n

.meas tran vdout0_3ck1170 FIND v(dout0_3) AT=590.025n

.meas tran vdout0_4ck1170 FIND v(dout0_4) AT=590.025n

.meas tran vdout0_5ck1170 FIND v(dout0_5) AT=590.025n

.meas tran vdout0_6ck1170 FIND v(dout0_6) AT=590.025n

.meas tran vdout0_7ck1170 FIND v(dout0_7) AT=590.025n

.meas tran vdout0_8ck1170 FIND v(dout0_8) AT=590.025n

.meas tran vdout0_9ck1170 FIND v(dout0_9) AT=590.025n

.meas tran vdout0_10ck1170 FIND v(dout0_10) AT=590.025n

.meas tran vdout0_11ck1170 FIND v(dout0_11) AT=590.025n

.meas tran vdout0_12ck1170 FIND v(dout0_12) AT=590.025n

.meas tran vdout0_13ck1170 FIND v(dout0_13) AT=590.025n

.meas tran vdout0_14ck1170 FIND v(dout0_14) AT=590.025n

.meas tran vdout0_15ck1170 FIND v(dout0_15) AT=590.025n

.meas tran vdout0_16ck1170 FIND v(dout0_16) AT=590.025n

.meas tran vdout0_17ck1170 FIND v(dout0_17) AT=590.025n

.meas tran vdout0_18ck1170 FIND v(dout0_18) AT=590.025n

.meas tran vdout0_19ck1170 FIND v(dout0_19) AT=590.025n

.meas tran vdout0_20ck1170 FIND v(dout0_20) AT=590.025n

.meas tran vdout0_21ck1170 FIND v(dout0_21) AT=590.025n

.meas tran vdout0_22ck1170 FIND v(dout0_22) AT=590.025n

.meas tran vdout0_23ck1170 FIND v(dout0_23) AT=590.025n

.meas tran vdout0_24ck1170 FIND v(dout0_24) AT=590.025n

.meas tran vdout0_25ck1170 FIND v(dout0_25) AT=590.025n

.meas tran vdout0_26ck1170 FIND v(dout0_26) AT=590.025n

.meas tran vdout0_27ck1170 FIND v(dout0_27) AT=590.025n

.meas tran vdout0_28ck1170 FIND v(dout0_28) AT=590.025n

.meas tran vdout0_29ck1170 FIND v(dout0_29) AT=590.025n

.meas tran vdout0_30ck1170 FIND v(dout0_30) AT=590.025n

.meas tran vdout0_31ck1170 FIND v(dout0_31) AT=590.025n

.meas tran vdout0_32ck1170 FIND v(dout0_32) AT=590.025n

.meas tran vdout0_33ck1170 FIND v(dout0_33) AT=590.025n

.meas tran vdout0_34ck1170 FIND v(dout0_34) AT=590.025n

.meas tran vdout0_35ck1170 FIND v(dout0_35) AT=590.025n

.meas tran vdout0_36ck1170 FIND v(dout0_36) AT=590.025n

.meas tran vdout0_37ck1170 FIND v(dout0_37) AT=590.025n

.meas tran vdout0_38ck1170 FIND v(dout0_38) AT=590.025n

.meas tran vdout0_39ck1170 FIND v(dout0_39) AT=590.025n

.meas tran vdout0_40ck1170 FIND v(dout0_40) AT=590.025n

.meas tran vdout0_41ck1170 FIND v(dout0_41) AT=590.025n

.meas tran vdout0_42ck1170 FIND v(dout0_42) AT=590.025n

.meas tran vdout0_43ck1170 FIND v(dout0_43) AT=590.025n

.meas tran vdout0_44ck1170 FIND v(dout0_44) AT=590.025n

.meas tran vdout0_45ck1170 FIND v(dout0_45) AT=590.025n

.meas tran vdout0_46ck1170 FIND v(dout0_46) AT=590.025n

.meas tran vdout0_47ck1170 FIND v(dout0_47) AT=590.025n

.meas tran vdout0_48ck1170 FIND v(dout0_48) AT=590.025n

.meas tran vdout0_49ck1170 FIND v(dout0_49) AT=590.025n

.meas tran vdout0_50ck1170 FIND v(dout0_50) AT=590.025n

.meas tran vdout0_51ck1170 FIND v(dout0_51) AT=590.025n

.meas tran vdout0_52ck1170 FIND v(dout0_52) AT=590.025n

.meas tran vdout0_53ck1170 FIND v(dout0_53) AT=590.025n

.meas tran vdout0_54ck1170 FIND v(dout0_54) AT=590.025n

.meas tran vdout0_55ck1170 FIND v(dout0_55) AT=590.025n

.meas tran vdout0_56ck1170 FIND v(dout0_56) AT=590.025n

.meas tran vdout0_57ck1170 FIND v(dout0_57) AT=590.025n

.meas tran vdout0_58ck1170 FIND v(dout0_58) AT=590.025n

.meas tran vdout0_59ck1170 FIND v(dout0_59) AT=590.025n

.meas tran vdout0_60ck1170 FIND v(dout0_60) AT=590.025n

.meas tran vdout0_61ck1170 FIND v(dout0_61) AT=590.025n

.meas tran vdout0_62ck1170 FIND v(dout0_62) AT=590.025n

.meas tran vdout0_63ck1170 FIND v(dout0_63) AT=590.025n

.meas tran vdout0_0ck1180 FIND v(dout0_0) AT=595.025n

.meas tran vdout0_1ck1180 FIND v(dout0_1) AT=595.025n

.meas tran vdout0_2ck1180 FIND v(dout0_2) AT=595.025n

.meas tran vdout0_3ck1180 FIND v(dout0_3) AT=595.025n

.meas tran vdout0_4ck1180 FIND v(dout0_4) AT=595.025n

.meas tran vdout0_5ck1180 FIND v(dout0_5) AT=595.025n

.meas tran vdout0_6ck1180 FIND v(dout0_6) AT=595.025n

.meas tran vdout0_7ck1180 FIND v(dout0_7) AT=595.025n

.meas tran vdout0_8ck1180 FIND v(dout0_8) AT=595.025n

.meas tran vdout0_9ck1180 FIND v(dout0_9) AT=595.025n

.meas tran vdout0_10ck1180 FIND v(dout0_10) AT=595.025n

.meas tran vdout0_11ck1180 FIND v(dout0_11) AT=595.025n

.meas tran vdout0_12ck1180 FIND v(dout0_12) AT=595.025n

.meas tran vdout0_13ck1180 FIND v(dout0_13) AT=595.025n

.meas tran vdout0_14ck1180 FIND v(dout0_14) AT=595.025n

.meas tran vdout0_15ck1180 FIND v(dout0_15) AT=595.025n

.meas tran vdout0_16ck1180 FIND v(dout0_16) AT=595.025n

.meas tran vdout0_17ck1180 FIND v(dout0_17) AT=595.025n

.meas tran vdout0_18ck1180 FIND v(dout0_18) AT=595.025n

.meas tran vdout0_19ck1180 FIND v(dout0_19) AT=595.025n

.meas tran vdout0_20ck1180 FIND v(dout0_20) AT=595.025n

.meas tran vdout0_21ck1180 FIND v(dout0_21) AT=595.025n

.meas tran vdout0_22ck1180 FIND v(dout0_22) AT=595.025n

.meas tran vdout0_23ck1180 FIND v(dout0_23) AT=595.025n

.meas tran vdout0_24ck1180 FIND v(dout0_24) AT=595.025n

.meas tran vdout0_25ck1180 FIND v(dout0_25) AT=595.025n

.meas tran vdout0_26ck1180 FIND v(dout0_26) AT=595.025n

.meas tran vdout0_27ck1180 FIND v(dout0_27) AT=595.025n

.meas tran vdout0_28ck1180 FIND v(dout0_28) AT=595.025n

.meas tran vdout0_29ck1180 FIND v(dout0_29) AT=595.025n

.meas tran vdout0_30ck1180 FIND v(dout0_30) AT=595.025n

.meas tran vdout0_31ck1180 FIND v(dout0_31) AT=595.025n

.meas tran vdout0_32ck1180 FIND v(dout0_32) AT=595.025n

.meas tran vdout0_33ck1180 FIND v(dout0_33) AT=595.025n

.meas tran vdout0_34ck1180 FIND v(dout0_34) AT=595.025n

.meas tran vdout0_35ck1180 FIND v(dout0_35) AT=595.025n

.meas tran vdout0_36ck1180 FIND v(dout0_36) AT=595.025n

.meas tran vdout0_37ck1180 FIND v(dout0_37) AT=595.025n

.meas tran vdout0_38ck1180 FIND v(dout0_38) AT=595.025n

.meas tran vdout0_39ck1180 FIND v(dout0_39) AT=595.025n

.meas tran vdout0_40ck1180 FIND v(dout0_40) AT=595.025n

.meas tran vdout0_41ck1180 FIND v(dout0_41) AT=595.025n

.meas tran vdout0_42ck1180 FIND v(dout0_42) AT=595.025n

.meas tran vdout0_43ck1180 FIND v(dout0_43) AT=595.025n

.meas tran vdout0_44ck1180 FIND v(dout0_44) AT=595.025n

.meas tran vdout0_45ck1180 FIND v(dout0_45) AT=595.025n

.meas tran vdout0_46ck1180 FIND v(dout0_46) AT=595.025n

.meas tran vdout0_47ck1180 FIND v(dout0_47) AT=595.025n

.meas tran vdout0_48ck1180 FIND v(dout0_48) AT=595.025n

.meas tran vdout0_49ck1180 FIND v(dout0_49) AT=595.025n

.meas tran vdout0_50ck1180 FIND v(dout0_50) AT=595.025n

.meas tran vdout0_51ck1180 FIND v(dout0_51) AT=595.025n

.meas tran vdout0_52ck1180 FIND v(dout0_52) AT=595.025n

.meas tran vdout0_53ck1180 FIND v(dout0_53) AT=595.025n

.meas tran vdout0_54ck1180 FIND v(dout0_54) AT=595.025n

.meas tran vdout0_55ck1180 FIND v(dout0_55) AT=595.025n

.meas tran vdout0_56ck1180 FIND v(dout0_56) AT=595.025n

.meas tran vdout0_57ck1180 FIND v(dout0_57) AT=595.025n

.meas tran vdout0_58ck1180 FIND v(dout0_58) AT=595.025n

.meas tran vdout0_59ck1180 FIND v(dout0_59) AT=595.025n

.meas tran vdout0_60ck1180 FIND v(dout0_60) AT=595.025n

.meas tran vdout0_61ck1180 FIND v(dout0_61) AT=595.025n

.meas tran vdout0_62ck1180 FIND v(dout0_62) AT=595.025n

.meas tran vdout0_63ck1180 FIND v(dout0_63) AT=595.025n

.meas tran vdout0_0ck1190 FIND v(dout0_0) AT=600.025n

.meas tran vdout0_1ck1190 FIND v(dout0_1) AT=600.025n

.meas tran vdout0_2ck1190 FIND v(dout0_2) AT=600.025n

.meas tran vdout0_3ck1190 FIND v(dout0_3) AT=600.025n

.meas tran vdout0_4ck1190 FIND v(dout0_4) AT=600.025n

.meas tran vdout0_5ck1190 FIND v(dout0_5) AT=600.025n

.meas tran vdout0_6ck1190 FIND v(dout0_6) AT=600.025n

.meas tran vdout0_7ck1190 FIND v(dout0_7) AT=600.025n

.meas tran vdout0_8ck1190 FIND v(dout0_8) AT=600.025n

.meas tran vdout0_9ck1190 FIND v(dout0_9) AT=600.025n

.meas tran vdout0_10ck1190 FIND v(dout0_10) AT=600.025n

.meas tran vdout0_11ck1190 FIND v(dout0_11) AT=600.025n

.meas tran vdout0_12ck1190 FIND v(dout0_12) AT=600.025n

.meas tran vdout0_13ck1190 FIND v(dout0_13) AT=600.025n

.meas tran vdout0_14ck1190 FIND v(dout0_14) AT=600.025n

.meas tran vdout0_15ck1190 FIND v(dout0_15) AT=600.025n

.meas tran vdout0_16ck1190 FIND v(dout0_16) AT=600.025n

.meas tran vdout0_17ck1190 FIND v(dout0_17) AT=600.025n

.meas tran vdout0_18ck1190 FIND v(dout0_18) AT=600.025n

.meas tran vdout0_19ck1190 FIND v(dout0_19) AT=600.025n

.meas tran vdout0_20ck1190 FIND v(dout0_20) AT=600.025n

.meas tran vdout0_21ck1190 FIND v(dout0_21) AT=600.025n

.meas tran vdout0_22ck1190 FIND v(dout0_22) AT=600.025n

.meas tran vdout0_23ck1190 FIND v(dout0_23) AT=600.025n

.meas tran vdout0_24ck1190 FIND v(dout0_24) AT=600.025n

.meas tran vdout0_25ck1190 FIND v(dout0_25) AT=600.025n

.meas tran vdout0_26ck1190 FIND v(dout0_26) AT=600.025n

.meas tran vdout0_27ck1190 FIND v(dout0_27) AT=600.025n

.meas tran vdout0_28ck1190 FIND v(dout0_28) AT=600.025n

.meas tran vdout0_29ck1190 FIND v(dout0_29) AT=600.025n

.meas tran vdout0_30ck1190 FIND v(dout0_30) AT=600.025n

.meas tran vdout0_31ck1190 FIND v(dout0_31) AT=600.025n

.meas tran vdout0_32ck1190 FIND v(dout0_32) AT=600.025n

.meas tran vdout0_33ck1190 FIND v(dout0_33) AT=600.025n

.meas tran vdout0_34ck1190 FIND v(dout0_34) AT=600.025n

.meas tran vdout0_35ck1190 FIND v(dout0_35) AT=600.025n

.meas tran vdout0_36ck1190 FIND v(dout0_36) AT=600.025n

.meas tran vdout0_37ck1190 FIND v(dout0_37) AT=600.025n

.meas tran vdout0_38ck1190 FIND v(dout0_38) AT=600.025n

.meas tran vdout0_39ck1190 FIND v(dout0_39) AT=600.025n

.meas tran vdout0_40ck1190 FIND v(dout0_40) AT=600.025n

.meas tran vdout0_41ck1190 FIND v(dout0_41) AT=600.025n

.meas tran vdout0_42ck1190 FIND v(dout0_42) AT=600.025n

.meas tran vdout0_43ck1190 FIND v(dout0_43) AT=600.025n

.meas tran vdout0_44ck1190 FIND v(dout0_44) AT=600.025n

.meas tran vdout0_45ck1190 FIND v(dout0_45) AT=600.025n

.meas tran vdout0_46ck1190 FIND v(dout0_46) AT=600.025n

.meas tran vdout0_47ck1190 FIND v(dout0_47) AT=600.025n

.meas tran vdout0_48ck1190 FIND v(dout0_48) AT=600.025n

.meas tran vdout0_49ck1190 FIND v(dout0_49) AT=600.025n

.meas tran vdout0_50ck1190 FIND v(dout0_50) AT=600.025n

.meas tran vdout0_51ck1190 FIND v(dout0_51) AT=600.025n

.meas tran vdout0_52ck1190 FIND v(dout0_52) AT=600.025n

.meas tran vdout0_53ck1190 FIND v(dout0_53) AT=600.025n

.meas tran vdout0_54ck1190 FIND v(dout0_54) AT=600.025n

.meas tran vdout0_55ck1190 FIND v(dout0_55) AT=600.025n

.meas tran vdout0_56ck1190 FIND v(dout0_56) AT=600.025n

.meas tran vdout0_57ck1190 FIND v(dout0_57) AT=600.025n

.meas tran vdout0_58ck1190 FIND v(dout0_58) AT=600.025n

.meas tran vdout0_59ck1190 FIND v(dout0_59) AT=600.025n

.meas tran vdout0_60ck1190 FIND v(dout0_60) AT=600.025n

.meas tran vdout0_61ck1190 FIND v(dout0_61) AT=600.025n

.meas tran vdout0_62ck1190 FIND v(dout0_62) AT=600.025n

.meas tran vdout0_63ck1190 FIND v(dout0_63) AT=600.025n

.meas tran vdout0_0ck1200 FIND v(dout0_0) AT=605.025n

.meas tran vdout0_1ck1200 FIND v(dout0_1) AT=605.025n

.meas tran vdout0_2ck1200 FIND v(dout0_2) AT=605.025n

.meas tran vdout0_3ck1200 FIND v(dout0_3) AT=605.025n

.meas tran vdout0_4ck1200 FIND v(dout0_4) AT=605.025n

.meas tran vdout0_5ck1200 FIND v(dout0_5) AT=605.025n

.meas tran vdout0_6ck1200 FIND v(dout0_6) AT=605.025n

.meas tran vdout0_7ck1200 FIND v(dout0_7) AT=605.025n

.meas tran vdout0_8ck1200 FIND v(dout0_8) AT=605.025n

.meas tran vdout0_9ck1200 FIND v(dout0_9) AT=605.025n

.meas tran vdout0_10ck1200 FIND v(dout0_10) AT=605.025n

.meas tran vdout0_11ck1200 FIND v(dout0_11) AT=605.025n

.meas tran vdout0_12ck1200 FIND v(dout0_12) AT=605.025n

.meas tran vdout0_13ck1200 FIND v(dout0_13) AT=605.025n

.meas tran vdout0_14ck1200 FIND v(dout0_14) AT=605.025n

.meas tran vdout0_15ck1200 FIND v(dout0_15) AT=605.025n

.meas tran vdout0_16ck1200 FIND v(dout0_16) AT=605.025n

.meas tran vdout0_17ck1200 FIND v(dout0_17) AT=605.025n

.meas tran vdout0_18ck1200 FIND v(dout0_18) AT=605.025n

.meas tran vdout0_19ck1200 FIND v(dout0_19) AT=605.025n

.meas tran vdout0_20ck1200 FIND v(dout0_20) AT=605.025n

.meas tran vdout0_21ck1200 FIND v(dout0_21) AT=605.025n

.meas tran vdout0_22ck1200 FIND v(dout0_22) AT=605.025n

.meas tran vdout0_23ck1200 FIND v(dout0_23) AT=605.025n

.meas tran vdout0_24ck1200 FIND v(dout0_24) AT=605.025n

.meas tran vdout0_25ck1200 FIND v(dout0_25) AT=605.025n

.meas tran vdout0_26ck1200 FIND v(dout0_26) AT=605.025n

.meas tran vdout0_27ck1200 FIND v(dout0_27) AT=605.025n

.meas tran vdout0_28ck1200 FIND v(dout0_28) AT=605.025n

.meas tran vdout0_29ck1200 FIND v(dout0_29) AT=605.025n

.meas tran vdout0_30ck1200 FIND v(dout0_30) AT=605.025n

.meas tran vdout0_31ck1200 FIND v(dout0_31) AT=605.025n

.meas tran vdout0_32ck1200 FIND v(dout0_32) AT=605.025n

.meas tran vdout0_33ck1200 FIND v(dout0_33) AT=605.025n

.meas tran vdout0_34ck1200 FIND v(dout0_34) AT=605.025n

.meas tran vdout0_35ck1200 FIND v(dout0_35) AT=605.025n

.meas tran vdout0_36ck1200 FIND v(dout0_36) AT=605.025n

.meas tran vdout0_37ck1200 FIND v(dout0_37) AT=605.025n

.meas tran vdout0_38ck1200 FIND v(dout0_38) AT=605.025n

.meas tran vdout0_39ck1200 FIND v(dout0_39) AT=605.025n

.meas tran vdout0_40ck1200 FIND v(dout0_40) AT=605.025n

.meas tran vdout0_41ck1200 FIND v(dout0_41) AT=605.025n

.meas tran vdout0_42ck1200 FIND v(dout0_42) AT=605.025n

.meas tran vdout0_43ck1200 FIND v(dout0_43) AT=605.025n

.meas tran vdout0_44ck1200 FIND v(dout0_44) AT=605.025n

.meas tran vdout0_45ck1200 FIND v(dout0_45) AT=605.025n

.meas tran vdout0_46ck1200 FIND v(dout0_46) AT=605.025n

.meas tran vdout0_47ck1200 FIND v(dout0_47) AT=605.025n

.meas tran vdout0_48ck1200 FIND v(dout0_48) AT=605.025n

.meas tran vdout0_49ck1200 FIND v(dout0_49) AT=605.025n

.meas tran vdout0_50ck1200 FIND v(dout0_50) AT=605.025n

.meas tran vdout0_51ck1200 FIND v(dout0_51) AT=605.025n

.meas tran vdout0_52ck1200 FIND v(dout0_52) AT=605.025n

.meas tran vdout0_53ck1200 FIND v(dout0_53) AT=605.025n

.meas tran vdout0_54ck1200 FIND v(dout0_54) AT=605.025n

.meas tran vdout0_55ck1200 FIND v(dout0_55) AT=605.025n

.meas tran vdout0_56ck1200 FIND v(dout0_56) AT=605.025n

.meas tran vdout0_57ck1200 FIND v(dout0_57) AT=605.025n

.meas tran vdout0_58ck1200 FIND v(dout0_58) AT=605.025n

.meas tran vdout0_59ck1200 FIND v(dout0_59) AT=605.025n

.meas tran vdout0_60ck1200 FIND v(dout0_60) AT=605.025n

.meas tran vdout0_61ck1200 FIND v(dout0_61) AT=605.025n

.meas tran vdout0_62ck1200 FIND v(dout0_62) AT=605.025n

.meas tran vdout0_63ck1200 FIND v(dout0_63) AT=605.025n

.meas tran vdout0_0ck1210 FIND v(dout0_0) AT=610.025n

.meas tran vdout0_1ck1210 FIND v(dout0_1) AT=610.025n

.meas tran vdout0_2ck1210 FIND v(dout0_2) AT=610.025n

.meas tran vdout0_3ck1210 FIND v(dout0_3) AT=610.025n

.meas tran vdout0_4ck1210 FIND v(dout0_4) AT=610.025n

.meas tran vdout0_5ck1210 FIND v(dout0_5) AT=610.025n

.meas tran vdout0_6ck1210 FIND v(dout0_6) AT=610.025n

.meas tran vdout0_7ck1210 FIND v(dout0_7) AT=610.025n

.meas tran vdout0_8ck1210 FIND v(dout0_8) AT=610.025n

.meas tran vdout0_9ck1210 FIND v(dout0_9) AT=610.025n

.meas tran vdout0_10ck1210 FIND v(dout0_10) AT=610.025n

.meas tran vdout0_11ck1210 FIND v(dout0_11) AT=610.025n

.meas tran vdout0_12ck1210 FIND v(dout0_12) AT=610.025n

.meas tran vdout0_13ck1210 FIND v(dout0_13) AT=610.025n

.meas tran vdout0_14ck1210 FIND v(dout0_14) AT=610.025n

.meas tran vdout0_15ck1210 FIND v(dout0_15) AT=610.025n

.meas tran vdout0_16ck1210 FIND v(dout0_16) AT=610.025n

.meas tran vdout0_17ck1210 FIND v(dout0_17) AT=610.025n

.meas tran vdout0_18ck1210 FIND v(dout0_18) AT=610.025n

.meas tran vdout0_19ck1210 FIND v(dout0_19) AT=610.025n

.meas tran vdout0_20ck1210 FIND v(dout0_20) AT=610.025n

.meas tran vdout0_21ck1210 FIND v(dout0_21) AT=610.025n

.meas tran vdout0_22ck1210 FIND v(dout0_22) AT=610.025n

.meas tran vdout0_23ck1210 FIND v(dout0_23) AT=610.025n

.meas tran vdout0_24ck1210 FIND v(dout0_24) AT=610.025n

.meas tran vdout0_25ck1210 FIND v(dout0_25) AT=610.025n

.meas tran vdout0_26ck1210 FIND v(dout0_26) AT=610.025n

.meas tran vdout0_27ck1210 FIND v(dout0_27) AT=610.025n

.meas tran vdout0_28ck1210 FIND v(dout0_28) AT=610.025n

.meas tran vdout0_29ck1210 FIND v(dout0_29) AT=610.025n

.meas tran vdout0_30ck1210 FIND v(dout0_30) AT=610.025n

.meas tran vdout0_31ck1210 FIND v(dout0_31) AT=610.025n

.meas tran vdout0_32ck1210 FIND v(dout0_32) AT=610.025n

.meas tran vdout0_33ck1210 FIND v(dout0_33) AT=610.025n

.meas tran vdout0_34ck1210 FIND v(dout0_34) AT=610.025n

.meas tran vdout0_35ck1210 FIND v(dout0_35) AT=610.025n

.meas tran vdout0_36ck1210 FIND v(dout0_36) AT=610.025n

.meas tran vdout0_37ck1210 FIND v(dout0_37) AT=610.025n

.meas tran vdout0_38ck1210 FIND v(dout0_38) AT=610.025n

.meas tran vdout0_39ck1210 FIND v(dout0_39) AT=610.025n

.meas tran vdout0_40ck1210 FIND v(dout0_40) AT=610.025n

.meas tran vdout0_41ck1210 FIND v(dout0_41) AT=610.025n

.meas tran vdout0_42ck1210 FIND v(dout0_42) AT=610.025n

.meas tran vdout0_43ck1210 FIND v(dout0_43) AT=610.025n

.meas tran vdout0_44ck1210 FIND v(dout0_44) AT=610.025n

.meas tran vdout0_45ck1210 FIND v(dout0_45) AT=610.025n

.meas tran vdout0_46ck1210 FIND v(dout0_46) AT=610.025n

.meas tran vdout0_47ck1210 FIND v(dout0_47) AT=610.025n

.meas tran vdout0_48ck1210 FIND v(dout0_48) AT=610.025n

.meas tran vdout0_49ck1210 FIND v(dout0_49) AT=610.025n

.meas tran vdout0_50ck1210 FIND v(dout0_50) AT=610.025n

.meas tran vdout0_51ck1210 FIND v(dout0_51) AT=610.025n

.meas tran vdout0_52ck1210 FIND v(dout0_52) AT=610.025n

.meas tran vdout0_53ck1210 FIND v(dout0_53) AT=610.025n

.meas tran vdout0_54ck1210 FIND v(dout0_54) AT=610.025n

.meas tran vdout0_55ck1210 FIND v(dout0_55) AT=610.025n

.meas tran vdout0_56ck1210 FIND v(dout0_56) AT=610.025n

.meas tran vdout0_57ck1210 FIND v(dout0_57) AT=610.025n

.meas tran vdout0_58ck1210 FIND v(dout0_58) AT=610.025n

.meas tran vdout0_59ck1210 FIND v(dout0_59) AT=610.025n

.meas tran vdout0_60ck1210 FIND v(dout0_60) AT=610.025n

.meas tran vdout0_61ck1210 FIND v(dout0_61) AT=610.025n

.meas tran vdout0_62ck1210 FIND v(dout0_62) AT=610.025n

.meas tran vdout0_63ck1210 FIND v(dout0_63) AT=610.025n

.meas tran vdout0_0ck1220 FIND v(dout0_0) AT=615.025n

.meas tran vdout0_1ck1220 FIND v(dout0_1) AT=615.025n

.meas tran vdout0_2ck1220 FIND v(dout0_2) AT=615.025n

.meas tran vdout0_3ck1220 FIND v(dout0_3) AT=615.025n

.meas tran vdout0_4ck1220 FIND v(dout0_4) AT=615.025n

.meas tran vdout0_5ck1220 FIND v(dout0_5) AT=615.025n

.meas tran vdout0_6ck1220 FIND v(dout0_6) AT=615.025n

.meas tran vdout0_7ck1220 FIND v(dout0_7) AT=615.025n

.meas tran vdout0_8ck1220 FIND v(dout0_8) AT=615.025n

.meas tran vdout0_9ck1220 FIND v(dout0_9) AT=615.025n

.meas tran vdout0_10ck1220 FIND v(dout0_10) AT=615.025n

.meas tran vdout0_11ck1220 FIND v(dout0_11) AT=615.025n

.meas tran vdout0_12ck1220 FIND v(dout0_12) AT=615.025n

.meas tran vdout0_13ck1220 FIND v(dout0_13) AT=615.025n

.meas tran vdout0_14ck1220 FIND v(dout0_14) AT=615.025n

.meas tran vdout0_15ck1220 FIND v(dout0_15) AT=615.025n

.meas tran vdout0_16ck1220 FIND v(dout0_16) AT=615.025n

.meas tran vdout0_17ck1220 FIND v(dout0_17) AT=615.025n

.meas tran vdout0_18ck1220 FIND v(dout0_18) AT=615.025n

.meas tran vdout0_19ck1220 FIND v(dout0_19) AT=615.025n

.meas tran vdout0_20ck1220 FIND v(dout0_20) AT=615.025n

.meas tran vdout0_21ck1220 FIND v(dout0_21) AT=615.025n

.meas tran vdout0_22ck1220 FIND v(dout0_22) AT=615.025n

.meas tran vdout0_23ck1220 FIND v(dout0_23) AT=615.025n

.meas tran vdout0_24ck1220 FIND v(dout0_24) AT=615.025n

.meas tran vdout0_25ck1220 FIND v(dout0_25) AT=615.025n

.meas tran vdout0_26ck1220 FIND v(dout0_26) AT=615.025n

.meas tran vdout0_27ck1220 FIND v(dout0_27) AT=615.025n

.meas tran vdout0_28ck1220 FIND v(dout0_28) AT=615.025n

.meas tran vdout0_29ck1220 FIND v(dout0_29) AT=615.025n

.meas tran vdout0_30ck1220 FIND v(dout0_30) AT=615.025n

.meas tran vdout0_31ck1220 FIND v(dout0_31) AT=615.025n

.meas tran vdout0_32ck1220 FIND v(dout0_32) AT=615.025n

.meas tran vdout0_33ck1220 FIND v(dout0_33) AT=615.025n

.meas tran vdout0_34ck1220 FIND v(dout0_34) AT=615.025n

.meas tran vdout0_35ck1220 FIND v(dout0_35) AT=615.025n

.meas tran vdout0_36ck1220 FIND v(dout0_36) AT=615.025n

.meas tran vdout0_37ck1220 FIND v(dout0_37) AT=615.025n

.meas tran vdout0_38ck1220 FIND v(dout0_38) AT=615.025n

.meas tran vdout0_39ck1220 FIND v(dout0_39) AT=615.025n

.meas tran vdout0_40ck1220 FIND v(dout0_40) AT=615.025n

.meas tran vdout0_41ck1220 FIND v(dout0_41) AT=615.025n

.meas tran vdout0_42ck1220 FIND v(dout0_42) AT=615.025n

.meas tran vdout0_43ck1220 FIND v(dout0_43) AT=615.025n

.meas tran vdout0_44ck1220 FIND v(dout0_44) AT=615.025n

.meas tran vdout0_45ck1220 FIND v(dout0_45) AT=615.025n

.meas tran vdout0_46ck1220 FIND v(dout0_46) AT=615.025n

.meas tran vdout0_47ck1220 FIND v(dout0_47) AT=615.025n

.meas tran vdout0_48ck1220 FIND v(dout0_48) AT=615.025n

.meas tran vdout0_49ck1220 FIND v(dout0_49) AT=615.025n

.meas tran vdout0_50ck1220 FIND v(dout0_50) AT=615.025n

.meas tran vdout0_51ck1220 FIND v(dout0_51) AT=615.025n

.meas tran vdout0_52ck1220 FIND v(dout0_52) AT=615.025n

.meas tran vdout0_53ck1220 FIND v(dout0_53) AT=615.025n

.meas tran vdout0_54ck1220 FIND v(dout0_54) AT=615.025n

.meas tran vdout0_55ck1220 FIND v(dout0_55) AT=615.025n

.meas tran vdout0_56ck1220 FIND v(dout0_56) AT=615.025n

.meas tran vdout0_57ck1220 FIND v(dout0_57) AT=615.025n

.meas tran vdout0_58ck1220 FIND v(dout0_58) AT=615.025n

.meas tran vdout0_59ck1220 FIND v(dout0_59) AT=615.025n

.meas tran vdout0_60ck1220 FIND v(dout0_60) AT=615.025n

.meas tran vdout0_61ck1220 FIND v(dout0_61) AT=615.025n

.meas tran vdout0_62ck1220 FIND v(dout0_62) AT=615.025n

.meas tran vdout0_63ck1220 FIND v(dout0_63) AT=615.025n

.meas tran vdout0_0ck1240 FIND v(dout0_0) AT=625.025n

.meas tran vdout0_1ck1240 FIND v(dout0_1) AT=625.025n

.meas tran vdout0_2ck1240 FIND v(dout0_2) AT=625.025n

.meas tran vdout0_3ck1240 FIND v(dout0_3) AT=625.025n

.meas tran vdout0_4ck1240 FIND v(dout0_4) AT=625.025n

.meas tran vdout0_5ck1240 FIND v(dout0_5) AT=625.025n

.meas tran vdout0_6ck1240 FIND v(dout0_6) AT=625.025n

.meas tran vdout0_7ck1240 FIND v(dout0_7) AT=625.025n

.meas tran vdout0_8ck1240 FIND v(dout0_8) AT=625.025n

.meas tran vdout0_9ck1240 FIND v(dout0_9) AT=625.025n

.meas tran vdout0_10ck1240 FIND v(dout0_10) AT=625.025n

.meas tran vdout0_11ck1240 FIND v(dout0_11) AT=625.025n

.meas tran vdout0_12ck1240 FIND v(dout0_12) AT=625.025n

.meas tran vdout0_13ck1240 FIND v(dout0_13) AT=625.025n

.meas tran vdout0_14ck1240 FIND v(dout0_14) AT=625.025n

.meas tran vdout0_15ck1240 FIND v(dout0_15) AT=625.025n

.meas tran vdout0_16ck1240 FIND v(dout0_16) AT=625.025n

.meas tran vdout0_17ck1240 FIND v(dout0_17) AT=625.025n

.meas tran vdout0_18ck1240 FIND v(dout0_18) AT=625.025n

.meas tran vdout0_19ck1240 FIND v(dout0_19) AT=625.025n

.meas tran vdout0_20ck1240 FIND v(dout0_20) AT=625.025n

.meas tran vdout0_21ck1240 FIND v(dout0_21) AT=625.025n

.meas tran vdout0_22ck1240 FIND v(dout0_22) AT=625.025n

.meas tran vdout0_23ck1240 FIND v(dout0_23) AT=625.025n

.meas tran vdout0_24ck1240 FIND v(dout0_24) AT=625.025n

.meas tran vdout0_25ck1240 FIND v(dout0_25) AT=625.025n

.meas tran vdout0_26ck1240 FIND v(dout0_26) AT=625.025n

.meas tran vdout0_27ck1240 FIND v(dout0_27) AT=625.025n

.meas tran vdout0_28ck1240 FIND v(dout0_28) AT=625.025n

.meas tran vdout0_29ck1240 FIND v(dout0_29) AT=625.025n

.meas tran vdout0_30ck1240 FIND v(dout0_30) AT=625.025n

.meas tran vdout0_31ck1240 FIND v(dout0_31) AT=625.025n

.meas tran vdout0_32ck1240 FIND v(dout0_32) AT=625.025n

.meas tran vdout0_33ck1240 FIND v(dout0_33) AT=625.025n

.meas tran vdout0_34ck1240 FIND v(dout0_34) AT=625.025n

.meas tran vdout0_35ck1240 FIND v(dout0_35) AT=625.025n

.meas tran vdout0_36ck1240 FIND v(dout0_36) AT=625.025n

.meas tran vdout0_37ck1240 FIND v(dout0_37) AT=625.025n

.meas tran vdout0_38ck1240 FIND v(dout0_38) AT=625.025n

.meas tran vdout0_39ck1240 FIND v(dout0_39) AT=625.025n

.meas tran vdout0_40ck1240 FIND v(dout0_40) AT=625.025n

.meas tran vdout0_41ck1240 FIND v(dout0_41) AT=625.025n

.meas tran vdout0_42ck1240 FIND v(dout0_42) AT=625.025n

.meas tran vdout0_43ck1240 FIND v(dout0_43) AT=625.025n

.meas tran vdout0_44ck1240 FIND v(dout0_44) AT=625.025n

.meas tran vdout0_45ck1240 FIND v(dout0_45) AT=625.025n

.meas tran vdout0_46ck1240 FIND v(dout0_46) AT=625.025n

.meas tran vdout0_47ck1240 FIND v(dout0_47) AT=625.025n

.meas tran vdout0_48ck1240 FIND v(dout0_48) AT=625.025n

.meas tran vdout0_49ck1240 FIND v(dout0_49) AT=625.025n

.meas tran vdout0_50ck1240 FIND v(dout0_50) AT=625.025n

.meas tran vdout0_51ck1240 FIND v(dout0_51) AT=625.025n

.meas tran vdout0_52ck1240 FIND v(dout0_52) AT=625.025n

.meas tran vdout0_53ck1240 FIND v(dout0_53) AT=625.025n

.meas tran vdout0_54ck1240 FIND v(dout0_54) AT=625.025n

.meas tran vdout0_55ck1240 FIND v(dout0_55) AT=625.025n

.meas tran vdout0_56ck1240 FIND v(dout0_56) AT=625.025n

.meas tran vdout0_57ck1240 FIND v(dout0_57) AT=625.025n

.meas tran vdout0_58ck1240 FIND v(dout0_58) AT=625.025n

.meas tran vdout0_59ck1240 FIND v(dout0_59) AT=625.025n

.meas tran vdout0_60ck1240 FIND v(dout0_60) AT=625.025n

.meas tran vdout0_61ck1240 FIND v(dout0_61) AT=625.025n

.meas tran vdout0_62ck1240 FIND v(dout0_62) AT=625.025n

.meas tran vdout0_63ck1240 FIND v(dout0_63) AT=625.025n

.meas tran vdout0_0ck1290 FIND v(dout0_0) AT=650.025n

.meas tran vdout0_1ck1290 FIND v(dout0_1) AT=650.025n

.meas tran vdout0_2ck1290 FIND v(dout0_2) AT=650.025n

.meas tran vdout0_3ck1290 FIND v(dout0_3) AT=650.025n

.meas tran vdout0_4ck1290 FIND v(dout0_4) AT=650.025n

.meas tran vdout0_5ck1290 FIND v(dout0_5) AT=650.025n

.meas tran vdout0_6ck1290 FIND v(dout0_6) AT=650.025n

.meas tran vdout0_7ck1290 FIND v(dout0_7) AT=650.025n

.meas tran vdout0_8ck1290 FIND v(dout0_8) AT=650.025n

.meas tran vdout0_9ck1290 FIND v(dout0_9) AT=650.025n

.meas tran vdout0_10ck1290 FIND v(dout0_10) AT=650.025n

.meas tran vdout0_11ck1290 FIND v(dout0_11) AT=650.025n

.meas tran vdout0_12ck1290 FIND v(dout0_12) AT=650.025n

.meas tran vdout0_13ck1290 FIND v(dout0_13) AT=650.025n

.meas tran vdout0_14ck1290 FIND v(dout0_14) AT=650.025n

.meas tran vdout0_15ck1290 FIND v(dout0_15) AT=650.025n

.meas tran vdout0_16ck1290 FIND v(dout0_16) AT=650.025n

.meas tran vdout0_17ck1290 FIND v(dout0_17) AT=650.025n

.meas tran vdout0_18ck1290 FIND v(dout0_18) AT=650.025n

.meas tran vdout0_19ck1290 FIND v(dout0_19) AT=650.025n

.meas tran vdout0_20ck1290 FIND v(dout0_20) AT=650.025n

.meas tran vdout0_21ck1290 FIND v(dout0_21) AT=650.025n

.meas tran vdout0_22ck1290 FIND v(dout0_22) AT=650.025n

.meas tran vdout0_23ck1290 FIND v(dout0_23) AT=650.025n

.meas tran vdout0_24ck1290 FIND v(dout0_24) AT=650.025n

.meas tran vdout0_25ck1290 FIND v(dout0_25) AT=650.025n

.meas tran vdout0_26ck1290 FIND v(dout0_26) AT=650.025n

.meas tran vdout0_27ck1290 FIND v(dout0_27) AT=650.025n

.meas tran vdout0_28ck1290 FIND v(dout0_28) AT=650.025n

.meas tran vdout0_29ck1290 FIND v(dout0_29) AT=650.025n

.meas tran vdout0_30ck1290 FIND v(dout0_30) AT=650.025n

.meas tran vdout0_31ck1290 FIND v(dout0_31) AT=650.025n

.meas tran vdout0_32ck1290 FIND v(dout0_32) AT=650.025n

.meas tran vdout0_33ck1290 FIND v(dout0_33) AT=650.025n

.meas tran vdout0_34ck1290 FIND v(dout0_34) AT=650.025n

.meas tran vdout0_35ck1290 FIND v(dout0_35) AT=650.025n

.meas tran vdout0_36ck1290 FIND v(dout0_36) AT=650.025n

.meas tran vdout0_37ck1290 FIND v(dout0_37) AT=650.025n

.meas tran vdout0_38ck1290 FIND v(dout0_38) AT=650.025n

.meas tran vdout0_39ck1290 FIND v(dout0_39) AT=650.025n

.meas tran vdout0_40ck1290 FIND v(dout0_40) AT=650.025n

.meas tran vdout0_41ck1290 FIND v(dout0_41) AT=650.025n

.meas tran vdout0_42ck1290 FIND v(dout0_42) AT=650.025n

.meas tran vdout0_43ck1290 FIND v(dout0_43) AT=650.025n

.meas tran vdout0_44ck1290 FIND v(dout0_44) AT=650.025n

.meas tran vdout0_45ck1290 FIND v(dout0_45) AT=650.025n

.meas tran vdout0_46ck1290 FIND v(dout0_46) AT=650.025n

.meas tran vdout0_47ck1290 FIND v(dout0_47) AT=650.025n

.meas tran vdout0_48ck1290 FIND v(dout0_48) AT=650.025n

.meas tran vdout0_49ck1290 FIND v(dout0_49) AT=650.025n

.meas tran vdout0_50ck1290 FIND v(dout0_50) AT=650.025n

.meas tran vdout0_51ck1290 FIND v(dout0_51) AT=650.025n

.meas tran vdout0_52ck1290 FIND v(dout0_52) AT=650.025n

.meas tran vdout0_53ck1290 FIND v(dout0_53) AT=650.025n

.meas tran vdout0_54ck1290 FIND v(dout0_54) AT=650.025n

.meas tran vdout0_55ck1290 FIND v(dout0_55) AT=650.025n

.meas tran vdout0_56ck1290 FIND v(dout0_56) AT=650.025n

.meas tran vdout0_57ck1290 FIND v(dout0_57) AT=650.025n

.meas tran vdout0_58ck1290 FIND v(dout0_58) AT=650.025n

.meas tran vdout0_59ck1290 FIND v(dout0_59) AT=650.025n

.meas tran vdout0_60ck1290 FIND v(dout0_60) AT=650.025n

.meas tran vdout0_61ck1290 FIND v(dout0_61) AT=650.025n

.meas tran vdout0_62ck1290 FIND v(dout0_62) AT=650.025n

.meas tran vdout0_63ck1290 FIND v(dout0_63) AT=650.025n

.meas tran vdout0_0ck1300 FIND v(dout0_0) AT=655.025n

.meas tran vdout0_1ck1300 FIND v(dout0_1) AT=655.025n

.meas tran vdout0_2ck1300 FIND v(dout0_2) AT=655.025n

.meas tran vdout0_3ck1300 FIND v(dout0_3) AT=655.025n

.meas tran vdout0_4ck1300 FIND v(dout0_4) AT=655.025n

.meas tran vdout0_5ck1300 FIND v(dout0_5) AT=655.025n

.meas tran vdout0_6ck1300 FIND v(dout0_6) AT=655.025n

.meas tran vdout0_7ck1300 FIND v(dout0_7) AT=655.025n

.meas tran vdout0_8ck1300 FIND v(dout0_8) AT=655.025n

.meas tran vdout0_9ck1300 FIND v(dout0_9) AT=655.025n

.meas tran vdout0_10ck1300 FIND v(dout0_10) AT=655.025n

.meas tran vdout0_11ck1300 FIND v(dout0_11) AT=655.025n

.meas tran vdout0_12ck1300 FIND v(dout0_12) AT=655.025n

.meas tran vdout0_13ck1300 FIND v(dout0_13) AT=655.025n

.meas tran vdout0_14ck1300 FIND v(dout0_14) AT=655.025n

.meas tran vdout0_15ck1300 FIND v(dout0_15) AT=655.025n

.meas tran vdout0_16ck1300 FIND v(dout0_16) AT=655.025n

.meas tran vdout0_17ck1300 FIND v(dout0_17) AT=655.025n

.meas tran vdout0_18ck1300 FIND v(dout0_18) AT=655.025n

.meas tran vdout0_19ck1300 FIND v(dout0_19) AT=655.025n

.meas tran vdout0_20ck1300 FIND v(dout0_20) AT=655.025n

.meas tran vdout0_21ck1300 FIND v(dout0_21) AT=655.025n

.meas tran vdout0_22ck1300 FIND v(dout0_22) AT=655.025n

.meas tran vdout0_23ck1300 FIND v(dout0_23) AT=655.025n

.meas tran vdout0_24ck1300 FIND v(dout0_24) AT=655.025n

.meas tran vdout0_25ck1300 FIND v(dout0_25) AT=655.025n

.meas tran vdout0_26ck1300 FIND v(dout0_26) AT=655.025n

.meas tran vdout0_27ck1300 FIND v(dout0_27) AT=655.025n

.meas tran vdout0_28ck1300 FIND v(dout0_28) AT=655.025n

.meas tran vdout0_29ck1300 FIND v(dout0_29) AT=655.025n

.meas tran vdout0_30ck1300 FIND v(dout0_30) AT=655.025n

.meas tran vdout0_31ck1300 FIND v(dout0_31) AT=655.025n

.meas tran vdout0_32ck1300 FIND v(dout0_32) AT=655.025n

.meas tran vdout0_33ck1300 FIND v(dout0_33) AT=655.025n

.meas tran vdout0_34ck1300 FIND v(dout0_34) AT=655.025n

.meas tran vdout0_35ck1300 FIND v(dout0_35) AT=655.025n

.meas tran vdout0_36ck1300 FIND v(dout0_36) AT=655.025n

.meas tran vdout0_37ck1300 FIND v(dout0_37) AT=655.025n

.meas tran vdout0_38ck1300 FIND v(dout0_38) AT=655.025n

.meas tran vdout0_39ck1300 FIND v(dout0_39) AT=655.025n

.meas tran vdout0_40ck1300 FIND v(dout0_40) AT=655.025n

.meas tran vdout0_41ck1300 FIND v(dout0_41) AT=655.025n

.meas tran vdout0_42ck1300 FIND v(dout0_42) AT=655.025n

.meas tran vdout0_43ck1300 FIND v(dout0_43) AT=655.025n

.meas tran vdout0_44ck1300 FIND v(dout0_44) AT=655.025n

.meas tran vdout0_45ck1300 FIND v(dout0_45) AT=655.025n

.meas tran vdout0_46ck1300 FIND v(dout0_46) AT=655.025n

.meas tran vdout0_47ck1300 FIND v(dout0_47) AT=655.025n

.meas tran vdout0_48ck1300 FIND v(dout0_48) AT=655.025n

.meas tran vdout0_49ck1300 FIND v(dout0_49) AT=655.025n

.meas tran vdout0_50ck1300 FIND v(dout0_50) AT=655.025n

.meas tran vdout0_51ck1300 FIND v(dout0_51) AT=655.025n

.meas tran vdout0_52ck1300 FIND v(dout0_52) AT=655.025n

.meas tran vdout0_53ck1300 FIND v(dout0_53) AT=655.025n

.meas tran vdout0_54ck1300 FIND v(dout0_54) AT=655.025n

.meas tran vdout0_55ck1300 FIND v(dout0_55) AT=655.025n

.meas tran vdout0_56ck1300 FIND v(dout0_56) AT=655.025n

.meas tran vdout0_57ck1300 FIND v(dout0_57) AT=655.025n

.meas tran vdout0_58ck1300 FIND v(dout0_58) AT=655.025n

.meas tran vdout0_59ck1300 FIND v(dout0_59) AT=655.025n

.meas tran vdout0_60ck1300 FIND v(dout0_60) AT=655.025n

.meas tran vdout0_61ck1300 FIND v(dout0_61) AT=655.025n

.meas tran vdout0_62ck1300 FIND v(dout0_62) AT=655.025n

.meas tran vdout0_63ck1300 FIND v(dout0_63) AT=655.025n

.meas tran vdout0_0ck1350 FIND v(dout0_0) AT=680.025n

.meas tran vdout0_1ck1350 FIND v(dout0_1) AT=680.025n

.meas tran vdout0_2ck1350 FIND v(dout0_2) AT=680.025n

.meas tran vdout0_3ck1350 FIND v(dout0_3) AT=680.025n

.meas tran vdout0_4ck1350 FIND v(dout0_4) AT=680.025n

.meas tran vdout0_5ck1350 FIND v(dout0_5) AT=680.025n

.meas tran vdout0_6ck1350 FIND v(dout0_6) AT=680.025n

.meas tran vdout0_7ck1350 FIND v(dout0_7) AT=680.025n

.meas tran vdout0_8ck1350 FIND v(dout0_8) AT=680.025n

.meas tran vdout0_9ck1350 FIND v(dout0_9) AT=680.025n

.meas tran vdout0_10ck1350 FIND v(dout0_10) AT=680.025n

.meas tran vdout0_11ck1350 FIND v(dout0_11) AT=680.025n

.meas tran vdout0_12ck1350 FIND v(dout0_12) AT=680.025n

.meas tran vdout0_13ck1350 FIND v(dout0_13) AT=680.025n

.meas tran vdout0_14ck1350 FIND v(dout0_14) AT=680.025n

.meas tran vdout0_15ck1350 FIND v(dout0_15) AT=680.025n

.meas tran vdout0_16ck1350 FIND v(dout0_16) AT=680.025n

.meas tran vdout0_17ck1350 FIND v(dout0_17) AT=680.025n

.meas tran vdout0_18ck1350 FIND v(dout0_18) AT=680.025n

.meas tran vdout0_19ck1350 FIND v(dout0_19) AT=680.025n

.meas tran vdout0_20ck1350 FIND v(dout0_20) AT=680.025n

.meas tran vdout0_21ck1350 FIND v(dout0_21) AT=680.025n

.meas tran vdout0_22ck1350 FIND v(dout0_22) AT=680.025n

.meas tran vdout0_23ck1350 FIND v(dout0_23) AT=680.025n

.meas tran vdout0_24ck1350 FIND v(dout0_24) AT=680.025n

.meas tran vdout0_25ck1350 FIND v(dout0_25) AT=680.025n

.meas tran vdout0_26ck1350 FIND v(dout0_26) AT=680.025n

.meas tran vdout0_27ck1350 FIND v(dout0_27) AT=680.025n

.meas tran vdout0_28ck1350 FIND v(dout0_28) AT=680.025n

.meas tran vdout0_29ck1350 FIND v(dout0_29) AT=680.025n

.meas tran vdout0_30ck1350 FIND v(dout0_30) AT=680.025n

.meas tran vdout0_31ck1350 FIND v(dout0_31) AT=680.025n

.meas tran vdout0_32ck1350 FIND v(dout0_32) AT=680.025n

.meas tran vdout0_33ck1350 FIND v(dout0_33) AT=680.025n

.meas tran vdout0_34ck1350 FIND v(dout0_34) AT=680.025n

.meas tran vdout0_35ck1350 FIND v(dout0_35) AT=680.025n

.meas tran vdout0_36ck1350 FIND v(dout0_36) AT=680.025n

.meas tran vdout0_37ck1350 FIND v(dout0_37) AT=680.025n

.meas tran vdout0_38ck1350 FIND v(dout0_38) AT=680.025n

.meas tran vdout0_39ck1350 FIND v(dout0_39) AT=680.025n

.meas tran vdout0_40ck1350 FIND v(dout0_40) AT=680.025n

.meas tran vdout0_41ck1350 FIND v(dout0_41) AT=680.025n

.meas tran vdout0_42ck1350 FIND v(dout0_42) AT=680.025n

.meas tran vdout0_43ck1350 FIND v(dout0_43) AT=680.025n

.meas tran vdout0_44ck1350 FIND v(dout0_44) AT=680.025n

.meas tran vdout0_45ck1350 FIND v(dout0_45) AT=680.025n

.meas tran vdout0_46ck1350 FIND v(dout0_46) AT=680.025n

.meas tran vdout0_47ck1350 FIND v(dout0_47) AT=680.025n

.meas tran vdout0_48ck1350 FIND v(dout0_48) AT=680.025n

.meas tran vdout0_49ck1350 FIND v(dout0_49) AT=680.025n

.meas tran vdout0_50ck1350 FIND v(dout0_50) AT=680.025n

.meas tran vdout0_51ck1350 FIND v(dout0_51) AT=680.025n

.meas tran vdout0_52ck1350 FIND v(dout0_52) AT=680.025n

.meas tran vdout0_53ck1350 FIND v(dout0_53) AT=680.025n

.meas tran vdout0_54ck1350 FIND v(dout0_54) AT=680.025n

.meas tran vdout0_55ck1350 FIND v(dout0_55) AT=680.025n

.meas tran vdout0_56ck1350 FIND v(dout0_56) AT=680.025n

.meas tran vdout0_57ck1350 FIND v(dout0_57) AT=680.025n

.meas tran vdout0_58ck1350 FIND v(dout0_58) AT=680.025n

.meas tran vdout0_59ck1350 FIND v(dout0_59) AT=680.025n

.meas tran vdout0_60ck1350 FIND v(dout0_60) AT=680.025n

.meas tran vdout0_61ck1350 FIND v(dout0_61) AT=680.025n

.meas tran vdout0_62ck1350 FIND v(dout0_62) AT=680.025n

.meas tran vdout0_63ck1350 FIND v(dout0_63) AT=680.025n

.meas tran vdout0_0ck1360 FIND v(dout0_0) AT=685.025n

.meas tran vdout0_1ck1360 FIND v(dout0_1) AT=685.025n

.meas tran vdout0_2ck1360 FIND v(dout0_2) AT=685.025n

.meas tran vdout0_3ck1360 FIND v(dout0_3) AT=685.025n

.meas tran vdout0_4ck1360 FIND v(dout0_4) AT=685.025n

.meas tran vdout0_5ck1360 FIND v(dout0_5) AT=685.025n

.meas tran vdout0_6ck1360 FIND v(dout0_6) AT=685.025n

.meas tran vdout0_7ck1360 FIND v(dout0_7) AT=685.025n

.meas tran vdout0_8ck1360 FIND v(dout0_8) AT=685.025n

.meas tran vdout0_9ck1360 FIND v(dout0_9) AT=685.025n

.meas tran vdout0_10ck1360 FIND v(dout0_10) AT=685.025n

.meas tran vdout0_11ck1360 FIND v(dout0_11) AT=685.025n

.meas tran vdout0_12ck1360 FIND v(dout0_12) AT=685.025n

.meas tran vdout0_13ck1360 FIND v(dout0_13) AT=685.025n

.meas tran vdout0_14ck1360 FIND v(dout0_14) AT=685.025n

.meas tran vdout0_15ck1360 FIND v(dout0_15) AT=685.025n

.meas tran vdout0_16ck1360 FIND v(dout0_16) AT=685.025n

.meas tran vdout0_17ck1360 FIND v(dout0_17) AT=685.025n

.meas tran vdout0_18ck1360 FIND v(dout0_18) AT=685.025n

.meas tran vdout0_19ck1360 FIND v(dout0_19) AT=685.025n

.meas tran vdout0_20ck1360 FIND v(dout0_20) AT=685.025n

.meas tran vdout0_21ck1360 FIND v(dout0_21) AT=685.025n

.meas tran vdout0_22ck1360 FIND v(dout0_22) AT=685.025n

.meas tran vdout0_23ck1360 FIND v(dout0_23) AT=685.025n

.meas tran vdout0_24ck1360 FIND v(dout0_24) AT=685.025n

.meas tran vdout0_25ck1360 FIND v(dout0_25) AT=685.025n

.meas tran vdout0_26ck1360 FIND v(dout0_26) AT=685.025n

.meas tran vdout0_27ck1360 FIND v(dout0_27) AT=685.025n

.meas tran vdout0_28ck1360 FIND v(dout0_28) AT=685.025n

.meas tran vdout0_29ck1360 FIND v(dout0_29) AT=685.025n

.meas tran vdout0_30ck1360 FIND v(dout0_30) AT=685.025n

.meas tran vdout0_31ck1360 FIND v(dout0_31) AT=685.025n

.meas tran vdout0_32ck1360 FIND v(dout0_32) AT=685.025n

.meas tran vdout0_33ck1360 FIND v(dout0_33) AT=685.025n

.meas tran vdout0_34ck1360 FIND v(dout0_34) AT=685.025n

.meas tran vdout0_35ck1360 FIND v(dout0_35) AT=685.025n

.meas tran vdout0_36ck1360 FIND v(dout0_36) AT=685.025n

.meas tran vdout0_37ck1360 FIND v(dout0_37) AT=685.025n

.meas tran vdout0_38ck1360 FIND v(dout0_38) AT=685.025n

.meas tran vdout0_39ck1360 FIND v(dout0_39) AT=685.025n

.meas tran vdout0_40ck1360 FIND v(dout0_40) AT=685.025n

.meas tran vdout0_41ck1360 FIND v(dout0_41) AT=685.025n

.meas tran vdout0_42ck1360 FIND v(dout0_42) AT=685.025n

.meas tran vdout0_43ck1360 FIND v(dout0_43) AT=685.025n

.meas tran vdout0_44ck1360 FIND v(dout0_44) AT=685.025n

.meas tran vdout0_45ck1360 FIND v(dout0_45) AT=685.025n

.meas tran vdout0_46ck1360 FIND v(dout0_46) AT=685.025n

.meas tran vdout0_47ck1360 FIND v(dout0_47) AT=685.025n

.meas tran vdout0_48ck1360 FIND v(dout0_48) AT=685.025n

.meas tran vdout0_49ck1360 FIND v(dout0_49) AT=685.025n

.meas tran vdout0_50ck1360 FIND v(dout0_50) AT=685.025n

.meas tran vdout0_51ck1360 FIND v(dout0_51) AT=685.025n

.meas tran vdout0_52ck1360 FIND v(dout0_52) AT=685.025n

.meas tran vdout0_53ck1360 FIND v(dout0_53) AT=685.025n

.meas tran vdout0_54ck1360 FIND v(dout0_54) AT=685.025n

.meas tran vdout0_55ck1360 FIND v(dout0_55) AT=685.025n

.meas tran vdout0_56ck1360 FIND v(dout0_56) AT=685.025n

.meas tran vdout0_57ck1360 FIND v(dout0_57) AT=685.025n

.meas tran vdout0_58ck1360 FIND v(dout0_58) AT=685.025n

.meas tran vdout0_59ck1360 FIND v(dout0_59) AT=685.025n

.meas tran vdout0_60ck1360 FIND v(dout0_60) AT=685.025n

.meas tran vdout0_61ck1360 FIND v(dout0_61) AT=685.025n

.meas tran vdout0_62ck1360 FIND v(dout0_62) AT=685.025n

.meas tran vdout0_63ck1360 FIND v(dout0_63) AT=685.025n

.meas tran vdout0_0ck1370 FIND v(dout0_0) AT=690.025n

.meas tran vdout0_1ck1370 FIND v(dout0_1) AT=690.025n

.meas tran vdout0_2ck1370 FIND v(dout0_2) AT=690.025n

.meas tran vdout0_3ck1370 FIND v(dout0_3) AT=690.025n

.meas tran vdout0_4ck1370 FIND v(dout0_4) AT=690.025n

.meas tran vdout0_5ck1370 FIND v(dout0_5) AT=690.025n

.meas tran vdout0_6ck1370 FIND v(dout0_6) AT=690.025n

.meas tran vdout0_7ck1370 FIND v(dout0_7) AT=690.025n

.meas tran vdout0_8ck1370 FIND v(dout0_8) AT=690.025n

.meas tran vdout0_9ck1370 FIND v(dout0_9) AT=690.025n

.meas tran vdout0_10ck1370 FIND v(dout0_10) AT=690.025n

.meas tran vdout0_11ck1370 FIND v(dout0_11) AT=690.025n

.meas tran vdout0_12ck1370 FIND v(dout0_12) AT=690.025n

.meas tran vdout0_13ck1370 FIND v(dout0_13) AT=690.025n

.meas tran vdout0_14ck1370 FIND v(dout0_14) AT=690.025n

.meas tran vdout0_15ck1370 FIND v(dout0_15) AT=690.025n

.meas tran vdout0_16ck1370 FIND v(dout0_16) AT=690.025n

.meas tran vdout0_17ck1370 FIND v(dout0_17) AT=690.025n

.meas tran vdout0_18ck1370 FIND v(dout0_18) AT=690.025n

.meas tran vdout0_19ck1370 FIND v(dout0_19) AT=690.025n

.meas tran vdout0_20ck1370 FIND v(dout0_20) AT=690.025n

.meas tran vdout0_21ck1370 FIND v(dout0_21) AT=690.025n

.meas tran vdout0_22ck1370 FIND v(dout0_22) AT=690.025n

.meas tran vdout0_23ck1370 FIND v(dout0_23) AT=690.025n

.meas tran vdout0_24ck1370 FIND v(dout0_24) AT=690.025n

.meas tran vdout0_25ck1370 FIND v(dout0_25) AT=690.025n

.meas tran vdout0_26ck1370 FIND v(dout0_26) AT=690.025n

.meas tran vdout0_27ck1370 FIND v(dout0_27) AT=690.025n

.meas tran vdout0_28ck1370 FIND v(dout0_28) AT=690.025n

.meas tran vdout0_29ck1370 FIND v(dout0_29) AT=690.025n

.meas tran vdout0_30ck1370 FIND v(dout0_30) AT=690.025n

.meas tran vdout0_31ck1370 FIND v(dout0_31) AT=690.025n

.meas tran vdout0_32ck1370 FIND v(dout0_32) AT=690.025n

.meas tran vdout0_33ck1370 FIND v(dout0_33) AT=690.025n

.meas tran vdout0_34ck1370 FIND v(dout0_34) AT=690.025n

.meas tran vdout0_35ck1370 FIND v(dout0_35) AT=690.025n

.meas tran vdout0_36ck1370 FIND v(dout0_36) AT=690.025n

.meas tran vdout0_37ck1370 FIND v(dout0_37) AT=690.025n

.meas tran vdout0_38ck1370 FIND v(dout0_38) AT=690.025n

.meas tran vdout0_39ck1370 FIND v(dout0_39) AT=690.025n

.meas tran vdout0_40ck1370 FIND v(dout0_40) AT=690.025n

.meas tran vdout0_41ck1370 FIND v(dout0_41) AT=690.025n

.meas tran vdout0_42ck1370 FIND v(dout0_42) AT=690.025n

.meas tran vdout0_43ck1370 FIND v(dout0_43) AT=690.025n

.meas tran vdout0_44ck1370 FIND v(dout0_44) AT=690.025n

.meas tran vdout0_45ck1370 FIND v(dout0_45) AT=690.025n

.meas tran vdout0_46ck1370 FIND v(dout0_46) AT=690.025n

.meas tran vdout0_47ck1370 FIND v(dout0_47) AT=690.025n

.meas tran vdout0_48ck1370 FIND v(dout0_48) AT=690.025n

.meas tran vdout0_49ck1370 FIND v(dout0_49) AT=690.025n

.meas tran vdout0_50ck1370 FIND v(dout0_50) AT=690.025n

.meas tran vdout0_51ck1370 FIND v(dout0_51) AT=690.025n

.meas tran vdout0_52ck1370 FIND v(dout0_52) AT=690.025n

.meas tran vdout0_53ck1370 FIND v(dout0_53) AT=690.025n

.meas tran vdout0_54ck1370 FIND v(dout0_54) AT=690.025n

.meas tran vdout0_55ck1370 FIND v(dout0_55) AT=690.025n

.meas tran vdout0_56ck1370 FIND v(dout0_56) AT=690.025n

.meas tran vdout0_57ck1370 FIND v(dout0_57) AT=690.025n

.meas tran vdout0_58ck1370 FIND v(dout0_58) AT=690.025n

.meas tran vdout0_59ck1370 FIND v(dout0_59) AT=690.025n

.meas tran vdout0_60ck1370 FIND v(dout0_60) AT=690.025n

.meas tran vdout0_61ck1370 FIND v(dout0_61) AT=690.025n

.meas tran vdout0_62ck1370 FIND v(dout0_62) AT=690.025n

.meas tran vdout0_63ck1370 FIND v(dout0_63) AT=690.025n

.meas tran vdout0_0ck1380 FIND v(dout0_0) AT=695.025n

.meas tran vdout0_1ck1380 FIND v(dout0_1) AT=695.025n

.meas tran vdout0_2ck1380 FIND v(dout0_2) AT=695.025n

.meas tran vdout0_3ck1380 FIND v(dout0_3) AT=695.025n

.meas tran vdout0_4ck1380 FIND v(dout0_4) AT=695.025n

.meas tran vdout0_5ck1380 FIND v(dout0_5) AT=695.025n

.meas tran vdout0_6ck1380 FIND v(dout0_6) AT=695.025n

.meas tran vdout0_7ck1380 FIND v(dout0_7) AT=695.025n

.meas tran vdout0_8ck1380 FIND v(dout0_8) AT=695.025n

.meas tran vdout0_9ck1380 FIND v(dout0_9) AT=695.025n

.meas tran vdout0_10ck1380 FIND v(dout0_10) AT=695.025n

.meas tran vdout0_11ck1380 FIND v(dout0_11) AT=695.025n

.meas tran vdout0_12ck1380 FIND v(dout0_12) AT=695.025n

.meas tran vdout0_13ck1380 FIND v(dout0_13) AT=695.025n

.meas tran vdout0_14ck1380 FIND v(dout0_14) AT=695.025n

.meas tran vdout0_15ck1380 FIND v(dout0_15) AT=695.025n

.meas tran vdout0_16ck1380 FIND v(dout0_16) AT=695.025n

.meas tran vdout0_17ck1380 FIND v(dout0_17) AT=695.025n

.meas tran vdout0_18ck1380 FIND v(dout0_18) AT=695.025n

.meas tran vdout0_19ck1380 FIND v(dout0_19) AT=695.025n

.meas tran vdout0_20ck1380 FIND v(dout0_20) AT=695.025n

.meas tran vdout0_21ck1380 FIND v(dout0_21) AT=695.025n

.meas tran vdout0_22ck1380 FIND v(dout0_22) AT=695.025n

.meas tran vdout0_23ck1380 FIND v(dout0_23) AT=695.025n

.meas tran vdout0_24ck1380 FIND v(dout0_24) AT=695.025n

.meas tran vdout0_25ck1380 FIND v(dout0_25) AT=695.025n

.meas tran vdout0_26ck1380 FIND v(dout0_26) AT=695.025n

.meas tran vdout0_27ck1380 FIND v(dout0_27) AT=695.025n

.meas tran vdout0_28ck1380 FIND v(dout0_28) AT=695.025n

.meas tran vdout0_29ck1380 FIND v(dout0_29) AT=695.025n

.meas tran vdout0_30ck1380 FIND v(dout0_30) AT=695.025n

.meas tran vdout0_31ck1380 FIND v(dout0_31) AT=695.025n

.meas tran vdout0_32ck1380 FIND v(dout0_32) AT=695.025n

.meas tran vdout0_33ck1380 FIND v(dout0_33) AT=695.025n

.meas tran vdout0_34ck1380 FIND v(dout0_34) AT=695.025n

.meas tran vdout0_35ck1380 FIND v(dout0_35) AT=695.025n

.meas tran vdout0_36ck1380 FIND v(dout0_36) AT=695.025n

.meas tran vdout0_37ck1380 FIND v(dout0_37) AT=695.025n

.meas tran vdout0_38ck1380 FIND v(dout0_38) AT=695.025n

.meas tran vdout0_39ck1380 FIND v(dout0_39) AT=695.025n

.meas tran vdout0_40ck1380 FIND v(dout0_40) AT=695.025n

.meas tran vdout0_41ck1380 FIND v(dout0_41) AT=695.025n

.meas tran vdout0_42ck1380 FIND v(dout0_42) AT=695.025n

.meas tran vdout0_43ck1380 FIND v(dout0_43) AT=695.025n

.meas tran vdout0_44ck1380 FIND v(dout0_44) AT=695.025n

.meas tran vdout0_45ck1380 FIND v(dout0_45) AT=695.025n

.meas tran vdout0_46ck1380 FIND v(dout0_46) AT=695.025n

.meas tran vdout0_47ck1380 FIND v(dout0_47) AT=695.025n

.meas tran vdout0_48ck1380 FIND v(dout0_48) AT=695.025n

.meas tran vdout0_49ck1380 FIND v(dout0_49) AT=695.025n

.meas tran vdout0_50ck1380 FIND v(dout0_50) AT=695.025n

.meas tran vdout0_51ck1380 FIND v(dout0_51) AT=695.025n

.meas tran vdout0_52ck1380 FIND v(dout0_52) AT=695.025n

.meas tran vdout0_53ck1380 FIND v(dout0_53) AT=695.025n

.meas tran vdout0_54ck1380 FIND v(dout0_54) AT=695.025n

.meas tran vdout0_55ck1380 FIND v(dout0_55) AT=695.025n

.meas tran vdout0_56ck1380 FIND v(dout0_56) AT=695.025n

.meas tran vdout0_57ck1380 FIND v(dout0_57) AT=695.025n

.meas tran vdout0_58ck1380 FIND v(dout0_58) AT=695.025n

.meas tran vdout0_59ck1380 FIND v(dout0_59) AT=695.025n

.meas tran vdout0_60ck1380 FIND v(dout0_60) AT=695.025n

.meas tran vdout0_61ck1380 FIND v(dout0_61) AT=695.025n

.meas tran vdout0_62ck1380 FIND v(dout0_62) AT=695.025n

.meas tran vdout0_63ck1380 FIND v(dout0_63) AT=695.025n

.meas tran vdout0_0ck1390 FIND v(dout0_0) AT=700.025n

.meas tran vdout0_1ck1390 FIND v(dout0_1) AT=700.025n

.meas tran vdout0_2ck1390 FIND v(dout0_2) AT=700.025n

.meas tran vdout0_3ck1390 FIND v(dout0_3) AT=700.025n

.meas tran vdout0_4ck1390 FIND v(dout0_4) AT=700.025n

.meas tran vdout0_5ck1390 FIND v(dout0_5) AT=700.025n

.meas tran vdout0_6ck1390 FIND v(dout0_6) AT=700.025n

.meas tran vdout0_7ck1390 FIND v(dout0_7) AT=700.025n

.meas tran vdout0_8ck1390 FIND v(dout0_8) AT=700.025n

.meas tran vdout0_9ck1390 FIND v(dout0_9) AT=700.025n

.meas tran vdout0_10ck1390 FIND v(dout0_10) AT=700.025n

.meas tran vdout0_11ck1390 FIND v(dout0_11) AT=700.025n

.meas tran vdout0_12ck1390 FIND v(dout0_12) AT=700.025n

.meas tran vdout0_13ck1390 FIND v(dout0_13) AT=700.025n

.meas tran vdout0_14ck1390 FIND v(dout0_14) AT=700.025n

.meas tran vdout0_15ck1390 FIND v(dout0_15) AT=700.025n

.meas tran vdout0_16ck1390 FIND v(dout0_16) AT=700.025n

.meas tran vdout0_17ck1390 FIND v(dout0_17) AT=700.025n

.meas tran vdout0_18ck1390 FIND v(dout0_18) AT=700.025n

.meas tran vdout0_19ck1390 FIND v(dout0_19) AT=700.025n

.meas tran vdout0_20ck1390 FIND v(dout0_20) AT=700.025n

.meas tran vdout0_21ck1390 FIND v(dout0_21) AT=700.025n

.meas tran vdout0_22ck1390 FIND v(dout0_22) AT=700.025n

.meas tran vdout0_23ck1390 FIND v(dout0_23) AT=700.025n

.meas tran vdout0_24ck1390 FIND v(dout0_24) AT=700.025n

.meas tran vdout0_25ck1390 FIND v(dout0_25) AT=700.025n

.meas tran vdout0_26ck1390 FIND v(dout0_26) AT=700.025n

.meas tran vdout0_27ck1390 FIND v(dout0_27) AT=700.025n

.meas tran vdout0_28ck1390 FIND v(dout0_28) AT=700.025n

.meas tran vdout0_29ck1390 FIND v(dout0_29) AT=700.025n

.meas tran vdout0_30ck1390 FIND v(dout0_30) AT=700.025n

.meas tran vdout0_31ck1390 FIND v(dout0_31) AT=700.025n

.meas tran vdout0_32ck1390 FIND v(dout0_32) AT=700.025n

.meas tran vdout0_33ck1390 FIND v(dout0_33) AT=700.025n

.meas tran vdout0_34ck1390 FIND v(dout0_34) AT=700.025n

.meas tran vdout0_35ck1390 FIND v(dout0_35) AT=700.025n

.meas tran vdout0_36ck1390 FIND v(dout0_36) AT=700.025n

.meas tran vdout0_37ck1390 FIND v(dout0_37) AT=700.025n

.meas tran vdout0_38ck1390 FIND v(dout0_38) AT=700.025n

.meas tran vdout0_39ck1390 FIND v(dout0_39) AT=700.025n

.meas tran vdout0_40ck1390 FIND v(dout0_40) AT=700.025n

.meas tran vdout0_41ck1390 FIND v(dout0_41) AT=700.025n

.meas tran vdout0_42ck1390 FIND v(dout0_42) AT=700.025n

.meas tran vdout0_43ck1390 FIND v(dout0_43) AT=700.025n

.meas tran vdout0_44ck1390 FIND v(dout0_44) AT=700.025n

.meas tran vdout0_45ck1390 FIND v(dout0_45) AT=700.025n

.meas tran vdout0_46ck1390 FIND v(dout0_46) AT=700.025n

.meas tran vdout0_47ck1390 FIND v(dout0_47) AT=700.025n

.meas tran vdout0_48ck1390 FIND v(dout0_48) AT=700.025n

.meas tran vdout0_49ck1390 FIND v(dout0_49) AT=700.025n

.meas tran vdout0_50ck1390 FIND v(dout0_50) AT=700.025n

.meas tran vdout0_51ck1390 FIND v(dout0_51) AT=700.025n

.meas tran vdout0_52ck1390 FIND v(dout0_52) AT=700.025n

.meas tran vdout0_53ck1390 FIND v(dout0_53) AT=700.025n

.meas tran vdout0_54ck1390 FIND v(dout0_54) AT=700.025n

.meas tran vdout0_55ck1390 FIND v(dout0_55) AT=700.025n

.meas tran vdout0_56ck1390 FIND v(dout0_56) AT=700.025n

.meas tran vdout0_57ck1390 FIND v(dout0_57) AT=700.025n

.meas tran vdout0_58ck1390 FIND v(dout0_58) AT=700.025n

.meas tran vdout0_59ck1390 FIND v(dout0_59) AT=700.025n

.meas tran vdout0_60ck1390 FIND v(dout0_60) AT=700.025n

.meas tran vdout0_61ck1390 FIND v(dout0_61) AT=700.025n

.meas tran vdout0_62ck1390 FIND v(dout0_62) AT=700.025n

.meas tran vdout0_63ck1390 FIND v(dout0_63) AT=700.025n

.meas tran vdout0_0ck1440 FIND v(dout0_0) AT=725.025n

.meas tran vdout0_1ck1440 FIND v(dout0_1) AT=725.025n

.meas tran vdout0_2ck1440 FIND v(dout0_2) AT=725.025n

.meas tran vdout0_3ck1440 FIND v(dout0_3) AT=725.025n

.meas tran vdout0_4ck1440 FIND v(dout0_4) AT=725.025n

.meas tran vdout0_5ck1440 FIND v(dout0_5) AT=725.025n

.meas tran vdout0_6ck1440 FIND v(dout0_6) AT=725.025n

.meas tran vdout0_7ck1440 FIND v(dout0_7) AT=725.025n

.meas tran vdout0_8ck1440 FIND v(dout0_8) AT=725.025n

.meas tran vdout0_9ck1440 FIND v(dout0_9) AT=725.025n

.meas tran vdout0_10ck1440 FIND v(dout0_10) AT=725.025n

.meas tran vdout0_11ck1440 FIND v(dout0_11) AT=725.025n

.meas tran vdout0_12ck1440 FIND v(dout0_12) AT=725.025n

.meas tran vdout0_13ck1440 FIND v(dout0_13) AT=725.025n

.meas tran vdout0_14ck1440 FIND v(dout0_14) AT=725.025n

.meas tran vdout0_15ck1440 FIND v(dout0_15) AT=725.025n

.meas tran vdout0_16ck1440 FIND v(dout0_16) AT=725.025n

.meas tran vdout0_17ck1440 FIND v(dout0_17) AT=725.025n

.meas tran vdout0_18ck1440 FIND v(dout0_18) AT=725.025n

.meas tran vdout0_19ck1440 FIND v(dout0_19) AT=725.025n

.meas tran vdout0_20ck1440 FIND v(dout0_20) AT=725.025n

.meas tran vdout0_21ck1440 FIND v(dout0_21) AT=725.025n

.meas tran vdout0_22ck1440 FIND v(dout0_22) AT=725.025n

.meas tran vdout0_23ck1440 FIND v(dout0_23) AT=725.025n

.meas tran vdout0_24ck1440 FIND v(dout0_24) AT=725.025n

.meas tran vdout0_25ck1440 FIND v(dout0_25) AT=725.025n

.meas tran vdout0_26ck1440 FIND v(dout0_26) AT=725.025n

.meas tran vdout0_27ck1440 FIND v(dout0_27) AT=725.025n

.meas tran vdout0_28ck1440 FIND v(dout0_28) AT=725.025n

.meas tran vdout0_29ck1440 FIND v(dout0_29) AT=725.025n

.meas tran vdout0_30ck1440 FIND v(dout0_30) AT=725.025n

.meas tran vdout0_31ck1440 FIND v(dout0_31) AT=725.025n

.meas tran vdout0_32ck1440 FIND v(dout0_32) AT=725.025n

.meas tran vdout0_33ck1440 FIND v(dout0_33) AT=725.025n

.meas tran vdout0_34ck1440 FIND v(dout0_34) AT=725.025n

.meas tran vdout0_35ck1440 FIND v(dout0_35) AT=725.025n

.meas tran vdout0_36ck1440 FIND v(dout0_36) AT=725.025n

.meas tran vdout0_37ck1440 FIND v(dout0_37) AT=725.025n

.meas tran vdout0_38ck1440 FIND v(dout0_38) AT=725.025n

.meas tran vdout0_39ck1440 FIND v(dout0_39) AT=725.025n

.meas tran vdout0_40ck1440 FIND v(dout0_40) AT=725.025n

.meas tran vdout0_41ck1440 FIND v(dout0_41) AT=725.025n

.meas tran vdout0_42ck1440 FIND v(dout0_42) AT=725.025n

.meas tran vdout0_43ck1440 FIND v(dout0_43) AT=725.025n

.meas tran vdout0_44ck1440 FIND v(dout0_44) AT=725.025n

.meas tran vdout0_45ck1440 FIND v(dout0_45) AT=725.025n

.meas tran vdout0_46ck1440 FIND v(dout0_46) AT=725.025n

.meas tran vdout0_47ck1440 FIND v(dout0_47) AT=725.025n

.meas tran vdout0_48ck1440 FIND v(dout0_48) AT=725.025n

.meas tran vdout0_49ck1440 FIND v(dout0_49) AT=725.025n

.meas tran vdout0_50ck1440 FIND v(dout0_50) AT=725.025n

.meas tran vdout0_51ck1440 FIND v(dout0_51) AT=725.025n

.meas tran vdout0_52ck1440 FIND v(dout0_52) AT=725.025n

.meas tran vdout0_53ck1440 FIND v(dout0_53) AT=725.025n

.meas tran vdout0_54ck1440 FIND v(dout0_54) AT=725.025n

.meas tran vdout0_55ck1440 FIND v(dout0_55) AT=725.025n

.meas tran vdout0_56ck1440 FIND v(dout0_56) AT=725.025n

.meas tran vdout0_57ck1440 FIND v(dout0_57) AT=725.025n

.meas tran vdout0_58ck1440 FIND v(dout0_58) AT=725.025n

.meas tran vdout0_59ck1440 FIND v(dout0_59) AT=725.025n

.meas tran vdout0_60ck1440 FIND v(dout0_60) AT=725.025n

.meas tran vdout0_61ck1440 FIND v(dout0_61) AT=725.025n

.meas tran vdout0_62ck1440 FIND v(dout0_62) AT=725.025n

.meas tran vdout0_63ck1440 FIND v(dout0_63) AT=725.025n

.meas tran vdout0_0ck1450 FIND v(dout0_0) AT=730.025n

.meas tran vdout0_1ck1450 FIND v(dout0_1) AT=730.025n

.meas tran vdout0_2ck1450 FIND v(dout0_2) AT=730.025n

.meas tran vdout0_3ck1450 FIND v(dout0_3) AT=730.025n

.meas tran vdout0_4ck1450 FIND v(dout0_4) AT=730.025n

.meas tran vdout0_5ck1450 FIND v(dout0_5) AT=730.025n

.meas tran vdout0_6ck1450 FIND v(dout0_6) AT=730.025n

.meas tran vdout0_7ck1450 FIND v(dout0_7) AT=730.025n

.meas tran vdout0_8ck1450 FIND v(dout0_8) AT=730.025n

.meas tran vdout0_9ck1450 FIND v(dout0_9) AT=730.025n

.meas tran vdout0_10ck1450 FIND v(dout0_10) AT=730.025n

.meas tran vdout0_11ck1450 FIND v(dout0_11) AT=730.025n

.meas tran vdout0_12ck1450 FIND v(dout0_12) AT=730.025n

.meas tran vdout0_13ck1450 FIND v(dout0_13) AT=730.025n

.meas tran vdout0_14ck1450 FIND v(dout0_14) AT=730.025n

.meas tran vdout0_15ck1450 FIND v(dout0_15) AT=730.025n

.meas tran vdout0_16ck1450 FIND v(dout0_16) AT=730.025n

.meas tran vdout0_17ck1450 FIND v(dout0_17) AT=730.025n

.meas tran vdout0_18ck1450 FIND v(dout0_18) AT=730.025n

.meas tran vdout0_19ck1450 FIND v(dout0_19) AT=730.025n

.meas tran vdout0_20ck1450 FIND v(dout0_20) AT=730.025n

.meas tran vdout0_21ck1450 FIND v(dout0_21) AT=730.025n

.meas tran vdout0_22ck1450 FIND v(dout0_22) AT=730.025n

.meas tran vdout0_23ck1450 FIND v(dout0_23) AT=730.025n

.meas tran vdout0_24ck1450 FIND v(dout0_24) AT=730.025n

.meas tran vdout0_25ck1450 FIND v(dout0_25) AT=730.025n

.meas tran vdout0_26ck1450 FIND v(dout0_26) AT=730.025n

.meas tran vdout0_27ck1450 FIND v(dout0_27) AT=730.025n

.meas tran vdout0_28ck1450 FIND v(dout0_28) AT=730.025n

.meas tran vdout0_29ck1450 FIND v(dout0_29) AT=730.025n

.meas tran vdout0_30ck1450 FIND v(dout0_30) AT=730.025n

.meas tran vdout0_31ck1450 FIND v(dout0_31) AT=730.025n

.meas tran vdout0_32ck1450 FIND v(dout0_32) AT=730.025n

.meas tran vdout0_33ck1450 FIND v(dout0_33) AT=730.025n

.meas tran vdout0_34ck1450 FIND v(dout0_34) AT=730.025n

.meas tran vdout0_35ck1450 FIND v(dout0_35) AT=730.025n

.meas tran vdout0_36ck1450 FIND v(dout0_36) AT=730.025n

.meas tran vdout0_37ck1450 FIND v(dout0_37) AT=730.025n

.meas tran vdout0_38ck1450 FIND v(dout0_38) AT=730.025n

.meas tran vdout0_39ck1450 FIND v(dout0_39) AT=730.025n

.meas tran vdout0_40ck1450 FIND v(dout0_40) AT=730.025n

.meas tran vdout0_41ck1450 FIND v(dout0_41) AT=730.025n

.meas tran vdout0_42ck1450 FIND v(dout0_42) AT=730.025n

.meas tran vdout0_43ck1450 FIND v(dout0_43) AT=730.025n

.meas tran vdout0_44ck1450 FIND v(dout0_44) AT=730.025n

.meas tran vdout0_45ck1450 FIND v(dout0_45) AT=730.025n

.meas tran vdout0_46ck1450 FIND v(dout0_46) AT=730.025n

.meas tran vdout0_47ck1450 FIND v(dout0_47) AT=730.025n

.meas tran vdout0_48ck1450 FIND v(dout0_48) AT=730.025n

.meas tran vdout0_49ck1450 FIND v(dout0_49) AT=730.025n

.meas tran vdout0_50ck1450 FIND v(dout0_50) AT=730.025n

.meas tran vdout0_51ck1450 FIND v(dout0_51) AT=730.025n

.meas tran vdout0_52ck1450 FIND v(dout0_52) AT=730.025n

.meas tran vdout0_53ck1450 FIND v(dout0_53) AT=730.025n

.meas tran vdout0_54ck1450 FIND v(dout0_54) AT=730.025n

.meas tran vdout0_55ck1450 FIND v(dout0_55) AT=730.025n

.meas tran vdout0_56ck1450 FIND v(dout0_56) AT=730.025n

.meas tran vdout0_57ck1450 FIND v(dout0_57) AT=730.025n

.meas tran vdout0_58ck1450 FIND v(dout0_58) AT=730.025n

.meas tran vdout0_59ck1450 FIND v(dout0_59) AT=730.025n

.meas tran vdout0_60ck1450 FIND v(dout0_60) AT=730.025n

.meas tran vdout0_61ck1450 FIND v(dout0_61) AT=730.025n

.meas tran vdout0_62ck1450 FIND v(dout0_62) AT=730.025n

.meas tran vdout0_63ck1450 FIND v(dout0_63) AT=730.025n

.meas tran vdout0_0ck1490 FIND v(dout0_0) AT=750.025n

.meas tran vdout0_1ck1490 FIND v(dout0_1) AT=750.025n

.meas tran vdout0_2ck1490 FIND v(dout0_2) AT=750.025n

.meas tran vdout0_3ck1490 FIND v(dout0_3) AT=750.025n

.meas tran vdout0_4ck1490 FIND v(dout0_4) AT=750.025n

.meas tran vdout0_5ck1490 FIND v(dout0_5) AT=750.025n

.meas tran vdout0_6ck1490 FIND v(dout0_6) AT=750.025n

.meas tran vdout0_7ck1490 FIND v(dout0_7) AT=750.025n

.meas tran vdout0_8ck1490 FIND v(dout0_8) AT=750.025n

.meas tran vdout0_9ck1490 FIND v(dout0_9) AT=750.025n

.meas tran vdout0_10ck1490 FIND v(dout0_10) AT=750.025n

.meas tran vdout0_11ck1490 FIND v(dout0_11) AT=750.025n

.meas tran vdout0_12ck1490 FIND v(dout0_12) AT=750.025n

.meas tran vdout0_13ck1490 FIND v(dout0_13) AT=750.025n

.meas tran vdout0_14ck1490 FIND v(dout0_14) AT=750.025n

.meas tran vdout0_15ck1490 FIND v(dout0_15) AT=750.025n

.meas tran vdout0_16ck1490 FIND v(dout0_16) AT=750.025n

.meas tran vdout0_17ck1490 FIND v(dout0_17) AT=750.025n

.meas tran vdout0_18ck1490 FIND v(dout0_18) AT=750.025n

.meas tran vdout0_19ck1490 FIND v(dout0_19) AT=750.025n

.meas tran vdout0_20ck1490 FIND v(dout0_20) AT=750.025n

.meas tran vdout0_21ck1490 FIND v(dout0_21) AT=750.025n

.meas tran vdout0_22ck1490 FIND v(dout0_22) AT=750.025n

.meas tran vdout0_23ck1490 FIND v(dout0_23) AT=750.025n

.meas tran vdout0_24ck1490 FIND v(dout0_24) AT=750.025n

.meas tran vdout0_25ck1490 FIND v(dout0_25) AT=750.025n

.meas tran vdout0_26ck1490 FIND v(dout0_26) AT=750.025n

.meas tran vdout0_27ck1490 FIND v(dout0_27) AT=750.025n

.meas tran vdout0_28ck1490 FIND v(dout0_28) AT=750.025n

.meas tran vdout0_29ck1490 FIND v(dout0_29) AT=750.025n

.meas tran vdout0_30ck1490 FIND v(dout0_30) AT=750.025n

.meas tran vdout0_31ck1490 FIND v(dout0_31) AT=750.025n

.meas tran vdout0_32ck1490 FIND v(dout0_32) AT=750.025n

.meas tran vdout0_33ck1490 FIND v(dout0_33) AT=750.025n

.meas tran vdout0_34ck1490 FIND v(dout0_34) AT=750.025n

.meas tran vdout0_35ck1490 FIND v(dout0_35) AT=750.025n

.meas tran vdout0_36ck1490 FIND v(dout0_36) AT=750.025n

.meas tran vdout0_37ck1490 FIND v(dout0_37) AT=750.025n

.meas tran vdout0_38ck1490 FIND v(dout0_38) AT=750.025n

.meas tran vdout0_39ck1490 FIND v(dout0_39) AT=750.025n

.meas tran vdout0_40ck1490 FIND v(dout0_40) AT=750.025n

.meas tran vdout0_41ck1490 FIND v(dout0_41) AT=750.025n

.meas tran vdout0_42ck1490 FIND v(dout0_42) AT=750.025n

.meas tran vdout0_43ck1490 FIND v(dout0_43) AT=750.025n

.meas tran vdout0_44ck1490 FIND v(dout0_44) AT=750.025n

.meas tran vdout0_45ck1490 FIND v(dout0_45) AT=750.025n

.meas tran vdout0_46ck1490 FIND v(dout0_46) AT=750.025n

.meas tran vdout0_47ck1490 FIND v(dout0_47) AT=750.025n

.meas tran vdout0_48ck1490 FIND v(dout0_48) AT=750.025n

.meas tran vdout0_49ck1490 FIND v(dout0_49) AT=750.025n

.meas tran vdout0_50ck1490 FIND v(dout0_50) AT=750.025n

.meas tran vdout0_51ck1490 FIND v(dout0_51) AT=750.025n

.meas tran vdout0_52ck1490 FIND v(dout0_52) AT=750.025n

.meas tran vdout0_53ck1490 FIND v(dout0_53) AT=750.025n

.meas tran vdout0_54ck1490 FIND v(dout0_54) AT=750.025n

.meas tran vdout0_55ck1490 FIND v(dout0_55) AT=750.025n

.meas tran vdout0_56ck1490 FIND v(dout0_56) AT=750.025n

.meas tran vdout0_57ck1490 FIND v(dout0_57) AT=750.025n

.meas tran vdout0_58ck1490 FIND v(dout0_58) AT=750.025n

.meas tran vdout0_59ck1490 FIND v(dout0_59) AT=750.025n

.meas tran vdout0_60ck1490 FIND v(dout0_60) AT=750.025n

.meas tran vdout0_61ck1490 FIND v(dout0_61) AT=750.025n

.meas tran vdout0_62ck1490 FIND v(dout0_62) AT=750.025n

.meas tran vdout0_63ck1490 FIND v(dout0_63) AT=750.025n

.meas tran vdout0_0ck1520 FIND v(dout0_0) AT=765.025n

.meas tran vdout0_1ck1520 FIND v(dout0_1) AT=765.025n

.meas tran vdout0_2ck1520 FIND v(dout0_2) AT=765.025n

.meas tran vdout0_3ck1520 FIND v(dout0_3) AT=765.025n

.meas tran vdout0_4ck1520 FIND v(dout0_4) AT=765.025n

.meas tran vdout0_5ck1520 FIND v(dout0_5) AT=765.025n

.meas tran vdout0_6ck1520 FIND v(dout0_6) AT=765.025n

.meas tran vdout0_7ck1520 FIND v(dout0_7) AT=765.025n

.meas tran vdout0_8ck1520 FIND v(dout0_8) AT=765.025n

.meas tran vdout0_9ck1520 FIND v(dout0_9) AT=765.025n

.meas tran vdout0_10ck1520 FIND v(dout0_10) AT=765.025n

.meas tran vdout0_11ck1520 FIND v(dout0_11) AT=765.025n

.meas tran vdout0_12ck1520 FIND v(dout0_12) AT=765.025n

.meas tran vdout0_13ck1520 FIND v(dout0_13) AT=765.025n

.meas tran vdout0_14ck1520 FIND v(dout0_14) AT=765.025n

.meas tran vdout0_15ck1520 FIND v(dout0_15) AT=765.025n

.meas tran vdout0_16ck1520 FIND v(dout0_16) AT=765.025n

.meas tran vdout0_17ck1520 FIND v(dout0_17) AT=765.025n

.meas tran vdout0_18ck1520 FIND v(dout0_18) AT=765.025n

.meas tran vdout0_19ck1520 FIND v(dout0_19) AT=765.025n

.meas tran vdout0_20ck1520 FIND v(dout0_20) AT=765.025n

.meas tran vdout0_21ck1520 FIND v(dout0_21) AT=765.025n

.meas tran vdout0_22ck1520 FIND v(dout0_22) AT=765.025n

.meas tran vdout0_23ck1520 FIND v(dout0_23) AT=765.025n

.meas tran vdout0_24ck1520 FIND v(dout0_24) AT=765.025n

.meas tran vdout0_25ck1520 FIND v(dout0_25) AT=765.025n

.meas tran vdout0_26ck1520 FIND v(dout0_26) AT=765.025n

.meas tran vdout0_27ck1520 FIND v(dout0_27) AT=765.025n

.meas tran vdout0_28ck1520 FIND v(dout0_28) AT=765.025n

.meas tran vdout0_29ck1520 FIND v(dout0_29) AT=765.025n

.meas tran vdout0_30ck1520 FIND v(dout0_30) AT=765.025n

.meas tran vdout0_31ck1520 FIND v(dout0_31) AT=765.025n

.meas tran vdout0_32ck1520 FIND v(dout0_32) AT=765.025n

.meas tran vdout0_33ck1520 FIND v(dout0_33) AT=765.025n

.meas tran vdout0_34ck1520 FIND v(dout0_34) AT=765.025n

.meas tran vdout0_35ck1520 FIND v(dout0_35) AT=765.025n

.meas tran vdout0_36ck1520 FIND v(dout0_36) AT=765.025n

.meas tran vdout0_37ck1520 FIND v(dout0_37) AT=765.025n

.meas tran vdout0_38ck1520 FIND v(dout0_38) AT=765.025n

.meas tran vdout0_39ck1520 FIND v(dout0_39) AT=765.025n

.meas tran vdout0_40ck1520 FIND v(dout0_40) AT=765.025n

.meas tran vdout0_41ck1520 FIND v(dout0_41) AT=765.025n

.meas tran vdout0_42ck1520 FIND v(dout0_42) AT=765.025n

.meas tran vdout0_43ck1520 FIND v(dout0_43) AT=765.025n

.meas tran vdout0_44ck1520 FIND v(dout0_44) AT=765.025n

.meas tran vdout0_45ck1520 FIND v(dout0_45) AT=765.025n

.meas tran vdout0_46ck1520 FIND v(dout0_46) AT=765.025n

.meas tran vdout0_47ck1520 FIND v(dout0_47) AT=765.025n

.meas tran vdout0_48ck1520 FIND v(dout0_48) AT=765.025n

.meas tran vdout0_49ck1520 FIND v(dout0_49) AT=765.025n

.meas tran vdout0_50ck1520 FIND v(dout0_50) AT=765.025n

.meas tran vdout0_51ck1520 FIND v(dout0_51) AT=765.025n

.meas tran vdout0_52ck1520 FIND v(dout0_52) AT=765.025n

.meas tran vdout0_53ck1520 FIND v(dout0_53) AT=765.025n

.meas tran vdout0_54ck1520 FIND v(dout0_54) AT=765.025n

.meas tran vdout0_55ck1520 FIND v(dout0_55) AT=765.025n

.meas tran vdout0_56ck1520 FIND v(dout0_56) AT=765.025n

.meas tran vdout0_57ck1520 FIND v(dout0_57) AT=765.025n

.meas tran vdout0_58ck1520 FIND v(dout0_58) AT=765.025n

.meas tran vdout0_59ck1520 FIND v(dout0_59) AT=765.025n

.meas tran vdout0_60ck1520 FIND v(dout0_60) AT=765.025n

.meas tran vdout0_61ck1520 FIND v(dout0_61) AT=765.025n

.meas tran vdout0_62ck1520 FIND v(dout0_62) AT=765.025n

.meas tran vdout0_63ck1520 FIND v(dout0_63) AT=765.025n

.meas tran vdout0_0ck1530 FIND v(dout0_0) AT=770.025n

.meas tran vdout0_1ck1530 FIND v(dout0_1) AT=770.025n

.meas tran vdout0_2ck1530 FIND v(dout0_2) AT=770.025n

.meas tran vdout0_3ck1530 FIND v(dout0_3) AT=770.025n

.meas tran vdout0_4ck1530 FIND v(dout0_4) AT=770.025n

.meas tran vdout0_5ck1530 FIND v(dout0_5) AT=770.025n

.meas tran vdout0_6ck1530 FIND v(dout0_6) AT=770.025n

.meas tran vdout0_7ck1530 FIND v(dout0_7) AT=770.025n

.meas tran vdout0_8ck1530 FIND v(dout0_8) AT=770.025n

.meas tran vdout0_9ck1530 FIND v(dout0_9) AT=770.025n

.meas tran vdout0_10ck1530 FIND v(dout0_10) AT=770.025n

.meas tran vdout0_11ck1530 FIND v(dout0_11) AT=770.025n

.meas tran vdout0_12ck1530 FIND v(dout0_12) AT=770.025n

.meas tran vdout0_13ck1530 FIND v(dout0_13) AT=770.025n

.meas tran vdout0_14ck1530 FIND v(dout0_14) AT=770.025n

.meas tran vdout0_15ck1530 FIND v(dout0_15) AT=770.025n

.meas tran vdout0_16ck1530 FIND v(dout0_16) AT=770.025n

.meas tran vdout0_17ck1530 FIND v(dout0_17) AT=770.025n

.meas tran vdout0_18ck1530 FIND v(dout0_18) AT=770.025n

.meas tran vdout0_19ck1530 FIND v(dout0_19) AT=770.025n

.meas tran vdout0_20ck1530 FIND v(dout0_20) AT=770.025n

.meas tran vdout0_21ck1530 FIND v(dout0_21) AT=770.025n

.meas tran vdout0_22ck1530 FIND v(dout0_22) AT=770.025n

.meas tran vdout0_23ck1530 FIND v(dout0_23) AT=770.025n

.meas tran vdout0_24ck1530 FIND v(dout0_24) AT=770.025n

.meas tran vdout0_25ck1530 FIND v(dout0_25) AT=770.025n

.meas tran vdout0_26ck1530 FIND v(dout0_26) AT=770.025n

.meas tran vdout0_27ck1530 FIND v(dout0_27) AT=770.025n

.meas tran vdout0_28ck1530 FIND v(dout0_28) AT=770.025n

.meas tran vdout0_29ck1530 FIND v(dout0_29) AT=770.025n

.meas tran vdout0_30ck1530 FIND v(dout0_30) AT=770.025n

.meas tran vdout0_31ck1530 FIND v(dout0_31) AT=770.025n

.meas tran vdout0_32ck1530 FIND v(dout0_32) AT=770.025n

.meas tran vdout0_33ck1530 FIND v(dout0_33) AT=770.025n

.meas tran vdout0_34ck1530 FIND v(dout0_34) AT=770.025n

.meas tran vdout0_35ck1530 FIND v(dout0_35) AT=770.025n

.meas tran vdout0_36ck1530 FIND v(dout0_36) AT=770.025n

.meas tran vdout0_37ck1530 FIND v(dout0_37) AT=770.025n

.meas tran vdout0_38ck1530 FIND v(dout0_38) AT=770.025n

.meas tran vdout0_39ck1530 FIND v(dout0_39) AT=770.025n

.meas tran vdout0_40ck1530 FIND v(dout0_40) AT=770.025n

.meas tran vdout0_41ck1530 FIND v(dout0_41) AT=770.025n

.meas tran vdout0_42ck1530 FIND v(dout0_42) AT=770.025n

.meas tran vdout0_43ck1530 FIND v(dout0_43) AT=770.025n

.meas tran vdout0_44ck1530 FIND v(dout0_44) AT=770.025n

.meas tran vdout0_45ck1530 FIND v(dout0_45) AT=770.025n

.meas tran vdout0_46ck1530 FIND v(dout0_46) AT=770.025n

.meas tran vdout0_47ck1530 FIND v(dout0_47) AT=770.025n

.meas tran vdout0_48ck1530 FIND v(dout0_48) AT=770.025n

.meas tran vdout0_49ck1530 FIND v(dout0_49) AT=770.025n

.meas tran vdout0_50ck1530 FIND v(dout0_50) AT=770.025n

.meas tran vdout0_51ck1530 FIND v(dout0_51) AT=770.025n

.meas tran vdout0_52ck1530 FIND v(dout0_52) AT=770.025n

.meas tran vdout0_53ck1530 FIND v(dout0_53) AT=770.025n

.meas tran vdout0_54ck1530 FIND v(dout0_54) AT=770.025n

.meas tran vdout0_55ck1530 FIND v(dout0_55) AT=770.025n

.meas tran vdout0_56ck1530 FIND v(dout0_56) AT=770.025n

.meas tran vdout0_57ck1530 FIND v(dout0_57) AT=770.025n

.meas tran vdout0_58ck1530 FIND v(dout0_58) AT=770.025n

.meas tran vdout0_59ck1530 FIND v(dout0_59) AT=770.025n

.meas tran vdout0_60ck1530 FIND v(dout0_60) AT=770.025n

.meas tran vdout0_61ck1530 FIND v(dout0_61) AT=770.025n

.meas tran vdout0_62ck1530 FIND v(dout0_62) AT=770.025n

.meas tran vdout0_63ck1530 FIND v(dout0_63) AT=770.025n

.meas tran vdout0_0ck1560 FIND v(dout0_0) AT=785.025n

.meas tran vdout0_1ck1560 FIND v(dout0_1) AT=785.025n

.meas tran vdout0_2ck1560 FIND v(dout0_2) AT=785.025n

.meas tran vdout0_3ck1560 FIND v(dout0_3) AT=785.025n

.meas tran vdout0_4ck1560 FIND v(dout0_4) AT=785.025n

.meas tran vdout0_5ck1560 FIND v(dout0_5) AT=785.025n

.meas tran vdout0_6ck1560 FIND v(dout0_6) AT=785.025n

.meas tran vdout0_7ck1560 FIND v(dout0_7) AT=785.025n

.meas tran vdout0_8ck1560 FIND v(dout0_8) AT=785.025n

.meas tran vdout0_9ck1560 FIND v(dout0_9) AT=785.025n

.meas tran vdout0_10ck1560 FIND v(dout0_10) AT=785.025n

.meas tran vdout0_11ck1560 FIND v(dout0_11) AT=785.025n

.meas tran vdout0_12ck1560 FIND v(dout0_12) AT=785.025n

.meas tran vdout0_13ck1560 FIND v(dout0_13) AT=785.025n

.meas tran vdout0_14ck1560 FIND v(dout0_14) AT=785.025n

.meas tran vdout0_15ck1560 FIND v(dout0_15) AT=785.025n

.meas tran vdout0_16ck1560 FIND v(dout0_16) AT=785.025n

.meas tran vdout0_17ck1560 FIND v(dout0_17) AT=785.025n

.meas tran vdout0_18ck1560 FIND v(dout0_18) AT=785.025n

.meas tran vdout0_19ck1560 FIND v(dout0_19) AT=785.025n

.meas tran vdout0_20ck1560 FIND v(dout0_20) AT=785.025n

.meas tran vdout0_21ck1560 FIND v(dout0_21) AT=785.025n

.meas tran vdout0_22ck1560 FIND v(dout0_22) AT=785.025n

.meas tran vdout0_23ck1560 FIND v(dout0_23) AT=785.025n

.meas tran vdout0_24ck1560 FIND v(dout0_24) AT=785.025n

.meas tran vdout0_25ck1560 FIND v(dout0_25) AT=785.025n

.meas tran vdout0_26ck1560 FIND v(dout0_26) AT=785.025n

.meas tran vdout0_27ck1560 FIND v(dout0_27) AT=785.025n

.meas tran vdout0_28ck1560 FIND v(dout0_28) AT=785.025n

.meas tran vdout0_29ck1560 FIND v(dout0_29) AT=785.025n

.meas tran vdout0_30ck1560 FIND v(dout0_30) AT=785.025n

.meas tran vdout0_31ck1560 FIND v(dout0_31) AT=785.025n

.meas tran vdout0_32ck1560 FIND v(dout0_32) AT=785.025n

.meas tran vdout0_33ck1560 FIND v(dout0_33) AT=785.025n

.meas tran vdout0_34ck1560 FIND v(dout0_34) AT=785.025n

.meas tran vdout0_35ck1560 FIND v(dout0_35) AT=785.025n

.meas tran vdout0_36ck1560 FIND v(dout0_36) AT=785.025n

.meas tran vdout0_37ck1560 FIND v(dout0_37) AT=785.025n

.meas tran vdout0_38ck1560 FIND v(dout0_38) AT=785.025n

.meas tran vdout0_39ck1560 FIND v(dout0_39) AT=785.025n

.meas tran vdout0_40ck1560 FIND v(dout0_40) AT=785.025n

.meas tran vdout0_41ck1560 FIND v(dout0_41) AT=785.025n

.meas tran vdout0_42ck1560 FIND v(dout0_42) AT=785.025n

.meas tran vdout0_43ck1560 FIND v(dout0_43) AT=785.025n

.meas tran vdout0_44ck1560 FIND v(dout0_44) AT=785.025n

.meas tran vdout0_45ck1560 FIND v(dout0_45) AT=785.025n

.meas tran vdout0_46ck1560 FIND v(dout0_46) AT=785.025n

.meas tran vdout0_47ck1560 FIND v(dout0_47) AT=785.025n

.meas tran vdout0_48ck1560 FIND v(dout0_48) AT=785.025n

.meas tran vdout0_49ck1560 FIND v(dout0_49) AT=785.025n

.meas tran vdout0_50ck1560 FIND v(dout0_50) AT=785.025n

.meas tran vdout0_51ck1560 FIND v(dout0_51) AT=785.025n

.meas tran vdout0_52ck1560 FIND v(dout0_52) AT=785.025n

.meas tran vdout0_53ck1560 FIND v(dout0_53) AT=785.025n

.meas tran vdout0_54ck1560 FIND v(dout0_54) AT=785.025n

.meas tran vdout0_55ck1560 FIND v(dout0_55) AT=785.025n

.meas tran vdout0_56ck1560 FIND v(dout0_56) AT=785.025n

.meas tran vdout0_57ck1560 FIND v(dout0_57) AT=785.025n

.meas tran vdout0_58ck1560 FIND v(dout0_58) AT=785.025n

.meas tran vdout0_59ck1560 FIND v(dout0_59) AT=785.025n

.meas tran vdout0_60ck1560 FIND v(dout0_60) AT=785.025n

.meas tran vdout0_61ck1560 FIND v(dout0_61) AT=785.025n

.meas tran vdout0_62ck1560 FIND v(dout0_62) AT=785.025n

.meas tran vdout0_63ck1560 FIND v(dout0_63) AT=785.025n

.meas tran vdout0_0ck1610 FIND v(dout0_0) AT=810.025n

.meas tran vdout0_1ck1610 FIND v(dout0_1) AT=810.025n

.meas tran vdout0_2ck1610 FIND v(dout0_2) AT=810.025n

.meas tran vdout0_3ck1610 FIND v(dout0_3) AT=810.025n

.meas tran vdout0_4ck1610 FIND v(dout0_4) AT=810.025n

.meas tran vdout0_5ck1610 FIND v(dout0_5) AT=810.025n

.meas tran vdout0_6ck1610 FIND v(dout0_6) AT=810.025n

.meas tran vdout0_7ck1610 FIND v(dout0_7) AT=810.025n

.meas tran vdout0_8ck1610 FIND v(dout0_8) AT=810.025n

.meas tran vdout0_9ck1610 FIND v(dout0_9) AT=810.025n

.meas tran vdout0_10ck1610 FIND v(dout0_10) AT=810.025n

.meas tran vdout0_11ck1610 FIND v(dout0_11) AT=810.025n

.meas tran vdout0_12ck1610 FIND v(dout0_12) AT=810.025n

.meas tran vdout0_13ck1610 FIND v(dout0_13) AT=810.025n

.meas tran vdout0_14ck1610 FIND v(dout0_14) AT=810.025n

.meas tran vdout0_15ck1610 FIND v(dout0_15) AT=810.025n

.meas tran vdout0_16ck1610 FIND v(dout0_16) AT=810.025n

.meas tran vdout0_17ck1610 FIND v(dout0_17) AT=810.025n

.meas tran vdout0_18ck1610 FIND v(dout0_18) AT=810.025n

.meas tran vdout0_19ck1610 FIND v(dout0_19) AT=810.025n

.meas tran vdout0_20ck1610 FIND v(dout0_20) AT=810.025n

.meas tran vdout0_21ck1610 FIND v(dout0_21) AT=810.025n

.meas tran vdout0_22ck1610 FIND v(dout0_22) AT=810.025n

.meas tran vdout0_23ck1610 FIND v(dout0_23) AT=810.025n

.meas tran vdout0_24ck1610 FIND v(dout0_24) AT=810.025n

.meas tran vdout0_25ck1610 FIND v(dout0_25) AT=810.025n

.meas tran vdout0_26ck1610 FIND v(dout0_26) AT=810.025n

.meas tran vdout0_27ck1610 FIND v(dout0_27) AT=810.025n

.meas tran vdout0_28ck1610 FIND v(dout0_28) AT=810.025n

.meas tran vdout0_29ck1610 FIND v(dout0_29) AT=810.025n

.meas tran vdout0_30ck1610 FIND v(dout0_30) AT=810.025n

.meas tran vdout0_31ck1610 FIND v(dout0_31) AT=810.025n

.meas tran vdout0_32ck1610 FIND v(dout0_32) AT=810.025n

.meas tran vdout0_33ck1610 FIND v(dout0_33) AT=810.025n

.meas tran vdout0_34ck1610 FIND v(dout0_34) AT=810.025n

.meas tran vdout0_35ck1610 FIND v(dout0_35) AT=810.025n

.meas tran vdout0_36ck1610 FIND v(dout0_36) AT=810.025n

.meas tran vdout0_37ck1610 FIND v(dout0_37) AT=810.025n

.meas tran vdout0_38ck1610 FIND v(dout0_38) AT=810.025n

.meas tran vdout0_39ck1610 FIND v(dout0_39) AT=810.025n

.meas tran vdout0_40ck1610 FIND v(dout0_40) AT=810.025n

.meas tran vdout0_41ck1610 FIND v(dout0_41) AT=810.025n

.meas tran vdout0_42ck1610 FIND v(dout0_42) AT=810.025n

.meas tran vdout0_43ck1610 FIND v(dout0_43) AT=810.025n

.meas tran vdout0_44ck1610 FIND v(dout0_44) AT=810.025n

.meas tran vdout0_45ck1610 FIND v(dout0_45) AT=810.025n

.meas tran vdout0_46ck1610 FIND v(dout0_46) AT=810.025n

.meas tran vdout0_47ck1610 FIND v(dout0_47) AT=810.025n

.meas tran vdout0_48ck1610 FIND v(dout0_48) AT=810.025n

.meas tran vdout0_49ck1610 FIND v(dout0_49) AT=810.025n

.meas tran vdout0_50ck1610 FIND v(dout0_50) AT=810.025n

.meas tran vdout0_51ck1610 FIND v(dout0_51) AT=810.025n

.meas tran vdout0_52ck1610 FIND v(dout0_52) AT=810.025n

.meas tran vdout0_53ck1610 FIND v(dout0_53) AT=810.025n

.meas tran vdout0_54ck1610 FIND v(dout0_54) AT=810.025n

.meas tran vdout0_55ck1610 FIND v(dout0_55) AT=810.025n

.meas tran vdout0_56ck1610 FIND v(dout0_56) AT=810.025n

.meas tran vdout0_57ck1610 FIND v(dout0_57) AT=810.025n

.meas tran vdout0_58ck1610 FIND v(dout0_58) AT=810.025n

.meas tran vdout0_59ck1610 FIND v(dout0_59) AT=810.025n

.meas tran vdout0_60ck1610 FIND v(dout0_60) AT=810.025n

.meas tran vdout0_61ck1610 FIND v(dout0_61) AT=810.025n

.meas tran vdout0_62ck1610 FIND v(dout0_62) AT=810.025n

.meas tran vdout0_63ck1610 FIND v(dout0_63) AT=810.025n

.meas tran vdout0_0ck1620 FIND v(dout0_0) AT=815.025n

.meas tran vdout0_1ck1620 FIND v(dout0_1) AT=815.025n

.meas tran vdout0_2ck1620 FIND v(dout0_2) AT=815.025n

.meas tran vdout0_3ck1620 FIND v(dout0_3) AT=815.025n

.meas tran vdout0_4ck1620 FIND v(dout0_4) AT=815.025n

.meas tran vdout0_5ck1620 FIND v(dout0_5) AT=815.025n

.meas tran vdout0_6ck1620 FIND v(dout0_6) AT=815.025n

.meas tran vdout0_7ck1620 FIND v(dout0_7) AT=815.025n

.meas tran vdout0_8ck1620 FIND v(dout0_8) AT=815.025n

.meas tran vdout0_9ck1620 FIND v(dout0_9) AT=815.025n

.meas tran vdout0_10ck1620 FIND v(dout0_10) AT=815.025n

.meas tran vdout0_11ck1620 FIND v(dout0_11) AT=815.025n

.meas tran vdout0_12ck1620 FIND v(dout0_12) AT=815.025n

.meas tran vdout0_13ck1620 FIND v(dout0_13) AT=815.025n

.meas tran vdout0_14ck1620 FIND v(dout0_14) AT=815.025n

.meas tran vdout0_15ck1620 FIND v(dout0_15) AT=815.025n

.meas tran vdout0_16ck1620 FIND v(dout0_16) AT=815.025n

.meas tran vdout0_17ck1620 FIND v(dout0_17) AT=815.025n

.meas tran vdout0_18ck1620 FIND v(dout0_18) AT=815.025n

.meas tran vdout0_19ck1620 FIND v(dout0_19) AT=815.025n

.meas tran vdout0_20ck1620 FIND v(dout0_20) AT=815.025n

.meas tran vdout0_21ck1620 FIND v(dout0_21) AT=815.025n

.meas tran vdout0_22ck1620 FIND v(dout0_22) AT=815.025n

.meas tran vdout0_23ck1620 FIND v(dout0_23) AT=815.025n

.meas tran vdout0_24ck1620 FIND v(dout0_24) AT=815.025n

.meas tran vdout0_25ck1620 FIND v(dout0_25) AT=815.025n

.meas tran vdout0_26ck1620 FIND v(dout0_26) AT=815.025n

.meas tran vdout0_27ck1620 FIND v(dout0_27) AT=815.025n

.meas tran vdout0_28ck1620 FIND v(dout0_28) AT=815.025n

.meas tran vdout0_29ck1620 FIND v(dout0_29) AT=815.025n

.meas tran vdout0_30ck1620 FIND v(dout0_30) AT=815.025n

.meas tran vdout0_31ck1620 FIND v(dout0_31) AT=815.025n

.meas tran vdout0_32ck1620 FIND v(dout0_32) AT=815.025n

.meas tran vdout0_33ck1620 FIND v(dout0_33) AT=815.025n

.meas tran vdout0_34ck1620 FIND v(dout0_34) AT=815.025n

.meas tran vdout0_35ck1620 FIND v(dout0_35) AT=815.025n

.meas tran vdout0_36ck1620 FIND v(dout0_36) AT=815.025n

.meas tran vdout0_37ck1620 FIND v(dout0_37) AT=815.025n

.meas tran vdout0_38ck1620 FIND v(dout0_38) AT=815.025n

.meas tran vdout0_39ck1620 FIND v(dout0_39) AT=815.025n

.meas tran vdout0_40ck1620 FIND v(dout0_40) AT=815.025n

.meas tran vdout0_41ck1620 FIND v(dout0_41) AT=815.025n

.meas tran vdout0_42ck1620 FIND v(dout0_42) AT=815.025n

.meas tran vdout0_43ck1620 FIND v(dout0_43) AT=815.025n

.meas tran vdout0_44ck1620 FIND v(dout0_44) AT=815.025n

.meas tran vdout0_45ck1620 FIND v(dout0_45) AT=815.025n

.meas tran vdout0_46ck1620 FIND v(dout0_46) AT=815.025n

.meas tran vdout0_47ck1620 FIND v(dout0_47) AT=815.025n

.meas tran vdout0_48ck1620 FIND v(dout0_48) AT=815.025n

.meas tran vdout0_49ck1620 FIND v(dout0_49) AT=815.025n

.meas tran vdout0_50ck1620 FIND v(dout0_50) AT=815.025n

.meas tran vdout0_51ck1620 FIND v(dout0_51) AT=815.025n

.meas tran vdout0_52ck1620 FIND v(dout0_52) AT=815.025n

.meas tran vdout0_53ck1620 FIND v(dout0_53) AT=815.025n

.meas tran vdout0_54ck1620 FIND v(dout0_54) AT=815.025n

.meas tran vdout0_55ck1620 FIND v(dout0_55) AT=815.025n

.meas tran vdout0_56ck1620 FIND v(dout0_56) AT=815.025n

.meas tran vdout0_57ck1620 FIND v(dout0_57) AT=815.025n

.meas tran vdout0_58ck1620 FIND v(dout0_58) AT=815.025n

.meas tran vdout0_59ck1620 FIND v(dout0_59) AT=815.025n

.meas tran vdout0_60ck1620 FIND v(dout0_60) AT=815.025n

.meas tran vdout0_61ck1620 FIND v(dout0_61) AT=815.025n

.meas tran vdout0_62ck1620 FIND v(dout0_62) AT=815.025n

.meas tran vdout0_63ck1620 FIND v(dout0_63) AT=815.025n

.meas tran vdout0_0ck1630 FIND v(dout0_0) AT=820.025n

.meas tran vdout0_1ck1630 FIND v(dout0_1) AT=820.025n

.meas tran vdout0_2ck1630 FIND v(dout0_2) AT=820.025n

.meas tran vdout0_3ck1630 FIND v(dout0_3) AT=820.025n

.meas tran vdout0_4ck1630 FIND v(dout0_4) AT=820.025n

.meas tran vdout0_5ck1630 FIND v(dout0_5) AT=820.025n

.meas tran vdout0_6ck1630 FIND v(dout0_6) AT=820.025n

.meas tran vdout0_7ck1630 FIND v(dout0_7) AT=820.025n

.meas tran vdout0_8ck1630 FIND v(dout0_8) AT=820.025n

.meas tran vdout0_9ck1630 FIND v(dout0_9) AT=820.025n

.meas tran vdout0_10ck1630 FIND v(dout0_10) AT=820.025n

.meas tran vdout0_11ck1630 FIND v(dout0_11) AT=820.025n

.meas tran vdout0_12ck1630 FIND v(dout0_12) AT=820.025n

.meas tran vdout0_13ck1630 FIND v(dout0_13) AT=820.025n

.meas tran vdout0_14ck1630 FIND v(dout0_14) AT=820.025n

.meas tran vdout0_15ck1630 FIND v(dout0_15) AT=820.025n

.meas tran vdout0_16ck1630 FIND v(dout0_16) AT=820.025n

.meas tran vdout0_17ck1630 FIND v(dout0_17) AT=820.025n

.meas tran vdout0_18ck1630 FIND v(dout0_18) AT=820.025n

.meas tran vdout0_19ck1630 FIND v(dout0_19) AT=820.025n

.meas tran vdout0_20ck1630 FIND v(dout0_20) AT=820.025n

.meas tran vdout0_21ck1630 FIND v(dout0_21) AT=820.025n

.meas tran vdout0_22ck1630 FIND v(dout0_22) AT=820.025n

.meas tran vdout0_23ck1630 FIND v(dout0_23) AT=820.025n

.meas tran vdout0_24ck1630 FIND v(dout0_24) AT=820.025n

.meas tran vdout0_25ck1630 FIND v(dout0_25) AT=820.025n

.meas tran vdout0_26ck1630 FIND v(dout0_26) AT=820.025n

.meas tran vdout0_27ck1630 FIND v(dout0_27) AT=820.025n

.meas tran vdout0_28ck1630 FIND v(dout0_28) AT=820.025n

.meas tran vdout0_29ck1630 FIND v(dout0_29) AT=820.025n

.meas tran vdout0_30ck1630 FIND v(dout0_30) AT=820.025n

.meas tran vdout0_31ck1630 FIND v(dout0_31) AT=820.025n

.meas tran vdout0_32ck1630 FIND v(dout0_32) AT=820.025n

.meas tran vdout0_33ck1630 FIND v(dout0_33) AT=820.025n

.meas tran vdout0_34ck1630 FIND v(dout0_34) AT=820.025n

.meas tran vdout0_35ck1630 FIND v(dout0_35) AT=820.025n

.meas tran vdout0_36ck1630 FIND v(dout0_36) AT=820.025n

.meas tran vdout0_37ck1630 FIND v(dout0_37) AT=820.025n

.meas tran vdout0_38ck1630 FIND v(dout0_38) AT=820.025n

.meas tran vdout0_39ck1630 FIND v(dout0_39) AT=820.025n

.meas tran vdout0_40ck1630 FIND v(dout0_40) AT=820.025n

.meas tran vdout0_41ck1630 FIND v(dout0_41) AT=820.025n

.meas tran vdout0_42ck1630 FIND v(dout0_42) AT=820.025n

.meas tran vdout0_43ck1630 FIND v(dout0_43) AT=820.025n

.meas tran vdout0_44ck1630 FIND v(dout0_44) AT=820.025n

.meas tran vdout0_45ck1630 FIND v(dout0_45) AT=820.025n

.meas tran vdout0_46ck1630 FIND v(dout0_46) AT=820.025n

.meas tran vdout0_47ck1630 FIND v(dout0_47) AT=820.025n

.meas tran vdout0_48ck1630 FIND v(dout0_48) AT=820.025n

.meas tran vdout0_49ck1630 FIND v(dout0_49) AT=820.025n

.meas tran vdout0_50ck1630 FIND v(dout0_50) AT=820.025n

.meas tran vdout0_51ck1630 FIND v(dout0_51) AT=820.025n

.meas tran vdout0_52ck1630 FIND v(dout0_52) AT=820.025n

.meas tran vdout0_53ck1630 FIND v(dout0_53) AT=820.025n

.meas tran vdout0_54ck1630 FIND v(dout0_54) AT=820.025n

.meas tran vdout0_55ck1630 FIND v(dout0_55) AT=820.025n

.meas tran vdout0_56ck1630 FIND v(dout0_56) AT=820.025n

.meas tran vdout0_57ck1630 FIND v(dout0_57) AT=820.025n

.meas tran vdout0_58ck1630 FIND v(dout0_58) AT=820.025n

.meas tran vdout0_59ck1630 FIND v(dout0_59) AT=820.025n

.meas tran vdout0_60ck1630 FIND v(dout0_60) AT=820.025n

.meas tran vdout0_61ck1630 FIND v(dout0_61) AT=820.025n

.meas tran vdout0_62ck1630 FIND v(dout0_62) AT=820.025n

.meas tran vdout0_63ck1630 FIND v(dout0_63) AT=820.025n

.meas tran vdout0_0ck1650 FIND v(dout0_0) AT=830.025n

.meas tran vdout0_1ck1650 FIND v(dout0_1) AT=830.025n

.meas tran vdout0_2ck1650 FIND v(dout0_2) AT=830.025n

.meas tran vdout0_3ck1650 FIND v(dout0_3) AT=830.025n

.meas tran vdout0_4ck1650 FIND v(dout0_4) AT=830.025n

.meas tran vdout0_5ck1650 FIND v(dout0_5) AT=830.025n

.meas tran vdout0_6ck1650 FIND v(dout0_6) AT=830.025n

.meas tran vdout0_7ck1650 FIND v(dout0_7) AT=830.025n

.meas tran vdout0_8ck1650 FIND v(dout0_8) AT=830.025n

.meas tran vdout0_9ck1650 FIND v(dout0_9) AT=830.025n

.meas tran vdout0_10ck1650 FIND v(dout0_10) AT=830.025n

.meas tran vdout0_11ck1650 FIND v(dout0_11) AT=830.025n

.meas tran vdout0_12ck1650 FIND v(dout0_12) AT=830.025n

.meas tran vdout0_13ck1650 FIND v(dout0_13) AT=830.025n

.meas tran vdout0_14ck1650 FIND v(dout0_14) AT=830.025n

.meas tran vdout0_15ck1650 FIND v(dout0_15) AT=830.025n

.meas tran vdout0_16ck1650 FIND v(dout0_16) AT=830.025n

.meas tran vdout0_17ck1650 FIND v(dout0_17) AT=830.025n

.meas tran vdout0_18ck1650 FIND v(dout0_18) AT=830.025n

.meas tran vdout0_19ck1650 FIND v(dout0_19) AT=830.025n

.meas tran vdout0_20ck1650 FIND v(dout0_20) AT=830.025n

.meas tran vdout0_21ck1650 FIND v(dout0_21) AT=830.025n

.meas tran vdout0_22ck1650 FIND v(dout0_22) AT=830.025n

.meas tran vdout0_23ck1650 FIND v(dout0_23) AT=830.025n

.meas tran vdout0_24ck1650 FIND v(dout0_24) AT=830.025n

.meas tran vdout0_25ck1650 FIND v(dout0_25) AT=830.025n

.meas tran vdout0_26ck1650 FIND v(dout0_26) AT=830.025n

.meas tran vdout0_27ck1650 FIND v(dout0_27) AT=830.025n

.meas tran vdout0_28ck1650 FIND v(dout0_28) AT=830.025n

.meas tran vdout0_29ck1650 FIND v(dout0_29) AT=830.025n

.meas tran vdout0_30ck1650 FIND v(dout0_30) AT=830.025n

.meas tran vdout0_31ck1650 FIND v(dout0_31) AT=830.025n

.meas tran vdout0_32ck1650 FIND v(dout0_32) AT=830.025n

.meas tran vdout0_33ck1650 FIND v(dout0_33) AT=830.025n

.meas tran vdout0_34ck1650 FIND v(dout0_34) AT=830.025n

.meas tran vdout0_35ck1650 FIND v(dout0_35) AT=830.025n

.meas tran vdout0_36ck1650 FIND v(dout0_36) AT=830.025n

.meas tran vdout0_37ck1650 FIND v(dout0_37) AT=830.025n

.meas tran vdout0_38ck1650 FIND v(dout0_38) AT=830.025n

.meas tran vdout0_39ck1650 FIND v(dout0_39) AT=830.025n

.meas tran vdout0_40ck1650 FIND v(dout0_40) AT=830.025n

.meas tran vdout0_41ck1650 FIND v(dout0_41) AT=830.025n

.meas tran vdout0_42ck1650 FIND v(dout0_42) AT=830.025n

.meas tran vdout0_43ck1650 FIND v(dout0_43) AT=830.025n

.meas tran vdout0_44ck1650 FIND v(dout0_44) AT=830.025n

.meas tran vdout0_45ck1650 FIND v(dout0_45) AT=830.025n

.meas tran vdout0_46ck1650 FIND v(dout0_46) AT=830.025n

.meas tran vdout0_47ck1650 FIND v(dout0_47) AT=830.025n

.meas tran vdout0_48ck1650 FIND v(dout0_48) AT=830.025n

.meas tran vdout0_49ck1650 FIND v(dout0_49) AT=830.025n

.meas tran vdout0_50ck1650 FIND v(dout0_50) AT=830.025n

.meas tran vdout0_51ck1650 FIND v(dout0_51) AT=830.025n

.meas tran vdout0_52ck1650 FIND v(dout0_52) AT=830.025n

.meas tran vdout0_53ck1650 FIND v(dout0_53) AT=830.025n

.meas tran vdout0_54ck1650 FIND v(dout0_54) AT=830.025n

.meas tran vdout0_55ck1650 FIND v(dout0_55) AT=830.025n

.meas tran vdout0_56ck1650 FIND v(dout0_56) AT=830.025n

.meas tran vdout0_57ck1650 FIND v(dout0_57) AT=830.025n

.meas tran vdout0_58ck1650 FIND v(dout0_58) AT=830.025n

.meas tran vdout0_59ck1650 FIND v(dout0_59) AT=830.025n

.meas tran vdout0_60ck1650 FIND v(dout0_60) AT=830.025n

.meas tran vdout0_61ck1650 FIND v(dout0_61) AT=830.025n

.meas tran vdout0_62ck1650 FIND v(dout0_62) AT=830.025n

.meas tran vdout0_63ck1650 FIND v(dout0_63) AT=830.025n

.meas tran vdout0_0ck1680 FIND v(dout0_0) AT=845.025n

.meas tran vdout0_1ck1680 FIND v(dout0_1) AT=845.025n

.meas tran vdout0_2ck1680 FIND v(dout0_2) AT=845.025n

.meas tran vdout0_3ck1680 FIND v(dout0_3) AT=845.025n

.meas tran vdout0_4ck1680 FIND v(dout0_4) AT=845.025n

.meas tran vdout0_5ck1680 FIND v(dout0_5) AT=845.025n

.meas tran vdout0_6ck1680 FIND v(dout0_6) AT=845.025n

.meas tran vdout0_7ck1680 FIND v(dout0_7) AT=845.025n

.meas tran vdout0_8ck1680 FIND v(dout0_8) AT=845.025n

.meas tran vdout0_9ck1680 FIND v(dout0_9) AT=845.025n

.meas tran vdout0_10ck1680 FIND v(dout0_10) AT=845.025n

.meas tran vdout0_11ck1680 FIND v(dout0_11) AT=845.025n

.meas tran vdout0_12ck1680 FIND v(dout0_12) AT=845.025n

.meas tran vdout0_13ck1680 FIND v(dout0_13) AT=845.025n

.meas tran vdout0_14ck1680 FIND v(dout0_14) AT=845.025n

.meas tran vdout0_15ck1680 FIND v(dout0_15) AT=845.025n

.meas tran vdout0_16ck1680 FIND v(dout0_16) AT=845.025n

.meas tran vdout0_17ck1680 FIND v(dout0_17) AT=845.025n

.meas tran vdout0_18ck1680 FIND v(dout0_18) AT=845.025n

.meas tran vdout0_19ck1680 FIND v(dout0_19) AT=845.025n

.meas tran vdout0_20ck1680 FIND v(dout0_20) AT=845.025n

.meas tran vdout0_21ck1680 FIND v(dout0_21) AT=845.025n

.meas tran vdout0_22ck1680 FIND v(dout0_22) AT=845.025n

.meas tran vdout0_23ck1680 FIND v(dout0_23) AT=845.025n

.meas tran vdout0_24ck1680 FIND v(dout0_24) AT=845.025n

.meas tran vdout0_25ck1680 FIND v(dout0_25) AT=845.025n

.meas tran vdout0_26ck1680 FIND v(dout0_26) AT=845.025n

.meas tran vdout0_27ck1680 FIND v(dout0_27) AT=845.025n

.meas tran vdout0_28ck1680 FIND v(dout0_28) AT=845.025n

.meas tran vdout0_29ck1680 FIND v(dout0_29) AT=845.025n

.meas tran vdout0_30ck1680 FIND v(dout0_30) AT=845.025n

.meas tran vdout0_31ck1680 FIND v(dout0_31) AT=845.025n

.meas tran vdout0_32ck1680 FIND v(dout0_32) AT=845.025n

.meas tran vdout0_33ck1680 FIND v(dout0_33) AT=845.025n

.meas tran vdout0_34ck1680 FIND v(dout0_34) AT=845.025n

.meas tran vdout0_35ck1680 FIND v(dout0_35) AT=845.025n

.meas tran vdout0_36ck1680 FIND v(dout0_36) AT=845.025n

.meas tran vdout0_37ck1680 FIND v(dout0_37) AT=845.025n

.meas tran vdout0_38ck1680 FIND v(dout0_38) AT=845.025n

.meas tran vdout0_39ck1680 FIND v(dout0_39) AT=845.025n

.meas tran vdout0_40ck1680 FIND v(dout0_40) AT=845.025n

.meas tran vdout0_41ck1680 FIND v(dout0_41) AT=845.025n

.meas tran vdout0_42ck1680 FIND v(dout0_42) AT=845.025n

.meas tran vdout0_43ck1680 FIND v(dout0_43) AT=845.025n

.meas tran vdout0_44ck1680 FIND v(dout0_44) AT=845.025n

.meas tran vdout0_45ck1680 FIND v(dout0_45) AT=845.025n

.meas tran vdout0_46ck1680 FIND v(dout0_46) AT=845.025n

.meas tran vdout0_47ck1680 FIND v(dout0_47) AT=845.025n

.meas tran vdout0_48ck1680 FIND v(dout0_48) AT=845.025n

.meas tran vdout0_49ck1680 FIND v(dout0_49) AT=845.025n

.meas tran vdout0_50ck1680 FIND v(dout0_50) AT=845.025n

.meas tran vdout0_51ck1680 FIND v(dout0_51) AT=845.025n

.meas tran vdout0_52ck1680 FIND v(dout0_52) AT=845.025n

.meas tran vdout0_53ck1680 FIND v(dout0_53) AT=845.025n

.meas tran vdout0_54ck1680 FIND v(dout0_54) AT=845.025n

.meas tran vdout0_55ck1680 FIND v(dout0_55) AT=845.025n

.meas tran vdout0_56ck1680 FIND v(dout0_56) AT=845.025n

.meas tran vdout0_57ck1680 FIND v(dout0_57) AT=845.025n

.meas tran vdout0_58ck1680 FIND v(dout0_58) AT=845.025n

.meas tran vdout0_59ck1680 FIND v(dout0_59) AT=845.025n

.meas tran vdout0_60ck1680 FIND v(dout0_60) AT=845.025n

.meas tran vdout0_61ck1680 FIND v(dout0_61) AT=845.025n

.meas tran vdout0_62ck1680 FIND v(dout0_62) AT=845.025n

.meas tran vdout0_63ck1680 FIND v(dout0_63) AT=845.025n

.meas tran vdout0_0ck1690 FIND v(dout0_0) AT=850.025n

.meas tran vdout0_1ck1690 FIND v(dout0_1) AT=850.025n

.meas tran vdout0_2ck1690 FIND v(dout0_2) AT=850.025n

.meas tran vdout0_3ck1690 FIND v(dout0_3) AT=850.025n

.meas tran vdout0_4ck1690 FIND v(dout0_4) AT=850.025n

.meas tran vdout0_5ck1690 FIND v(dout0_5) AT=850.025n

.meas tran vdout0_6ck1690 FIND v(dout0_6) AT=850.025n

.meas tran vdout0_7ck1690 FIND v(dout0_7) AT=850.025n

.meas tran vdout0_8ck1690 FIND v(dout0_8) AT=850.025n

.meas tran vdout0_9ck1690 FIND v(dout0_9) AT=850.025n

.meas tran vdout0_10ck1690 FIND v(dout0_10) AT=850.025n

.meas tran vdout0_11ck1690 FIND v(dout0_11) AT=850.025n

.meas tran vdout0_12ck1690 FIND v(dout0_12) AT=850.025n

.meas tran vdout0_13ck1690 FIND v(dout0_13) AT=850.025n

.meas tran vdout0_14ck1690 FIND v(dout0_14) AT=850.025n

.meas tran vdout0_15ck1690 FIND v(dout0_15) AT=850.025n

.meas tran vdout0_16ck1690 FIND v(dout0_16) AT=850.025n

.meas tran vdout0_17ck1690 FIND v(dout0_17) AT=850.025n

.meas tran vdout0_18ck1690 FIND v(dout0_18) AT=850.025n

.meas tran vdout0_19ck1690 FIND v(dout0_19) AT=850.025n

.meas tran vdout0_20ck1690 FIND v(dout0_20) AT=850.025n

.meas tran vdout0_21ck1690 FIND v(dout0_21) AT=850.025n

.meas tran vdout0_22ck1690 FIND v(dout0_22) AT=850.025n

.meas tran vdout0_23ck1690 FIND v(dout0_23) AT=850.025n

.meas tran vdout0_24ck1690 FIND v(dout0_24) AT=850.025n

.meas tran vdout0_25ck1690 FIND v(dout0_25) AT=850.025n

.meas tran vdout0_26ck1690 FIND v(dout0_26) AT=850.025n

.meas tran vdout0_27ck1690 FIND v(dout0_27) AT=850.025n

.meas tran vdout0_28ck1690 FIND v(dout0_28) AT=850.025n

.meas tran vdout0_29ck1690 FIND v(dout0_29) AT=850.025n

.meas tran vdout0_30ck1690 FIND v(dout0_30) AT=850.025n

.meas tran vdout0_31ck1690 FIND v(dout0_31) AT=850.025n

.meas tran vdout0_32ck1690 FIND v(dout0_32) AT=850.025n

.meas tran vdout0_33ck1690 FIND v(dout0_33) AT=850.025n

.meas tran vdout0_34ck1690 FIND v(dout0_34) AT=850.025n

.meas tran vdout0_35ck1690 FIND v(dout0_35) AT=850.025n

.meas tran vdout0_36ck1690 FIND v(dout0_36) AT=850.025n

.meas tran vdout0_37ck1690 FIND v(dout0_37) AT=850.025n

.meas tran vdout0_38ck1690 FIND v(dout0_38) AT=850.025n

.meas tran vdout0_39ck1690 FIND v(dout0_39) AT=850.025n

.meas tran vdout0_40ck1690 FIND v(dout0_40) AT=850.025n

.meas tran vdout0_41ck1690 FIND v(dout0_41) AT=850.025n

.meas tran vdout0_42ck1690 FIND v(dout0_42) AT=850.025n

.meas tran vdout0_43ck1690 FIND v(dout0_43) AT=850.025n

.meas tran vdout0_44ck1690 FIND v(dout0_44) AT=850.025n

.meas tran vdout0_45ck1690 FIND v(dout0_45) AT=850.025n

.meas tran vdout0_46ck1690 FIND v(dout0_46) AT=850.025n

.meas tran vdout0_47ck1690 FIND v(dout0_47) AT=850.025n

.meas tran vdout0_48ck1690 FIND v(dout0_48) AT=850.025n

.meas tran vdout0_49ck1690 FIND v(dout0_49) AT=850.025n

.meas tran vdout0_50ck1690 FIND v(dout0_50) AT=850.025n

.meas tran vdout0_51ck1690 FIND v(dout0_51) AT=850.025n

.meas tran vdout0_52ck1690 FIND v(dout0_52) AT=850.025n

.meas tran vdout0_53ck1690 FIND v(dout0_53) AT=850.025n

.meas tran vdout0_54ck1690 FIND v(dout0_54) AT=850.025n

.meas tran vdout0_55ck1690 FIND v(dout0_55) AT=850.025n

.meas tran vdout0_56ck1690 FIND v(dout0_56) AT=850.025n

.meas tran vdout0_57ck1690 FIND v(dout0_57) AT=850.025n

.meas tran vdout0_58ck1690 FIND v(dout0_58) AT=850.025n

.meas tran vdout0_59ck1690 FIND v(dout0_59) AT=850.025n

.meas tran vdout0_60ck1690 FIND v(dout0_60) AT=850.025n

.meas tran vdout0_61ck1690 FIND v(dout0_61) AT=850.025n

.meas tran vdout0_62ck1690 FIND v(dout0_62) AT=850.025n

.meas tran vdout0_63ck1690 FIND v(dout0_63) AT=850.025n

.meas tran vdout0_0ck1780 FIND v(dout0_0) AT=895.025n

.meas tran vdout0_1ck1780 FIND v(dout0_1) AT=895.025n

.meas tran vdout0_2ck1780 FIND v(dout0_2) AT=895.025n

.meas tran vdout0_3ck1780 FIND v(dout0_3) AT=895.025n

.meas tran vdout0_4ck1780 FIND v(dout0_4) AT=895.025n

.meas tran vdout0_5ck1780 FIND v(dout0_5) AT=895.025n

.meas tran vdout0_6ck1780 FIND v(dout0_6) AT=895.025n

.meas tran vdout0_7ck1780 FIND v(dout0_7) AT=895.025n

.meas tran vdout0_8ck1780 FIND v(dout0_8) AT=895.025n

.meas tran vdout0_9ck1780 FIND v(dout0_9) AT=895.025n

.meas tran vdout0_10ck1780 FIND v(dout0_10) AT=895.025n

.meas tran vdout0_11ck1780 FIND v(dout0_11) AT=895.025n

.meas tran vdout0_12ck1780 FIND v(dout0_12) AT=895.025n

.meas tran vdout0_13ck1780 FIND v(dout0_13) AT=895.025n

.meas tran vdout0_14ck1780 FIND v(dout0_14) AT=895.025n

.meas tran vdout0_15ck1780 FIND v(dout0_15) AT=895.025n

.meas tran vdout0_16ck1780 FIND v(dout0_16) AT=895.025n

.meas tran vdout0_17ck1780 FIND v(dout0_17) AT=895.025n

.meas tran vdout0_18ck1780 FIND v(dout0_18) AT=895.025n

.meas tran vdout0_19ck1780 FIND v(dout0_19) AT=895.025n

.meas tran vdout0_20ck1780 FIND v(dout0_20) AT=895.025n

.meas tran vdout0_21ck1780 FIND v(dout0_21) AT=895.025n

.meas tran vdout0_22ck1780 FIND v(dout0_22) AT=895.025n

.meas tran vdout0_23ck1780 FIND v(dout0_23) AT=895.025n

.meas tran vdout0_24ck1780 FIND v(dout0_24) AT=895.025n

.meas tran vdout0_25ck1780 FIND v(dout0_25) AT=895.025n

.meas tran vdout0_26ck1780 FIND v(dout0_26) AT=895.025n

.meas tran vdout0_27ck1780 FIND v(dout0_27) AT=895.025n

.meas tran vdout0_28ck1780 FIND v(dout0_28) AT=895.025n

.meas tran vdout0_29ck1780 FIND v(dout0_29) AT=895.025n

.meas tran vdout0_30ck1780 FIND v(dout0_30) AT=895.025n

.meas tran vdout0_31ck1780 FIND v(dout0_31) AT=895.025n

.meas tran vdout0_32ck1780 FIND v(dout0_32) AT=895.025n

.meas tran vdout0_33ck1780 FIND v(dout0_33) AT=895.025n

.meas tran vdout0_34ck1780 FIND v(dout0_34) AT=895.025n

.meas tran vdout0_35ck1780 FIND v(dout0_35) AT=895.025n

.meas tran vdout0_36ck1780 FIND v(dout0_36) AT=895.025n

.meas tran vdout0_37ck1780 FIND v(dout0_37) AT=895.025n

.meas tran vdout0_38ck1780 FIND v(dout0_38) AT=895.025n

.meas tran vdout0_39ck1780 FIND v(dout0_39) AT=895.025n

.meas tran vdout0_40ck1780 FIND v(dout0_40) AT=895.025n

.meas tran vdout0_41ck1780 FIND v(dout0_41) AT=895.025n

.meas tran vdout0_42ck1780 FIND v(dout0_42) AT=895.025n

.meas tran vdout0_43ck1780 FIND v(dout0_43) AT=895.025n

.meas tran vdout0_44ck1780 FIND v(dout0_44) AT=895.025n

.meas tran vdout0_45ck1780 FIND v(dout0_45) AT=895.025n

.meas tran vdout0_46ck1780 FIND v(dout0_46) AT=895.025n

.meas tran vdout0_47ck1780 FIND v(dout0_47) AT=895.025n

.meas tran vdout0_48ck1780 FIND v(dout0_48) AT=895.025n

.meas tran vdout0_49ck1780 FIND v(dout0_49) AT=895.025n

.meas tran vdout0_50ck1780 FIND v(dout0_50) AT=895.025n

.meas tran vdout0_51ck1780 FIND v(dout0_51) AT=895.025n

.meas tran vdout0_52ck1780 FIND v(dout0_52) AT=895.025n

.meas tran vdout0_53ck1780 FIND v(dout0_53) AT=895.025n

.meas tran vdout0_54ck1780 FIND v(dout0_54) AT=895.025n

.meas tran vdout0_55ck1780 FIND v(dout0_55) AT=895.025n

.meas tran vdout0_56ck1780 FIND v(dout0_56) AT=895.025n

.meas tran vdout0_57ck1780 FIND v(dout0_57) AT=895.025n

.meas tran vdout0_58ck1780 FIND v(dout0_58) AT=895.025n

.meas tran vdout0_59ck1780 FIND v(dout0_59) AT=895.025n

.meas tran vdout0_60ck1780 FIND v(dout0_60) AT=895.025n

.meas tran vdout0_61ck1780 FIND v(dout0_61) AT=895.025n

.meas tran vdout0_62ck1780 FIND v(dout0_62) AT=895.025n

.meas tran vdout0_63ck1780 FIND v(dout0_63) AT=895.025n

.meas tran vdout0_0ck1810 FIND v(dout0_0) AT=910.025n

.meas tran vdout0_1ck1810 FIND v(dout0_1) AT=910.025n

.meas tran vdout0_2ck1810 FIND v(dout0_2) AT=910.025n

.meas tran vdout0_3ck1810 FIND v(dout0_3) AT=910.025n

.meas tran vdout0_4ck1810 FIND v(dout0_4) AT=910.025n

.meas tran vdout0_5ck1810 FIND v(dout0_5) AT=910.025n

.meas tran vdout0_6ck1810 FIND v(dout0_6) AT=910.025n

.meas tran vdout0_7ck1810 FIND v(dout0_7) AT=910.025n

.meas tran vdout0_8ck1810 FIND v(dout0_8) AT=910.025n

.meas tran vdout0_9ck1810 FIND v(dout0_9) AT=910.025n

.meas tran vdout0_10ck1810 FIND v(dout0_10) AT=910.025n

.meas tran vdout0_11ck1810 FIND v(dout0_11) AT=910.025n

.meas tran vdout0_12ck1810 FIND v(dout0_12) AT=910.025n

.meas tran vdout0_13ck1810 FIND v(dout0_13) AT=910.025n

.meas tran vdout0_14ck1810 FIND v(dout0_14) AT=910.025n

.meas tran vdout0_15ck1810 FIND v(dout0_15) AT=910.025n

.meas tran vdout0_16ck1810 FIND v(dout0_16) AT=910.025n

.meas tran vdout0_17ck1810 FIND v(dout0_17) AT=910.025n

.meas tran vdout0_18ck1810 FIND v(dout0_18) AT=910.025n

.meas tran vdout0_19ck1810 FIND v(dout0_19) AT=910.025n

.meas tran vdout0_20ck1810 FIND v(dout0_20) AT=910.025n

.meas tran vdout0_21ck1810 FIND v(dout0_21) AT=910.025n

.meas tran vdout0_22ck1810 FIND v(dout0_22) AT=910.025n

.meas tran vdout0_23ck1810 FIND v(dout0_23) AT=910.025n

.meas tran vdout0_24ck1810 FIND v(dout0_24) AT=910.025n

.meas tran vdout0_25ck1810 FIND v(dout0_25) AT=910.025n

.meas tran vdout0_26ck1810 FIND v(dout0_26) AT=910.025n

.meas tran vdout0_27ck1810 FIND v(dout0_27) AT=910.025n

.meas tran vdout0_28ck1810 FIND v(dout0_28) AT=910.025n

.meas tran vdout0_29ck1810 FIND v(dout0_29) AT=910.025n

.meas tran vdout0_30ck1810 FIND v(dout0_30) AT=910.025n

.meas tran vdout0_31ck1810 FIND v(dout0_31) AT=910.025n

.meas tran vdout0_32ck1810 FIND v(dout0_32) AT=910.025n

.meas tran vdout0_33ck1810 FIND v(dout0_33) AT=910.025n

.meas tran vdout0_34ck1810 FIND v(dout0_34) AT=910.025n

.meas tran vdout0_35ck1810 FIND v(dout0_35) AT=910.025n

.meas tran vdout0_36ck1810 FIND v(dout0_36) AT=910.025n

.meas tran vdout0_37ck1810 FIND v(dout0_37) AT=910.025n

.meas tran vdout0_38ck1810 FIND v(dout0_38) AT=910.025n

.meas tran vdout0_39ck1810 FIND v(dout0_39) AT=910.025n

.meas tran vdout0_40ck1810 FIND v(dout0_40) AT=910.025n

.meas tran vdout0_41ck1810 FIND v(dout0_41) AT=910.025n

.meas tran vdout0_42ck1810 FIND v(dout0_42) AT=910.025n

.meas tran vdout0_43ck1810 FIND v(dout0_43) AT=910.025n

.meas tran vdout0_44ck1810 FIND v(dout0_44) AT=910.025n

.meas tran vdout0_45ck1810 FIND v(dout0_45) AT=910.025n

.meas tran vdout0_46ck1810 FIND v(dout0_46) AT=910.025n

.meas tran vdout0_47ck1810 FIND v(dout0_47) AT=910.025n

.meas tran vdout0_48ck1810 FIND v(dout0_48) AT=910.025n

.meas tran vdout0_49ck1810 FIND v(dout0_49) AT=910.025n

.meas tran vdout0_50ck1810 FIND v(dout0_50) AT=910.025n

.meas tran vdout0_51ck1810 FIND v(dout0_51) AT=910.025n

.meas tran vdout0_52ck1810 FIND v(dout0_52) AT=910.025n

.meas tran vdout0_53ck1810 FIND v(dout0_53) AT=910.025n

.meas tran vdout0_54ck1810 FIND v(dout0_54) AT=910.025n

.meas tran vdout0_55ck1810 FIND v(dout0_55) AT=910.025n

.meas tran vdout0_56ck1810 FIND v(dout0_56) AT=910.025n

.meas tran vdout0_57ck1810 FIND v(dout0_57) AT=910.025n

.meas tran vdout0_58ck1810 FIND v(dout0_58) AT=910.025n

.meas tran vdout0_59ck1810 FIND v(dout0_59) AT=910.025n

.meas tran vdout0_60ck1810 FIND v(dout0_60) AT=910.025n

.meas tran vdout0_61ck1810 FIND v(dout0_61) AT=910.025n

.meas tran vdout0_62ck1810 FIND v(dout0_62) AT=910.025n

.meas tran vdout0_63ck1810 FIND v(dout0_63) AT=910.025n

.meas tran vdout0_0ck1830 FIND v(dout0_0) AT=920.025n

.meas tran vdout0_1ck1830 FIND v(dout0_1) AT=920.025n

.meas tran vdout0_2ck1830 FIND v(dout0_2) AT=920.025n

.meas tran vdout0_3ck1830 FIND v(dout0_3) AT=920.025n

.meas tran vdout0_4ck1830 FIND v(dout0_4) AT=920.025n

.meas tran vdout0_5ck1830 FIND v(dout0_5) AT=920.025n

.meas tran vdout0_6ck1830 FIND v(dout0_6) AT=920.025n

.meas tran vdout0_7ck1830 FIND v(dout0_7) AT=920.025n

.meas tran vdout0_8ck1830 FIND v(dout0_8) AT=920.025n

.meas tran vdout0_9ck1830 FIND v(dout0_9) AT=920.025n

.meas tran vdout0_10ck1830 FIND v(dout0_10) AT=920.025n

.meas tran vdout0_11ck1830 FIND v(dout0_11) AT=920.025n

.meas tran vdout0_12ck1830 FIND v(dout0_12) AT=920.025n

.meas tran vdout0_13ck1830 FIND v(dout0_13) AT=920.025n

.meas tran vdout0_14ck1830 FIND v(dout0_14) AT=920.025n

.meas tran vdout0_15ck1830 FIND v(dout0_15) AT=920.025n

.meas tran vdout0_16ck1830 FIND v(dout0_16) AT=920.025n

.meas tran vdout0_17ck1830 FIND v(dout0_17) AT=920.025n

.meas tran vdout0_18ck1830 FIND v(dout0_18) AT=920.025n

.meas tran vdout0_19ck1830 FIND v(dout0_19) AT=920.025n

.meas tran vdout0_20ck1830 FIND v(dout0_20) AT=920.025n

.meas tran vdout0_21ck1830 FIND v(dout0_21) AT=920.025n

.meas tran vdout0_22ck1830 FIND v(dout0_22) AT=920.025n

.meas tran vdout0_23ck1830 FIND v(dout0_23) AT=920.025n

.meas tran vdout0_24ck1830 FIND v(dout0_24) AT=920.025n

.meas tran vdout0_25ck1830 FIND v(dout0_25) AT=920.025n

.meas tran vdout0_26ck1830 FIND v(dout0_26) AT=920.025n

.meas tran vdout0_27ck1830 FIND v(dout0_27) AT=920.025n

.meas tran vdout0_28ck1830 FIND v(dout0_28) AT=920.025n

.meas tran vdout0_29ck1830 FIND v(dout0_29) AT=920.025n

.meas tran vdout0_30ck1830 FIND v(dout0_30) AT=920.025n

.meas tran vdout0_31ck1830 FIND v(dout0_31) AT=920.025n

.meas tran vdout0_32ck1830 FIND v(dout0_32) AT=920.025n

.meas tran vdout0_33ck1830 FIND v(dout0_33) AT=920.025n

.meas tran vdout0_34ck1830 FIND v(dout0_34) AT=920.025n

.meas tran vdout0_35ck1830 FIND v(dout0_35) AT=920.025n

.meas tran vdout0_36ck1830 FIND v(dout0_36) AT=920.025n

.meas tran vdout0_37ck1830 FIND v(dout0_37) AT=920.025n

.meas tran vdout0_38ck1830 FIND v(dout0_38) AT=920.025n

.meas tran vdout0_39ck1830 FIND v(dout0_39) AT=920.025n

.meas tran vdout0_40ck1830 FIND v(dout0_40) AT=920.025n

.meas tran vdout0_41ck1830 FIND v(dout0_41) AT=920.025n

.meas tran vdout0_42ck1830 FIND v(dout0_42) AT=920.025n

.meas tran vdout0_43ck1830 FIND v(dout0_43) AT=920.025n

.meas tran vdout0_44ck1830 FIND v(dout0_44) AT=920.025n

.meas tran vdout0_45ck1830 FIND v(dout0_45) AT=920.025n

.meas tran vdout0_46ck1830 FIND v(dout0_46) AT=920.025n

.meas tran vdout0_47ck1830 FIND v(dout0_47) AT=920.025n

.meas tran vdout0_48ck1830 FIND v(dout0_48) AT=920.025n

.meas tran vdout0_49ck1830 FIND v(dout0_49) AT=920.025n

.meas tran vdout0_50ck1830 FIND v(dout0_50) AT=920.025n

.meas tran vdout0_51ck1830 FIND v(dout0_51) AT=920.025n

.meas tran vdout0_52ck1830 FIND v(dout0_52) AT=920.025n

.meas tran vdout0_53ck1830 FIND v(dout0_53) AT=920.025n

.meas tran vdout0_54ck1830 FIND v(dout0_54) AT=920.025n

.meas tran vdout0_55ck1830 FIND v(dout0_55) AT=920.025n

.meas tran vdout0_56ck1830 FIND v(dout0_56) AT=920.025n

.meas tran vdout0_57ck1830 FIND v(dout0_57) AT=920.025n

.meas tran vdout0_58ck1830 FIND v(dout0_58) AT=920.025n

.meas tran vdout0_59ck1830 FIND v(dout0_59) AT=920.025n

.meas tran vdout0_60ck1830 FIND v(dout0_60) AT=920.025n

.meas tran vdout0_61ck1830 FIND v(dout0_61) AT=920.025n

.meas tran vdout0_62ck1830 FIND v(dout0_62) AT=920.025n

.meas tran vdout0_63ck1830 FIND v(dout0_63) AT=920.025n

.meas tran vdout0_0ck1840 FIND v(dout0_0) AT=925.025n

.meas tran vdout0_1ck1840 FIND v(dout0_1) AT=925.025n

.meas tran vdout0_2ck1840 FIND v(dout0_2) AT=925.025n

.meas tran vdout0_3ck1840 FIND v(dout0_3) AT=925.025n

.meas tran vdout0_4ck1840 FIND v(dout0_4) AT=925.025n

.meas tran vdout0_5ck1840 FIND v(dout0_5) AT=925.025n

.meas tran vdout0_6ck1840 FIND v(dout0_6) AT=925.025n

.meas tran vdout0_7ck1840 FIND v(dout0_7) AT=925.025n

.meas tran vdout0_8ck1840 FIND v(dout0_8) AT=925.025n

.meas tran vdout0_9ck1840 FIND v(dout0_9) AT=925.025n

.meas tran vdout0_10ck1840 FIND v(dout0_10) AT=925.025n

.meas tran vdout0_11ck1840 FIND v(dout0_11) AT=925.025n

.meas tran vdout0_12ck1840 FIND v(dout0_12) AT=925.025n

.meas tran vdout0_13ck1840 FIND v(dout0_13) AT=925.025n

.meas tran vdout0_14ck1840 FIND v(dout0_14) AT=925.025n

.meas tran vdout0_15ck1840 FIND v(dout0_15) AT=925.025n

.meas tran vdout0_16ck1840 FIND v(dout0_16) AT=925.025n

.meas tran vdout0_17ck1840 FIND v(dout0_17) AT=925.025n

.meas tran vdout0_18ck1840 FIND v(dout0_18) AT=925.025n

.meas tran vdout0_19ck1840 FIND v(dout0_19) AT=925.025n

.meas tran vdout0_20ck1840 FIND v(dout0_20) AT=925.025n

.meas tran vdout0_21ck1840 FIND v(dout0_21) AT=925.025n

.meas tran vdout0_22ck1840 FIND v(dout0_22) AT=925.025n

.meas tran vdout0_23ck1840 FIND v(dout0_23) AT=925.025n

.meas tran vdout0_24ck1840 FIND v(dout0_24) AT=925.025n

.meas tran vdout0_25ck1840 FIND v(dout0_25) AT=925.025n

.meas tran vdout0_26ck1840 FIND v(dout0_26) AT=925.025n

.meas tran vdout0_27ck1840 FIND v(dout0_27) AT=925.025n

.meas tran vdout0_28ck1840 FIND v(dout0_28) AT=925.025n

.meas tran vdout0_29ck1840 FIND v(dout0_29) AT=925.025n

.meas tran vdout0_30ck1840 FIND v(dout0_30) AT=925.025n

.meas tran vdout0_31ck1840 FIND v(dout0_31) AT=925.025n

.meas tran vdout0_32ck1840 FIND v(dout0_32) AT=925.025n

.meas tran vdout0_33ck1840 FIND v(dout0_33) AT=925.025n

.meas tran vdout0_34ck1840 FIND v(dout0_34) AT=925.025n

.meas tran vdout0_35ck1840 FIND v(dout0_35) AT=925.025n

.meas tran vdout0_36ck1840 FIND v(dout0_36) AT=925.025n

.meas tran vdout0_37ck1840 FIND v(dout0_37) AT=925.025n

.meas tran vdout0_38ck1840 FIND v(dout0_38) AT=925.025n

.meas tran vdout0_39ck1840 FIND v(dout0_39) AT=925.025n

.meas tran vdout0_40ck1840 FIND v(dout0_40) AT=925.025n

.meas tran vdout0_41ck1840 FIND v(dout0_41) AT=925.025n

.meas tran vdout0_42ck1840 FIND v(dout0_42) AT=925.025n

.meas tran vdout0_43ck1840 FIND v(dout0_43) AT=925.025n

.meas tran vdout0_44ck1840 FIND v(dout0_44) AT=925.025n

.meas tran vdout0_45ck1840 FIND v(dout0_45) AT=925.025n

.meas tran vdout0_46ck1840 FIND v(dout0_46) AT=925.025n

.meas tran vdout0_47ck1840 FIND v(dout0_47) AT=925.025n

.meas tran vdout0_48ck1840 FIND v(dout0_48) AT=925.025n

.meas tran vdout0_49ck1840 FIND v(dout0_49) AT=925.025n

.meas tran vdout0_50ck1840 FIND v(dout0_50) AT=925.025n

.meas tran vdout0_51ck1840 FIND v(dout0_51) AT=925.025n

.meas tran vdout0_52ck1840 FIND v(dout0_52) AT=925.025n

.meas tran vdout0_53ck1840 FIND v(dout0_53) AT=925.025n

.meas tran vdout0_54ck1840 FIND v(dout0_54) AT=925.025n

.meas tran vdout0_55ck1840 FIND v(dout0_55) AT=925.025n

.meas tran vdout0_56ck1840 FIND v(dout0_56) AT=925.025n

.meas tran vdout0_57ck1840 FIND v(dout0_57) AT=925.025n

.meas tran vdout0_58ck1840 FIND v(dout0_58) AT=925.025n

.meas tran vdout0_59ck1840 FIND v(dout0_59) AT=925.025n

.meas tran vdout0_60ck1840 FIND v(dout0_60) AT=925.025n

.meas tran vdout0_61ck1840 FIND v(dout0_61) AT=925.025n

.meas tran vdout0_62ck1840 FIND v(dout0_62) AT=925.025n

.meas tran vdout0_63ck1840 FIND v(dout0_63) AT=925.025n

.meas tran vdout0_0ck1850 FIND v(dout0_0) AT=930.025n

.meas tran vdout0_1ck1850 FIND v(dout0_1) AT=930.025n

.meas tran vdout0_2ck1850 FIND v(dout0_2) AT=930.025n

.meas tran vdout0_3ck1850 FIND v(dout0_3) AT=930.025n

.meas tran vdout0_4ck1850 FIND v(dout0_4) AT=930.025n

.meas tran vdout0_5ck1850 FIND v(dout0_5) AT=930.025n

.meas tran vdout0_6ck1850 FIND v(dout0_6) AT=930.025n

.meas tran vdout0_7ck1850 FIND v(dout0_7) AT=930.025n

.meas tran vdout0_8ck1850 FIND v(dout0_8) AT=930.025n

.meas tran vdout0_9ck1850 FIND v(dout0_9) AT=930.025n

.meas tran vdout0_10ck1850 FIND v(dout0_10) AT=930.025n

.meas tran vdout0_11ck1850 FIND v(dout0_11) AT=930.025n

.meas tran vdout0_12ck1850 FIND v(dout0_12) AT=930.025n

.meas tran vdout0_13ck1850 FIND v(dout0_13) AT=930.025n

.meas tran vdout0_14ck1850 FIND v(dout0_14) AT=930.025n

.meas tran vdout0_15ck1850 FIND v(dout0_15) AT=930.025n

.meas tran vdout0_16ck1850 FIND v(dout0_16) AT=930.025n

.meas tran vdout0_17ck1850 FIND v(dout0_17) AT=930.025n

.meas tran vdout0_18ck1850 FIND v(dout0_18) AT=930.025n

.meas tran vdout0_19ck1850 FIND v(dout0_19) AT=930.025n

.meas tran vdout0_20ck1850 FIND v(dout0_20) AT=930.025n

.meas tran vdout0_21ck1850 FIND v(dout0_21) AT=930.025n

.meas tran vdout0_22ck1850 FIND v(dout0_22) AT=930.025n

.meas tran vdout0_23ck1850 FIND v(dout0_23) AT=930.025n

.meas tran vdout0_24ck1850 FIND v(dout0_24) AT=930.025n

.meas tran vdout0_25ck1850 FIND v(dout0_25) AT=930.025n

.meas tran vdout0_26ck1850 FIND v(dout0_26) AT=930.025n

.meas tran vdout0_27ck1850 FIND v(dout0_27) AT=930.025n

.meas tran vdout0_28ck1850 FIND v(dout0_28) AT=930.025n

.meas tran vdout0_29ck1850 FIND v(dout0_29) AT=930.025n

.meas tran vdout0_30ck1850 FIND v(dout0_30) AT=930.025n

.meas tran vdout0_31ck1850 FIND v(dout0_31) AT=930.025n

.meas tran vdout0_32ck1850 FIND v(dout0_32) AT=930.025n

.meas tran vdout0_33ck1850 FIND v(dout0_33) AT=930.025n

.meas tran vdout0_34ck1850 FIND v(dout0_34) AT=930.025n

.meas tran vdout0_35ck1850 FIND v(dout0_35) AT=930.025n

.meas tran vdout0_36ck1850 FIND v(dout0_36) AT=930.025n

.meas tran vdout0_37ck1850 FIND v(dout0_37) AT=930.025n

.meas tran vdout0_38ck1850 FIND v(dout0_38) AT=930.025n

.meas tran vdout0_39ck1850 FIND v(dout0_39) AT=930.025n

.meas tran vdout0_40ck1850 FIND v(dout0_40) AT=930.025n

.meas tran vdout0_41ck1850 FIND v(dout0_41) AT=930.025n

.meas tran vdout0_42ck1850 FIND v(dout0_42) AT=930.025n

.meas tran vdout0_43ck1850 FIND v(dout0_43) AT=930.025n

.meas tran vdout0_44ck1850 FIND v(dout0_44) AT=930.025n

.meas tran vdout0_45ck1850 FIND v(dout0_45) AT=930.025n

.meas tran vdout0_46ck1850 FIND v(dout0_46) AT=930.025n

.meas tran vdout0_47ck1850 FIND v(dout0_47) AT=930.025n

.meas tran vdout0_48ck1850 FIND v(dout0_48) AT=930.025n

.meas tran vdout0_49ck1850 FIND v(dout0_49) AT=930.025n

.meas tran vdout0_50ck1850 FIND v(dout0_50) AT=930.025n

.meas tran vdout0_51ck1850 FIND v(dout0_51) AT=930.025n

.meas tran vdout0_52ck1850 FIND v(dout0_52) AT=930.025n

.meas tran vdout0_53ck1850 FIND v(dout0_53) AT=930.025n

.meas tran vdout0_54ck1850 FIND v(dout0_54) AT=930.025n

.meas tran vdout0_55ck1850 FIND v(dout0_55) AT=930.025n

.meas tran vdout0_56ck1850 FIND v(dout0_56) AT=930.025n

.meas tran vdout0_57ck1850 FIND v(dout0_57) AT=930.025n

.meas tran vdout0_58ck1850 FIND v(dout0_58) AT=930.025n

.meas tran vdout0_59ck1850 FIND v(dout0_59) AT=930.025n

.meas tran vdout0_60ck1850 FIND v(dout0_60) AT=930.025n

.meas tran vdout0_61ck1850 FIND v(dout0_61) AT=930.025n

.meas tran vdout0_62ck1850 FIND v(dout0_62) AT=930.025n

.meas tran vdout0_63ck1850 FIND v(dout0_63) AT=930.025n

.meas tran vdout0_0ck1950 FIND v(dout0_0) AT=980.025n

.meas tran vdout0_1ck1950 FIND v(dout0_1) AT=980.025n

.meas tran vdout0_2ck1950 FIND v(dout0_2) AT=980.025n

.meas tran vdout0_3ck1950 FIND v(dout0_3) AT=980.025n

.meas tran vdout0_4ck1950 FIND v(dout0_4) AT=980.025n

.meas tran vdout0_5ck1950 FIND v(dout0_5) AT=980.025n

.meas tran vdout0_6ck1950 FIND v(dout0_6) AT=980.025n

.meas tran vdout0_7ck1950 FIND v(dout0_7) AT=980.025n

.meas tran vdout0_8ck1950 FIND v(dout0_8) AT=980.025n

.meas tran vdout0_9ck1950 FIND v(dout0_9) AT=980.025n

.meas tran vdout0_10ck1950 FIND v(dout0_10) AT=980.025n

.meas tran vdout0_11ck1950 FIND v(dout0_11) AT=980.025n

.meas tran vdout0_12ck1950 FIND v(dout0_12) AT=980.025n

.meas tran vdout0_13ck1950 FIND v(dout0_13) AT=980.025n

.meas tran vdout0_14ck1950 FIND v(dout0_14) AT=980.025n

.meas tran vdout0_15ck1950 FIND v(dout0_15) AT=980.025n

.meas tran vdout0_16ck1950 FIND v(dout0_16) AT=980.025n

.meas tran vdout0_17ck1950 FIND v(dout0_17) AT=980.025n

.meas tran vdout0_18ck1950 FIND v(dout0_18) AT=980.025n

.meas tran vdout0_19ck1950 FIND v(dout0_19) AT=980.025n

.meas tran vdout0_20ck1950 FIND v(dout0_20) AT=980.025n

.meas tran vdout0_21ck1950 FIND v(dout0_21) AT=980.025n

.meas tran vdout0_22ck1950 FIND v(dout0_22) AT=980.025n

.meas tran vdout0_23ck1950 FIND v(dout0_23) AT=980.025n

.meas tran vdout0_24ck1950 FIND v(dout0_24) AT=980.025n

.meas tran vdout0_25ck1950 FIND v(dout0_25) AT=980.025n

.meas tran vdout0_26ck1950 FIND v(dout0_26) AT=980.025n

.meas tran vdout0_27ck1950 FIND v(dout0_27) AT=980.025n

.meas tran vdout0_28ck1950 FIND v(dout0_28) AT=980.025n

.meas tran vdout0_29ck1950 FIND v(dout0_29) AT=980.025n

.meas tran vdout0_30ck1950 FIND v(dout0_30) AT=980.025n

.meas tran vdout0_31ck1950 FIND v(dout0_31) AT=980.025n

.meas tran vdout0_32ck1950 FIND v(dout0_32) AT=980.025n

.meas tran vdout0_33ck1950 FIND v(dout0_33) AT=980.025n

.meas tran vdout0_34ck1950 FIND v(dout0_34) AT=980.025n

.meas tran vdout0_35ck1950 FIND v(dout0_35) AT=980.025n

.meas tran vdout0_36ck1950 FIND v(dout0_36) AT=980.025n

.meas tran vdout0_37ck1950 FIND v(dout0_37) AT=980.025n

.meas tran vdout0_38ck1950 FIND v(dout0_38) AT=980.025n

.meas tran vdout0_39ck1950 FIND v(dout0_39) AT=980.025n

.meas tran vdout0_40ck1950 FIND v(dout0_40) AT=980.025n

.meas tran vdout0_41ck1950 FIND v(dout0_41) AT=980.025n

.meas tran vdout0_42ck1950 FIND v(dout0_42) AT=980.025n

.meas tran vdout0_43ck1950 FIND v(dout0_43) AT=980.025n

.meas tran vdout0_44ck1950 FIND v(dout0_44) AT=980.025n

.meas tran vdout0_45ck1950 FIND v(dout0_45) AT=980.025n

.meas tran vdout0_46ck1950 FIND v(dout0_46) AT=980.025n

.meas tran vdout0_47ck1950 FIND v(dout0_47) AT=980.025n

.meas tran vdout0_48ck1950 FIND v(dout0_48) AT=980.025n

.meas tran vdout0_49ck1950 FIND v(dout0_49) AT=980.025n

.meas tran vdout0_50ck1950 FIND v(dout0_50) AT=980.025n

.meas tran vdout0_51ck1950 FIND v(dout0_51) AT=980.025n

.meas tran vdout0_52ck1950 FIND v(dout0_52) AT=980.025n

.meas tran vdout0_53ck1950 FIND v(dout0_53) AT=980.025n

.meas tran vdout0_54ck1950 FIND v(dout0_54) AT=980.025n

.meas tran vdout0_55ck1950 FIND v(dout0_55) AT=980.025n

.meas tran vdout0_56ck1950 FIND v(dout0_56) AT=980.025n

.meas tran vdout0_57ck1950 FIND v(dout0_57) AT=980.025n

.meas tran vdout0_58ck1950 FIND v(dout0_58) AT=980.025n

.meas tran vdout0_59ck1950 FIND v(dout0_59) AT=980.025n

.meas tran vdout0_60ck1950 FIND v(dout0_60) AT=980.025n

.meas tran vdout0_61ck1950 FIND v(dout0_61) AT=980.025n

.meas tran vdout0_62ck1950 FIND v(dout0_62) AT=980.025n

.meas tran vdout0_63ck1950 FIND v(dout0_63) AT=980.025n

.meas tran vdout0_0ck2010 FIND v(dout0_0) AT=1010.025n

.meas tran vdout0_1ck2010 FIND v(dout0_1) AT=1010.025n

.meas tran vdout0_2ck2010 FIND v(dout0_2) AT=1010.025n

.meas tran vdout0_3ck2010 FIND v(dout0_3) AT=1010.025n

.meas tran vdout0_4ck2010 FIND v(dout0_4) AT=1010.025n

.meas tran vdout0_5ck2010 FIND v(dout0_5) AT=1010.025n

.meas tran vdout0_6ck2010 FIND v(dout0_6) AT=1010.025n

.meas tran vdout0_7ck2010 FIND v(dout0_7) AT=1010.025n

.meas tran vdout0_8ck2010 FIND v(dout0_8) AT=1010.025n

.meas tran vdout0_9ck2010 FIND v(dout0_9) AT=1010.025n

.meas tran vdout0_10ck2010 FIND v(dout0_10) AT=1010.025n

.meas tran vdout0_11ck2010 FIND v(dout0_11) AT=1010.025n

.meas tran vdout0_12ck2010 FIND v(dout0_12) AT=1010.025n

.meas tran vdout0_13ck2010 FIND v(dout0_13) AT=1010.025n

.meas tran vdout0_14ck2010 FIND v(dout0_14) AT=1010.025n

.meas tran vdout0_15ck2010 FIND v(dout0_15) AT=1010.025n

.meas tran vdout0_16ck2010 FIND v(dout0_16) AT=1010.025n

.meas tran vdout0_17ck2010 FIND v(dout0_17) AT=1010.025n

.meas tran vdout0_18ck2010 FIND v(dout0_18) AT=1010.025n

.meas tran vdout0_19ck2010 FIND v(dout0_19) AT=1010.025n

.meas tran vdout0_20ck2010 FIND v(dout0_20) AT=1010.025n

.meas tran vdout0_21ck2010 FIND v(dout0_21) AT=1010.025n

.meas tran vdout0_22ck2010 FIND v(dout0_22) AT=1010.025n

.meas tran vdout0_23ck2010 FIND v(dout0_23) AT=1010.025n

.meas tran vdout0_24ck2010 FIND v(dout0_24) AT=1010.025n

.meas tran vdout0_25ck2010 FIND v(dout0_25) AT=1010.025n

.meas tran vdout0_26ck2010 FIND v(dout0_26) AT=1010.025n

.meas tran vdout0_27ck2010 FIND v(dout0_27) AT=1010.025n

.meas tran vdout0_28ck2010 FIND v(dout0_28) AT=1010.025n

.meas tran vdout0_29ck2010 FIND v(dout0_29) AT=1010.025n

.meas tran vdout0_30ck2010 FIND v(dout0_30) AT=1010.025n

.meas tran vdout0_31ck2010 FIND v(dout0_31) AT=1010.025n

.meas tran vdout0_32ck2010 FIND v(dout0_32) AT=1010.025n

.meas tran vdout0_33ck2010 FIND v(dout0_33) AT=1010.025n

.meas tran vdout0_34ck2010 FIND v(dout0_34) AT=1010.025n

.meas tran vdout0_35ck2010 FIND v(dout0_35) AT=1010.025n

.meas tran vdout0_36ck2010 FIND v(dout0_36) AT=1010.025n

.meas tran vdout0_37ck2010 FIND v(dout0_37) AT=1010.025n

.meas tran vdout0_38ck2010 FIND v(dout0_38) AT=1010.025n

.meas tran vdout0_39ck2010 FIND v(dout0_39) AT=1010.025n

.meas tran vdout0_40ck2010 FIND v(dout0_40) AT=1010.025n

.meas tran vdout0_41ck2010 FIND v(dout0_41) AT=1010.025n

.meas tran vdout0_42ck2010 FIND v(dout0_42) AT=1010.025n

.meas tran vdout0_43ck2010 FIND v(dout0_43) AT=1010.025n

.meas tran vdout0_44ck2010 FIND v(dout0_44) AT=1010.025n

.meas tran vdout0_45ck2010 FIND v(dout0_45) AT=1010.025n

.meas tran vdout0_46ck2010 FIND v(dout0_46) AT=1010.025n

.meas tran vdout0_47ck2010 FIND v(dout0_47) AT=1010.025n

.meas tran vdout0_48ck2010 FIND v(dout0_48) AT=1010.025n

.meas tran vdout0_49ck2010 FIND v(dout0_49) AT=1010.025n

.meas tran vdout0_50ck2010 FIND v(dout0_50) AT=1010.025n

.meas tran vdout0_51ck2010 FIND v(dout0_51) AT=1010.025n

.meas tran vdout0_52ck2010 FIND v(dout0_52) AT=1010.025n

.meas tran vdout0_53ck2010 FIND v(dout0_53) AT=1010.025n

.meas tran vdout0_54ck2010 FIND v(dout0_54) AT=1010.025n

.meas tran vdout0_55ck2010 FIND v(dout0_55) AT=1010.025n

.meas tran vdout0_56ck2010 FIND v(dout0_56) AT=1010.025n

.meas tran vdout0_57ck2010 FIND v(dout0_57) AT=1010.025n

.meas tran vdout0_58ck2010 FIND v(dout0_58) AT=1010.025n

.meas tran vdout0_59ck2010 FIND v(dout0_59) AT=1010.025n

.meas tran vdout0_60ck2010 FIND v(dout0_60) AT=1010.025n

.meas tran vdout0_61ck2010 FIND v(dout0_61) AT=1010.025n

.meas tran vdout0_62ck2010 FIND v(dout0_62) AT=1010.025n

.meas tran vdout0_63ck2010 FIND v(dout0_63) AT=1010.025n

.meas tran vdout0_0ck2020 FIND v(dout0_0) AT=1015.025n

.meas tran vdout0_1ck2020 FIND v(dout0_1) AT=1015.025n

.meas tran vdout0_2ck2020 FIND v(dout0_2) AT=1015.025n

.meas tran vdout0_3ck2020 FIND v(dout0_3) AT=1015.025n

.meas tran vdout0_4ck2020 FIND v(dout0_4) AT=1015.025n

.meas tran vdout0_5ck2020 FIND v(dout0_5) AT=1015.025n

.meas tran vdout0_6ck2020 FIND v(dout0_6) AT=1015.025n

.meas tran vdout0_7ck2020 FIND v(dout0_7) AT=1015.025n

.meas tran vdout0_8ck2020 FIND v(dout0_8) AT=1015.025n

.meas tran vdout0_9ck2020 FIND v(dout0_9) AT=1015.025n

.meas tran vdout0_10ck2020 FIND v(dout0_10) AT=1015.025n

.meas tran vdout0_11ck2020 FIND v(dout0_11) AT=1015.025n

.meas tran vdout0_12ck2020 FIND v(dout0_12) AT=1015.025n

.meas tran vdout0_13ck2020 FIND v(dout0_13) AT=1015.025n

.meas tran vdout0_14ck2020 FIND v(dout0_14) AT=1015.025n

.meas tran vdout0_15ck2020 FIND v(dout0_15) AT=1015.025n

.meas tran vdout0_16ck2020 FIND v(dout0_16) AT=1015.025n

.meas tran vdout0_17ck2020 FIND v(dout0_17) AT=1015.025n

.meas tran vdout0_18ck2020 FIND v(dout0_18) AT=1015.025n

.meas tran vdout0_19ck2020 FIND v(dout0_19) AT=1015.025n

.meas tran vdout0_20ck2020 FIND v(dout0_20) AT=1015.025n

.meas tran vdout0_21ck2020 FIND v(dout0_21) AT=1015.025n

.meas tran vdout0_22ck2020 FIND v(dout0_22) AT=1015.025n

.meas tran vdout0_23ck2020 FIND v(dout0_23) AT=1015.025n

.meas tran vdout0_24ck2020 FIND v(dout0_24) AT=1015.025n

.meas tran vdout0_25ck2020 FIND v(dout0_25) AT=1015.025n

.meas tran vdout0_26ck2020 FIND v(dout0_26) AT=1015.025n

.meas tran vdout0_27ck2020 FIND v(dout0_27) AT=1015.025n

.meas tran vdout0_28ck2020 FIND v(dout0_28) AT=1015.025n

.meas tran vdout0_29ck2020 FIND v(dout0_29) AT=1015.025n

.meas tran vdout0_30ck2020 FIND v(dout0_30) AT=1015.025n

.meas tran vdout0_31ck2020 FIND v(dout0_31) AT=1015.025n

.meas tran vdout0_32ck2020 FIND v(dout0_32) AT=1015.025n

.meas tran vdout0_33ck2020 FIND v(dout0_33) AT=1015.025n

.meas tran vdout0_34ck2020 FIND v(dout0_34) AT=1015.025n

.meas tran vdout0_35ck2020 FIND v(dout0_35) AT=1015.025n

.meas tran vdout0_36ck2020 FIND v(dout0_36) AT=1015.025n

.meas tran vdout0_37ck2020 FIND v(dout0_37) AT=1015.025n

.meas tran vdout0_38ck2020 FIND v(dout0_38) AT=1015.025n

.meas tran vdout0_39ck2020 FIND v(dout0_39) AT=1015.025n

.meas tran vdout0_40ck2020 FIND v(dout0_40) AT=1015.025n

.meas tran vdout0_41ck2020 FIND v(dout0_41) AT=1015.025n

.meas tran vdout0_42ck2020 FIND v(dout0_42) AT=1015.025n

.meas tran vdout0_43ck2020 FIND v(dout0_43) AT=1015.025n

.meas tran vdout0_44ck2020 FIND v(dout0_44) AT=1015.025n

.meas tran vdout0_45ck2020 FIND v(dout0_45) AT=1015.025n

.meas tran vdout0_46ck2020 FIND v(dout0_46) AT=1015.025n

.meas tran vdout0_47ck2020 FIND v(dout0_47) AT=1015.025n

.meas tran vdout0_48ck2020 FIND v(dout0_48) AT=1015.025n

.meas tran vdout0_49ck2020 FIND v(dout0_49) AT=1015.025n

.meas tran vdout0_50ck2020 FIND v(dout0_50) AT=1015.025n

.meas tran vdout0_51ck2020 FIND v(dout0_51) AT=1015.025n

.meas tran vdout0_52ck2020 FIND v(dout0_52) AT=1015.025n

.meas tran vdout0_53ck2020 FIND v(dout0_53) AT=1015.025n

.meas tran vdout0_54ck2020 FIND v(dout0_54) AT=1015.025n

.meas tran vdout0_55ck2020 FIND v(dout0_55) AT=1015.025n

.meas tran vdout0_56ck2020 FIND v(dout0_56) AT=1015.025n

.meas tran vdout0_57ck2020 FIND v(dout0_57) AT=1015.025n

.meas tran vdout0_58ck2020 FIND v(dout0_58) AT=1015.025n

.meas tran vdout0_59ck2020 FIND v(dout0_59) AT=1015.025n

.meas tran vdout0_60ck2020 FIND v(dout0_60) AT=1015.025n

.meas tran vdout0_61ck2020 FIND v(dout0_61) AT=1015.025n

.meas tran vdout0_62ck2020 FIND v(dout0_62) AT=1015.025n

.meas tran vdout0_63ck2020 FIND v(dout0_63) AT=1015.025n

.meas tran vdout0_0ck2030 FIND v(dout0_0) AT=1020.025n

.meas tran vdout0_1ck2030 FIND v(dout0_1) AT=1020.025n

.meas tran vdout0_2ck2030 FIND v(dout0_2) AT=1020.025n

.meas tran vdout0_3ck2030 FIND v(dout0_3) AT=1020.025n

.meas tran vdout0_4ck2030 FIND v(dout0_4) AT=1020.025n

.meas tran vdout0_5ck2030 FIND v(dout0_5) AT=1020.025n

.meas tran vdout0_6ck2030 FIND v(dout0_6) AT=1020.025n

.meas tran vdout0_7ck2030 FIND v(dout0_7) AT=1020.025n

.meas tran vdout0_8ck2030 FIND v(dout0_8) AT=1020.025n

.meas tran vdout0_9ck2030 FIND v(dout0_9) AT=1020.025n

.meas tran vdout0_10ck2030 FIND v(dout0_10) AT=1020.025n

.meas tran vdout0_11ck2030 FIND v(dout0_11) AT=1020.025n

.meas tran vdout0_12ck2030 FIND v(dout0_12) AT=1020.025n

.meas tran vdout0_13ck2030 FIND v(dout0_13) AT=1020.025n

.meas tran vdout0_14ck2030 FIND v(dout0_14) AT=1020.025n

.meas tran vdout0_15ck2030 FIND v(dout0_15) AT=1020.025n

.meas tran vdout0_16ck2030 FIND v(dout0_16) AT=1020.025n

.meas tran vdout0_17ck2030 FIND v(dout0_17) AT=1020.025n

.meas tran vdout0_18ck2030 FIND v(dout0_18) AT=1020.025n

.meas tran vdout0_19ck2030 FIND v(dout0_19) AT=1020.025n

.meas tran vdout0_20ck2030 FIND v(dout0_20) AT=1020.025n

.meas tran vdout0_21ck2030 FIND v(dout0_21) AT=1020.025n

.meas tran vdout0_22ck2030 FIND v(dout0_22) AT=1020.025n

.meas tran vdout0_23ck2030 FIND v(dout0_23) AT=1020.025n

.meas tran vdout0_24ck2030 FIND v(dout0_24) AT=1020.025n

.meas tran vdout0_25ck2030 FIND v(dout0_25) AT=1020.025n

.meas tran vdout0_26ck2030 FIND v(dout0_26) AT=1020.025n

.meas tran vdout0_27ck2030 FIND v(dout0_27) AT=1020.025n

.meas tran vdout0_28ck2030 FIND v(dout0_28) AT=1020.025n

.meas tran vdout0_29ck2030 FIND v(dout0_29) AT=1020.025n

.meas tran vdout0_30ck2030 FIND v(dout0_30) AT=1020.025n

.meas tran vdout0_31ck2030 FIND v(dout0_31) AT=1020.025n

.meas tran vdout0_32ck2030 FIND v(dout0_32) AT=1020.025n

.meas tran vdout0_33ck2030 FIND v(dout0_33) AT=1020.025n

.meas tran vdout0_34ck2030 FIND v(dout0_34) AT=1020.025n

.meas tran vdout0_35ck2030 FIND v(dout0_35) AT=1020.025n

.meas tran vdout0_36ck2030 FIND v(dout0_36) AT=1020.025n

.meas tran vdout0_37ck2030 FIND v(dout0_37) AT=1020.025n

.meas tran vdout0_38ck2030 FIND v(dout0_38) AT=1020.025n

.meas tran vdout0_39ck2030 FIND v(dout0_39) AT=1020.025n

.meas tran vdout0_40ck2030 FIND v(dout0_40) AT=1020.025n

.meas tran vdout0_41ck2030 FIND v(dout0_41) AT=1020.025n

.meas tran vdout0_42ck2030 FIND v(dout0_42) AT=1020.025n

.meas tran vdout0_43ck2030 FIND v(dout0_43) AT=1020.025n

.meas tran vdout0_44ck2030 FIND v(dout0_44) AT=1020.025n

.meas tran vdout0_45ck2030 FIND v(dout0_45) AT=1020.025n

.meas tran vdout0_46ck2030 FIND v(dout0_46) AT=1020.025n

.meas tran vdout0_47ck2030 FIND v(dout0_47) AT=1020.025n

.meas tran vdout0_48ck2030 FIND v(dout0_48) AT=1020.025n

.meas tran vdout0_49ck2030 FIND v(dout0_49) AT=1020.025n

.meas tran vdout0_50ck2030 FIND v(dout0_50) AT=1020.025n

.meas tran vdout0_51ck2030 FIND v(dout0_51) AT=1020.025n

.meas tran vdout0_52ck2030 FIND v(dout0_52) AT=1020.025n

.meas tran vdout0_53ck2030 FIND v(dout0_53) AT=1020.025n

.meas tran vdout0_54ck2030 FIND v(dout0_54) AT=1020.025n

.meas tran vdout0_55ck2030 FIND v(dout0_55) AT=1020.025n

.meas tran vdout0_56ck2030 FIND v(dout0_56) AT=1020.025n

.meas tran vdout0_57ck2030 FIND v(dout0_57) AT=1020.025n

.meas tran vdout0_58ck2030 FIND v(dout0_58) AT=1020.025n

.meas tran vdout0_59ck2030 FIND v(dout0_59) AT=1020.025n

.meas tran vdout0_60ck2030 FIND v(dout0_60) AT=1020.025n

.meas tran vdout0_61ck2030 FIND v(dout0_61) AT=1020.025n

.meas tran vdout0_62ck2030 FIND v(dout0_62) AT=1020.025n

.meas tran vdout0_63ck2030 FIND v(dout0_63) AT=1020.025n
