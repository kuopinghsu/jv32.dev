.meas tran vdout0_0ck40 FIND v(dout0_0) AT=25.025n

.meas tran vdout0_1ck40 FIND v(dout0_1) AT=25.025n

.meas tran vdout0_2ck40 FIND v(dout0_2) AT=25.025n

.meas tran vdout0_3ck40 FIND v(dout0_3) AT=25.025n

.meas tran vdout0_4ck40 FIND v(dout0_4) AT=25.025n

.meas tran vdout0_5ck40 FIND v(dout0_5) AT=25.025n

.meas tran vdout0_6ck40 FIND v(dout0_6) AT=25.025n

.meas tran vdout0_7ck40 FIND v(dout0_7) AT=25.025n

.meas tran vdout0_8ck40 FIND v(dout0_8) AT=25.025n

.meas tran vdout0_9ck40 FIND v(dout0_9) AT=25.025n

.meas tran vdout0_10ck40 FIND v(dout0_10) AT=25.025n

.meas tran vdout0_11ck40 FIND v(dout0_11) AT=25.025n

.meas tran vdout0_12ck40 FIND v(dout0_12) AT=25.025n

.meas tran vdout0_13ck40 FIND v(dout0_13) AT=25.025n

.meas tran vdout0_14ck40 FIND v(dout0_14) AT=25.025n

.meas tran vdout0_15ck40 FIND v(dout0_15) AT=25.025n

.meas tran vdout0_16ck40 FIND v(dout0_16) AT=25.025n

.meas tran vdout0_17ck40 FIND v(dout0_17) AT=25.025n

.meas tran vdout0_18ck40 FIND v(dout0_18) AT=25.025n

.meas tran vdout0_19ck40 FIND v(dout0_19) AT=25.025n

.meas tran vdout0_20ck40 FIND v(dout0_20) AT=25.025n

.meas tran vdout0_21ck40 FIND v(dout0_21) AT=25.025n

.meas tran vdout0_22ck40 FIND v(dout0_22) AT=25.025n

.meas tran vdout0_23ck40 FIND v(dout0_23) AT=25.025n

.meas tran vdout0_24ck40 FIND v(dout0_24) AT=25.025n

.meas tran vdout0_25ck40 FIND v(dout0_25) AT=25.025n

.meas tran vdout0_26ck40 FIND v(dout0_26) AT=25.025n

.meas tran vdout0_27ck40 FIND v(dout0_27) AT=25.025n

.meas tran vdout0_28ck40 FIND v(dout0_28) AT=25.025n

.meas tran vdout0_29ck40 FIND v(dout0_29) AT=25.025n

.meas tran vdout0_30ck40 FIND v(dout0_30) AT=25.025n

.meas tran vdout0_31ck40 FIND v(dout0_31) AT=25.025n

.meas tran vdout0_0ck50 FIND v(dout0_0) AT=30.025n

.meas tran vdout0_1ck50 FIND v(dout0_1) AT=30.025n

.meas tran vdout0_2ck50 FIND v(dout0_2) AT=30.025n

.meas tran vdout0_3ck50 FIND v(dout0_3) AT=30.025n

.meas tran vdout0_4ck50 FIND v(dout0_4) AT=30.025n

.meas tran vdout0_5ck50 FIND v(dout0_5) AT=30.025n

.meas tran vdout0_6ck50 FIND v(dout0_6) AT=30.025n

.meas tran vdout0_7ck50 FIND v(dout0_7) AT=30.025n

.meas tran vdout0_8ck50 FIND v(dout0_8) AT=30.025n

.meas tran vdout0_9ck50 FIND v(dout0_9) AT=30.025n

.meas tran vdout0_10ck50 FIND v(dout0_10) AT=30.025n

.meas tran vdout0_11ck50 FIND v(dout0_11) AT=30.025n

.meas tran vdout0_12ck50 FIND v(dout0_12) AT=30.025n

.meas tran vdout0_13ck50 FIND v(dout0_13) AT=30.025n

.meas tran vdout0_14ck50 FIND v(dout0_14) AT=30.025n

.meas tran vdout0_15ck50 FIND v(dout0_15) AT=30.025n

.meas tran vdout0_16ck50 FIND v(dout0_16) AT=30.025n

.meas tran vdout0_17ck50 FIND v(dout0_17) AT=30.025n

.meas tran vdout0_18ck50 FIND v(dout0_18) AT=30.025n

.meas tran vdout0_19ck50 FIND v(dout0_19) AT=30.025n

.meas tran vdout0_20ck50 FIND v(dout0_20) AT=30.025n

.meas tran vdout0_21ck50 FIND v(dout0_21) AT=30.025n

.meas tran vdout0_22ck50 FIND v(dout0_22) AT=30.025n

.meas tran vdout0_23ck50 FIND v(dout0_23) AT=30.025n

.meas tran vdout0_24ck50 FIND v(dout0_24) AT=30.025n

.meas tran vdout0_25ck50 FIND v(dout0_25) AT=30.025n

.meas tran vdout0_26ck50 FIND v(dout0_26) AT=30.025n

.meas tran vdout0_27ck50 FIND v(dout0_27) AT=30.025n

.meas tran vdout0_28ck50 FIND v(dout0_28) AT=30.025n

.meas tran vdout0_29ck50 FIND v(dout0_29) AT=30.025n

.meas tran vdout0_30ck50 FIND v(dout0_30) AT=30.025n

.meas tran vdout0_31ck50 FIND v(dout0_31) AT=30.025n

.meas tran vdout0_0ck90 FIND v(dout0_0) AT=50.025n

.meas tran vdout0_1ck90 FIND v(dout0_1) AT=50.025n

.meas tran vdout0_2ck90 FIND v(dout0_2) AT=50.025n

.meas tran vdout0_3ck90 FIND v(dout0_3) AT=50.025n

.meas tran vdout0_4ck90 FIND v(dout0_4) AT=50.025n

.meas tran vdout0_5ck90 FIND v(dout0_5) AT=50.025n

.meas tran vdout0_6ck90 FIND v(dout0_6) AT=50.025n

.meas tran vdout0_7ck90 FIND v(dout0_7) AT=50.025n

.meas tran vdout0_8ck90 FIND v(dout0_8) AT=50.025n

.meas tran vdout0_9ck90 FIND v(dout0_9) AT=50.025n

.meas tran vdout0_10ck90 FIND v(dout0_10) AT=50.025n

.meas tran vdout0_11ck90 FIND v(dout0_11) AT=50.025n

.meas tran vdout0_12ck90 FIND v(dout0_12) AT=50.025n

.meas tran vdout0_13ck90 FIND v(dout0_13) AT=50.025n

.meas tran vdout0_14ck90 FIND v(dout0_14) AT=50.025n

.meas tran vdout0_15ck90 FIND v(dout0_15) AT=50.025n

.meas tran vdout0_16ck90 FIND v(dout0_16) AT=50.025n

.meas tran vdout0_17ck90 FIND v(dout0_17) AT=50.025n

.meas tran vdout0_18ck90 FIND v(dout0_18) AT=50.025n

.meas tran vdout0_19ck90 FIND v(dout0_19) AT=50.025n

.meas tran vdout0_20ck90 FIND v(dout0_20) AT=50.025n

.meas tran vdout0_21ck90 FIND v(dout0_21) AT=50.025n

.meas tran vdout0_22ck90 FIND v(dout0_22) AT=50.025n

.meas tran vdout0_23ck90 FIND v(dout0_23) AT=50.025n

.meas tran vdout0_24ck90 FIND v(dout0_24) AT=50.025n

.meas tran vdout0_25ck90 FIND v(dout0_25) AT=50.025n

.meas tran vdout0_26ck90 FIND v(dout0_26) AT=50.025n

.meas tran vdout0_27ck90 FIND v(dout0_27) AT=50.025n

.meas tran vdout0_28ck90 FIND v(dout0_28) AT=50.025n

.meas tran vdout0_29ck90 FIND v(dout0_29) AT=50.025n

.meas tran vdout0_30ck90 FIND v(dout0_30) AT=50.025n

.meas tran vdout0_31ck90 FIND v(dout0_31) AT=50.025n

.meas tran vdout0_0ck120 FIND v(dout0_0) AT=65.025n

.meas tran vdout0_1ck120 FIND v(dout0_1) AT=65.025n

.meas tran vdout0_2ck120 FIND v(dout0_2) AT=65.025n

.meas tran vdout0_3ck120 FIND v(dout0_3) AT=65.025n

.meas tran vdout0_4ck120 FIND v(dout0_4) AT=65.025n

.meas tran vdout0_5ck120 FIND v(dout0_5) AT=65.025n

.meas tran vdout0_6ck120 FIND v(dout0_6) AT=65.025n

.meas tran vdout0_7ck120 FIND v(dout0_7) AT=65.025n

.meas tran vdout0_8ck120 FIND v(dout0_8) AT=65.025n

.meas tran vdout0_9ck120 FIND v(dout0_9) AT=65.025n

.meas tran vdout0_10ck120 FIND v(dout0_10) AT=65.025n

.meas tran vdout0_11ck120 FIND v(dout0_11) AT=65.025n

.meas tran vdout0_12ck120 FIND v(dout0_12) AT=65.025n

.meas tran vdout0_13ck120 FIND v(dout0_13) AT=65.025n

.meas tran vdout0_14ck120 FIND v(dout0_14) AT=65.025n

.meas tran vdout0_15ck120 FIND v(dout0_15) AT=65.025n

.meas tran vdout0_16ck120 FIND v(dout0_16) AT=65.025n

.meas tran vdout0_17ck120 FIND v(dout0_17) AT=65.025n

.meas tran vdout0_18ck120 FIND v(dout0_18) AT=65.025n

.meas tran vdout0_19ck120 FIND v(dout0_19) AT=65.025n

.meas tran vdout0_20ck120 FIND v(dout0_20) AT=65.025n

.meas tran vdout0_21ck120 FIND v(dout0_21) AT=65.025n

.meas tran vdout0_22ck120 FIND v(dout0_22) AT=65.025n

.meas tran vdout0_23ck120 FIND v(dout0_23) AT=65.025n

.meas tran vdout0_24ck120 FIND v(dout0_24) AT=65.025n

.meas tran vdout0_25ck120 FIND v(dout0_25) AT=65.025n

.meas tran vdout0_26ck120 FIND v(dout0_26) AT=65.025n

.meas tran vdout0_27ck120 FIND v(dout0_27) AT=65.025n

.meas tran vdout0_28ck120 FIND v(dout0_28) AT=65.025n

.meas tran vdout0_29ck120 FIND v(dout0_29) AT=65.025n

.meas tran vdout0_30ck120 FIND v(dout0_30) AT=65.025n

.meas tran vdout0_31ck120 FIND v(dout0_31) AT=65.025n

.meas tran vdout0_0ck130 FIND v(dout0_0) AT=70.025n

.meas tran vdout0_1ck130 FIND v(dout0_1) AT=70.025n

.meas tran vdout0_2ck130 FIND v(dout0_2) AT=70.025n

.meas tran vdout0_3ck130 FIND v(dout0_3) AT=70.025n

.meas tran vdout0_4ck130 FIND v(dout0_4) AT=70.025n

.meas tran vdout0_5ck130 FIND v(dout0_5) AT=70.025n

.meas tran vdout0_6ck130 FIND v(dout0_6) AT=70.025n

.meas tran vdout0_7ck130 FIND v(dout0_7) AT=70.025n

.meas tran vdout0_8ck130 FIND v(dout0_8) AT=70.025n

.meas tran vdout0_9ck130 FIND v(dout0_9) AT=70.025n

.meas tran vdout0_10ck130 FIND v(dout0_10) AT=70.025n

.meas tran vdout0_11ck130 FIND v(dout0_11) AT=70.025n

.meas tran vdout0_12ck130 FIND v(dout0_12) AT=70.025n

.meas tran vdout0_13ck130 FIND v(dout0_13) AT=70.025n

.meas tran vdout0_14ck130 FIND v(dout0_14) AT=70.025n

.meas tran vdout0_15ck130 FIND v(dout0_15) AT=70.025n

.meas tran vdout0_16ck130 FIND v(dout0_16) AT=70.025n

.meas tran vdout0_17ck130 FIND v(dout0_17) AT=70.025n

.meas tran vdout0_18ck130 FIND v(dout0_18) AT=70.025n

.meas tran vdout0_19ck130 FIND v(dout0_19) AT=70.025n

.meas tran vdout0_20ck130 FIND v(dout0_20) AT=70.025n

.meas tran vdout0_21ck130 FIND v(dout0_21) AT=70.025n

.meas tran vdout0_22ck130 FIND v(dout0_22) AT=70.025n

.meas tran vdout0_23ck130 FIND v(dout0_23) AT=70.025n

.meas tran vdout0_24ck130 FIND v(dout0_24) AT=70.025n

.meas tran vdout0_25ck130 FIND v(dout0_25) AT=70.025n

.meas tran vdout0_26ck130 FIND v(dout0_26) AT=70.025n

.meas tran vdout0_27ck130 FIND v(dout0_27) AT=70.025n

.meas tran vdout0_28ck130 FIND v(dout0_28) AT=70.025n

.meas tran vdout0_29ck130 FIND v(dout0_29) AT=70.025n

.meas tran vdout0_30ck130 FIND v(dout0_30) AT=70.025n

.meas tran vdout0_31ck130 FIND v(dout0_31) AT=70.025n

.meas tran vdout0_0ck160 FIND v(dout0_0) AT=85.025n

.meas tran vdout0_1ck160 FIND v(dout0_1) AT=85.025n

.meas tran vdout0_2ck160 FIND v(dout0_2) AT=85.025n

.meas tran vdout0_3ck160 FIND v(dout0_3) AT=85.025n

.meas tran vdout0_4ck160 FIND v(dout0_4) AT=85.025n

.meas tran vdout0_5ck160 FIND v(dout0_5) AT=85.025n

.meas tran vdout0_6ck160 FIND v(dout0_6) AT=85.025n

.meas tran vdout0_7ck160 FIND v(dout0_7) AT=85.025n

.meas tran vdout0_8ck160 FIND v(dout0_8) AT=85.025n

.meas tran vdout0_9ck160 FIND v(dout0_9) AT=85.025n

.meas tran vdout0_10ck160 FIND v(dout0_10) AT=85.025n

.meas tran vdout0_11ck160 FIND v(dout0_11) AT=85.025n

.meas tran vdout0_12ck160 FIND v(dout0_12) AT=85.025n

.meas tran vdout0_13ck160 FIND v(dout0_13) AT=85.025n

.meas tran vdout0_14ck160 FIND v(dout0_14) AT=85.025n

.meas tran vdout0_15ck160 FIND v(dout0_15) AT=85.025n

.meas tran vdout0_16ck160 FIND v(dout0_16) AT=85.025n

.meas tran vdout0_17ck160 FIND v(dout0_17) AT=85.025n

.meas tran vdout0_18ck160 FIND v(dout0_18) AT=85.025n

.meas tran vdout0_19ck160 FIND v(dout0_19) AT=85.025n

.meas tran vdout0_20ck160 FIND v(dout0_20) AT=85.025n

.meas tran vdout0_21ck160 FIND v(dout0_21) AT=85.025n

.meas tran vdout0_22ck160 FIND v(dout0_22) AT=85.025n

.meas tran vdout0_23ck160 FIND v(dout0_23) AT=85.025n

.meas tran vdout0_24ck160 FIND v(dout0_24) AT=85.025n

.meas tran vdout0_25ck160 FIND v(dout0_25) AT=85.025n

.meas tran vdout0_26ck160 FIND v(dout0_26) AT=85.025n

.meas tran vdout0_27ck160 FIND v(dout0_27) AT=85.025n

.meas tran vdout0_28ck160 FIND v(dout0_28) AT=85.025n

.meas tran vdout0_29ck160 FIND v(dout0_29) AT=85.025n

.meas tran vdout0_30ck160 FIND v(dout0_30) AT=85.025n

.meas tran vdout0_31ck160 FIND v(dout0_31) AT=85.025n

.meas tran vdout0_0ck210 FIND v(dout0_0) AT=110.025n

.meas tran vdout0_1ck210 FIND v(dout0_1) AT=110.025n

.meas tran vdout0_2ck210 FIND v(dout0_2) AT=110.025n

.meas tran vdout0_3ck210 FIND v(dout0_3) AT=110.025n

.meas tran vdout0_4ck210 FIND v(dout0_4) AT=110.025n

.meas tran vdout0_5ck210 FIND v(dout0_5) AT=110.025n

.meas tran vdout0_6ck210 FIND v(dout0_6) AT=110.025n

.meas tran vdout0_7ck210 FIND v(dout0_7) AT=110.025n

.meas tran vdout0_8ck210 FIND v(dout0_8) AT=110.025n

.meas tran vdout0_9ck210 FIND v(dout0_9) AT=110.025n

.meas tran vdout0_10ck210 FIND v(dout0_10) AT=110.025n

.meas tran vdout0_11ck210 FIND v(dout0_11) AT=110.025n

.meas tran vdout0_12ck210 FIND v(dout0_12) AT=110.025n

.meas tran vdout0_13ck210 FIND v(dout0_13) AT=110.025n

.meas tran vdout0_14ck210 FIND v(dout0_14) AT=110.025n

.meas tran vdout0_15ck210 FIND v(dout0_15) AT=110.025n

.meas tran vdout0_16ck210 FIND v(dout0_16) AT=110.025n

.meas tran vdout0_17ck210 FIND v(dout0_17) AT=110.025n

.meas tran vdout0_18ck210 FIND v(dout0_18) AT=110.025n

.meas tran vdout0_19ck210 FIND v(dout0_19) AT=110.025n

.meas tran vdout0_20ck210 FIND v(dout0_20) AT=110.025n

.meas tran vdout0_21ck210 FIND v(dout0_21) AT=110.025n

.meas tran vdout0_22ck210 FIND v(dout0_22) AT=110.025n

.meas tran vdout0_23ck210 FIND v(dout0_23) AT=110.025n

.meas tran vdout0_24ck210 FIND v(dout0_24) AT=110.025n

.meas tran vdout0_25ck210 FIND v(dout0_25) AT=110.025n

.meas tran vdout0_26ck210 FIND v(dout0_26) AT=110.025n

.meas tran vdout0_27ck210 FIND v(dout0_27) AT=110.025n

.meas tran vdout0_28ck210 FIND v(dout0_28) AT=110.025n

.meas tran vdout0_29ck210 FIND v(dout0_29) AT=110.025n

.meas tran vdout0_30ck210 FIND v(dout0_30) AT=110.025n

.meas tran vdout0_31ck210 FIND v(dout0_31) AT=110.025n

.meas tran vdout0_0ck240 FIND v(dout0_0) AT=125.025n

.meas tran vdout0_1ck240 FIND v(dout0_1) AT=125.025n

.meas tran vdout0_2ck240 FIND v(dout0_2) AT=125.025n

.meas tran vdout0_3ck240 FIND v(dout0_3) AT=125.025n

.meas tran vdout0_4ck240 FIND v(dout0_4) AT=125.025n

.meas tran vdout0_5ck240 FIND v(dout0_5) AT=125.025n

.meas tran vdout0_6ck240 FIND v(dout0_6) AT=125.025n

.meas tran vdout0_7ck240 FIND v(dout0_7) AT=125.025n

.meas tran vdout0_8ck240 FIND v(dout0_8) AT=125.025n

.meas tran vdout0_9ck240 FIND v(dout0_9) AT=125.025n

.meas tran vdout0_10ck240 FIND v(dout0_10) AT=125.025n

.meas tran vdout0_11ck240 FIND v(dout0_11) AT=125.025n

.meas tran vdout0_12ck240 FIND v(dout0_12) AT=125.025n

.meas tran vdout0_13ck240 FIND v(dout0_13) AT=125.025n

.meas tran vdout0_14ck240 FIND v(dout0_14) AT=125.025n

.meas tran vdout0_15ck240 FIND v(dout0_15) AT=125.025n

.meas tran vdout0_16ck240 FIND v(dout0_16) AT=125.025n

.meas tran vdout0_17ck240 FIND v(dout0_17) AT=125.025n

.meas tran vdout0_18ck240 FIND v(dout0_18) AT=125.025n

.meas tran vdout0_19ck240 FIND v(dout0_19) AT=125.025n

.meas tran vdout0_20ck240 FIND v(dout0_20) AT=125.025n

.meas tran vdout0_21ck240 FIND v(dout0_21) AT=125.025n

.meas tran vdout0_22ck240 FIND v(dout0_22) AT=125.025n

.meas tran vdout0_23ck240 FIND v(dout0_23) AT=125.025n

.meas tran vdout0_24ck240 FIND v(dout0_24) AT=125.025n

.meas tran vdout0_25ck240 FIND v(dout0_25) AT=125.025n

.meas tran vdout0_26ck240 FIND v(dout0_26) AT=125.025n

.meas tran vdout0_27ck240 FIND v(dout0_27) AT=125.025n

.meas tran vdout0_28ck240 FIND v(dout0_28) AT=125.025n

.meas tran vdout0_29ck240 FIND v(dout0_29) AT=125.025n

.meas tran vdout0_30ck240 FIND v(dout0_30) AT=125.025n

.meas tran vdout0_31ck240 FIND v(dout0_31) AT=125.025n

.meas tran vdout0_0ck260 FIND v(dout0_0) AT=135.025n

.meas tran vdout0_1ck260 FIND v(dout0_1) AT=135.025n

.meas tran vdout0_2ck260 FIND v(dout0_2) AT=135.025n

.meas tran vdout0_3ck260 FIND v(dout0_3) AT=135.025n

.meas tran vdout0_4ck260 FIND v(dout0_4) AT=135.025n

.meas tran vdout0_5ck260 FIND v(dout0_5) AT=135.025n

.meas tran vdout0_6ck260 FIND v(dout0_6) AT=135.025n

.meas tran vdout0_7ck260 FIND v(dout0_7) AT=135.025n

.meas tran vdout0_8ck260 FIND v(dout0_8) AT=135.025n

.meas tran vdout0_9ck260 FIND v(dout0_9) AT=135.025n

.meas tran vdout0_10ck260 FIND v(dout0_10) AT=135.025n

.meas tran vdout0_11ck260 FIND v(dout0_11) AT=135.025n

.meas tran vdout0_12ck260 FIND v(dout0_12) AT=135.025n

.meas tran vdout0_13ck260 FIND v(dout0_13) AT=135.025n

.meas tran vdout0_14ck260 FIND v(dout0_14) AT=135.025n

.meas tran vdout0_15ck260 FIND v(dout0_15) AT=135.025n

.meas tran vdout0_16ck260 FIND v(dout0_16) AT=135.025n

.meas tran vdout0_17ck260 FIND v(dout0_17) AT=135.025n

.meas tran vdout0_18ck260 FIND v(dout0_18) AT=135.025n

.meas tran vdout0_19ck260 FIND v(dout0_19) AT=135.025n

.meas tran vdout0_20ck260 FIND v(dout0_20) AT=135.025n

.meas tran vdout0_21ck260 FIND v(dout0_21) AT=135.025n

.meas tran vdout0_22ck260 FIND v(dout0_22) AT=135.025n

.meas tran vdout0_23ck260 FIND v(dout0_23) AT=135.025n

.meas tran vdout0_24ck260 FIND v(dout0_24) AT=135.025n

.meas tran vdout0_25ck260 FIND v(dout0_25) AT=135.025n

.meas tran vdout0_26ck260 FIND v(dout0_26) AT=135.025n

.meas tran vdout0_27ck260 FIND v(dout0_27) AT=135.025n

.meas tran vdout0_28ck260 FIND v(dout0_28) AT=135.025n

.meas tran vdout0_29ck260 FIND v(dout0_29) AT=135.025n

.meas tran vdout0_30ck260 FIND v(dout0_30) AT=135.025n

.meas tran vdout0_31ck260 FIND v(dout0_31) AT=135.025n

.meas tran vdout0_0ck310 FIND v(dout0_0) AT=160.025n

.meas tran vdout0_1ck310 FIND v(dout0_1) AT=160.025n

.meas tran vdout0_2ck310 FIND v(dout0_2) AT=160.025n

.meas tran vdout0_3ck310 FIND v(dout0_3) AT=160.025n

.meas tran vdout0_4ck310 FIND v(dout0_4) AT=160.025n

.meas tran vdout0_5ck310 FIND v(dout0_5) AT=160.025n

.meas tran vdout0_6ck310 FIND v(dout0_6) AT=160.025n

.meas tran vdout0_7ck310 FIND v(dout0_7) AT=160.025n

.meas tran vdout0_8ck310 FIND v(dout0_8) AT=160.025n

.meas tran vdout0_9ck310 FIND v(dout0_9) AT=160.025n

.meas tran vdout0_10ck310 FIND v(dout0_10) AT=160.025n

.meas tran vdout0_11ck310 FIND v(dout0_11) AT=160.025n

.meas tran vdout0_12ck310 FIND v(dout0_12) AT=160.025n

.meas tran vdout0_13ck310 FIND v(dout0_13) AT=160.025n

.meas tran vdout0_14ck310 FIND v(dout0_14) AT=160.025n

.meas tran vdout0_15ck310 FIND v(dout0_15) AT=160.025n

.meas tran vdout0_16ck310 FIND v(dout0_16) AT=160.025n

.meas tran vdout0_17ck310 FIND v(dout0_17) AT=160.025n

.meas tran vdout0_18ck310 FIND v(dout0_18) AT=160.025n

.meas tran vdout0_19ck310 FIND v(dout0_19) AT=160.025n

.meas tran vdout0_20ck310 FIND v(dout0_20) AT=160.025n

.meas tran vdout0_21ck310 FIND v(dout0_21) AT=160.025n

.meas tran vdout0_22ck310 FIND v(dout0_22) AT=160.025n

.meas tran vdout0_23ck310 FIND v(dout0_23) AT=160.025n

.meas tran vdout0_24ck310 FIND v(dout0_24) AT=160.025n

.meas tran vdout0_25ck310 FIND v(dout0_25) AT=160.025n

.meas tran vdout0_26ck310 FIND v(dout0_26) AT=160.025n

.meas tran vdout0_27ck310 FIND v(dout0_27) AT=160.025n

.meas tran vdout0_28ck310 FIND v(dout0_28) AT=160.025n

.meas tran vdout0_29ck310 FIND v(dout0_29) AT=160.025n

.meas tran vdout0_30ck310 FIND v(dout0_30) AT=160.025n

.meas tran vdout0_31ck310 FIND v(dout0_31) AT=160.025n

.meas tran vdout0_0ck320 FIND v(dout0_0) AT=165.025n

.meas tran vdout0_1ck320 FIND v(dout0_1) AT=165.025n

.meas tran vdout0_2ck320 FIND v(dout0_2) AT=165.025n

.meas tran vdout0_3ck320 FIND v(dout0_3) AT=165.025n

.meas tran vdout0_4ck320 FIND v(dout0_4) AT=165.025n

.meas tran vdout0_5ck320 FIND v(dout0_5) AT=165.025n

.meas tran vdout0_6ck320 FIND v(dout0_6) AT=165.025n

.meas tran vdout0_7ck320 FIND v(dout0_7) AT=165.025n

.meas tran vdout0_8ck320 FIND v(dout0_8) AT=165.025n

.meas tran vdout0_9ck320 FIND v(dout0_9) AT=165.025n

.meas tran vdout0_10ck320 FIND v(dout0_10) AT=165.025n

.meas tran vdout0_11ck320 FIND v(dout0_11) AT=165.025n

.meas tran vdout0_12ck320 FIND v(dout0_12) AT=165.025n

.meas tran vdout0_13ck320 FIND v(dout0_13) AT=165.025n

.meas tran vdout0_14ck320 FIND v(dout0_14) AT=165.025n

.meas tran vdout0_15ck320 FIND v(dout0_15) AT=165.025n

.meas tran vdout0_16ck320 FIND v(dout0_16) AT=165.025n

.meas tran vdout0_17ck320 FIND v(dout0_17) AT=165.025n

.meas tran vdout0_18ck320 FIND v(dout0_18) AT=165.025n

.meas tran vdout0_19ck320 FIND v(dout0_19) AT=165.025n

.meas tran vdout0_20ck320 FIND v(dout0_20) AT=165.025n

.meas tran vdout0_21ck320 FIND v(dout0_21) AT=165.025n

.meas tran vdout0_22ck320 FIND v(dout0_22) AT=165.025n

.meas tran vdout0_23ck320 FIND v(dout0_23) AT=165.025n

.meas tran vdout0_24ck320 FIND v(dout0_24) AT=165.025n

.meas tran vdout0_25ck320 FIND v(dout0_25) AT=165.025n

.meas tran vdout0_26ck320 FIND v(dout0_26) AT=165.025n

.meas tran vdout0_27ck320 FIND v(dout0_27) AT=165.025n

.meas tran vdout0_28ck320 FIND v(dout0_28) AT=165.025n

.meas tran vdout0_29ck320 FIND v(dout0_29) AT=165.025n

.meas tran vdout0_30ck320 FIND v(dout0_30) AT=165.025n

.meas tran vdout0_31ck320 FIND v(dout0_31) AT=165.025n

.meas tran vdout0_0ck330 FIND v(dout0_0) AT=170.025n

.meas tran vdout0_1ck330 FIND v(dout0_1) AT=170.025n

.meas tran vdout0_2ck330 FIND v(dout0_2) AT=170.025n

.meas tran vdout0_3ck330 FIND v(dout0_3) AT=170.025n

.meas tran vdout0_4ck330 FIND v(dout0_4) AT=170.025n

.meas tran vdout0_5ck330 FIND v(dout0_5) AT=170.025n

.meas tran vdout0_6ck330 FIND v(dout0_6) AT=170.025n

.meas tran vdout0_7ck330 FIND v(dout0_7) AT=170.025n

.meas tran vdout0_8ck330 FIND v(dout0_8) AT=170.025n

.meas tran vdout0_9ck330 FIND v(dout0_9) AT=170.025n

.meas tran vdout0_10ck330 FIND v(dout0_10) AT=170.025n

.meas tran vdout0_11ck330 FIND v(dout0_11) AT=170.025n

.meas tran vdout0_12ck330 FIND v(dout0_12) AT=170.025n

.meas tran vdout0_13ck330 FIND v(dout0_13) AT=170.025n

.meas tran vdout0_14ck330 FIND v(dout0_14) AT=170.025n

.meas tran vdout0_15ck330 FIND v(dout0_15) AT=170.025n

.meas tran vdout0_16ck330 FIND v(dout0_16) AT=170.025n

.meas tran vdout0_17ck330 FIND v(dout0_17) AT=170.025n

.meas tran vdout0_18ck330 FIND v(dout0_18) AT=170.025n

.meas tran vdout0_19ck330 FIND v(dout0_19) AT=170.025n

.meas tran vdout0_20ck330 FIND v(dout0_20) AT=170.025n

.meas tran vdout0_21ck330 FIND v(dout0_21) AT=170.025n

.meas tran vdout0_22ck330 FIND v(dout0_22) AT=170.025n

.meas tran vdout0_23ck330 FIND v(dout0_23) AT=170.025n

.meas tran vdout0_24ck330 FIND v(dout0_24) AT=170.025n

.meas tran vdout0_25ck330 FIND v(dout0_25) AT=170.025n

.meas tran vdout0_26ck330 FIND v(dout0_26) AT=170.025n

.meas tran vdout0_27ck330 FIND v(dout0_27) AT=170.025n

.meas tran vdout0_28ck330 FIND v(dout0_28) AT=170.025n

.meas tran vdout0_29ck330 FIND v(dout0_29) AT=170.025n

.meas tran vdout0_30ck330 FIND v(dout0_30) AT=170.025n

.meas tran vdout0_31ck330 FIND v(dout0_31) AT=170.025n

.meas tran vdout0_0ck340 FIND v(dout0_0) AT=175.025n

.meas tran vdout0_1ck340 FIND v(dout0_1) AT=175.025n

.meas tran vdout0_2ck340 FIND v(dout0_2) AT=175.025n

.meas tran vdout0_3ck340 FIND v(dout0_3) AT=175.025n

.meas tran vdout0_4ck340 FIND v(dout0_4) AT=175.025n

.meas tran vdout0_5ck340 FIND v(dout0_5) AT=175.025n

.meas tran vdout0_6ck340 FIND v(dout0_6) AT=175.025n

.meas tran vdout0_7ck340 FIND v(dout0_7) AT=175.025n

.meas tran vdout0_8ck340 FIND v(dout0_8) AT=175.025n

.meas tran vdout0_9ck340 FIND v(dout0_9) AT=175.025n

.meas tran vdout0_10ck340 FIND v(dout0_10) AT=175.025n

.meas tran vdout0_11ck340 FIND v(dout0_11) AT=175.025n

.meas tran vdout0_12ck340 FIND v(dout0_12) AT=175.025n

.meas tran vdout0_13ck340 FIND v(dout0_13) AT=175.025n

.meas tran vdout0_14ck340 FIND v(dout0_14) AT=175.025n

.meas tran vdout0_15ck340 FIND v(dout0_15) AT=175.025n

.meas tran vdout0_16ck340 FIND v(dout0_16) AT=175.025n

.meas tran vdout0_17ck340 FIND v(dout0_17) AT=175.025n

.meas tran vdout0_18ck340 FIND v(dout0_18) AT=175.025n

.meas tran vdout0_19ck340 FIND v(dout0_19) AT=175.025n

.meas tran vdout0_20ck340 FIND v(dout0_20) AT=175.025n

.meas tran vdout0_21ck340 FIND v(dout0_21) AT=175.025n

.meas tran vdout0_22ck340 FIND v(dout0_22) AT=175.025n

.meas tran vdout0_23ck340 FIND v(dout0_23) AT=175.025n

.meas tran vdout0_24ck340 FIND v(dout0_24) AT=175.025n

.meas tran vdout0_25ck340 FIND v(dout0_25) AT=175.025n

.meas tran vdout0_26ck340 FIND v(dout0_26) AT=175.025n

.meas tran vdout0_27ck340 FIND v(dout0_27) AT=175.025n

.meas tran vdout0_28ck340 FIND v(dout0_28) AT=175.025n

.meas tran vdout0_29ck340 FIND v(dout0_29) AT=175.025n

.meas tran vdout0_30ck340 FIND v(dout0_30) AT=175.025n

.meas tran vdout0_31ck340 FIND v(dout0_31) AT=175.025n

.meas tran vdout0_0ck350 FIND v(dout0_0) AT=180.025n

.meas tran vdout0_1ck350 FIND v(dout0_1) AT=180.025n

.meas tran vdout0_2ck350 FIND v(dout0_2) AT=180.025n

.meas tran vdout0_3ck350 FIND v(dout0_3) AT=180.025n

.meas tran vdout0_4ck350 FIND v(dout0_4) AT=180.025n

.meas tran vdout0_5ck350 FIND v(dout0_5) AT=180.025n

.meas tran vdout0_6ck350 FIND v(dout0_6) AT=180.025n

.meas tran vdout0_7ck350 FIND v(dout0_7) AT=180.025n

.meas tran vdout0_8ck350 FIND v(dout0_8) AT=180.025n

.meas tran vdout0_9ck350 FIND v(dout0_9) AT=180.025n

.meas tran vdout0_10ck350 FIND v(dout0_10) AT=180.025n

.meas tran vdout0_11ck350 FIND v(dout0_11) AT=180.025n

.meas tran vdout0_12ck350 FIND v(dout0_12) AT=180.025n

.meas tran vdout0_13ck350 FIND v(dout0_13) AT=180.025n

.meas tran vdout0_14ck350 FIND v(dout0_14) AT=180.025n

.meas tran vdout0_15ck350 FIND v(dout0_15) AT=180.025n

.meas tran vdout0_16ck350 FIND v(dout0_16) AT=180.025n

.meas tran vdout0_17ck350 FIND v(dout0_17) AT=180.025n

.meas tran vdout0_18ck350 FIND v(dout0_18) AT=180.025n

.meas tran vdout0_19ck350 FIND v(dout0_19) AT=180.025n

.meas tran vdout0_20ck350 FIND v(dout0_20) AT=180.025n

.meas tran vdout0_21ck350 FIND v(dout0_21) AT=180.025n

.meas tran vdout0_22ck350 FIND v(dout0_22) AT=180.025n

.meas tran vdout0_23ck350 FIND v(dout0_23) AT=180.025n

.meas tran vdout0_24ck350 FIND v(dout0_24) AT=180.025n

.meas tran vdout0_25ck350 FIND v(dout0_25) AT=180.025n

.meas tran vdout0_26ck350 FIND v(dout0_26) AT=180.025n

.meas tran vdout0_27ck350 FIND v(dout0_27) AT=180.025n

.meas tran vdout0_28ck350 FIND v(dout0_28) AT=180.025n

.meas tran vdout0_29ck350 FIND v(dout0_29) AT=180.025n

.meas tran vdout0_30ck350 FIND v(dout0_30) AT=180.025n

.meas tran vdout0_31ck350 FIND v(dout0_31) AT=180.025n

.meas tran vdout0_0ck370 FIND v(dout0_0) AT=190.025n

.meas tran vdout0_1ck370 FIND v(dout0_1) AT=190.025n

.meas tran vdout0_2ck370 FIND v(dout0_2) AT=190.025n

.meas tran vdout0_3ck370 FIND v(dout0_3) AT=190.025n

.meas tran vdout0_4ck370 FIND v(dout0_4) AT=190.025n

.meas tran vdout0_5ck370 FIND v(dout0_5) AT=190.025n

.meas tran vdout0_6ck370 FIND v(dout0_6) AT=190.025n

.meas tran vdout0_7ck370 FIND v(dout0_7) AT=190.025n

.meas tran vdout0_8ck370 FIND v(dout0_8) AT=190.025n

.meas tran vdout0_9ck370 FIND v(dout0_9) AT=190.025n

.meas tran vdout0_10ck370 FIND v(dout0_10) AT=190.025n

.meas tran vdout0_11ck370 FIND v(dout0_11) AT=190.025n

.meas tran vdout0_12ck370 FIND v(dout0_12) AT=190.025n

.meas tran vdout0_13ck370 FIND v(dout0_13) AT=190.025n

.meas tran vdout0_14ck370 FIND v(dout0_14) AT=190.025n

.meas tran vdout0_15ck370 FIND v(dout0_15) AT=190.025n

.meas tran vdout0_16ck370 FIND v(dout0_16) AT=190.025n

.meas tran vdout0_17ck370 FIND v(dout0_17) AT=190.025n

.meas tran vdout0_18ck370 FIND v(dout0_18) AT=190.025n

.meas tran vdout0_19ck370 FIND v(dout0_19) AT=190.025n

.meas tran vdout0_20ck370 FIND v(dout0_20) AT=190.025n

.meas tran vdout0_21ck370 FIND v(dout0_21) AT=190.025n

.meas tran vdout0_22ck370 FIND v(dout0_22) AT=190.025n

.meas tran vdout0_23ck370 FIND v(dout0_23) AT=190.025n

.meas tran vdout0_24ck370 FIND v(dout0_24) AT=190.025n

.meas tran vdout0_25ck370 FIND v(dout0_25) AT=190.025n

.meas tran vdout0_26ck370 FIND v(dout0_26) AT=190.025n

.meas tran vdout0_27ck370 FIND v(dout0_27) AT=190.025n

.meas tran vdout0_28ck370 FIND v(dout0_28) AT=190.025n

.meas tran vdout0_29ck370 FIND v(dout0_29) AT=190.025n

.meas tran vdout0_30ck370 FIND v(dout0_30) AT=190.025n

.meas tran vdout0_31ck370 FIND v(dout0_31) AT=190.025n

.meas tran vdout0_0ck380 FIND v(dout0_0) AT=195.025n

.meas tran vdout0_1ck380 FIND v(dout0_1) AT=195.025n

.meas tran vdout0_2ck380 FIND v(dout0_2) AT=195.025n

.meas tran vdout0_3ck380 FIND v(dout0_3) AT=195.025n

.meas tran vdout0_4ck380 FIND v(dout0_4) AT=195.025n

.meas tran vdout0_5ck380 FIND v(dout0_5) AT=195.025n

.meas tran vdout0_6ck380 FIND v(dout0_6) AT=195.025n

.meas tran vdout0_7ck380 FIND v(dout0_7) AT=195.025n

.meas tran vdout0_8ck380 FIND v(dout0_8) AT=195.025n

.meas tran vdout0_9ck380 FIND v(dout0_9) AT=195.025n

.meas tran vdout0_10ck380 FIND v(dout0_10) AT=195.025n

.meas tran vdout0_11ck380 FIND v(dout0_11) AT=195.025n

.meas tran vdout0_12ck380 FIND v(dout0_12) AT=195.025n

.meas tran vdout0_13ck380 FIND v(dout0_13) AT=195.025n

.meas tran vdout0_14ck380 FIND v(dout0_14) AT=195.025n

.meas tran vdout0_15ck380 FIND v(dout0_15) AT=195.025n

.meas tran vdout0_16ck380 FIND v(dout0_16) AT=195.025n

.meas tran vdout0_17ck380 FIND v(dout0_17) AT=195.025n

.meas tran vdout0_18ck380 FIND v(dout0_18) AT=195.025n

.meas tran vdout0_19ck380 FIND v(dout0_19) AT=195.025n

.meas tran vdout0_20ck380 FIND v(dout0_20) AT=195.025n

.meas tran vdout0_21ck380 FIND v(dout0_21) AT=195.025n

.meas tran vdout0_22ck380 FIND v(dout0_22) AT=195.025n

.meas tran vdout0_23ck380 FIND v(dout0_23) AT=195.025n

.meas tran vdout0_24ck380 FIND v(dout0_24) AT=195.025n

.meas tran vdout0_25ck380 FIND v(dout0_25) AT=195.025n

.meas tran vdout0_26ck380 FIND v(dout0_26) AT=195.025n

.meas tran vdout0_27ck380 FIND v(dout0_27) AT=195.025n

.meas tran vdout0_28ck380 FIND v(dout0_28) AT=195.025n

.meas tran vdout0_29ck380 FIND v(dout0_29) AT=195.025n

.meas tran vdout0_30ck380 FIND v(dout0_30) AT=195.025n

.meas tran vdout0_31ck380 FIND v(dout0_31) AT=195.025n

.meas tran vdout0_0ck430 FIND v(dout0_0) AT=220.025n

.meas tran vdout0_1ck430 FIND v(dout0_1) AT=220.025n

.meas tran vdout0_2ck430 FIND v(dout0_2) AT=220.025n

.meas tran vdout0_3ck430 FIND v(dout0_3) AT=220.025n

.meas tran vdout0_4ck430 FIND v(dout0_4) AT=220.025n

.meas tran vdout0_5ck430 FIND v(dout0_5) AT=220.025n

.meas tran vdout0_6ck430 FIND v(dout0_6) AT=220.025n

.meas tran vdout0_7ck430 FIND v(dout0_7) AT=220.025n

.meas tran vdout0_8ck430 FIND v(dout0_8) AT=220.025n

.meas tran vdout0_9ck430 FIND v(dout0_9) AT=220.025n

.meas tran vdout0_10ck430 FIND v(dout0_10) AT=220.025n

.meas tran vdout0_11ck430 FIND v(dout0_11) AT=220.025n

.meas tran vdout0_12ck430 FIND v(dout0_12) AT=220.025n

.meas tran vdout0_13ck430 FIND v(dout0_13) AT=220.025n

.meas tran vdout0_14ck430 FIND v(dout0_14) AT=220.025n

.meas tran vdout0_15ck430 FIND v(dout0_15) AT=220.025n

.meas tran vdout0_16ck430 FIND v(dout0_16) AT=220.025n

.meas tran vdout0_17ck430 FIND v(dout0_17) AT=220.025n

.meas tran vdout0_18ck430 FIND v(dout0_18) AT=220.025n

.meas tran vdout0_19ck430 FIND v(dout0_19) AT=220.025n

.meas tran vdout0_20ck430 FIND v(dout0_20) AT=220.025n

.meas tran vdout0_21ck430 FIND v(dout0_21) AT=220.025n

.meas tran vdout0_22ck430 FIND v(dout0_22) AT=220.025n

.meas tran vdout0_23ck430 FIND v(dout0_23) AT=220.025n

.meas tran vdout0_24ck430 FIND v(dout0_24) AT=220.025n

.meas tran vdout0_25ck430 FIND v(dout0_25) AT=220.025n

.meas tran vdout0_26ck430 FIND v(dout0_26) AT=220.025n

.meas tran vdout0_27ck430 FIND v(dout0_27) AT=220.025n

.meas tran vdout0_28ck430 FIND v(dout0_28) AT=220.025n

.meas tran vdout0_29ck430 FIND v(dout0_29) AT=220.025n

.meas tran vdout0_30ck430 FIND v(dout0_30) AT=220.025n

.meas tran vdout0_31ck430 FIND v(dout0_31) AT=220.025n

.meas tran vdout0_0ck460 FIND v(dout0_0) AT=235.025n

.meas tran vdout0_1ck460 FIND v(dout0_1) AT=235.025n

.meas tran vdout0_2ck460 FIND v(dout0_2) AT=235.025n

.meas tran vdout0_3ck460 FIND v(dout0_3) AT=235.025n

.meas tran vdout0_4ck460 FIND v(dout0_4) AT=235.025n

.meas tran vdout0_5ck460 FIND v(dout0_5) AT=235.025n

.meas tran vdout0_6ck460 FIND v(dout0_6) AT=235.025n

.meas tran vdout0_7ck460 FIND v(dout0_7) AT=235.025n

.meas tran vdout0_8ck460 FIND v(dout0_8) AT=235.025n

.meas tran vdout0_9ck460 FIND v(dout0_9) AT=235.025n

.meas tran vdout0_10ck460 FIND v(dout0_10) AT=235.025n

.meas tran vdout0_11ck460 FIND v(dout0_11) AT=235.025n

.meas tran vdout0_12ck460 FIND v(dout0_12) AT=235.025n

.meas tran vdout0_13ck460 FIND v(dout0_13) AT=235.025n

.meas tran vdout0_14ck460 FIND v(dout0_14) AT=235.025n

.meas tran vdout0_15ck460 FIND v(dout0_15) AT=235.025n

.meas tran vdout0_16ck460 FIND v(dout0_16) AT=235.025n

.meas tran vdout0_17ck460 FIND v(dout0_17) AT=235.025n

.meas tran vdout0_18ck460 FIND v(dout0_18) AT=235.025n

.meas tran vdout0_19ck460 FIND v(dout0_19) AT=235.025n

.meas tran vdout0_20ck460 FIND v(dout0_20) AT=235.025n

.meas tran vdout0_21ck460 FIND v(dout0_21) AT=235.025n

.meas tran vdout0_22ck460 FIND v(dout0_22) AT=235.025n

.meas tran vdout0_23ck460 FIND v(dout0_23) AT=235.025n

.meas tran vdout0_24ck460 FIND v(dout0_24) AT=235.025n

.meas tran vdout0_25ck460 FIND v(dout0_25) AT=235.025n

.meas tran vdout0_26ck460 FIND v(dout0_26) AT=235.025n

.meas tran vdout0_27ck460 FIND v(dout0_27) AT=235.025n

.meas tran vdout0_28ck460 FIND v(dout0_28) AT=235.025n

.meas tran vdout0_29ck460 FIND v(dout0_29) AT=235.025n

.meas tran vdout0_30ck460 FIND v(dout0_30) AT=235.025n

.meas tran vdout0_31ck460 FIND v(dout0_31) AT=235.025n

.meas tran vdout0_0ck470 FIND v(dout0_0) AT=240.025n

.meas tran vdout0_1ck470 FIND v(dout0_1) AT=240.025n

.meas tran vdout0_2ck470 FIND v(dout0_2) AT=240.025n

.meas tran vdout0_3ck470 FIND v(dout0_3) AT=240.025n

.meas tran vdout0_4ck470 FIND v(dout0_4) AT=240.025n

.meas tran vdout0_5ck470 FIND v(dout0_5) AT=240.025n

.meas tran vdout0_6ck470 FIND v(dout0_6) AT=240.025n

.meas tran vdout0_7ck470 FIND v(dout0_7) AT=240.025n

.meas tran vdout0_8ck470 FIND v(dout0_8) AT=240.025n

.meas tran vdout0_9ck470 FIND v(dout0_9) AT=240.025n

.meas tran vdout0_10ck470 FIND v(dout0_10) AT=240.025n

.meas tran vdout0_11ck470 FIND v(dout0_11) AT=240.025n

.meas tran vdout0_12ck470 FIND v(dout0_12) AT=240.025n

.meas tran vdout0_13ck470 FIND v(dout0_13) AT=240.025n

.meas tran vdout0_14ck470 FIND v(dout0_14) AT=240.025n

.meas tran vdout0_15ck470 FIND v(dout0_15) AT=240.025n

.meas tran vdout0_16ck470 FIND v(dout0_16) AT=240.025n

.meas tran vdout0_17ck470 FIND v(dout0_17) AT=240.025n

.meas tran vdout0_18ck470 FIND v(dout0_18) AT=240.025n

.meas tran vdout0_19ck470 FIND v(dout0_19) AT=240.025n

.meas tran vdout0_20ck470 FIND v(dout0_20) AT=240.025n

.meas tran vdout0_21ck470 FIND v(dout0_21) AT=240.025n

.meas tran vdout0_22ck470 FIND v(dout0_22) AT=240.025n

.meas tran vdout0_23ck470 FIND v(dout0_23) AT=240.025n

.meas tran vdout0_24ck470 FIND v(dout0_24) AT=240.025n

.meas tran vdout0_25ck470 FIND v(dout0_25) AT=240.025n

.meas tran vdout0_26ck470 FIND v(dout0_26) AT=240.025n

.meas tran vdout0_27ck470 FIND v(dout0_27) AT=240.025n

.meas tran vdout0_28ck470 FIND v(dout0_28) AT=240.025n

.meas tran vdout0_29ck470 FIND v(dout0_29) AT=240.025n

.meas tran vdout0_30ck470 FIND v(dout0_30) AT=240.025n

.meas tran vdout0_31ck470 FIND v(dout0_31) AT=240.025n

.meas tran vdout0_0ck490 FIND v(dout0_0) AT=250.025n

.meas tran vdout0_1ck490 FIND v(dout0_1) AT=250.025n

.meas tran vdout0_2ck490 FIND v(dout0_2) AT=250.025n

.meas tran vdout0_3ck490 FIND v(dout0_3) AT=250.025n

.meas tran vdout0_4ck490 FIND v(dout0_4) AT=250.025n

.meas tran vdout0_5ck490 FIND v(dout0_5) AT=250.025n

.meas tran vdout0_6ck490 FIND v(dout0_6) AT=250.025n

.meas tran vdout0_7ck490 FIND v(dout0_7) AT=250.025n

.meas tran vdout0_8ck490 FIND v(dout0_8) AT=250.025n

.meas tran vdout0_9ck490 FIND v(dout0_9) AT=250.025n

.meas tran vdout0_10ck490 FIND v(dout0_10) AT=250.025n

.meas tran vdout0_11ck490 FIND v(dout0_11) AT=250.025n

.meas tran vdout0_12ck490 FIND v(dout0_12) AT=250.025n

.meas tran vdout0_13ck490 FIND v(dout0_13) AT=250.025n

.meas tran vdout0_14ck490 FIND v(dout0_14) AT=250.025n

.meas tran vdout0_15ck490 FIND v(dout0_15) AT=250.025n

.meas tran vdout0_16ck490 FIND v(dout0_16) AT=250.025n

.meas tran vdout0_17ck490 FIND v(dout0_17) AT=250.025n

.meas tran vdout0_18ck490 FIND v(dout0_18) AT=250.025n

.meas tran vdout0_19ck490 FIND v(dout0_19) AT=250.025n

.meas tran vdout0_20ck490 FIND v(dout0_20) AT=250.025n

.meas tran vdout0_21ck490 FIND v(dout0_21) AT=250.025n

.meas tran vdout0_22ck490 FIND v(dout0_22) AT=250.025n

.meas tran vdout0_23ck490 FIND v(dout0_23) AT=250.025n

.meas tran vdout0_24ck490 FIND v(dout0_24) AT=250.025n

.meas tran vdout0_25ck490 FIND v(dout0_25) AT=250.025n

.meas tran vdout0_26ck490 FIND v(dout0_26) AT=250.025n

.meas tran vdout0_27ck490 FIND v(dout0_27) AT=250.025n

.meas tran vdout0_28ck490 FIND v(dout0_28) AT=250.025n

.meas tran vdout0_29ck490 FIND v(dout0_29) AT=250.025n

.meas tran vdout0_30ck490 FIND v(dout0_30) AT=250.025n

.meas tran vdout0_31ck490 FIND v(dout0_31) AT=250.025n

.meas tran vdout0_0ck500 FIND v(dout0_0) AT=255.025n

.meas tran vdout0_1ck500 FIND v(dout0_1) AT=255.025n

.meas tran vdout0_2ck500 FIND v(dout0_2) AT=255.025n

.meas tran vdout0_3ck500 FIND v(dout0_3) AT=255.025n

.meas tran vdout0_4ck500 FIND v(dout0_4) AT=255.025n

.meas tran vdout0_5ck500 FIND v(dout0_5) AT=255.025n

.meas tran vdout0_6ck500 FIND v(dout0_6) AT=255.025n

.meas tran vdout0_7ck500 FIND v(dout0_7) AT=255.025n

.meas tran vdout0_8ck500 FIND v(dout0_8) AT=255.025n

.meas tran vdout0_9ck500 FIND v(dout0_9) AT=255.025n

.meas tran vdout0_10ck500 FIND v(dout0_10) AT=255.025n

.meas tran vdout0_11ck500 FIND v(dout0_11) AT=255.025n

.meas tran vdout0_12ck500 FIND v(dout0_12) AT=255.025n

.meas tran vdout0_13ck500 FIND v(dout0_13) AT=255.025n

.meas tran vdout0_14ck500 FIND v(dout0_14) AT=255.025n

.meas tran vdout0_15ck500 FIND v(dout0_15) AT=255.025n

.meas tran vdout0_16ck500 FIND v(dout0_16) AT=255.025n

.meas tran vdout0_17ck500 FIND v(dout0_17) AT=255.025n

.meas tran vdout0_18ck500 FIND v(dout0_18) AT=255.025n

.meas tran vdout0_19ck500 FIND v(dout0_19) AT=255.025n

.meas tran vdout0_20ck500 FIND v(dout0_20) AT=255.025n

.meas tran vdout0_21ck500 FIND v(dout0_21) AT=255.025n

.meas tran vdout0_22ck500 FIND v(dout0_22) AT=255.025n

.meas tran vdout0_23ck500 FIND v(dout0_23) AT=255.025n

.meas tran vdout0_24ck500 FIND v(dout0_24) AT=255.025n

.meas tran vdout0_25ck500 FIND v(dout0_25) AT=255.025n

.meas tran vdout0_26ck500 FIND v(dout0_26) AT=255.025n

.meas tran vdout0_27ck500 FIND v(dout0_27) AT=255.025n

.meas tran vdout0_28ck500 FIND v(dout0_28) AT=255.025n

.meas tran vdout0_29ck500 FIND v(dout0_29) AT=255.025n

.meas tran vdout0_30ck500 FIND v(dout0_30) AT=255.025n

.meas tran vdout0_31ck500 FIND v(dout0_31) AT=255.025n

.meas tran vdout0_0ck510 FIND v(dout0_0) AT=260.025n

.meas tran vdout0_1ck510 FIND v(dout0_1) AT=260.025n

.meas tran vdout0_2ck510 FIND v(dout0_2) AT=260.025n

.meas tran vdout0_3ck510 FIND v(dout0_3) AT=260.025n

.meas tran vdout0_4ck510 FIND v(dout0_4) AT=260.025n

.meas tran vdout0_5ck510 FIND v(dout0_5) AT=260.025n

.meas tran vdout0_6ck510 FIND v(dout0_6) AT=260.025n

.meas tran vdout0_7ck510 FIND v(dout0_7) AT=260.025n

.meas tran vdout0_8ck510 FIND v(dout0_8) AT=260.025n

.meas tran vdout0_9ck510 FIND v(dout0_9) AT=260.025n

.meas tran vdout0_10ck510 FIND v(dout0_10) AT=260.025n

.meas tran vdout0_11ck510 FIND v(dout0_11) AT=260.025n

.meas tran vdout0_12ck510 FIND v(dout0_12) AT=260.025n

.meas tran vdout0_13ck510 FIND v(dout0_13) AT=260.025n

.meas tran vdout0_14ck510 FIND v(dout0_14) AT=260.025n

.meas tran vdout0_15ck510 FIND v(dout0_15) AT=260.025n

.meas tran vdout0_16ck510 FIND v(dout0_16) AT=260.025n

.meas tran vdout0_17ck510 FIND v(dout0_17) AT=260.025n

.meas tran vdout0_18ck510 FIND v(dout0_18) AT=260.025n

.meas tran vdout0_19ck510 FIND v(dout0_19) AT=260.025n

.meas tran vdout0_20ck510 FIND v(dout0_20) AT=260.025n

.meas tran vdout0_21ck510 FIND v(dout0_21) AT=260.025n

.meas tran vdout0_22ck510 FIND v(dout0_22) AT=260.025n

.meas tran vdout0_23ck510 FIND v(dout0_23) AT=260.025n

.meas tran vdout0_24ck510 FIND v(dout0_24) AT=260.025n

.meas tran vdout0_25ck510 FIND v(dout0_25) AT=260.025n

.meas tran vdout0_26ck510 FIND v(dout0_26) AT=260.025n

.meas tran vdout0_27ck510 FIND v(dout0_27) AT=260.025n

.meas tran vdout0_28ck510 FIND v(dout0_28) AT=260.025n

.meas tran vdout0_29ck510 FIND v(dout0_29) AT=260.025n

.meas tran vdout0_30ck510 FIND v(dout0_30) AT=260.025n

.meas tran vdout0_31ck510 FIND v(dout0_31) AT=260.025n

.meas tran vdout0_0ck520 FIND v(dout0_0) AT=265.025n

.meas tran vdout0_1ck520 FIND v(dout0_1) AT=265.025n

.meas tran vdout0_2ck520 FIND v(dout0_2) AT=265.025n

.meas tran vdout0_3ck520 FIND v(dout0_3) AT=265.025n

.meas tran vdout0_4ck520 FIND v(dout0_4) AT=265.025n

.meas tran vdout0_5ck520 FIND v(dout0_5) AT=265.025n

.meas tran vdout0_6ck520 FIND v(dout0_6) AT=265.025n

.meas tran vdout0_7ck520 FIND v(dout0_7) AT=265.025n

.meas tran vdout0_8ck520 FIND v(dout0_8) AT=265.025n

.meas tran vdout0_9ck520 FIND v(dout0_9) AT=265.025n

.meas tran vdout0_10ck520 FIND v(dout0_10) AT=265.025n

.meas tran vdout0_11ck520 FIND v(dout0_11) AT=265.025n

.meas tran vdout0_12ck520 FIND v(dout0_12) AT=265.025n

.meas tran vdout0_13ck520 FIND v(dout0_13) AT=265.025n

.meas tran vdout0_14ck520 FIND v(dout0_14) AT=265.025n

.meas tran vdout0_15ck520 FIND v(dout0_15) AT=265.025n

.meas tran vdout0_16ck520 FIND v(dout0_16) AT=265.025n

.meas tran vdout0_17ck520 FIND v(dout0_17) AT=265.025n

.meas tran vdout0_18ck520 FIND v(dout0_18) AT=265.025n

.meas tran vdout0_19ck520 FIND v(dout0_19) AT=265.025n

.meas tran vdout0_20ck520 FIND v(dout0_20) AT=265.025n

.meas tran vdout0_21ck520 FIND v(dout0_21) AT=265.025n

.meas tran vdout0_22ck520 FIND v(dout0_22) AT=265.025n

.meas tran vdout0_23ck520 FIND v(dout0_23) AT=265.025n

.meas tran vdout0_24ck520 FIND v(dout0_24) AT=265.025n

.meas tran vdout0_25ck520 FIND v(dout0_25) AT=265.025n

.meas tran vdout0_26ck520 FIND v(dout0_26) AT=265.025n

.meas tran vdout0_27ck520 FIND v(dout0_27) AT=265.025n

.meas tran vdout0_28ck520 FIND v(dout0_28) AT=265.025n

.meas tran vdout0_29ck520 FIND v(dout0_29) AT=265.025n

.meas tran vdout0_30ck520 FIND v(dout0_30) AT=265.025n

.meas tran vdout0_31ck520 FIND v(dout0_31) AT=265.025n

.meas tran vdout0_0ck550 FIND v(dout0_0) AT=280.025n

.meas tran vdout0_1ck550 FIND v(dout0_1) AT=280.025n

.meas tran vdout0_2ck550 FIND v(dout0_2) AT=280.025n

.meas tran vdout0_3ck550 FIND v(dout0_3) AT=280.025n

.meas tran vdout0_4ck550 FIND v(dout0_4) AT=280.025n

.meas tran vdout0_5ck550 FIND v(dout0_5) AT=280.025n

.meas tran vdout0_6ck550 FIND v(dout0_6) AT=280.025n

.meas tran vdout0_7ck550 FIND v(dout0_7) AT=280.025n

.meas tran vdout0_8ck550 FIND v(dout0_8) AT=280.025n

.meas tran vdout0_9ck550 FIND v(dout0_9) AT=280.025n

.meas tran vdout0_10ck550 FIND v(dout0_10) AT=280.025n

.meas tran vdout0_11ck550 FIND v(dout0_11) AT=280.025n

.meas tran vdout0_12ck550 FIND v(dout0_12) AT=280.025n

.meas tran vdout0_13ck550 FIND v(dout0_13) AT=280.025n

.meas tran vdout0_14ck550 FIND v(dout0_14) AT=280.025n

.meas tran vdout0_15ck550 FIND v(dout0_15) AT=280.025n

.meas tran vdout0_16ck550 FIND v(dout0_16) AT=280.025n

.meas tran vdout0_17ck550 FIND v(dout0_17) AT=280.025n

.meas tran vdout0_18ck550 FIND v(dout0_18) AT=280.025n

.meas tran vdout0_19ck550 FIND v(dout0_19) AT=280.025n

.meas tran vdout0_20ck550 FIND v(dout0_20) AT=280.025n

.meas tran vdout0_21ck550 FIND v(dout0_21) AT=280.025n

.meas tran vdout0_22ck550 FIND v(dout0_22) AT=280.025n

.meas tran vdout0_23ck550 FIND v(dout0_23) AT=280.025n

.meas tran vdout0_24ck550 FIND v(dout0_24) AT=280.025n

.meas tran vdout0_25ck550 FIND v(dout0_25) AT=280.025n

.meas tran vdout0_26ck550 FIND v(dout0_26) AT=280.025n

.meas tran vdout0_27ck550 FIND v(dout0_27) AT=280.025n

.meas tran vdout0_28ck550 FIND v(dout0_28) AT=280.025n

.meas tran vdout0_29ck550 FIND v(dout0_29) AT=280.025n

.meas tran vdout0_30ck550 FIND v(dout0_30) AT=280.025n

.meas tran vdout0_31ck550 FIND v(dout0_31) AT=280.025n

.meas tran vdout0_0ck620 FIND v(dout0_0) AT=315.025n

.meas tran vdout0_1ck620 FIND v(dout0_1) AT=315.025n

.meas tran vdout0_2ck620 FIND v(dout0_2) AT=315.025n

.meas tran vdout0_3ck620 FIND v(dout0_3) AT=315.025n

.meas tran vdout0_4ck620 FIND v(dout0_4) AT=315.025n

.meas tran vdout0_5ck620 FIND v(dout0_5) AT=315.025n

.meas tran vdout0_6ck620 FIND v(dout0_6) AT=315.025n

.meas tran vdout0_7ck620 FIND v(dout0_7) AT=315.025n

.meas tran vdout0_8ck620 FIND v(dout0_8) AT=315.025n

.meas tran vdout0_9ck620 FIND v(dout0_9) AT=315.025n

.meas tran vdout0_10ck620 FIND v(dout0_10) AT=315.025n

.meas tran vdout0_11ck620 FIND v(dout0_11) AT=315.025n

.meas tran vdout0_12ck620 FIND v(dout0_12) AT=315.025n

.meas tran vdout0_13ck620 FIND v(dout0_13) AT=315.025n

.meas tran vdout0_14ck620 FIND v(dout0_14) AT=315.025n

.meas tran vdout0_15ck620 FIND v(dout0_15) AT=315.025n

.meas tran vdout0_16ck620 FIND v(dout0_16) AT=315.025n

.meas tran vdout0_17ck620 FIND v(dout0_17) AT=315.025n

.meas tran vdout0_18ck620 FIND v(dout0_18) AT=315.025n

.meas tran vdout0_19ck620 FIND v(dout0_19) AT=315.025n

.meas tran vdout0_20ck620 FIND v(dout0_20) AT=315.025n

.meas tran vdout0_21ck620 FIND v(dout0_21) AT=315.025n

.meas tran vdout0_22ck620 FIND v(dout0_22) AT=315.025n

.meas tran vdout0_23ck620 FIND v(dout0_23) AT=315.025n

.meas tran vdout0_24ck620 FIND v(dout0_24) AT=315.025n

.meas tran vdout0_25ck620 FIND v(dout0_25) AT=315.025n

.meas tran vdout0_26ck620 FIND v(dout0_26) AT=315.025n

.meas tran vdout0_27ck620 FIND v(dout0_27) AT=315.025n

.meas tran vdout0_28ck620 FIND v(dout0_28) AT=315.025n

.meas tran vdout0_29ck620 FIND v(dout0_29) AT=315.025n

.meas tran vdout0_30ck620 FIND v(dout0_30) AT=315.025n

.meas tran vdout0_31ck620 FIND v(dout0_31) AT=315.025n

.meas tran vdout0_0ck700 FIND v(dout0_0) AT=355.025n

.meas tran vdout0_1ck700 FIND v(dout0_1) AT=355.025n

.meas tran vdout0_2ck700 FIND v(dout0_2) AT=355.025n

.meas tran vdout0_3ck700 FIND v(dout0_3) AT=355.025n

.meas tran vdout0_4ck700 FIND v(dout0_4) AT=355.025n

.meas tran vdout0_5ck700 FIND v(dout0_5) AT=355.025n

.meas tran vdout0_6ck700 FIND v(dout0_6) AT=355.025n

.meas tran vdout0_7ck700 FIND v(dout0_7) AT=355.025n

.meas tran vdout0_8ck700 FIND v(dout0_8) AT=355.025n

.meas tran vdout0_9ck700 FIND v(dout0_9) AT=355.025n

.meas tran vdout0_10ck700 FIND v(dout0_10) AT=355.025n

.meas tran vdout0_11ck700 FIND v(dout0_11) AT=355.025n

.meas tran vdout0_12ck700 FIND v(dout0_12) AT=355.025n

.meas tran vdout0_13ck700 FIND v(dout0_13) AT=355.025n

.meas tran vdout0_14ck700 FIND v(dout0_14) AT=355.025n

.meas tran vdout0_15ck700 FIND v(dout0_15) AT=355.025n

.meas tran vdout0_16ck700 FIND v(dout0_16) AT=355.025n

.meas tran vdout0_17ck700 FIND v(dout0_17) AT=355.025n

.meas tran vdout0_18ck700 FIND v(dout0_18) AT=355.025n

.meas tran vdout0_19ck700 FIND v(dout0_19) AT=355.025n

.meas tran vdout0_20ck700 FIND v(dout0_20) AT=355.025n

.meas tran vdout0_21ck700 FIND v(dout0_21) AT=355.025n

.meas tran vdout0_22ck700 FIND v(dout0_22) AT=355.025n

.meas tran vdout0_23ck700 FIND v(dout0_23) AT=355.025n

.meas tran vdout0_24ck700 FIND v(dout0_24) AT=355.025n

.meas tran vdout0_25ck700 FIND v(dout0_25) AT=355.025n

.meas tran vdout0_26ck700 FIND v(dout0_26) AT=355.025n

.meas tran vdout0_27ck700 FIND v(dout0_27) AT=355.025n

.meas tran vdout0_28ck700 FIND v(dout0_28) AT=355.025n

.meas tran vdout0_29ck700 FIND v(dout0_29) AT=355.025n

.meas tran vdout0_30ck700 FIND v(dout0_30) AT=355.025n

.meas tran vdout0_31ck700 FIND v(dout0_31) AT=355.025n

.meas tran vdout0_0ck710 FIND v(dout0_0) AT=360.025n

.meas tran vdout0_1ck710 FIND v(dout0_1) AT=360.025n

.meas tran vdout0_2ck710 FIND v(dout0_2) AT=360.025n

.meas tran vdout0_3ck710 FIND v(dout0_3) AT=360.025n

.meas tran vdout0_4ck710 FIND v(dout0_4) AT=360.025n

.meas tran vdout0_5ck710 FIND v(dout0_5) AT=360.025n

.meas tran vdout0_6ck710 FIND v(dout0_6) AT=360.025n

.meas tran vdout0_7ck710 FIND v(dout0_7) AT=360.025n

.meas tran vdout0_8ck710 FIND v(dout0_8) AT=360.025n

.meas tran vdout0_9ck710 FIND v(dout0_9) AT=360.025n

.meas tran vdout0_10ck710 FIND v(dout0_10) AT=360.025n

.meas tran vdout0_11ck710 FIND v(dout0_11) AT=360.025n

.meas tran vdout0_12ck710 FIND v(dout0_12) AT=360.025n

.meas tran vdout0_13ck710 FIND v(dout0_13) AT=360.025n

.meas tran vdout0_14ck710 FIND v(dout0_14) AT=360.025n

.meas tran vdout0_15ck710 FIND v(dout0_15) AT=360.025n

.meas tran vdout0_16ck710 FIND v(dout0_16) AT=360.025n

.meas tran vdout0_17ck710 FIND v(dout0_17) AT=360.025n

.meas tran vdout0_18ck710 FIND v(dout0_18) AT=360.025n

.meas tran vdout0_19ck710 FIND v(dout0_19) AT=360.025n

.meas tran vdout0_20ck710 FIND v(dout0_20) AT=360.025n

.meas tran vdout0_21ck710 FIND v(dout0_21) AT=360.025n

.meas tran vdout0_22ck710 FIND v(dout0_22) AT=360.025n

.meas tran vdout0_23ck710 FIND v(dout0_23) AT=360.025n

.meas tran vdout0_24ck710 FIND v(dout0_24) AT=360.025n

.meas tran vdout0_25ck710 FIND v(dout0_25) AT=360.025n

.meas tran vdout0_26ck710 FIND v(dout0_26) AT=360.025n

.meas tran vdout0_27ck710 FIND v(dout0_27) AT=360.025n

.meas tran vdout0_28ck710 FIND v(dout0_28) AT=360.025n

.meas tran vdout0_29ck710 FIND v(dout0_29) AT=360.025n

.meas tran vdout0_30ck710 FIND v(dout0_30) AT=360.025n

.meas tran vdout0_31ck710 FIND v(dout0_31) AT=360.025n

.meas tran vdout0_0ck720 FIND v(dout0_0) AT=365.025n

.meas tran vdout0_1ck720 FIND v(dout0_1) AT=365.025n

.meas tran vdout0_2ck720 FIND v(dout0_2) AT=365.025n

.meas tran vdout0_3ck720 FIND v(dout0_3) AT=365.025n

.meas tran vdout0_4ck720 FIND v(dout0_4) AT=365.025n

.meas tran vdout0_5ck720 FIND v(dout0_5) AT=365.025n

.meas tran vdout0_6ck720 FIND v(dout0_6) AT=365.025n

.meas tran vdout0_7ck720 FIND v(dout0_7) AT=365.025n

.meas tran vdout0_8ck720 FIND v(dout0_8) AT=365.025n

.meas tran vdout0_9ck720 FIND v(dout0_9) AT=365.025n

.meas tran vdout0_10ck720 FIND v(dout0_10) AT=365.025n

.meas tran vdout0_11ck720 FIND v(dout0_11) AT=365.025n

.meas tran vdout0_12ck720 FIND v(dout0_12) AT=365.025n

.meas tran vdout0_13ck720 FIND v(dout0_13) AT=365.025n

.meas tran vdout0_14ck720 FIND v(dout0_14) AT=365.025n

.meas tran vdout0_15ck720 FIND v(dout0_15) AT=365.025n

.meas tran vdout0_16ck720 FIND v(dout0_16) AT=365.025n

.meas tran vdout0_17ck720 FIND v(dout0_17) AT=365.025n

.meas tran vdout0_18ck720 FIND v(dout0_18) AT=365.025n

.meas tran vdout0_19ck720 FIND v(dout0_19) AT=365.025n

.meas tran vdout0_20ck720 FIND v(dout0_20) AT=365.025n

.meas tran vdout0_21ck720 FIND v(dout0_21) AT=365.025n

.meas tran vdout0_22ck720 FIND v(dout0_22) AT=365.025n

.meas tran vdout0_23ck720 FIND v(dout0_23) AT=365.025n

.meas tran vdout0_24ck720 FIND v(dout0_24) AT=365.025n

.meas tran vdout0_25ck720 FIND v(dout0_25) AT=365.025n

.meas tran vdout0_26ck720 FIND v(dout0_26) AT=365.025n

.meas tran vdout0_27ck720 FIND v(dout0_27) AT=365.025n

.meas tran vdout0_28ck720 FIND v(dout0_28) AT=365.025n

.meas tran vdout0_29ck720 FIND v(dout0_29) AT=365.025n

.meas tran vdout0_30ck720 FIND v(dout0_30) AT=365.025n

.meas tran vdout0_31ck720 FIND v(dout0_31) AT=365.025n

.meas tran vdout0_0ck730 FIND v(dout0_0) AT=370.025n

.meas tran vdout0_1ck730 FIND v(dout0_1) AT=370.025n

.meas tran vdout0_2ck730 FIND v(dout0_2) AT=370.025n

.meas tran vdout0_3ck730 FIND v(dout0_3) AT=370.025n

.meas tran vdout0_4ck730 FIND v(dout0_4) AT=370.025n

.meas tran vdout0_5ck730 FIND v(dout0_5) AT=370.025n

.meas tran vdout0_6ck730 FIND v(dout0_6) AT=370.025n

.meas tran vdout0_7ck730 FIND v(dout0_7) AT=370.025n

.meas tran vdout0_8ck730 FIND v(dout0_8) AT=370.025n

.meas tran vdout0_9ck730 FIND v(dout0_9) AT=370.025n

.meas tran vdout0_10ck730 FIND v(dout0_10) AT=370.025n

.meas tran vdout0_11ck730 FIND v(dout0_11) AT=370.025n

.meas tran vdout0_12ck730 FIND v(dout0_12) AT=370.025n

.meas tran vdout0_13ck730 FIND v(dout0_13) AT=370.025n

.meas tran vdout0_14ck730 FIND v(dout0_14) AT=370.025n

.meas tran vdout0_15ck730 FIND v(dout0_15) AT=370.025n

.meas tran vdout0_16ck730 FIND v(dout0_16) AT=370.025n

.meas tran vdout0_17ck730 FIND v(dout0_17) AT=370.025n

.meas tran vdout0_18ck730 FIND v(dout0_18) AT=370.025n

.meas tran vdout0_19ck730 FIND v(dout0_19) AT=370.025n

.meas tran vdout0_20ck730 FIND v(dout0_20) AT=370.025n

.meas tran vdout0_21ck730 FIND v(dout0_21) AT=370.025n

.meas tran vdout0_22ck730 FIND v(dout0_22) AT=370.025n

.meas tran vdout0_23ck730 FIND v(dout0_23) AT=370.025n

.meas tran vdout0_24ck730 FIND v(dout0_24) AT=370.025n

.meas tran vdout0_25ck730 FIND v(dout0_25) AT=370.025n

.meas tran vdout0_26ck730 FIND v(dout0_26) AT=370.025n

.meas tran vdout0_27ck730 FIND v(dout0_27) AT=370.025n

.meas tran vdout0_28ck730 FIND v(dout0_28) AT=370.025n

.meas tran vdout0_29ck730 FIND v(dout0_29) AT=370.025n

.meas tran vdout0_30ck730 FIND v(dout0_30) AT=370.025n

.meas tran vdout0_31ck730 FIND v(dout0_31) AT=370.025n

.meas tran vdout0_0ck760 FIND v(dout0_0) AT=385.025n

.meas tran vdout0_1ck760 FIND v(dout0_1) AT=385.025n

.meas tran vdout0_2ck760 FIND v(dout0_2) AT=385.025n

.meas tran vdout0_3ck760 FIND v(dout0_3) AT=385.025n

.meas tran vdout0_4ck760 FIND v(dout0_4) AT=385.025n

.meas tran vdout0_5ck760 FIND v(dout0_5) AT=385.025n

.meas tran vdout0_6ck760 FIND v(dout0_6) AT=385.025n

.meas tran vdout0_7ck760 FIND v(dout0_7) AT=385.025n

.meas tran vdout0_8ck760 FIND v(dout0_8) AT=385.025n

.meas tran vdout0_9ck760 FIND v(dout0_9) AT=385.025n

.meas tran vdout0_10ck760 FIND v(dout0_10) AT=385.025n

.meas tran vdout0_11ck760 FIND v(dout0_11) AT=385.025n

.meas tran vdout0_12ck760 FIND v(dout0_12) AT=385.025n

.meas tran vdout0_13ck760 FIND v(dout0_13) AT=385.025n

.meas tran vdout0_14ck760 FIND v(dout0_14) AT=385.025n

.meas tran vdout0_15ck760 FIND v(dout0_15) AT=385.025n

.meas tran vdout0_16ck760 FIND v(dout0_16) AT=385.025n

.meas tran vdout0_17ck760 FIND v(dout0_17) AT=385.025n

.meas tran vdout0_18ck760 FIND v(dout0_18) AT=385.025n

.meas tran vdout0_19ck760 FIND v(dout0_19) AT=385.025n

.meas tran vdout0_20ck760 FIND v(dout0_20) AT=385.025n

.meas tran vdout0_21ck760 FIND v(dout0_21) AT=385.025n

.meas tran vdout0_22ck760 FIND v(dout0_22) AT=385.025n

.meas tran vdout0_23ck760 FIND v(dout0_23) AT=385.025n

.meas tran vdout0_24ck760 FIND v(dout0_24) AT=385.025n

.meas tran vdout0_25ck760 FIND v(dout0_25) AT=385.025n

.meas tran vdout0_26ck760 FIND v(dout0_26) AT=385.025n

.meas tran vdout0_27ck760 FIND v(dout0_27) AT=385.025n

.meas tran vdout0_28ck760 FIND v(dout0_28) AT=385.025n

.meas tran vdout0_29ck760 FIND v(dout0_29) AT=385.025n

.meas tran vdout0_30ck760 FIND v(dout0_30) AT=385.025n

.meas tran vdout0_31ck760 FIND v(dout0_31) AT=385.025n

.meas tran vdout0_0ck800 FIND v(dout0_0) AT=405.025n

.meas tran vdout0_1ck800 FIND v(dout0_1) AT=405.025n

.meas tran vdout0_2ck800 FIND v(dout0_2) AT=405.025n

.meas tran vdout0_3ck800 FIND v(dout0_3) AT=405.025n

.meas tran vdout0_4ck800 FIND v(dout0_4) AT=405.025n

.meas tran vdout0_5ck800 FIND v(dout0_5) AT=405.025n

.meas tran vdout0_6ck800 FIND v(dout0_6) AT=405.025n

.meas tran vdout0_7ck800 FIND v(dout0_7) AT=405.025n

.meas tran vdout0_8ck800 FIND v(dout0_8) AT=405.025n

.meas tran vdout0_9ck800 FIND v(dout0_9) AT=405.025n

.meas tran vdout0_10ck800 FIND v(dout0_10) AT=405.025n

.meas tran vdout0_11ck800 FIND v(dout0_11) AT=405.025n

.meas tran vdout0_12ck800 FIND v(dout0_12) AT=405.025n

.meas tran vdout0_13ck800 FIND v(dout0_13) AT=405.025n

.meas tran vdout0_14ck800 FIND v(dout0_14) AT=405.025n

.meas tran vdout0_15ck800 FIND v(dout0_15) AT=405.025n

.meas tran vdout0_16ck800 FIND v(dout0_16) AT=405.025n

.meas tran vdout0_17ck800 FIND v(dout0_17) AT=405.025n

.meas tran vdout0_18ck800 FIND v(dout0_18) AT=405.025n

.meas tran vdout0_19ck800 FIND v(dout0_19) AT=405.025n

.meas tran vdout0_20ck800 FIND v(dout0_20) AT=405.025n

.meas tran vdout0_21ck800 FIND v(dout0_21) AT=405.025n

.meas tran vdout0_22ck800 FIND v(dout0_22) AT=405.025n

.meas tran vdout0_23ck800 FIND v(dout0_23) AT=405.025n

.meas tran vdout0_24ck800 FIND v(dout0_24) AT=405.025n

.meas tran vdout0_25ck800 FIND v(dout0_25) AT=405.025n

.meas tran vdout0_26ck800 FIND v(dout0_26) AT=405.025n

.meas tran vdout0_27ck800 FIND v(dout0_27) AT=405.025n

.meas tran vdout0_28ck800 FIND v(dout0_28) AT=405.025n

.meas tran vdout0_29ck800 FIND v(dout0_29) AT=405.025n

.meas tran vdout0_30ck800 FIND v(dout0_30) AT=405.025n

.meas tran vdout0_31ck800 FIND v(dout0_31) AT=405.025n

.meas tran vdout0_0ck830 FIND v(dout0_0) AT=420.025n

.meas tran vdout0_1ck830 FIND v(dout0_1) AT=420.025n

.meas tran vdout0_2ck830 FIND v(dout0_2) AT=420.025n

.meas tran vdout0_3ck830 FIND v(dout0_3) AT=420.025n

.meas tran vdout0_4ck830 FIND v(dout0_4) AT=420.025n

.meas tran vdout0_5ck830 FIND v(dout0_5) AT=420.025n

.meas tran vdout0_6ck830 FIND v(dout0_6) AT=420.025n

.meas tran vdout0_7ck830 FIND v(dout0_7) AT=420.025n

.meas tran vdout0_8ck830 FIND v(dout0_8) AT=420.025n

.meas tran vdout0_9ck830 FIND v(dout0_9) AT=420.025n

.meas tran vdout0_10ck830 FIND v(dout0_10) AT=420.025n

.meas tran vdout0_11ck830 FIND v(dout0_11) AT=420.025n

.meas tran vdout0_12ck830 FIND v(dout0_12) AT=420.025n

.meas tran vdout0_13ck830 FIND v(dout0_13) AT=420.025n

.meas tran vdout0_14ck830 FIND v(dout0_14) AT=420.025n

.meas tran vdout0_15ck830 FIND v(dout0_15) AT=420.025n

.meas tran vdout0_16ck830 FIND v(dout0_16) AT=420.025n

.meas tran vdout0_17ck830 FIND v(dout0_17) AT=420.025n

.meas tran vdout0_18ck830 FIND v(dout0_18) AT=420.025n

.meas tran vdout0_19ck830 FIND v(dout0_19) AT=420.025n

.meas tran vdout0_20ck830 FIND v(dout0_20) AT=420.025n

.meas tran vdout0_21ck830 FIND v(dout0_21) AT=420.025n

.meas tran vdout0_22ck830 FIND v(dout0_22) AT=420.025n

.meas tran vdout0_23ck830 FIND v(dout0_23) AT=420.025n

.meas tran vdout0_24ck830 FIND v(dout0_24) AT=420.025n

.meas tran vdout0_25ck830 FIND v(dout0_25) AT=420.025n

.meas tran vdout0_26ck830 FIND v(dout0_26) AT=420.025n

.meas tran vdout0_27ck830 FIND v(dout0_27) AT=420.025n

.meas tran vdout0_28ck830 FIND v(dout0_28) AT=420.025n

.meas tran vdout0_29ck830 FIND v(dout0_29) AT=420.025n

.meas tran vdout0_30ck830 FIND v(dout0_30) AT=420.025n

.meas tran vdout0_31ck830 FIND v(dout0_31) AT=420.025n

.meas tran vdout0_0ck840 FIND v(dout0_0) AT=425.025n

.meas tran vdout0_1ck840 FIND v(dout0_1) AT=425.025n

.meas tran vdout0_2ck840 FIND v(dout0_2) AT=425.025n

.meas tran vdout0_3ck840 FIND v(dout0_3) AT=425.025n

.meas tran vdout0_4ck840 FIND v(dout0_4) AT=425.025n

.meas tran vdout0_5ck840 FIND v(dout0_5) AT=425.025n

.meas tran vdout0_6ck840 FIND v(dout0_6) AT=425.025n

.meas tran vdout0_7ck840 FIND v(dout0_7) AT=425.025n

.meas tran vdout0_8ck840 FIND v(dout0_8) AT=425.025n

.meas tran vdout0_9ck840 FIND v(dout0_9) AT=425.025n

.meas tran vdout0_10ck840 FIND v(dout0_10) AT=425.025n

.meas tran vdout0_11ck840 FIND v(dout0_11) AT=425.025n

.meas tran vdout0_12ck840 FIND v(dout0_12) AT=425.025n

.meas tran vdout0_13ck840 FIND v(dout0_13) AT=425.025n

.meas tran vdout0_14ck840 FIND v(dout0_14) AT=425.025n

.meas tran vdout0_15ck840 FIND v(dout0_15) AT=425.025n

.meas tran vdout0_16ck840 FIND v(dout0_16) AT=425.025n

.meas tran vdout0_17ck840 FIND v(dout0_17) AT=425.025n

.meas tran vdout0_18ck840 FIND v(dout0_18) AT=425.025n

.meas tran vdout0_19ck840 FIND v(dout0_19) AT=425.025n

.meas tran vdout0_20ck840 FIND v(dout0_20) AT=425.025n

.meas tran vdout0_21ck840 FIND v(dout0_21) AT=425.025n

.meas tran vdout0_22ck840 FIND v(dout0_22) AT=425.025n

.meas tran vdout0_23ck840 FIND v(dout0_23) AT=425.025n

.meas tran vdout0_24ck840 FIND v(dout0_24) AT=425.025n

.meas tran vdout0_25ck840 FIND v(dout0_25) AT=425.025n

.meas tran vdout0_26ck840 FIND v(dout0_26) AT=425.025n

.meas tran vdout0_27ck840 FIND v(dout0_27) AT=425.025n

.meas tran vdout0_28ck840 FIND v(dout0_28) AT=425.025n

.meas tran vdout0_29ck840 FIND v(dout0_29) AT=425.025n

.meas tran vdout0_30ck840 FIND v(dout0_30) AT=425.025n

.meas tran vdout0_31ck840 FIND v(dout0_31) AT=425.025n

.meas tran vdout0_0ck880 FIND v(dout0_0) AT=445.025n

.meas tran vdout0_1ck880 FIND v(dout0_1) AT=445.025n

.meas tran vdout0_2ck880 FIND v(dout0_2) AT=445.025n

.meas tran vdout0_3ck880 FIND v(dout0_3) AT=445.025n

.meas tran vdout0_4ck880 FIND v(dout0_4) AT=445.025n

.meas tran vdout0_5ck880 FIND v(dout0_5) AT=445.025n

.meas tran vdout0_6ck880 FIND v(dout0_6) AT=445.025n

.meas tran vdout0_7ck880 FIND v(dout0_7) AT=445.025n

.meas tran vdout0_8ck880 FIND v(dout0_8) AT=445.025n

.meas tran vdout0_9ck880 FIND v(dout0_9) AT=445.025n

.meas tran vdout0_10ck880 FIND v(dout0_10) AT=445.025n

.meas tran vdout0_11ck880 FIND v(dout0_11) AT=445.025n

.meas tran vdout0_12ck880 FIND v(dout0_12) AT=445.025n

.meas tran vdout0_13ck880 FIND v(dout0_13) AT=445.025n

.meas tran vdout0_14ck880 FIND v(dout0_14) AT=445.025n

.meas tran vdout0_15ck880 FIND v(dout0_15) AT=445.025n

.meas tran vdout0_16ck880 FIND v(dout0_16) AT=445.025n

.meas tran vdout0_17ck880 FIND v(dout0_17) AT=445.025n

.meas tran vdout0_18ck880 FIND v(dout0_18) AT=445.025n

.meas tran vdout0_19ck880 FIND v(dout0_19) AT=445.025n

.meas tran vdout0_20ck880 FIND v(dout0_20) AT=445.025n

.meas tran vdout0_21ck880 FIND v(dout0_21) AT=445.025n

.meas tran vdout0_22ck880 FIND v(dout0_22) AT=445.025n

.meas tran vdout0_23ck880 FIND v(dout0_23) AT=445.025n

.meas tran vdout0_24ck880 FIND v(dout0_24) AT=445.025n

.meas tran vdout0_25ck880 FIND v(dout0_25) AT=445.025n

.meas tran vdout0_26ck880 FIND v(dout0_26) AT=445.025n

.meas tran vdout0_27ck880 FIND v(dout0_27) AT=445.025n

.meas tran vdout0_28ck880 FIND v(dout0_28) AT=445.025n

.meas tran vdout0_29ck880 FIND v(dout0_29) AT=445.025n

.meas tran vdout0_30ck880 FIND v(dout0_30) AT=445.025n

.meas tran vdout0_31ck880 FIND v(dout0_31) AT=445.025n

.meas tran vdout0_0ck930 FIND v(dout0_0) AT=470.025n

.meas tran vdout0_1ck930 FIND v(dout0_1) AT=470.025n

.meas tran vdout0_2ck930 FIND v(dout0_2) AT=470.025n

.meas tran vdout0_3ck930 FIND v(dout0_3) AT=470.025n

.meas tran vdout0_4ck930 FIND v(dout0_4) AT=470.025n

.meas tran vdout0_5ck930 FIND v(dout0_5) AT=470.025n

.meas tran vdout0_6ck930 FIND v(dout0_6) AT=470.025n

.meas tran vdout0_7ck930 FIND v(dout0_7) AT=470.025n

.meas tran vdout0_8ck930 FIND v(dout0_8) AT=470.025n

.meas tran vdout0_9ck930 FIND v(dout0_9) AT=470.025n

.meas tran vdout0_10ck930 FIND v(dout0_10) AT=470.025n

.meas tran vdout0_11ck930 FIND v(dout0_11) AT=470.025n

.meas tran vdout0_12ck930 FIND v(dout0_12) AT=470.025n

.meas tran vdout0_13ck930 FIND v(dout0_13) AT=470.025n

.meas tran vdout0_14ck930 FIND v(dout0_14) AT=470.025n

.meas tran vdout0_15ck930 FIND v(dout0_15) AT=470.025n

.meas tran vdout0_16ck930 FIND v(dout0_16) AT=470.025n

.meas tran vdout0_17ck930 FIND v(dout0_17) AT=470.025n

.meas tran vdout0_18ck930 FIND v(dout0_18) AT=470.025n

.meas tran vdout0_19ck930 FIND v(dout0_19) AT=470.025n

.meas tran vdout0_20ck930 FIND v(dout0_20) AT=470.025n

.meas tran vdout0_21ck930 FIND v(dout0_21) AT=470.025n

.meas tran vdout0_22ck930 FIND v(dout0_22) AT=470.025n

.meas tran vdout0_23ck930 FIND v(dout0_23) AT=470.025n

.meas tran vdout0_24ck930 FIND v(dout0_24) AT=470.025n

.meas tran vdout0_25ck930 FIND v(dout0_25) AT=470.025n

.meas tran vdout0_26ck930 FIND v(dout0_26) AT=470.025n

.meas tran vdout0_27ck930 FIND v(dout0_27) AT=470.025n

.meas tran vdout0_28ck930 FIND v(dout0_28) AT=470.025n

.meas tran vdout0_29ck930 FIND v(dout0_29) AT=470.025n

.meas tran vdout0_30ck930 FIND v(dout0_30) AT=470.025n

.meas tran vdout0_31ck930 FIND v(dout0_31) AT=470.025n

.meas tran vdout0_0ck940 FIND v(dout0_0) AT=475.025n

.meas tran vdout0_1ck940 FIND v(dout0_1) AT=475.025n

.meas tran vdout0_2ck940 FIND v(dout0_2) AT=475.025n

.meas tran vdout0_3ck940 FIND v(dout0_3) AT=475.025n

.meas tran vdout0_4ck940 FIND v(dout0_4) AT=475.025n

.meas tran vdout0_5ck940 FIND v(dout0_5) AT=475.025n

.meas tran vdout0_6ck940 FIND v(dout0_6) AT=475.025n

.meas tran vdout0_7ck940 FIND v(dout0_7) AT=475.025n

.meas tran vdout0_8ck940 FIND v(dout0_8) AT=475.025n

.meas tran vdout0_9ck940 FIND v(dout0_9) AT=475.025n

.meas tran vdout0_10ck940 FIND v(dout0_10) AT=475.025n

.meas tran vdout0_11ck940 FIND v(dout0_11) AT=475.025n

.meas tran vdout0_12ck940 FIND v(dout0_12) AT=475.025n

.meas tran vdout0_13ck940 FIND v(dout0_13) AT=475.025n

.meas tran vdout0_14ck940 FIND v(dout0_14) AT=475.025n

.meas tran vdout0_15ck940 FIND v(dout0_15) AT=475.025n

.meas tran vdout0_16ck940 FIND v(dout0_16) AT=475.025n

.meas tran vdout0_17ck940 FIND v(dout0_17) AT=475.025n

.meas tran vdout0_18ck940 FIND v(dout0_18) AT=475.025n

.meas tran vdout0_19ck940 FIND v(dout0_19) AT=475.025n

.meas tran vdout0_20ck940 FIND v(dout0_20) AT=475.025n

.meas tran vdout0_21ck940 FIND v(dout0_21) AT=475.025n

.meas tran vdout0_22ck940 FIND v(dout0_22) AT=475.025n

.meas tran vdout0_23ck940 FIND v(dout0_23) AT=475.025n

.meas tran vdout0_24ck940 FIND v(dout0_24) AT=475.025n

.meas tran vdout0_25ck940 FIND v(dout0_25) AT=475.025n

.meas tran vdout0_26ck940 FIND v(dout0_26) AT=475.025n

.meas tran vdout0_27ck940 FIND v(dout0_27) AT=475.025n

.meas tran vdout0_28ck940 FIND v(dout0_28) AT=475.025n

.meas tran vdout0_29ck940 FIND v(dout0_29) AT=475.025n

.meas tran vdout0_30ck940 FIND v(dout0_30) AT=475.025n

.meas tran vdout0_31ck940 FIND v(dout0_31) AT=475.025n

.meas tran vdout0_0ck990 FIND v(dout0_0) AT=500.025n

.meas tran vdout0_1ck990 FIND v(dout0_1) AT=500.025n

.meas tran vdout0_2ck990 FIND v(dout0_2) AT=500.025n

.meas tran vdout0_3ck990 FIND v(dout0_3) AT=500.025n

.meas tran vdout0_4ck990 FIND v(dout0_4) AT=500.025n

.meas tran vdout0_5ck990 FIND v(dout0_5) AT=500.025n

.meas tran vdout0_6ck990 FIND v(dout0_6) AT=500.025n

.meas tran vdout0_7ck990 FIND v(dout0_7) AT=500.025n

.meas tran vdout0_8ck990 FIND v(dout0_8) AT=500.025n

.meas tran vdout0_9ck990 FIND v(dout0_9) AT=500.025n

.meas tran vdout0_10ck990 FIND v(dout0_10) AT=500.025n

.meas tran vdout0_11ck990 FIND v(dout0_11) AT=500.025n

.meas tran vdout0_12ck990 FIND v(dout0_12) AT=500.025n

.meas tran vdout0_13ck990 FIND v(dout0_13) AT=500.025n

.meas tran vdout0_14ck990 FIND v(dout0_14) AT=500.025n

.meas tran vdout0_15ck990 FIND v(dout0_15) AT=500.025n

.meas tran vdout0_16ck990 FIND v(dout0_16) AT=500.025n

.meas tran vdout0_17ck990 FIND v(dout0_17) AT=500.025n

.meas tran vdout0_18ck990 FIND v(dout0_18) AT=500.025n

.meas tran vdout0_19ck990 FIND v(dout0_19) AT=500.025n

.meas tran vdout0_20ck990 FIND v(dout0_20) AT=500.025n

.meas tran vdout0_21ck990 FIND v(dout0_21) AT=500.025n

.meas tran vdout0_22ck990 FIND v(dout0_22) AT=500.025n

.meas tran vdout0_23ck990 FIND v(dout0_23) AT=500.025n

.meas tran vdout0_24ck990 FIND v(dout0_24) AT=500.025n

.meas tran vdout0_25ck990 FIND v(dout0_25) AT=500.025n

.meas tran vdout0_26ck990 FIND v(dout0_26) AT=500.025n

.meas tran vdout0_27ck990 FIND v(dout0_27) AT=500.025n

.meas tran vdout0_28ck990 FIND v(dout0_28) AT=500.025n

.meas tran vdout0_29ck990 FIND v(dout0_29) AT=500.025n

.meas tran vdout0_30ck990 FIND v(dout0_30) AT=500.025n

.meas tran vdout0_31ck990 FIND v(dout0_31) AT=500.025n

.meas tran vdout0_0ck1000 FIND v(dout0_0) AT=505.025n

.meas tran vdout0_1ck1000 FIND v(dout0_1) AT=505.025n

.meas tran vdout0_2ck1000 FIND v(dout0_2) AT=505.025n

.meas tran vdout0_3ck1000 FIND v(dout0_3) AT=505.025n

.meas tran vdout0_4ck1000 FIND v(dout0_4) AT=505.025n

.meas tran vdout0_5ck1000 FIND v(dout0_5) AT=505.025n

.meas tran vdout0_6ck1000 FIND v(dout0_6) AT=505.025n

.meas tran vdout0_7ck1000 FIND v(dout0_7) AT=505.025n

.meas tran vdout0_8ck1000 FIND v(dout0_8) AT=505.025n

.meas tran vdout0_9ck1000 FIND v(dout0_9) AT=505.025n

.meas tran vdout0_10ck1000 FIND v(dout0_10) AT=505.025n

.meas tran vdout0_11ck1000 FIND v(dout0_11) AT=505.025n

.meas tran vdout0_12ck1000 FIND v(dout0_12) AT=505.025n

.meas tran vdout0_13ck1000 FIND v(dout0_13) AT=505.025n

.meas tran vdout0_14ck1000 FIND v(dout0_14) AT=505.025n

.meas tran vdout0_15ck1000 FIND v(dout0_15) AT=505.025n

.meas tran vdout0_16ck1000 FIND v(dout0_16) AT=505.025n

.meas tran vdout0_17ck1000 FIND v(dout0_17) AT=505.025n

.meas tran vdout0_18ck1000 FIND v(dout0_18) AT=505.025n

.meas tran vdout0_19ck1000 FIND v(dout0_19) AT=505.025n

.meas tran vdout0_20ck1000 FIND v(dout0_20) AT=505.025n

.meas tran vdout0_21ck1000 FIND v(dout0_21) AT=505.025n

.meas tran vdout0_22ck1000 FIND v(dout0_22) AT=505.025n

.meas tran vdout0_23ck1000 FIND v(dout0_23) AT=505.025n

.meas tran vdout0_24ck1000 FIND v(dout0_24) AT=505.025n

.meas tran vdout0_25ck1000 FIND v(dout0_25) AT=505.025n

.meas tran vdout0_26ck1000 FIND v(dout0_26) AT=505.025n

.meas tran vdout0_27ck1000 FIND v(dout0_27) AT=505.025n

.meas tran vdout0_28ck1000 FIND v(dout0_28) AT=505.025n

.meas tran vdout0_29ck1000 FIND v(dout0_29) AT=505.025n

.meas tran vdout0_30ck1000 FIND v(dout0_30) AT=505.025n

.meas tran vdout0_31ck1000 FIND v(dout0_31) AT=505.025n

.meas tran vdout0_0ck1010 FIND v(dout0_0) AT=510.025n

.meas tran vdout0_1ck1010 FIND v(dout0_1) AT=510.025n

.meas tran vdout0_2ck1010 FIND v(dout0_2) AT=510.025n

.meas tran vdout0_3ck1010 FIND v(dout0_3) AT=510.025n

.meas tran vdout0_4ck1010 FIND v(dout0_4) AT=510.025n

.meas tran vdout0_5ck1010 FIND v(dout0_5) AT=510.025n

.meas tran vdout0_6ck1010 FIND v(dout0_6) AT=510.025n

.meas tran vdout0_7ck1010 FIND v(dout0_7) AT=510.025n

.meas tran vdout0_8ck1010 FIND v(dout0_8) AT=510.025n

.meas tran vdout0_9ck1010 FIND v(dout0_9) AT=510.025n

.meas tran vdout0_10ck1010 FIND v(dout0_10) AT=510.025n

.meas tran vdout0_11ck1010 FIND v(dout0_11) AT=510.025n

.meas tran vdout0_12ck1010 FIND v(dout0_12) AT=510.025n

.meas tran vdout0_13ck1010 FIND v(dout0_13) AT=510.025n

.meas tran vdout0_14ck1010 FIND v(dout0_14) AT=510.025n

.meas tran vdout0_15ck1010 FIND v(dout0_15) AT=510.025n

.meas tran vdout0_16ck1010 FIND v(dout0_16) AT=510.025n

.meas tran vdout0_17ck1010 FIND v(dout0_17) AT=510.025n

.meas tran vdout0_18ck1010 FIND v(dout0_18) AT=510.025n

.meas tran vdout0_19ck1010 FIND v(dout0_19) AT=510.025n

.meas tran vdout0_20ck1010 FIND v(dout0_20) AT=510.025n

.meas tran vdout0_21ck1010 FIND v(dout0_21) AT=510.025n

.meas tran vdout0_22ck1010 FIND v(dout0_22) AT=510.025n

.meas tran vdout0_23ck1010 FIND v(dout0_23) AT=510.025n

.meas tran vdout0_24ck1010 FIND v(dout0_24) AT=510.025n

.meas tran vdout0_25ck1010 FIND v(dout0_25) AT=510.025n

.meas tran vdout0_26ck1010 FIND v(dout0_26) AT=510.025n

.meas tran vdout0_27ck1010 FIND v(dout0_27) AT=510.025n

.meas tran vdout0_28ck1010 FIND v(dout0_28) AT=510.025n

.meas tran vdout0_29ck1010 FIND v(dout0_29) AT=510.025n

.meas tran vdout0_30ck1010 FIND v(dout0_30) AT=510.025n

.meas tran vdout0_31ck1010 FIND v(dout0_31) AT=510.025n

.meas tran vdout0_0ck1040 FIND v(dout0_0) AT=525.025n

.meas tran vdout0_1ck1040 FIND v(dout0_1) AT=525.025n

.meas tran vdout0_2ck1040 FIND v(dout0_2) AT=525.025n

.meas tran vdout0_3ck1040 FIND v(dout0_3) AT=525.025n

.meas tran vdout0_4ck1040 FIND v(dout0_4) AT=525.025n

.meas tran vdout0_5ck1040 FIND v(dout0_5) AT=525.025n

.meas tran vdout0_6ck1040 FIND v(dout0_6) AT=525.025n

.meas tran vdout0_7ck1040 FIND v(dout0_7) AT=525.025n

.meas tran vdout0_8ck1040 FIND v(dout0_8) AT=525.025n

.meas tran vdout0_9ck1040 FIND v(dout0_9) AT=525.025n

.meas tran vdout0_10ck1040 FIND v(dout0_10) AT=525.025n

.meas tran vdout0_11ck1040 FIND v(dout0_11) AT=525.025n

.meas tran vdout0_12ck1040 FIND v(dout0_12) AT=525.025n

.meas tran vdout0_13ck1040 FIND v(dout0_13) AT=525.025n

.meas tran vdout0_14ck1040 FIND v(dout0_14) AT=525.025n

.meas tran vdout0_15ck1040 FIND v(dout0_15) AT=525.025n

.meas tran vdout0_16ck1040 FIND v(dout0_16) AT=525.025n

.meas tran vdout0_17ck1040 FIND v(dout0_17) AT=525.025n

.meas tran vdout0_18ck1040 FIND v(dout0_18) AT=525.025n

.meas tran vdout0_19ck1040 FIND v(dout0_19) AT=525.025n

.meas tran vdout0_20ck1040 FIND v(dout0_20) AT=525.025n

.meas tran vdout0_21ck1040 FIND v(dout0_21) AT=525.025n

.meas tran vdout0_22ck1040 FIND v(dout0_22) AT=525.025n

.meas tran vdout0_23ck1040 FIND v(dout0_23) AT=525.025n

.meas tran vdout0_24ck1040 FIND v(dout0_24) AT=525.025n

.meas tran vdout0_25ck1040 FIND v(dout0_25) AT=525.025n

.meas tran vdout0_26ck1040 FIND v(dout0_26) AT=525.025n

.meas tran vdout0_27ck1040 FIND v(dout0_27) AT=525.025n

.meas tran vdout0_28ck1040 FIND v(dout0_28) AT=525.025n

.meas tran vdout0_29ck1040 FIND v(dout0_29) AT=525.025n

.meas tran vdout0_30ck1040 FIND v(dout0_30) AT=525.025n

.meas tran vdout0_31ck1040 FIND v(dout0_31) AT=525.025n

.meas tran vdout0_0ck1050 FIND v(dout0_0) AT=530.025n

.meas tran vdout0_1ck1050 FIND v(dout0_1) AT=530.025n

.meas tran vdout0_2ck1050 FIND v(dout0_2) AT=530.025n

.meas tran vdout0_3ck1050 FIND v(dout0_3) AT=530.025n

.meas tran vdout0_4ck1050 FIND v(dout0_4) AT=530.025n

.meas tran vdout0_5ck1050 FIND v(dout0_5) AT=530.025n

.meas tran vdout0_6ck1050 FIND v(dout0_6) AT=530.025n

.meas tran vdout0_7ck1050 FIND v(dout0_7) AT=530.025n

.meas tran vdout0_8ck1050 FIND v(dout0_8) AT=530.025n

.meas tran vdout0_9ck1050 FIND v(dout0_9) AT=530.025n

.meas tran vdout0_10ck1050 FIND v(dout0_10) AT=530.025n

.meas tran vdout0_11ck1050 FIND v(dout0_11) AT=530.025n

.meas tran vdout0_12ck1050 FIND v(dout0_12) AT=530.025n

.meas tran vdout0_13ck1050 FIND v(dout0_13) AT=530.025n

.meas tran vdout0_14ck1050 FIND v(dout0_14) AT=530.025n

.meas tran vdout0_15ck1050 FIND v(dout0_15) AT=530.025n

.meas tran vdout0_16ck1050 FIND v(dout0_16) AT=530.025n

.meas tran vdout0_17ck1050 FIND v(dout0_17) AT=530.025n

.meas tran vdout0_18ck1050 FIND v(dout0_18) AT=530.025n

.meas tran vdout0_19ck1050 FIND v(dout0_19) AT=530.025n

.meas tran vdout0_20ck1050 FIND v(dout0_20) AT=530.025n

.meas tran vdout0_21ck1050 FIND v(dout0_21) AT=530.025n

.meas tran vdout0_22ck1050 FIND v(dout0_22) AT=530.025n

.meas tran vdout0_23ck1050 FIND v(dout0_23) AT=530.025n

.meas tran vdout0_24ck1050 FIND v(dout0_24) AT=530.025n

.meas tran vdout0_25ck1050 FIND v(dout0_25) AT=530.025n

.meas tran vdout0_26ck1050 FIND v(dout0_26) AT=530.025n

.meas tran vdout0_27ck1050 FIND v(dout0_27) AT=530.025n

.meas tran vdout0_28ck1050 FIND v(dout0_28) AT=530.025n

.meas tran vdout0_29ck1050 FIND v(dout0_29) AT=530.025n

.meas tran vdout0_30ck1050 FIND v(dout0_30) AT=530.025n

.meas tran vdout0_31ck1050 FIND v(dout0_31) AT=530.025n

.meas tran vdout0_0ck1120 FIND v(dout0_0) AT=565.025n

.meas tran vdout0_1ck1120 FIND v(dout0_1) AT=565.025n

.meas tran vdout0_2ck1120 FIND v(dout0_2) AT=565.025n

.meas tran vdout0_3ck1120 FIND v(dout0_3) AT=565.025n

.meas tran vdout0_4ck1120 FIND v(dout0_4) AT=565.025n

.meas tran vdout0_5ck1120 FIND v(dout0_5) AT=565.025n

.meas tran vdout0_6ck1120 FIND v(dout0_6) AT=565.025n

.meas tran vdout0_7ck1120 FIND v(dout0_7) AT=565.025n

.meas tran vdout0_8ck1120 FIND v(dout0_8) AT=565.025n

.meas tran vdout0_9ck1120 FIND v(dout0_9) AT=565.025n

.meas tran vdout0_10ck1120 FIND v(dout0_10) AT=565.025n

.meas tran vdout0_11ck1120 FIND v(dout0_11) AT=565.025n

.meas tran vdout0_12ck1120 FIND v(dout0_12) AT=565.025n

.meas tran vdout0_13ck1120 FIND v(dout0_13) AT=565.025n

.meas tran vdout0_14ck1120 FIND v(dout0_14) AT=565.025n

.meas tran vdout0_15ck1120 FIND v(dout0_15) AT=565.025n

.meas tran vdout0_16ck1120 FIND v(dout0_16) AT=565.025n

.meas tran vdout0_17ck1120 FIND v(dout0_17) AT=565.025n

.meas tran vdout0_18ck1120 FIND v(dout0_18) AT=565.025n

.meas tran vdout0_19ck1120 FIND v(dout0_19) AT=565.025n

.meas tran vdout0_20ck1120 FIND v(dout0_20) AT=565.025n

.meas tran vdout0_21ck1120 FIND v(dout0_21) AT=565.025n

.meas tran vdout0_22ck1120 FIND v(dout0_22) AT=565.025n

.meas tran vdout0_23ck1120 FIND v(dout0_23) AT=565.025n

.meas tran vdout0_24ck1120 FIND v(dout0_24) AT=565.025n

.meas tran vdout0_25ck1120 FIND v(dout0_25) AT=565.025n

.meas tran vdout0_26ck1120 FIND v(dout0_26) AT=565.025n

.meas tran vdout0_27ck1120 FIND v(dout0_27) AT=565.025n

.meas tran vdout0_28ck1120 FIND v(dout0_28) AT=565.025n

.meas tran vdout0_29ck1120 FIND v(dout0_29) AT=565.025n

.meas tran vdout0_30ck1120 FIND v(dout0_30) AT=565.025n

.meas tran vdout0_31ck1120 FIND v(dout0_31) AT=565.025n

.meas tran vdout0_0ck1130 FIND v(dout0_0) AT=570.025n

.meas tran vdout0_1ck1130 FIND v(dout0_1) AT=570.025n

.meas tran vdout0_2ck1130 FIND v(dout0_2) AT=570.025n

.meas tran vdout0_3ck1130 FIND v(dout0_3) AT=570.025n

.meas tran vdout0_4ck1130 FIND v(dout0_4) AT=570.025n

.meas tran vdout0_5ck1130 FIND v(dout0_5) AT=570.025n

.meas tran vdout0_6ck1130 FIND v(dout0_6) AT=570.025n

.meas tran vdout0_7ck1130 FIND v(dout0_7) AT=570.025n

.meas tran vdout0_8ck1130 FIND v(dout0_8) AT=570.025n

.meas tran vdout0_9ck1130 FIND v(dout0_9) AT=570.025n

.meas tran vdout0_10ck1130 FIND v(dout0_10) AT=570.025n

.meas tran vdout0_11ck1130 FIND v(dout0_11) AT=570.025n

.meas tran vdout0_12ck1130 FIND v(dout0_12) AT=570.025n

.meas tran vdout0_13ck1130 FIND v(dout0_13) AT=570.025n

.meas tran vdout0_14ck1130 FIND v(dout0_14) AT=570.025n

.meas tran vdout0_15ck1130 FIND v(dout0_15) AT=570.025n

.meas tran vdout0_16ck1130 FIND v(dout0_16) AT=570.025n

.meas tran vdout0_17ck1130 FIND v(dout0_17) AT=570.025n

.meas tran vdout0_18ck1130 FIND v(dout0_18) AT=570.025n

.meas tran vdout0_19ck1130 FIND v(dout0_19) AT=570.025n

.meas tran vdout0_20ck1130 FIND v(dout0_20) AT=570.025n

.meas tran vdout0_21ck1130 FIND v(dout0_21) AT=570.025n

.meas tran vdout0_22ck1130 FIND v(dout0_22) AT=570.025n

.meas tran vdout0_23ck1130 FIND v(dout0_23) AT=570.025n

.meas tran vdout0_24ck1130 FIND v(dout0_24) AT=570.025n

.meas tran vdout0_25ck1130 FIND v(dout0_25) AT=570.025n

.meas tran vdout0_26ck1130 FIND v(dout0_26) AT=570.025n

.meas tran vdout0_27ck1130 FIND v(dout0_27) AT=570.025n

.meas tran vdout0_28ck1130 FIND v(dout0_28) AT=570.025n

.meas tran vdout0_29ck1130 FIND v(dout0_29) AT=570.025n

.meas tran vdout0_30ck1130 FIND v(dout0_30) AT=570.025n

.meas tran vdout0_31ck1130 FIND v(dout0_31) AT=570.025n

.meas tran vdout0_0ck1220 FIND v(dout0_0) AT=615.025n

.meas tran vdout0_1ck1220 FIND v(dout0_1) AT=615.025n

.meas tran vdout0_2ck1220 FIND v(dout0_2) AT=615.025n

.meas tran vdout0_3ck1220 FIND v(dout0_3) AT=615.025n

.meas tran vdout0_4ck1220 FIND v(dout0_4) AT=615.025n

.meas tran vdout0_5ck1220 FIND v(dout0_5) AT=615.025n

.meas tran vdout0_6ck1220 FIND v(dout0_6) AT=615.025n

.meas tran vdout0_7ck1220 FIND v(dout0_7) AT=615.025n

.meas tran vdout0_8ck1220 FIND v(dout0_8) AT=615.025n

.meas tran vdout0_9ck1220 FIND v(dout0_9) AT=615.025n

.meas tran vdout0_10ck1220 FIND v(dout0_10) AT=615.025n

.meas tran vdout0_11ck1220 FIND v(dout0_11) AT=615.025n

.meas tran vdout0_12ck1220 FIND v(dout0_12) AT=615.025n

.meas tran vdout0_13ck1220 FIND v(dout0_13) AT=615.025n

.meas tran vdout0_14ck1220 FIND v(dout0_14) AT=615.025n

.meas tran vdout0_15ck1220 FIND v(dout0_15) AT=615.025n

.meas tran vdout0_16ck1220 FIND v(dout0_16) AT=615.025n

.meas tran vdout0_17ck1220 FIND v(dout0_17) AT=615.025n

.meas tran vdout0_18ck1220 FIND v(dout0_18) AT=615.025n

.meas tran vdout0_19ck1220 FIND v(dout0_19) AT=615.025n

.meas tran vdout0_20ck1220 FIND v(dout0_20) AT=615.025n

.meas tran vdout0_21ck1220 FIND v(dout0_21) AT=615.025n

.meas tran vdout0_22ck1220 FIND v(dout0_22) AT=615.025n

.meas tran vdout0_23ck1220 FIND v(dout0_23) AT=615.025n

.meas tran vdout0_24ck1220 FIND v(dout0_24) AT=615.025n

.meas tran vdout0_25ck1220 FIND v(dout0_25) AT=615.025n

.meas tran vdout0_26ck1220 FIND v(dout0_26) AT=615.025n

.meas tran vdout0_27ck1220 FIND v(dout0_27) AT=615.025n

.meas tran vdout0_28ck1220 FIND v(dout0_28) AT=615.025n

.meas tran vdout0_29ck1220 FIND v(dout0_29) AT=615.025n

.meas tran vdout0_30ck1220 FIND v(dout0_30) AT=615.025n

.meas tran vdout0_31ck1220 FIND v(dout0_31) AT=615.025n

.meas tran vdout0_0ck1260 FIND v(dout0_0) AT=635.025n

.meas tran vdout0_1ck1260 FIND v(dout0_1) AT=635.025n

.meas tran vdout0_2ck1260 FIND v(dout0_2) AT=635.025n

.meas tran vdout0_3ck1260 FIND v(dout0_3) AT=635.025n

.meas tran vdout0_4ck1260 FIND v(dout0_4) AT=635.025n

.meas tran vdout0_5ck1260 FIND v(dout0_5) AT=635.025n

.meas tran vdout0_6ck1260 FIND v(dout0_6) AT=635.025n

.meas tran vdout0_7ck1260 FIND v(dout0_7) AT=635.025n

.meas tran vdout0_8ck1260 FIND v(dout0_8) AT=635.025n

.meas tran vdout0_9ck1260 FIND v(dout0_9) AT=635.025n

.meas tran vdout0_10ck1260 FIND v(dout0_10) AT=635.025n

.meas tran vdout0_11ck1260 FIND v(dout0_11) AT=635.025n

.meas tran vdout0_12ck1260 FIND v(dout0_12) AT=635.025n

.meas tran vdout0_13ck1260 FIND v(dout0_13) AT=635.025n

.meas tran vdout0_14ck1260 FIND v(dout0_14) AT=635.025n

.meas tran vdout0_15ck1260 FIND v(dout0_15) AT=635.025n

.meas tran vdout0_16ck1260 FIND v(dout0_16) AT=635.025n

.meas tran vdout0_17ck1260 FIND v(dout0_17) AT=635.025n

.meas tran vdout0_18ck1260 FIND v(dout0_18) AT=635.025n

.meas tran vdout0_19ck1260 FIND v(dout0_19) AT=635.025n

.meas tran vdout0_20ck1260 FIND v(dout0_20) AT=635.025n

.meas tran vdout0_21ck1260 FIND v(dout0_21) AT=635.025n

.meas tran vdout0_22ck1260 FIND v(dout0_22) AT=635.025n

.meas tran vdout0_23ck1260 FIND v(dout0_23) AT=635.025n

.meas tran vdout0_24ck1260 FIND v(dout0_24) AT=635.025n

.meas tran vdout0_25ck1260 FIND v(dout0_25) AT=635.025n

.meas tran vdout0_26ck1260 FIND v(dout0_26) AT=635.025n

.meas tran vdout0_27ck1260 FIND v(dout0_27) AT=635.025n

.meas tran vdout0_28ck1260 FIND v(dout0_28) AT=635.025n

.meas tran vdout0_29ck1260 FIND v(dout0_29) AT=635.025n

.meas tran vdout0_30ck1260 FIND v(dout0_30) AT=635.025n

.meas tran vdout0_31ck1260 FIND v(dout0_31) AT=635.025n

.meas tran vdout0_0ck1270 FIND v(dout0_0) AT=640.025n

.meas tran vdout0_1ck1270 FIND v(dout0_1) AT=640.025n

.meas tran vdout0_2ck1270 FIND v(dout0_2) AT=640.025n

.meas tran vdout0_3ck1270 FIND v(dout0_3) AT=640.025n

.meas tran vdout0_4ck1270 FIND v(dout0_4) AT=640.025n

.meas tran vdout0_5ck1270 FIND v(dout0_5) AT=640.025n

.meas tran vdout0_6ck1270 FIND v(dout0_6) AT=640.025n

.meas tran vdout0_7ck1270 FIND v(dout0_7) AT=640.025n

.meas tran vdout0_8ck1270 FIND v(dout0_8) AT=640.025n

.meas tran vdout0_9ck1270 FIND v(dout0_9) AT=640.025n

.meas tran vdout0_10ck1270 FIND v(dout0_10) AT=640.025n

.meas tran vdout0_11ck1270 FIND v(dout0_11) AT=640.025n

.meas tran vdout0_12ck1270 FIND v(dout0_12) AT=640.025n

.meas tran vdout0_13ck1270 FIND v(dout0_13) AT=640.025n

.meas tran vdout0_14ck1270 FIND v(dout0_14) AT=640.025n

.meas tran vdout0_15ck1270 FIND v(dout0_15) AT=640.025n

.meas tran vdout0_16ck1270 FIND v(dout0_16) AT=640.025n

.meas tran vdout0_17ck1270 FIND v(dout0_17) AT=640.025n

.meas tran vdout0_18ck1270 FIND v(dout0_18) AT=640.025n

.meas tran vdout0_19ck1270 FIND v(dout0_19) AT=640.025n

.meas tran vdout0_20ck1270 FIND v(dout0_20) AT=640.025n

.meas tran vdout0_21ck1270 FIND v(dout0_21) AT=640.025n

.meas tran vdout0_22ck1270 FIND v(dout0_22) AT=640.025n

.meas tran vdout0_23ck1270 FIND v(dout0_23) AT=640.025n

.meas tran vdout0_24ck1270 FIND v(dout0_24) AT=640.025n

.meas tran vdout0_25ck1270 FIND v(dout0_25) AT=640.025n

.meas tran vdout0_26ck1270 FIND v(dout0_26) AT=640.025n

.meas tran vdout0_27ck1270 FIND v(dout0_27) AT=640.025n

.meas tran vdout0_28ck1270 FIND v(dout0_28) AT=640.025n

.meas tran vdout0_29ck1270 FIND v(dout0_29) AT=640.025n

.meas tran vdout0_30ck1270 FIND v(dout0_30) AT=640.025n

.meas tran vdout0_31ck1270 FIND v(dout0_31) AT=640.025n

.meas tran vdout0_0ck1300 FIND v(dout0_0) AT=655.025n

.meas tran vdout0_1ck1300 FIND v(dout0_1) AT=655.025n

.meas tran vdout0_2ck1300 FIND v(dout0_2) AT=655.025n

.meas tran vdout0_3ck1300 FIND v(dout0_3) AT=655.025n

.meas tran vdout0_4ck1300 FIND v(dout0_4) AT=655.025n

.meas tran vdout0_5ck1300 FIND v(dout0_5) AT=655.025n

.meas tran vdout0_6ck1300 FIND v(dout0_6) AT=655.025n

.meas tran vdout0_7ck1300 FIND v(dout0_7) AT=655.025n

.meas tran vdout0_8ck1300 FIND v(dout0_8) AT=655.025n

.meas tran vdout0_9ck1300 FIND v(dout0_9) AT=655.025n

.meas tran vdout0_10ck1300 FIND v(dout0_10) AT=655.025n

.meas tran vdout0_11ck1300 FIND v(dout0_11) AT=655.025n

.meas tran vdout0_12ck1300 FIND v(dout0_12) AT=655.025n

.meas tran vdout0_13ck1300 FIND v(dout0_13) AT=655.025n

.meas tran vdout0_14ck1300 FIND v(dout0_14) AT=655.025n

.meas tran vdout0_15ck1300 FIND v(dout0_15) AT=655.025n

.meas tran vdout0_16ck1300 FIND v(dout0_16) AT=655.025n

.meas tran vdout0_17ck1300 FIND v(dout0_17) AT=655.025n

.meas tran vdout0_18ck1300 FIND v(dout0_18) AT=655.025n

.meas tran vdout0_19ck1300 FIND v(dout0_19) AT=655.025n

.meas tran vdout0_20ck1300 FIND v(dout0_20) AT=655.025n

.meas tran vdout0_21ck1300 FIND v(dout0_21) AT=655.025n

.meas tran vdout0_22ck1300 FIND v(dout0_22) AT=655.025n

.meas tran vdout0_23ck1300 FIND v(dout0_23) AT=655.025n

.meas tran vdout0_24ck1300 FIND v(dout0_24) AT=655.025n

.meas tran vdout0_25ck1300 FIND v(dout0_25) AT=655.025n

.meas tran vdout0_26ck1300 FIND v(dout0_26) AT=655.025n

.meas tran vdout0_27ck1300 FIND v(dout0_27) AT=655.025n

.meas tran vdout0_28ck1300 FIND v(dout0_28) AT=655.025n

.meas tran vdout0_29ck1300 FIND v(dout0_29) AT=655.025n

.meas tran vdout0_30ck1300 FIND v(dout0_30) AT=655.025n

.meas tran vdout0_31ck1300 FIND v(dout0_31) AT=655.025n

.meas tran vdout0_0ck1310 FIND v(dout0_0) AT=660.025n

.meas tran vdout0_1ck1310 FIND v(dout0_1) AT=660.025n

.meas tran vdout0_2ck1310 FIND v(dout0_2) AT=660.025n

.meas tran vdout0_3ck1310 FIND v(dout0_3) AT=660.025n

.meas tran vdout0_4ck1310 FIND v(dout0_4) AT=660.025n

.meas tran vdout0_5ck1310 FIND v(dout0_5) AT=660.025n

.meas tran vdout0_6ck1310 FIND v(dout0_6) AT=660.025n

.meas tran vdout0_7ck1310 FIND v(dout0_7) AT=660.025n

.meas tran vdout0_8ck1310 FIND v(dout0_8) AT=660.025n

.meas tran vdout0_9ck1310 FIND v(dout0_9) AT=660.025n

.meas tran vdout0_10ck1310 FIND v(dout0_10) AT=660.025n

.meas tran vdout0_11ck1310 FIND v(dout0_11) AT=660.025n

.meas tran vdout0_12ck1310 FIND v(dout0_12) AT=660.025n

.meas tran vdout0_13ck1310 FIND v(dout0_13) AT=660.025n

.meas tran vdout0_14ck1310 FIND v(dout0_14) AT=660.025n

.meas tran vdout0_15ck1310 FIND v(dout0_15) AT=660.025n

.meas tran vdout0_16ck1310 FIND v(dout0_16) AT=660.025n

.meas tran vdout0_17ck1310 FIND v(dout0_17) AT=660.025n

.meas tran vdout0_18ck1310 FIND v(dout0_18) AT=660.025n

.meas tran vdout0_19ck1310 FIND v(dout0_19) AT=660.025n

.meas tran vdout0_20ck1310 FIND v(dout0_20) AT=660.025n

.meas tran vdout0_21ck1310 FIND v(dout0_21) AT=660.025n

.meas tran vdout0_22ck1310 FIND v(dout0_22) AT=660.025n

.meas tran vdout0_23ck1310 FIND v(dout0_23) AT=660.025n

.meas tran vdout0_24ck1310 FIND v(dout0_24) AT=660.025n

.meas tran vdout0_25ck1310 FIND v(dout0_25) AT=660.025n

.meas tran vdout0_26ck1310 FIND v(dout0_26) AT=660.025n

.meas tran vdout0_27ck1310 FIND v(dout0_27) AT=660.025n

.meas tran vdout0_28ck1310 FIND v(dout0_28) AT=660.025n

.meas tran vdout0_29ck1310 FIND v(dout0_29) AT=660.025n

.meas tran vdout0_30ck1310 FIND v(dout0_30) AT=660.025n

.meas tran vdout0_31ck1310 FIND v(dout0_31) AT=660.025n

.meas tran vdout0_0ck1320 FIND v(dout0_0) AT=665.025n

.meas tran vdout0_1ck1320 FIND v(dout0_1) AT=665.025n

.meas tran vdout0_2ck1320 FIND v(dout0_2) AT=665.025n

.meas tran vdout0_3ck1320 FIND v(dout0_3) AT=665.025n

.meas tran vdout0_4ck1320 FIND v(dout0_4) AT=665.025n

.meas tran vdout0_5ck1320 FIND v(dout0_5) AT=665.025n

.meas tran vdout0_6ck1320 FIND v(dout0_6) AT=665.025n

.meas tran vdout0_7ck1320 FIND v(dout0_7) AT=665.025n

.meas tran vdout0_8ck1320 FIND v(dout0_8) AT=665.025n

.meas tran vdout0_9ck1320 FIND v(dout0_9) AT=665.025n

.meas tran vdout0_10ck1320 FIND v(dout0_10) AT=665.025n

.meas tran vdout0_11ck1320 FIND v(dout0_11) AT=665.025n

.meas tran vdout0_12ck1320 FIND v(dout0_12) AT=665.025n

.meas tran vdout0_13ck1320 FIND v(dout0_13) AT=665.025n

.meas tran vdout0_14ck1320 FIND v(dout0_14) AT=665.025n

.meas tran vdout0_15ck1320 FIND v(dout0_15) AT=665.025n

.meas tran vdout0_16ck1320 FIND v(dout0_16) AT=665.025n

.meas tran vdout0_17ck1320 FIND v(dout0_17) AT=665.025n

.meas tran vdout0_18ck1320 FIND v(dout0_18) AT=665.025n

.meas tran vdout0_19ck1320 FIND v(dout0_19) AT=665.025n

.meas tran vdout0_20ck1320 FIND v(dout0_20) AT=665.025n

.meas tran vdout0_21ck1320 FIND v(dout0_21) AT=665.025n

.meas tran vdout0_22ck1320 FIND v(dout0_22) AT=665.025n

.meas tran vdout0_23ck1320 FIND v(dout0_23) AT=665.025n

.meas tran vdout0_24ck1320 FIND v(dout0_24) AT=665.025n

.meas tran vdout0_25ck1320 FIND v(dout0_25) AT=665.025n

.meas tran vdout0_26ck1320 FIND v(dout0_26) AT=665.025n

.meas tran vdout0_27ck1320 FIND v(dout0_27) AT=665.025n

.meas tran vdout0_28ck1320 FIND v(dout0_28) AT=665.025n

.meas tran vdout0_29ck1320 FIND v(dout0_29) AT=665.025n

.meas tran vdout0_30ck1320 FIND v(dout0_30) AT=665.025n

.meas tran vdout0_31ck1320 FIND v(dout0_31) AT=665.025n

.meas tran vdout0_0ck1430 FIND v(dout0_0) AT=720.025n

.meas tran vdout0_1ck1430 FIND v(dout0_1) AT=720.025n

.meas tran vdout0_2ck1430 FIND v(dout0_2) AT=720.025n

.meas tran vdout0_3ck1430 FIND v(dout0_3) AT=720.025n

.meas tran vdout0_4ck1430 FIND v(dout0_4) AT=720.025n

.meas tran vdout0_5ck1430 FIND v(dout0_5) AT=720.025n

.meas tran vdout0_6ck1430 FIND v(dout0_6) AT=720.025n

.meas tran vdout0_7ck1430 FIND v(dout0_7) AT=720.025n

.meas tran vdout0_8ck1430 FIND v(dout0_8) AT=720.025n

.meas tran vdout0_9ck1430 FIND v(dout0_9) AT=720.025n

.meas tran vdout0_10ck1430 FIND v(dout0_10) AT=720.025n

.meas tran vdout0_11ck1430 FIND v(dout0_11) AT=720.025n

.meas tran vdout0_12ck1430 FIND v(dout0_12) AT=720.025n

.meas tran vdout0_13ck1430 FIND v(dout0_13) AT=720.025n

.meas tran vdout0_14ck1430 FIND v(dout0_14) AT=720.025n

.meas tran vdout0_15ck1430 FIND v(dout0_15) AT=720.025n

.meas tran vdout0_16ck1430 FIND v(dout0_16) AT=720.025n

.meas tran vdout0_17ck1430 FIND v(dout0_17) AT=720.025n

.meas tran vdout0_18ck1430 FIND v(dout0_18) AT=720.025n

.meas tran vdout0_19ck1430 FIND v(dout0_19) AT=720.025n

.meas tran vdout0_20ck1430 FIND v(dout0_20) AT=720.025n

.meas tran vdout0_21ck1430 FIND v(dout0_21) AT=720.025n

.meas tran vdout0_22ck1430 FIND v(dout0_22) AT=720.025n

.meas tran vdout0_23ck1430 FIND v(dout0_23) AT=720.025n

.meas tran vdout0_24ck1430 FIND v(dout0_24) AT=720.025n

.meas tran vdout0_25ck1430 FIND v(dout0_25) AT=720.025n

.meas tran vdout0_26ck1430 FIND v(dout0_26) AT=720.025n

.meas tran vdout0_27ck1430 FIND v(dout0_27) AT=720.025n

.meas tran vdout0_28ck1430 FIND v(dout0_28) AT=720.025n

.meas tran vdout0_29ck1430 FIND v(dout0_29) AT=720.025n

.meas tran vdout0_30ck1430 FIND v(dout0_30) AT=720.025n

.meas tran vdout0_31ck1430 FIND v(dout0_31) AT=720.025n

.meas tran vdout0_0ck1440 FIND v(dout0_0) AT=725.025n

.meas tran vdout0_1ck1440 FIND v(dout0_1) AT=725.025n

.meas tran vdout0_2ck1440 FIND v(dout0_2) AT=725.025n

.meas tran vdout0_3ck1440 FIND v(dout0_3) AT=725.025n

.meas tran vdout0_4ck1440 FIND v(dout0_4) AT=725.025n

.meas tran vdout0_5ck1440 FIND v(dout0_5) AT=725.025n

.meas tran vdout0_6ck1440 FIND v(dout0_6) AT=725.025n

.meas tran vdout0_7ck1440 FIND v(dout0_7) AT=725.025n

.meas tran vdout0_8ck1440 FIND v(dout0_8) AT=725.025n

.meas tran vdout0_9ck1440 FIND v(dout0_9) AT=725.025n

.meas tran vdout0_10ck1440 FIND v(dout0_10) AT=725.025n

.meas tran vdout0_11ck1440 FIND v(dout0_11) AT=725.025n

.meas tran vdout0_12ck1440 FIND v(dout0_12) AT=725.025n

.meas tran vdout0_13ck1440 FIND v(dout0_13) AT=725.025n

.meas tran vdout0_14ck1440 FIND v(dout0_14) AT=725.025n

.meas tran vdout0_15ck1440 FIND v(dout0_15) AT=725.025n

.meas tran vdout0_16ck1440 FIND v(dout0_16) AT=725.025n

.meas tran vdout0_17ck1440 FIND v(dout0_17) AT=725.025n

.meas tran vdout0_18ck1440 FIND v(dout0_18) AT=725.025n

.meas tran vdout0_19ck1440 FIND v(dout0_19) AT=725.025n

.meas tran vdout0_20ck1440 FIND v(dout0_20) AT=725.025n

.meas tran vdout0_21ck1440 FIND v(dout0_21) AT=725.025n

.meas tran vdout0_22ck1440 FIND v(dout0_22) AT=725.025n

.meas tran vdout0_23ck1440 FIND v(dout0_23) AT=725.025n

.meas tran vdout0_24ck1440 FIND v(dout0_24) AT=725.025n

.meas tran vdout0_25ck1440 FIND v(dout0_25) AT=725.025n

.meas tran vdout0_26ck1440 FIND v(dout0_26) AT=725.025n

.meas tran vdout0_27ck1440 FIND v(dout0_27) AT=725.025n

.meas tran vdout0_28ck1440 FIND v(dout0_28) AT=725.025n

.meas tran vdout0_29ck1440 FIND v(dout0_29) AT=725.025n

.meas tran vdout0_30ck1440 FIND v(dout0_30) AT=725.025n

.meas tran vdout0_31ck1440 FIND v(dout0_31) AT=725.025n

.meas tran vdout0_0ck1450 FIND v(dout0_0) AT=730.025n

.meas tran vdout0_1ck1450 FIND v(dout0_1) AT=730.025n

.meas tran vdout0_2ck1450 FIND v(dout0_2) AT=730.025n

.meas tran vdout0_3ck1450 FIND v(dout0_3) AT=730.025n

.meas tran vdout0_4ck1450 FIND v(dout0_4) AT=730.025n

.meas tran vdout0_5ck1450 FIND v(dout0_5) AT=730.025n

.meas tran vdout0_6ck1450 FIND v(dout0_6) AT=730.025n

.meas tran vdout0_7ck1450 FIND v(dout0_7) AT=730.025n

.meas tran vdout0_8ck1450 FIND v(dout0_8) AT=730.025n

.meas tran vdout0_9ck1450 FIND v(dout0_9) AT=730.025n

.meas tran vdout0_10ck1450 FIND v(dout0_10) AT=730.025n

.meas tran vdout0_11ck1450 FIND v(dout0_11) AT=730.025n

.meas tran vdout0_12ck1450 FIND v(dout0_12) AT=730.025n

.meas tran vdout0_13ck1450 FIND v(dout0_13) AT=730.025n

.meas tran vdout0_14ck1450 FIND v(dout0_14) AT=730.025n

.meas tran vdout0_15ck1450 FIND v(dout0_15) AT=730.025n

.meas tran vdout0_16ck1450 FIND v(dout0_16) AT=730.025n

.meas tran vdout0_17ck1450 FIND v(dout0_17) AT=730.025n

.meas tran vdout0_18ck1450 FIND v(dout0_18) AT=730.025n

.meas tran vdout0_19ck1450 FIND v(dout0_19) AT=730.025n

.meas tran vdout0_20ck1450 FIND v(dout0_20) AT=730.025n

.meas tran vdout0_21ck1450 FIND v(dout0_21) AT=730.025n

.meas tran vdout0_22ck1450 FIND v(dout0_22) AT=730.025n

.meas tran vdout0_23ck1450 FIND v(dout0_23) AT=730.025n

.meas tran vdout0_24ck1450 FIND v(dout0_24) AT=730.025n

.meas tran vdout0_25ck1450 FIND v(dout0_25) AT=730.025n

.meas tran vdout0_26ck1450 FIND v(dout0_26) AT=730.025n

.meas tran vdout0_27ck1450 FIND v(dout0_27) AT=730.025n

.meas tran vdout0_28ck1450 FIND v(dout0_28) AT=730.025n

.meas tran vdout0_29ck1450 FIND v(dout0_29) AT=730.025n

.meas tran vdout0_30ck1450 FIND v(dout0_30) AT=730.025n

.meas tran vdout0_31ck1450 FIND v(dout0_31) AT=730.025n

.meas tran vdout0_0ck1460 FIND v(dout0_0) AT=735.025n

.meas tran vdout0_1ck1460 FIND v(dout0_1) AT=735.025n

.meas tran vdout0_2ck1460 FIND v(dout0_2) AT=735.025n

.meas tran vdout0_3ck1460 FIND v(dout0_3) AT=735.025n

.meas tran vdout0_4ck1460 FIND v(dout0_4) AT=735.025n

.meas tran vdout0_5ck1460 FIND v(dout0_5) AT=735.025n

.meas tran vdout0_6ck1460 FIND v(dout0_6) AT=735.025n

.meas tran vdout0_7ck1460 FIND v(dout0_7) AT=735.025n

.meas tran vdout0_8ck1460 FIND v(dout0_8) AT=735.025n

.meas tran vdout0_9ck1460 FIND v(dout0_9) AT=735.025n

.meas tran vdout0_10ck1460 FIND v(dout0_10) AT=735.025n

.meas tran vdout0_11ck1460 FIND v(dout0_11) AT=735.025n

.meas tran vdout0_12ck1460 FIND v(dout0_12) AT=735.025n

.meas tran vdout0_13ck1460 FIND v(dout0_13) AT=735.025n

.meas tran vdout0_14ck1460 FIND v(dout0_14) AT=735.025n

.meas tran vdout0_15ck1460 FIND v(dout0_15) AT=735.025n

.meas tran vdout0_16ck1460 FIND v(dout0_16) AT=735.025n

.meas tran vdout0_17ck1460 FIND v(dout0_17) AT=735.025n

.meas tran vdout0_18ck1460 FIND v(dout0_18) AT=735.025n

.meas tran vdout0_19ck1460 FIND v(dout0_19) AT=735.025n

.meas tran vdout0_20ck1460 FIND v(dout0_20) AT=735.025n

.meas tran vdout0_21ck1460 FIND v(dout0_21) AT=735.025n

.meas tran vdout0_22ck1460 FIND v(dout0_22) AT=735.025n

.meas tran vdout0_23ck1460 FIND v(dout0_23) AT=735.025n

.meas tran vdout0_24ck1460 FIND v(dout0_24) AT=735.025n

.meas tran vdout0_25ck1460 FIND v(dout0_25) AT=735.025n

.meas tran vdout0_26ck1460 FIND v(dout0_26) AT=735.025n

.meas tran vdout0_27ck1460 FIND v(dout0_27) AT=735.025n

.meas tran vdout0_28ck1460 FIND v(dout0_28) AT=735.025n

.meas tran vdout0_29ck1460 FIND v(dout0_29) AT=735.025n

.meas tran vdout0_30ck1460 FIND v(dout0_30) AT=735.025n

.meas tran vdout0_31ck1460 FIND v(dout0_31) AT=735.025n

.meas tran vdout0_0ck1520 FIND v(dout0_0) AT=765.025n

.meas tran vdout0_1ck1520 FIND v(dout0_1) AT=765.025n

.meas tran vdout0_2ck1520 FIND v(dout0_2) AT=765.025n

.meas tran vdout0_3ck1520 FIND v(dout0_3) AT=765.025n

.meas tran vdout0_4ck1520 FIND v(dout0_4) AT=765.025n

.meas tran vdout0_5ck1520 FIND v(dout0_5) AT=765.025n

.meas tran vdout0_6ck1520 FIND v(dout0_6) AT=765.025n

.meas tran vdout0_7ck1520 FIND v(dout0_7) AT=765.025n

.meas tran vdout0_8ck1520 FIND v(dout0_8) AT=765.025n

.meas tran vdout0_9ck1520 FIND v(dout0_9) AT=765.025n

.meas tran vdout0_10ck1520 FIND v(dout0_10) AT=765.025n

.meas tran vdout0_11ck1520 FIND v(dout0_11) AT=765.025n

.meas tran vdout0_12ck1520 FIND v(dout0_12) AT=765.025n

.meas tran vdout0_13ck1520 FIND v(dout0_13) AT=765.025n

.meas tran vdout0_14ck1520 FIND v(dout0_14) AT=765.025n

.meas tran vdout0_15ck1520 FIND v(dout0_15) AT=765.025n

.meas tran vdout0_16ck1520 FIND v(dout0_16) AT=765.025n

.meas tran vdout0_17ck1520 FIND v(dout0_17) AT=765.025n

.meas tran vdout0_18ck1520 FIND v(dout0_18) AT=765.025n

.meas tran vdout0_19ck1520 FIND v(dout0_19) AT=765.025n

.meas tran vdout0_20ck1520 FIND v(dout0_20) AT=765.025n

.meas tran vdout0_21ck1520 FIND v(dout0_21) AT=765.025n

.meas tran vdout0_22ck1520 FIND v(dout0_22) AT=765.025n

.meas tran vdout0_23ck1520 FIND v(dout0_23) AT=765.025n

.meas tran vdout0_24ck1520 FIND v(dout0_24) AT=765.025n

.meas tran vdout0_25ck1520 FIND v(dout0_25) AT=765.025n

.meas tran vdout0_26ck1520 FIND v(dout0_26) AT=765.025n

.meas tran vdout0_27ck1520 FIND v(dout0_27) AT=765.025n

.meas tran vdout0_28ck1520 FIND v(dout0_28) AT=765.025n

.meas tran vdout0_29ck1520 FIND v(dout0_29) AT=765.025n

.meas tran vdout0_30ck1520 FIND v(dout0_30) AT=765.025n

.meas tran vdout0_31ck1520 FIND v(dout0_31) AT=765.025n

.meas tran vdout0_0ck1540 FIND v(dout0_0) AT=775.025n

.meas tran vdout0_1ck1540 FIND v(dout0_1) AT=775.025n

.meas tran vdout0_2ck1540 FIND v(dout0_2) AT=775.025n

.meas tran vdout0_3ck1540 FIND v(dout0_3) AT=775.025n

.meas tran vdout0_4ck1540 FIND v(dout0_4) AT=775.025n

.meas tran vdout0_5ck1540 FIND v(dout0_5) AT=775.025n

.meas tran vdout0_6ck1540 FIND v(dout0_6) AT=775.025n

.meas tran vdout0_7ck1540 FIND v(dout0_7) AT=775.025n

.meas tran vdout0_8ck1540 FIND v(dout0_8) AT=775.025n

.meas tran vdout0_9ck1540 FIND v(dout0_9) AT=775.025n

.meas tran vdout0_10ck1540 FIND v(dout0_10) AT=775.025n

.meas tran vdout0_11ck1540 FIND v(dout0_11) AT=775.025n

.meas tran vdout0_12ck1540 FIND v(dout0_12) AT=775.025n

.meas tran vdout0_13ck1540 FIND v(dout0_13) AT=775.025n

.meas tran vdout0_14ck1540 FIND v(dout0_14) AT=775.025n

.meas tran vdout0_15ck1540 FIND v(dout0_15) AT=775.025n

.meas tran vdout0_16ck1540 FIND v(dout0_16) AT=775.025n

.meas tran vdout0_17ck1540 FIND v(dout0_17) AT=775.025n

.meas tran vdout0_18ck1540 FIND v(dout0_18) AT=775.025n

.meas tran vdout0_19ck1540 FIND v(dout0_19) AT=775.025n

.meas tran vdout0_20ck1540 FIND v(dout0_20) AT=775.025n

.meas tran vdout0_21ck1540 FIND v(dout0_21) AT=775.025n

.meas tran vdout0_22ck1540 FIND v(dout0_22) AT=775.025n

.meas tran vdout0_23ck1540 FIND v(dout0_23) AT=775.025n

.meas tran vdout0_24ck1540 FIND v(dout0_24) AT=775.025n

.meas tran vdout0_25ck1540 FIND v(dout0_25) AT=775.025n

.meas tran vdout0_26ck1540 FIND v(dout0_26) AT=775.025n

.meas tran vdout0_27ck1540 FIND v(dout0_27) AT=775.025n

.meas tran vdout0_28ck1540 FIND v(dout0_28) AT=775.025n

.meas tran vdout0_29ck1540 FIND v(dout0_29) AT=775.025n

.meas tran vdout0_30ck1540 FIND v(dout0_30) AT=775.025n

.meas tran vdout0_31ck1540 FIND v(dout0_31) AT=775.025n

.meas tran vdout0_0ck1550 FIND v(dout0_0) AT=780.025n

.meas tran vdout0_1ck1550 FIND v(dout0_1) AT=780.025n

.meas tran vdout0_2ck1550 FIND v(dout0_2) AT=780.025n

.meas tran vdout0_3ck1550 FIND v(dout0_3) AT=780.025n

.meas tran vdout0_4ck1550 FIND v(dout0_4) AT=780.025n

.meas tran vdout0_5ck1550 FIND v(dout0_5) AT=780.025n

.meas tran vdout0_6ck1550 FIND v(dout0_6) AT=780.025n

.meas tran vdout0_7ck1550 FIND v(dout0_7) AT=780.025n

.meas tran vdout0_8ck1550 FIND v(dout0_8) AT=780.025n

.meas tran vdout0_9ck1550 FIND v(dout0_9) AT=780.025n

.meas tran vdout0_10ck1550 FIND v(dout0_10) AT=780.025n

.meas tran vdout0_11ck1550 FIND v(dout0_11) AT=780.025n

.meas tran vdout0_12ck1550 FIND v(dout0_12) AT=780.025n

.meas tran vdout0_13ck1550 FIND v(dout0_13) AT=780.025n

.meas tran vdout0_14ck1550 FIND v(dout0_14) AT=780.025n

.meas tran vdout0_15ck1550 FIND v(dout0_15) AT=780.025n

.meas tran vdout0_16ck1550 FIND v(dout0_16) AT=780.025n

.meas tran vdout0_17ck1550 FIND v(dout0_17) AT=780.025n

.meas tran vdout0_18ck1550 FIND v(dout0_18) AT=780.025n

.meas tran vdout0_19ck1550 FIND v(dout0_19) AT=780.025n

.meas tran vdout0_20ck1550 FIND v(dout0_20) AT=780.025n

.meas tran vdout0_21ck1550 FIND v(dout0_21) AT=780.025n

.meas tran vdout0_22ck1550 FIND v(dout0_22) AT=780.025n

.meas tran vdout0_23ck1550 FIND v(dout0_23) AT=780.025n

.meas tran vdout0_24ck1550 FIND v(dout0_24) AT=780.025n

.meas tran vdout0_25ck1550 FIND v(dout0_25) AT=780.025n

.meas tran vdout0_26ck1550 FIND v(dout0_26) AT=780.025n

.meas tran vdout0_27ck1550 FIND v(dout0_27) AT=780.025n

.meas tran vdout0_28ck1550 FIND v(dout0_28) AT=780.025n

.meas tran vdout0_29ck1550 FIND v(dout0_29) AT=780.025n

.meas tran vdout0_30ck1550 FIND v(dout0_30) AT=780.025n

.meas tran vdout0_31ck1550 FIND v(dout0_31) AT=780.025n

.meas tran vdout0_0ck1560 FIND v(dout0_0) AT=785.025n

.meas tran vdout0_1ck1560 FIND v(dout0_1) AT=785.025n

.meas tran vdout0_2ck1560 FIND v(dout0_2) AT=785.025n

.meas tran vdout0_3ck1560 FIND v(dout0_3) AT=785.025n

.meas tran vdout0_4ck1560 FIND v(dout0_4) AT=785.025n

.meas tran vdout0_5ck1560 FIND v(dout0_5) AT=785.025n

.meas tran vdout0_6ck1560 FIND v(dout0_6) AT=785.025n

.meas tran vdout0_7ck1560 FIND v(dout0_7) AT=785.025n

.meas tran vdout0_8ck1560 FIND v(dout0_8) AT=785.025n

.meas tran vdout0_9ck1560 FIND v(dout0_9) AT=785.025n

.meas tran vdout0_10ck1560 FIND v(dout0_10) AT=785.025n

.meas tran vdout0_11ck1560 FIND v(dout0_11) AT=785.025n

.meas tran vdout0_12ck1560 FIND v(dout0_12) AT=785.025n

.meas tran vdout0_13ck1560 FIND v(dout0_13) AT=785.025n

.meas tran vdout0_14ck1560 FIND v(dout0_14) AT=785.025n

.meas tran vdout0_15ck1560 FIND v(dout0_15) AT=785.025n

.meas tran vdout0_16ck1560 FIND v(dout0_16) AT=785.025n

.meas tran vdout0_17ck1560 FIND v(dout0_17) AT=785.025n

.meas tran vdout0_18ck1560 FIND v(dout0_18) AT=785.025n

.meas tran vdout0_19ck1560 FIND v(dout0_19) AT=785.025n

.meas tran vdout0_20ck1560 FIND v(dout0_20) AT=785.025n

.meas tran vdout0_21ck1560 FIND v(dout0_21) AT=785.025n

.meas tran vdout0_22ck1560 FIND v(dout0_22) AT=785.025n

.meas tran vdout0_23ck1560 FIND v(dout0_23) AT=785.025n

.meas tran vdout0_24ck1560 FIND v(dout0_24) AT=785.025n

.meas tran vdout0_25ck1560 FIND v(dout0_25) AT=785.025n

.meas tran vdout0_26ck1560 FIND v(dout0_26) AT=785.025n

.meas tran vdout0_27ck1560 FIND v(dout0_27) AT=785.025n

.meas tran vdout0_28ck1560 FIND v(dout0_28) AT=785.025n

.meas tran vdout0_29ck1560 FIND v(dout0_29) AT=785.025n

.meas tran vdout0_30ck1560 FIND v(dout0_30) AT=785.025n

.meas tran vdout0_31ck1560 FIND v(dout0_31) AT=785.025n

.meas tran vdout0_0ck1580 FIND v(dout0_0) AT=795.025n

.meas tran vdout0_1ck1580 FIND v(dout0_1) AT=795.025n

.meas tran vdout0_2ck1580 FIND v(dout0_2) AT=795.025n

.meas tran vdout0_3ck1580 FIND v(dout0_3) AT=795.025n

.meas tran vdout0_4ck1580 FIND v(dout0_4) AT=795.025n

.meas tran vdout0_5ck1580 FIND v(dout0_5) AT=795.025n

.meas tran vdout0_6ck1580 FIND v(dout0_6) AT=795.025n

.meas tran vdout0_7ck1580 FIND v(dout0_7) AT=795.025n

.meas tran vdout0_8ck1580 FIND v(dout0_8) AT=795.025n

.meas tran vdout0_9ck1580 FIND v(dout0_9) AT=795.025n

.meas tran vdout0_10ck1580 FIND v(dout0_10) AT=795.025n

.meas tran vdout0_11ck1580 FIND v(dout0_11) AT=795.025n

.meas tran vdout0_12ck1580 FIND v(dout0_12) AT=795.025n

.meas tran vdout0_13ck1580 FIND v(dout0_13) AT=795.025n

.meas tran vdout0_14ck1580 FIND v(dout0_14) AT=795.025n

.meas tran vdout0_15ck1580 FIND v(dout0_15) AT=795.025n

.meas tran vdout0_16ck1580 FIND v(dout0_16) AT=795.025n

.meas tran vdout0_17ck1580 FIND v(dout0_17) AT=795.025n

.meas tran vdout0_18ck1580 FIND v(dout0_18) AT=795.025n

.meas tran vdout0_19ck1580 FIND v(dout0_19) AT=795.025n

.meas tran vdout0_20ck1580 FIND v(dout0_20) AT=795.025n

.meas tran vdout0_21ck1580 FIND v(dout0_21) AT=795.025n

.meas tran vdout0_22ck1580 FIND v(dout0_22) AT=795.025n

.meas tran vdout0_23ck1580 FIND v(dout0_23) AT=795.025n

.meas tran vdout0_24ck1580 FIND v(dout0_24) AT=795.025n

.meas tran vdout0_25ck1580 FIND v(dout0_25) AT=795.025n

.meas tran vdout0_26ck1580 FIND v(dout0_26) AT=795.025n

.meas tran vdout0_27ck1580 FIND v(dout0_27) AT=795.025n

.meas tran vdout0_28ck1580 FIND v(dout0_28) AT=795.025n

.meas tran vdout0_29ck1580 FIND v(dout0_29) AT=795.025n

.meas tran vdout0_30ck1580 FIND v(dout0_30) AT=795.025n

.meas tran vdout0_31ck1580 FIND v(dout0_31) AT=795.025n

.meas tran vdout0_0ck1610 FIND v(dout0_0) AT=810.025n

.meas tran vdout0_1ck1610 FIND v(dout0_1) AT=810.025n

.meas tran vdout0_2ck1610 FIND v(dout0_2) AT=810.025n

.meas tran vdout0_3ck1610 FIND v(dout0_3) AT=810.025n

.meas tran vdout0_4ck1610 FIND v(dout0_4) AT=810.025n

.meas tran vdout0_5ck1610 FIND v(dout0_5) AT=810.025n

.meas tran vdout0_6ck1610 FIND v(dout0_6) AT=810.025n

.meas tran vdout0_7ck1610 FIND v(dout0_7) AT=810.025n

.meas tran vdout0_8ck1610 FIND v(dout0_8) AT=810.025n

.meas tran vdout0_9ck1610 FIND v(dout0_9) AT=810.025n

.meas tran vdout0_10ck1610 FIND v(dout0_10) AT=810.025n

.meas tran vdout0_11ck1610 FIND v(dout0_11) AT=810.025n

.meas tran vdout0_12ck1610 FIND v(dout0_12) AT=810.025n

.meas tran vdout0_13ck1610 FIND v(dout0_13) AT=810.025n

.meas tran vdout0_14ck1610 FIND v(dout0_14) AT=810.025n

.meas tran vdout0_15ck1610 FIND v(dout0_15) AT=810.025n

.meas tran vdout0_16ck1610 FIND v(dout0_16) AT=810.025n

.meas tran vdout0_17ck1610 FIND v(dout0_17) AT=810.025n

.meas tran vdout0_18ck1610 FIND v(dout0_18) AT=810.025n

.meas tran vdout0_19ck1610 FIND v(dout0_19) AT=810.025n

.meas tran vdout0_20ck1610 FIND v(dout0_20) AT=810.025n

.meas tran vdout0_21ck1610 FIND v(dout0_21) AT=810.025n

.meas tran vdout0_22ck1610 FIND v(dout0_22) AT=810.025n

.meas tran vdout0_23ck1610 FIND v(dout0_23) AT=810.025n

.meas tran vdout0_24ck1610 FIND v(dout0_24) AT=810.025n

.meas tran vdout0_25ck1610 FIND v(dout0_25) AT=810.025n

.meas tran vdout0_26ck1610 FIND v(dout0_26) AT=810.025n

.meas tran vdout0_27ck1610 FIND v(dout0_27) AT=810.025n

.meas tran vdout0_28ck1610 FIND v(dout0_28) AT=810.025n

.meas tran vdout0_29ck1610 FIND v(dout0_29) AT=810.025n

.meas tran vdout0_30ck1610 FIND v(dout0_30) AT=810.025n

.meas tran vdout0_31ck1610 FIND v(dout0_31) AT=810.025n

.meas tran vdout0_0ck1660 FIND v(dout0_0) AT=835.025n

.meas tran vdout0_1ck1660 FIND v(dout0_1) AT=835.025n

.meas tran vdout0_2ck1660 FIND v(dout0_2) AT=835.025n

.meas tran vdout0_3ck1660 FIND v(dout0_3) AT=835.025n

.meas tran vdout0_4ck1660 FIND v(dout0_4) AT=835.025n

.meas tran vdout0_5ck1660 FIND v(dout0_5) AT=835.025n

.meas tran vdout0_6ck1660 FIND v(dout0_6) AT=835.025n

.meas tran vdout0_7ck1660 FIND v(dout0_7) AT=835.025n

.meas tran vdout0_8ck1660 FIND v(dout0_8) AT=835.025n

.meas tran vdout0_9ck1660 FIND v(dout0_9) AT=835.025n

.meas tran vdout0_10ck1660 FIND v(dout0_10) AT=835.025n

.meas tran vdout0_11ck1660 FIND v(dout0_11) AT=835.025n

.meas tran vdout0_12ck1660 FIND v(dout0_12) AT=835.025n

.meas tran vdout0_13ck1660 FIND v(dout0_13) AT=835.025n

.meas tran vdout0_14ck1660 FIND v(dout0_14) AT=835.025n

.meas tran vdout0_15ck1660 FIND v(dout0_15) AT=835.025n

.meas tran vdout0_16ck1660 FIND v(dout0_16) AT=835.025n

.meas tran vdout0_17ck1660 FIND v(dout0_17) AT=835.025n

.meas tran vdout0_18ck1660 FIND v(dout0_18) AT=835.025n

.meas tran vdout0_19ck1660 FIND v(dout0_19) AT=835.025n

.meas tran vdout0_20ck1660 FIND v(dout0_20) AT=835.025n

.meas tran vdout0_21ck1660 FIND v(dout0_21) AT=835.025n

.meas tran vdout0_22ck1660 FIND v(dout0_22) AT=835.025n

.meas tran vdout0_23ck1660 FIND v(dout0_23) AT=835.025n

.meas tran vdout0_24ck1660 FIND v(dout0_24) AT=835.025n

.meas tran vdout0_25ck1660 FIND v(dout0_25) AT=835.025n

.meas tran vdout0_26ck1660 FIND v(dout0_26) AT=835.025n

.meas tran vdout0_27ck1660 FIND v(dout0_27) AT=835.025n

.meas tran vdout0_28ck1660 FIND v(dout0_28) AT=835.025n

.meas tran vdout0_29ck1660 FIND v(dout0_29) AT=835.025n

.meas tran vdout0_30ck1660 FIND v(dout0_30) AT=835.025n

.meas tran vdout0_31ck1660 FIND v(dout0_31) AT=835.025n

.meas tran vdout0_0ck1690 FIND v(dout0_0) AT=850.025n

.meas tran vdout0_1ck1690 FIND v(dout0_1) AT=850.025n

.meas tran vdout0_2ck1690 FIND v(dout0_2) AT=850.025n

.meas tran vdout0_3ck1690 FIND v(dout0_3) AT=850.025n

.meas tran vdout0_4ck1690 FIND v(dout0_4) AT=850.025n

.meas tran vdout0_5ck1690 FIND v(dout0_5) AT=850.025n

.meas tran vdout0_6ck1690 FIND v(dout0_6) AT=850.025n

.meas tran vdout0_7ck1690 FIND v(dout0_7) AT=850.025n

.meas tran vdout0_8ck1690 FIND v(dout0_8) AT=850.025n

.meas tran vdout0_9ck1690 FIND v(dout0_9) AT=850.025n

.meas tran vdout0_10ck1690 FIND v(dout0_10) AT=850.025n

.meas tran vdout0_11ck1690 FIND v(dout0_11) AT=850.025n

.meas tran vdout0_12ck1690 FIND v(dout0_12) AT=850.025n

.meas tran vdout0_13ck1690 FIND v(dout0_13) AT=850.025n

.meas tran vdout0_14ck1690 FIND v(dout0_14) AT=850.025n

.meas tran vdout0_15ck1690 FIND v(dout0_15) AT=850.025n

.meas tran vdout0_16ck1690 FIND v(dout0_16) AT=850.025n

.meas tran vdout0_17ck1690 FIND v(dout0_17) AT=850.025n

.meas tran vdout0_18ck1690 FIND v(dout0_18) AT=850.025n

.meas tran vdout0_19ck1690 FIND v(dout0_19) AT=850.025n

.meas tran vdout0_20ck1690 FIND v(dout0_20) AT=850.025n

.meas tran vdout0_21ck1690 FIND v(dout0_21) AT=850.025n

.meas tran vdout0_22ck1690 FIND v(dout0_22) AT=850.025n

.meas tran vdout0_23ck1690 FIND v(dout0_23) AT=850.025n

.meas tran vdout0_24ck1690 FIND v(dout0_24) AT=850.025n

.meas tran vdout0_25ck1690 FIND v(dout0_25) AT=850.025n

.meas tran vdout0_26ck1690 FIND v(dout0_26) AT=850.025n

.meas tran vdout0_27ck1690 FIND v(dout0_27) AT=850.025n

.meas tran vdout0_28ck1690 FIND v(dout0_28) AT=850.025n

.meas tran vdout0_29ck1690 FIND v(dout0_29) AT=850.025n

.meas tran vdout0_30ck1690 FIND v(dout0_30) AT=850.025n

.meas tran vdout0_31ck1690 FIND v(dout0_31) AT=850.025n

.meas tran vdout0_0ck1710 FIND v(dout0_0) AT=860.025n

.meas tran vdout0_1ck1710 FIND v(dout0_1) AT=860.025n

.meas tran vdout0_2ck1710 FIND v(dout0_2) AT=860.025n

.meas tran vdout0_3ck1710 FIND v(dout0_3) AT=860.025n

.meas tran vdout0_4ck1710 FIND v(dout0_4) AT=860.025n

.meas tran vdout0_5ck1710 FIND v(dout0_5) AT=860.025n

.meas tran vdout0_6ck1710 FIND v(dout0_6) AT=860.025n

.meas tran vdout0_7ck1710 FIND v(dout0_7) AT=860.025n

.meas tran vdout0_8ck1710 FIND v(dout0_8) AT=860.025n

.meas tran vdout0_9ck1710 FIND v(dout0_9) AT=860.025n

.meas tran vdout0_10ck1710 FIND v(dout0_10) AT=860.025n

.meas tran vdout0_11ck1710 FIND v(dout0_11) AT=860.025n

.meas tran vdout0_12ck1710 FIND v(dout0_12) AT=860.025n

.meas tran vdout0_13ck1710 FIND v(dout0_13) AT=860.025n

.meas tran vdout0_14ck1710 FIND v(dout0_14) AT=860.025n

.meas tran vdout0_15ck1710 FIND v(dout0_15) AT=860.025n

.meas tran vdout0_16ck1710 FIND v(dout0_16) AT=860.025n

.meas tran vdout0_17ck1710 FIND v(dout0_17) AT=860.025n

.meas tran vdout0_18ck1710 FIND v(dout0_18) AT=860.025n

.meas tran vdout0_19ck1710 FIND v(dout0_19) AT=860.025n

.meas tran vdout0_20ck1710 FIND v(dout0_20) AT=860.025n

.meas tran vdout0_21ck1710 FIND v(dout0_21) AT=860.025n

.meas tran vdout0_22ck1710 FIND v(dout0_22) AT=860.025n

.meas tran vdout0_23ck1710 FIND v(dout0_23) AT=860.025n

.meas tran vdout0_24ck1710 FIND v(dout0_24) AT=860.025n

.meas tran vdout0_25ck1710 FIND v(dout0_25) AT=860.025n

.meas tran vdout0_26ck1710 FIND v(dout0_26) AT=860.025n

.meas tran vdout0_27ck1710 FIND v(dout0_27) AT=860.025n

.meas tran vdout0_28ck1710 FIND v(dout0_28) AT=860.025n

.meas tran vdout0_29ck1710 FIND v(dout0_29) AT=860.025n

.meas tran vdout0_30ck1710 FIND v(dout0_30) AT=860.025n

.meas tran vdout0_31ck1710 FIND v(dout0_31) AT=860.025n

.meas tran vdout0_0ck1740 FIND v(dout0_0) AT=875.025n

.meas tran vdout0_1ck1740 FIND v(dout0_1) AT=875.025n

.meas tran vdout0_2ck1740 FIND v(dout0_2) AT=875.025n

.meas tran vdout0_3ck1740 FIND v(dout0_3) AT=875.025n

.meas tran vdout0_4ck1740 FIND v(dout0_4) AT=875.025n

.meas tran vdout0_5ck1740 FIND v(dout0_5) AT=875.025n

.meas tran vdout0_6ck1740 FIND v(dout0_6) AT=875.025n

.meas tran vdout0_7ck1740 FIND v(dout0_7) AT=875.025n

.meas tran vdout0_8ck1740 FIND v(dout0_8) AT=875.025n

.meas tran vdout0_9ck1740 FIND v(dout0_9) AT=875.025n

.meas tran vdout0_10ck1740 FIND v(dout0_10) AT=875.025n

.meas tran vdout0_11ck1740 FIND v(dout0_11) AT=875.025n

.meas tran vdout0_12ck1740 FIND v(dout0_12) AT=875.025n

.meas tran vdout0_13ck1740 FIND v(dout0_13) AT=875.025n

.meas tran vdout0_14ck1740 FIND v(dout0_14) AT=875.025n

.meas tran vdout0_15ck1740 FIND v(dout0_15) AT=875.025n

.meas tran vdout0_16ck1740 FIND v(dout0_16) AT=875.025n

.meas tran vdout0_17ck1740 FIND v(dout0_17) AT=875.025n

.meas tran vdout0_18ck1740 FIND v(dout0_18) AT=875.025n

.meas tran vdout0_19ck1740 FIND v(dout0_19) AT=875.025n

.meas tran vdout0_20ck1740 FIND v(dout0_20) AT=875.025n

.meas tran vdout0_21ck1740 FIND v(dout0_21) AT=875.025n

.meas tran vdout0_22ck1740 FIND v(dout0_22) AT=875.025n

.meas tran vdout0_23ck1740 FIND v(dout0_23) AT=875.025n

.meas tran vdout0_24ck1740 FIND v(dout0_24) AT=875.025n

.meas tran vdout0_25ck1740 FIND v(dout0_25) AT=875.025n

.meas tran vdout0_26ck1740 FIND v(dout0_26) AT=875.025n

.meas tran vdout0_27ck1740 FIND v(dout0_27) AT=875.025n

.meas tran vdout0_28ck1740 FIND v(dout0_28) AT=875.025n

.meas tran vdout0_29ck1740 FIND v(dout0_29) AT=875.025n

.meas tran vdout0_30ck1740 FIND v(dout0_30) AT=875.025n

.meas tran vdout0_31ck1740 FIND v(dout0_31) AT=875.025n

.meas tran vdout0_0ck1750 FIND v(dout0_0) AT=880.025n

.meas tran vdout0_1ck1750 FIND v(dout0_1) AT=880.025n

.meas tran vdout0_2ck1750 FIND v(dout0_2) AT=880.025n

.meas tran vdout0_3ck1750 FIND v(dout0_3) AT=880.025n

.meas tran vdout0_4ck1750 FIND v(dout0_4) AT=880.025n

.meas tran vdout0_5ck1750 FIND v(dout0_5) AT=880.025n

.meas tran vdout0_6ck1750 FIND v(dout0_6) AT=880.025n

.meas tran vdout0_7ck1750 FIND v(dout0_7) AT=880.025n

.meas tran vdout0_8ck1750 FIND v(dout0_8) AT=880.025n

.meas tran vdout0_9ck1750 FIND v(dout0_9) AT=880.025n

.meas tran vdout0_10ck1750 FIND v(dout0_10) AT=880.025n

.meas tran vdout0_11ck1750 FIND v(dout0_11) AT=880.025n

.meas tran vdout0_12ck1750 FIND v(dout0_12) AT=880.025n

.meas tran vdout0_13ck1750 FIND v(dout0_13) AT=880.025n

.meas tran vdout0_14ck1750 FIND v(dout0_14) AT=880.025n

.meas tran vdout0_15ck1750 FIND v(dout0_15) AT=880.025n

.meas tran vdout0_16ck1750 FIND v(dout0_16) AT=880.025n

.meas tran vdout0_17ck1750 FIND v(dout0_17) AT=880.025n

.meas tran vdout0_18ck1750 FIND v(dout0_18) AT=880.025n

.meas tran vdout0_19ck1750 FIND v(dout0_19) AT=880.025n

.meas tran vdout0_20ck1750 FIND v(dout0_20) AT=880.025n

.meas tran vdout0_21ck1750 FIND v(dout0_21) AT=880.025n

.meas tran vdout0_22ck1750 FIND v(dout0_22) AT=880.025n

.meas tran vdout0_23ck1750 FIND v(dout0_23) AT=880.025n

.meas tran vdout0_24ck1750 FIND v(dout0_24) AT=880.025n

.meas tran vdout0_25ck1750 FIND v(dout0_25) AT=880.025n

.meas tran vdout0_26ck1750 FIND v(dout0_26) AT=880.025n

.meas tran vdout0_27ck1750 FIND v(dout0_27) AT=880.025n

.meas tran vdout0_28ck1750 FIND v(dout0_28) AT=880.025n

.meas tran vdout0_29ck1750 FIND v(dout0_29) AT=880.025n

.meas tran vdout0_30ck1750 FIND v(dout0_30) AT=880.025n

.meas tran vdout0_31ck1750 FIND v(dout0_31) AT=880.025n

.meas tran vdout0_0ck1760 FIND v(dout0_0) AT=885.025n

.meas tran vdout0_1ck1760 FIND v(dout0_1) AT=885.025n

.meas tran vdout0_2ck1760 FIND v(dout0_2) AT=885.025n

.meas tran vdout0_3ck1760 FIND v(dout0_3) AT=885.025n

.meas tran vdout0_4ck1760 FIND v(dout0_4) AT=885.025n

.meas tran vdout0_5ck1760 FIND v(dout0_5) AT=885.025n

.meas tran vdout0_6ck1760 FIND v(dout0_6) AT=885.025n

.meas tran vdout0_7ck1760 FIND v(dout0_7) AT=885.025n

.meas tran vdout0_8ck1760 FIND v(dout0_8) AT=885.025n

.meas tran vdout0_9ck1760 FIND v(dout0_9) AT=885.025n

.meas tran vdout0_10ck1760 FIND v(dout0_10) AT=885.025n

.meas tran vdout0_11ck1760 FIND v(dout0_11) AT=885.025n

.meas tran vdout0_12ck1760 FIND v(dout0_12) AT=885.025n

.meas tran vdout0_13ck1760 FIND v(dout0_13) AT=885.025n

.meas tran vdout0_14ck1760 FIND v(dout0_14) AT=885.025n

.meas tran vdout0_15ck1760 FIND v(dout0_15) AT=885.025n

.meas tran vdout0_16ck1760 FIND v(dout0_16) AT=885.025n

.meas tran vdout0_17ck1760 FIND v(dout0_17) AT=885.025n

.meas tran vdout0_18ck1760 FIND v(dout0_18) AT=885.025n

.meas tran vdout0_19ck1760 FIND v(dout0_19) AT=885.025n

.meas tran vdout0_20ck1760 FIND v(dout0_20) AT=885.025n

.meas tran vdout0_21ck1760 FIND v(dout0_21) AT=885.025n

.meas tran vdout0_22ck1760 FIND v(dout0_22) AT=885.025n

.meas tran vdout0_23ck1760 FIND v(dout0_23) AT=885.025n

.meas tran vdout0_24ck1760 FIND v(dout0_24) AT=885.025n

.meas tran vdout0_25ck1760 FIND v(dout0_25) AT=885.025n

.meas tran vdout0_26ck1760 FIND v(dout0_26) AT=885.025n

.meas tran vdout0_27ck1760 FIND v(dout0_27) AT=885.025n

.meas tran vdout0_28ck1760 FIND v(dout0_28) AT=885.025n

.meas tran vdout0_29ck1760 FIND v(dout0_29) AT=885.025n

.meas tran vdout0_30ck1760 FIND v(dout0_30) AT=885.025n

.meas tran vdout0_31ck1760 FIND v(dout0_31) AT=885.025n

.meas tran vdout0_0ck1770 FIND v(dout0_0) AT=890.025n

.meas tran vdout0_1ck1770 FIND v(dout0_1) AT=890.025n

.meas tran vdout0_2ck1770 FIND v(dout0_2) AT=890.025n

.meas tran vdout0_3ck1770 FIND v(dout0_3) AT=890.025n

.meas tran vdout0_4ck1770 FIND v(dout0_4) AT=890.025n

.meas tran vdout0_5ck1770 FIND v(dout0_5) AT=890.025n

.meas tran vdout0_6ck1770 FIND v(dout0_6) AT=890.025n

.meas tran vdout0_7ck1770 FIND v(dout0_7) AT=890.025n

.meas tran vdout0_8ck1770 FIND v(dout0_8) AT=890.025n

.meas tran vdout0_9ck1770 FIND v(dout0_9) AT=890.025n

.meas tran vdout0_10ck1770 FIND v(dout0_10) AT=890.025n

.meas tran vdout0_11ck1770 FIND v(dout0_11) AT=890.025n

.meas tran vdout0_12ck1770 FIND v(dout0_12) AT=890.025n

.meas tran vdout0_13ck1770 FIND v(dout0_13) AT=890.025n

.meas tran vdout0_14ck1770 FIND v(dout0_14) AT=890.025n

.meas tran vdout0_15ck1770 FIND v(dout0_15) AT=890.025n

.meas tran vdout0_16ck1770 FIND v(dout0_16) AT=890.025n

.meas tran vdout0_17ck1770 FIND v(dout0_17) AT=890.025n

.meas tran vdout0_18ck1770 FIND v(dout0_18) AT=890.025n

.meas tran vdout0_19ck1770 FIND v(dout0_19) AT=890.025n

.meas tran vdout0_20ck1770 FIND v(dout0_20) AT=890.025n

.meas tran vdout0_21ck1770 FIND v(dout0_21) AT=890.025n

.meas tran vdout0_22ck1770 FIND v(dout0_22) AT=890.025n

.meas tran vdout0_23ck1770 FIND v(dout0_23) AT=890.025n

.meas tran vdout0_24ck1770 FIND v(dout0_24) AT=890.025n

.meas tran vdout0_25ck1770 FIND v(dout0_25) AT=890.025n

.meas tran vdout0_26ck1770 FIND v(dout0_26) AT=890.025n

.meas tran vdout0_27ck1770 FIND v(dout0_27) AT=890.025n

.meas tran vdout0_28ck1770 FIND v(dout0_28) AT=890.025n

.meas tran vdout0_29ck1770 FIND v(dout0_29) AT=890.025n

.meas tran vdout0_30ck1770 FIND v(dout0_30) AT=890.025n

.meas tran vdout0_31ck1770 FIND v(dout0_31) AT=890.025n

.meas tran vdout0_0ck1850 FIND v(dout0_0) AT=930.025n

.meas tran vdout0_1ck1850 FIND v(dout0_1) AT=930.025n

.meas tran vdout0_2ck1850 FIND v(dout0_2) AT=930.025n

.meas tran vdout0_3ck1850 FIND v(dout0_3) AT=930.025n

.meas tran vdout0_4ck1850 FIND v(dout0_4) AT=930.025n

.meas tran vdout0_5ck1850 FIND v(dout0_5) AT=930.025n

.meas tran vdout0_6ck1850 FIND v(dout0_6) AT=930.025n

.meas tran vdout0_7ck1850 FIND v(dout0_7) AT=930.025n

.meas tran vdout0_8ck1850 FIND v(dout0_8) AT=930.025n

.meas tran vdout0_9ck1850 FIND v(dout0_9) AT=930.025n

.meas tran vdout0_10ck1850 FIND v(dout0_10) AT=930.025n

.meas tran vdout0_11ck1850 FIND v(dout0_11) AT=930.025n

.meas tran vdout0_12ck1850 FIND v(dout0_12) AT=930.025n

.meas tran vdout0_13ck1850 FIND v(dout0_13) AT=930.025n

.meas tran vdout0_14ck1850 FIND v(dout0_14) AT=930.025n

.meas tran vdout0_15ck1850 FIND v(dout0_15) AT=930.025n

.meas tran vdout0_16ck1850 FIND v(dout0_16) AT=930.025n

.meas tran vdout0_17ck1850 FIND v(dout0_17) AT=930.025n

.meas tran vdout0_18ck1850 FIND v(dout0_18) AT=930.025n

.meas tran vdout0_19ck1850 FIND v(dout0_19) AT=930.025n

.meas tran vdout0_20ck1850 FIND v(dout0_20) AT=930.025n

.meas tran vdout0_21ck1850 FIND v(dout0_21) AT=930.025n

.meas tran vdout0_22ck1850 FIND v(dout0_22) AT=930.025n

.meas tran vdout0_23ck1850 FIND v(dout0_23) AT=930.025n

.meas tran vdout0_24ck1850 FIND v(dout0_24) AT=930.025n

.meas tran vdout0_25ck1850 FIND v(dout0_25) AT=930.025n

.meas tran vdout0_26ck1850 FIND v(dout0_26) AT=930.025n

.meas tran vdout0_27ck1850 FIND v(dout0_27) AT=930.025n

.meas tran vdout0_28ck1850 FIND v(dout0_28) AT=930.025n

.meas tran vdout0_29ck1850 FIND v(dout0_29) AT=930.025n

.meas tran vdout0_30ck1850 FIND v(dout0_30) AT=930.025n

.meas tran vdout0_31ck1850 FIND v(dout0_31) AT=930.025n

.meas tran vdout0_0ck1890 FIND v(dout0_0) AT=950.025n

.meas tran vdout0_1ck1890 FIND v(dout0_1) AT=950.025n

.meas tran vdout0_2ck1890 FIND v(dout0_2) AT=950.025n

.meas tran vdout0_3ck1890 FIND v(dout0_3) AT=950.025n

.meas tran vdout0_4ck1890 FIND v(dout0_4) AT=950.025n

.meas tran vdout0_5ck1890 FIND v(dout0_5) AT=950.025n

.meas tran vdout0_6ck1890 FIND v(dout0_6) AT=950.025n

.meas tran vdout0_7ck1890 FIND v(dout0_7) AT=950.025n

.meas tran vdout0_8ck1890 FIND v(dout0_8) AT=950.025n

.meas tran vdout0_9ck1890 FIND v(dout0_9) AT=950.025n

.meas tran vdout0_10ck1890 FIND v(dout0_10) AT=950.025n

.meas tran vdout0_11ck1890 FIND v(dout0_11) AT=950.025n

.meas tran vdout0_12ck1890 FIND v(dout0_12) AT=950.025n

.meas tran vdout0_13ck1890 FIND v(dout0_13) AT=950.025n

.meas tran vdout0_14ck1890 FIND v(dout0_14) AT=950.025n

.meas tran vdout0_15ck1890 FIND v(dout0_15) AT=950.025n

.meas tran vdout0_16ck1890 FIND v(dout0_16) AT=950.025n

.meas tran vdout0_17ck1890 FIND v(dout0_17) AT=950.025n

.meas tran vdout0_18ck1890 FIND v(dout0_18) AT=950.025n

.meas tran vdout0_19ck1890 FIND v(dout0_19) AT=950.025n

.meas tran vdout0_20ck1890 FIND v(dout0_20) AT=950.025n

.meas tran vdout0_21ck1890 FIND v(dout0_21) AT=950.025n

.meas tran vdout0_22ck1890 FIND v(dout0_22) AT=950.025n

.meas tran vdout0_23ck1890 FIND v(dout0_23) AT=950.025n

.meas tran vdout0_24ck1890 FIND v(dout0_24) AT=950.025n

.meas tran vdout0_25ck1890 FIND v(dout0_25) AT=950.025n

.meas tran vdout0_26ck1890 FIND v(dout0_26) AT=950.025n

.meas tran vdout0_27ck1890 FIND v(dout0_27) AT=950.025n

.meas tran vdout0_28ck1890 FIND v(dout0_28) AT=950.025n

.meas tran vdout0_29ck1890 FIND v(dout0_29) AT=950.025n

.meas tran vdout0_30ck1890 FIND v(dout0_30) AT=950.025n

.meas tran vdout0_31ck1890 FIND v(dout0_31) AT=950.025n

.meas tran vdout0_0ck1950 FIND v(dout0_0) AT=980.025n

.meas tran vdout0_1ck1950 FIND v(dout0_1) AT=980.025n

.meas tran vdout0_2ck1950 FIND v(dout0_2) AT=980.025n

.meas tran vdout0_3ck1950 FIND v(dout0_3) AT=980.025n

.meas tran vdout0_4ck1950 FIND v(dout0_4) AT=980.025n

.meas tran vdout0_5ck1950 FIND v(dout0_5) AT=980.025n

.meas tran vdout0_6ck1950 FIND v(dout0_6) AT=980.025n

.meas tran vdout0_7ck1950 FIND v(dout0_7) AT=980.025n

.meas tran vdout0_8ck1950 FIND v(dout0_8) AT=980.025n

.meas tran vdout0_9ck1950 FIND v(dout0_9) AT=980.025n

.meas tran vdout0_10ck1950 FIND v(dout0_10) AT=980.025n

.meas tran vdout0_11ck1950 FIND v(dout0_11) AT=980.025n

.meas tran vdout0_12ck1950 FIND v(dout0_12) AT=980.025n

.meas tran vdout0_13ck1950 FIND v(dout0_13) AT=980.025n

.meas tran vdout0_14ck1950 FIND v(dout0_14) AT=980.025n

.meas tran vdout0_15ck1950 FIND v(dout0_15) AT=980.025n

.meas tran vdout0_16ck1950 FIND v(dout0_16) AT=980.025n

.meas tran vdout0_17ck1950 FIND v(dout0_17) AT=980.025n

.meas tran vdout0_18ck1950 FIND v(dout0_18) AT=980.025n

.meas tran vdout0_19ck1950 FIND v(dout0_19) AT=980.025n

.meas tran vdout0_20ck1950 FIND v(dout0_20) AT=980.025n

.meas tran vdout0_21ck1950 FIND v(dout0_21) AT=980.025n

.meas tran vdout0_22ck1950 FIND v(dout0_22) AT=980.025n

.meas tran vdout0_23ck1950 FIND v(dout0_23) AT=980.025n

.meas tran vdout0_24ck1950 FIND v(dout0_24) AT=980.025n

.meas tran vdout0_25ck1950 FIND v(dout0_25) AT=980.025n

.meas tran vdout0_26ck1950 FIND v(dout0_26) AT=980.025n

.meas tran vdout0_27ck1950 FIND v(dout0_27) AT=980.025n

.meas tran vdout0_28ck1950 FIND v(dout0_28) AT=980.025n

.meas tran vdout0_29ck1950 FIND v(dout0_29) AT=980.025n

.meas tran vdout0_30ck1950 FIND v(dout0_30) AT=980.025n

.meas tran vdout0_31ck1950 FIND v(dout0_31) AT=980.025n

.meas tran vdout0_0ck1960 FIND v(dout0_0) AT=985.025n

.meas tran vdout0_1ck1960 FIND v(dout0_1) AT=985.025n

.meas tran vdout0_2ck1960 FIND v(dout0_2) AT=985.025n

.meas tran vdout0_3ck1960 FIND v(dout0_3) AT=985.025n

.meas tran vdout0_4ck1960 FIND v(dout0_4) AT=985.025n

.meas tran vdout0_5ck1960 FIND v(dout0_5) AT=985.025n

.meas tran vdout0_6ck1960 FIND v(dout0_6) AT=985.025n

.meas tran vdout0_7ck1960 FIND v(dout0_7) AT=985.025n

.meas tran vdout0_8ck1960 FIND v(dout0_8) AT=985.025n

.meas tran vdout0_9ck1960 FIND v(dout0_9) AT=985.025n

.meas tran vdout0_10ck1960 FIND v(dout0_10) AT=985.025n

.meas tran vdout0_11ck1960 FIND v(dout0_11) AT=985.025n

.meas tran vdout0_12ck1960 FIND v(dout0_12) AT=985.025n

.meas tran vdout0_13ck1960 FIND v(dout0_13) AT=985.025n

.meas tran vdout0_14ck1960 FIND v(dout0_14) AT=985.025n

.meas tran vdout0_15ck1960 FIND v(dout0_15) AT=985.025n

.meas tran vdout0_16ck1960 FIND v(dout0_16) AT=985.025n

.meas tran vdout0_17ck1960 FIND v(dout0_17) AT=985.025n

.meas tran vdout0_18ck1960 FIND v(dout0_18) AT=985.025n

.meas tran vdout0_19ck1960 FIND v(dout0_19) AT=985.025n

.meas tran vdout0_20ck1960 FIND v(dout0_20) AT=985.025n

.meas tran vdout0_21ck1960 FIND v(dout0_21) AT=985.025n

.meas tran vdout0_22ck1960 FIND v(dout0_22) AT=985.025n

.meas tran vdout0_23ck1960 FIND v(dout0_23) AT=985.025n

.meas tran vdout0_24ck1960 FIND v(dout0_24) AT=985.025n

.meas tran vdout0_25ck1960 FIND v(dout0_25) AT=985.025n

.meas tran vdout0_26ck1960 FIND v(dout0_26) AT=985.025n

.meas tran vdout0_27ck1960 FIND v(dout0_27) AT=985.025n

.meas tran vdout0_28ck1960 FIND v(dout0_28) AT=985.025n

.meas tran vdout0_29ck1960 FIND v(dout0_29) AT=985.025n

.meas tran vdout0_30ck1960 FIND v(dout0_30) AT=985.025n

.meas tran vdout0_31ck1960 FIND v(dout0_31) AT=985.025n

.meas tran vdout0_0ck2010 FIND v(dout0_0) AT=1010.025n

.meas tran vdout0_1ck2010 FIND v(dout0_1) AT=1010.025n

.meas tran vdout0_2ck2010 FIND v(dout0_2) AT=1010.025n

.meas tran vdout0_3ck2010 FIND v(dout0_3) AT=1010.025n

.meas tran vdout0_4ck2010 FIND v(dout0_4) AT=1010.025n

.meas tran vdout0_5ck2010 FIND v(dout0_5) AT=1010.025n

.meas tran vdout0_6ck2010 FIND v(dout0_6) AT=1010.025n

.meas tran vdout0_7ck2010 FIND v(dout0_7) AT=1010.025n

.meas tran vdout0_8ck2010 FIND v(dout0_8) AT=1010.025n

.meas tran vdout0_9ck2010 FIND v(dout0_9) AT=1010.025n

.meas tran vdout0_10ck2010 FIND v(dout0_10) AT=1010.025n

.meas tran vdout0_11ck2010 FIND v(dout0_11) AT=1010.025n

.meas tran vdout0_12ck2010 FIND v(dout0_12) AT=1010.025n

.meas tran vdout0_13ck2010 FIND v(dout0_13) AT=1010.025n

.meas tran vdout0_14ck2010 FIND v(dout0_14) AT=1010.025n

.meas tran vdout0_15ck2010 FIND v(dout0_15) AT=1010.025n

.meas tran vdout0_16ck2010 FIND v(dout0_16) AT=1010.025n

.meas tran vdout0_17ck2010 FIND v(dout0_17) AT=1010.025n

.meas tran vdout0_18ck2010 FIND v(dout0_18) AT=1010.025n

.meas tran vdout0_19ck2010 FIND v(dout0_19) AT=1010.025n

.meas tran vdout0_20ck2010 FIND v(dout0_20) AT=1010.025n

.meas tran vdout0_21ck2010 FIND v(dout0_21) AT=1010.025n

.meas tran vdout0_22ck2010 FIND v(dout0_22) AT=1010.025n

.meas tran vdout0_23ck2010 FIND v(dout0_23) AT=1010.025n

.meas tran vdout0_24ck2010 FIND v(dout0_24) AT=1010.025n

.meas tran vdout0_25ck2010 FIND v(dout0_25) AT=1010.025n

.meas tran vdout0_26ck2010 FIND v(dout0_26) AT=1010.025n

.meas tran vdout0_27ck2010 FIND v(dout0_27) AT=1010.025n

.meas tran vdout0_28ck2010 FIND v(dout0_28) AT=1010.025n

.meas tran vdout0_29ck2010 FIND v(dout0_29) AT=1010.025n

.meas tran vdout0_30ck2010 FIND v(dout0_30) AT=1010.025n

.meas tran vdout0_31ck2010 FIND v(dout0_31) AT=1010.025n

.meas tran vdout0_0ck2030 FIND v(dout0_0) AT=1020.025n

.meas tran vdout0_1ck2030 FIND v(dout0_1) AT=1020.025n

.meas tran vdout0_2ck2030 FIND v(dout0_2) AT=1020.025n

.meas tran vdout0_3ck2030 FIND v(dout0_3) AT=1020.025n

.meas tran vdout0_4ck2030 FIND v(dout0_4) AT=1020.025n

.meas tran vdout0_5ck2030 FIND v(dout0_5) AT=1020.025n

.meas tran vdout0_6ck2030 FIND v(dout0_6) AT=1020.025n

.meas tran vdout0_7ck2030 FIND v(dout0_7) AT=1020.025n

.meas tran vdout0_8ck2030 FIND v(dout0_8) AT=1020.025n

.meas tran vdout0_9ck2030 FIND v(dout0_9) AT=1020.025n

.meas tran vdout0_10ck2030 FIND v(dout0_10) AT=1020.025n

.meas tran vdout0_11ck2030 FIND v(dout0_11) AT=1020.025n

.meas tran vdout0_12ck2030 FIND v(dout0_12) AT=1020.025n

.meas tran vdout0_13ck2030 FIND v(dout0_13) AT=1020.025n

.meas tran vdout0_14ck2030 FIND v(dout0_14) AT=1020.025n

.meas tran vdout0_15ck2030 FIND v(dout0_15) AT=1020.025n

.meas tran vdout0_16ck2030 FIND v(dout0_16) AT=1020.025n

.meas tran vdout0_17ck2030 FIND v(dout0_17) AT=1020.025n

.meas tran vdout0_18ck2030 FIND v(dout0_18) AT=1020.025n

.meas tran vdout0_19ck2030 FIND v(dout0_19) AT=1020.025n

.meas tran vdout0_20ck2030 FIND v(dout0_20) AT=1020.025n

.meas tran vdout0_21ck2030 FIND v(dout0_21) AT=1020.025n

.meas tran vdout0_22ck2030 FIND v(dout0_22) AT=1020.025n

.meas tran vdout0_23ck2030 FIND v(dout0_23) AT=1020.025n

.meas tran vdout0_24ck2030 FIND v(dout0_24) AT=1020.025n

.meas tran vdout0_25ck2030 FIND v(dout0_25) AT=1020.025n

.meas tran vdout0_26ck2030 FIND v(dout0_26) AT=1020.025n

.meas tran vdout0_27ck2030 FIND v(dout0_27) AT=1020.025n

.meas tran vdout0_28ck2030 FIND v(dout0_28) AT=1020.025n

.meas tran vdout0_29ck2030 FIND v(dout0_29) AT=1020.025n

.meas tran vdout0_30ck2030 FIND v(dout0_30) AT=1020.025n

.meas tran vdout0_31ck2030 FIND v(dout0_31) AT=1020.025n

.meas tran vdout0_0ck2040 FIND v(dout0_0) AT=1025.025n

.meas tran vdout0_1ck2040 FIND v(dout0_1) AT=1025.025n

.meas tran vdout0_2ck2040 FIND v(dout0_2) AT=1025.025n

.meas tran vdout0_3ck2040 FIND v(dout0_3) AT=1025.025n

.meas tran vdout0_4ck2040 FIND v(dout0_4) AT=1025.025n

.meas tran vdout0_5ck2040 FIND v(dout0_5) AT=1025.025n

.meas tran vdout0_6ck2040 FIND v(dout0_6) AT=1025.025n

.meas tran vdout0_7ck2040 FIND v(dout0_7) AT=1025.025n

.meas tran vdout0_8ck2040 FIND v(dout0_8) AT=1025.025n

.meas tran vdout0_9ck2040 FIND v(dout0_9) AT=1025.025n

.meas tran vdout0_10ck2040 FIND v(dout0_10) AT=1025.025n

.meas tran vdout0_11ck2040 FIND v(dout0_11) AT=1025.025n

.meas tran vdout0_12ck2040 FIND v(dout0_12) AT=1025.025n

.meas tran vdout0_13ck2040 FIND v(dout0_13) AT=1025.025n

.meas tran vdout0_14ck2040 FIND v(dout0_14) AT=1025.025n

.meas tran vdout0_15ck2040 FIND v(dout0_15) AT=1025.025n

.meas tran vdout0_16ck2040 FIND v(dout0_16) AT=1025.025n

.meas tran vdout0_17ck2040 FIND v(dout0_17) AT=1025.025n

.meas tran vdout0_18ck2040 FIND v(dout0_18) AT=1025.025n

.meas tran vdout0_19ck2040 FIND v(dout0_19) AT=1025.025n

.meas tran vdout0_20ck2040 FIND v(dout0_20) AT=1025.025n

.meas tran vdout0_21ck2040 FIND v(dout0_21) AT=1025.025n

.meas tran vdout0_22ck2040 FIND v(dout0_22) AT=1025.025n

.meas tran vdout0_23ck2040 FIND v(dout0_23) AT=1025.025n

.meas tran vdout0_24ck2040 FIND v(dout0_24) AT=1025.025n

.meas tran vdout0_25ck2040 FIND v(dout0_25) AT=1025.025n

.meas tran vdout0_26ck2040 FIND v(dout0_26) AT=1025.025n

.meas tran vdout0_27ck2040 FIND v(dout0_27) AT=1025.025n

.meas tran vdout0_28ck2040 FIND v(dout0_28) AT=1025.025n

.meas tran vdout0_29ck2040 FIND v(dout0_29) AT=1025.025n

.meas tran vdout0_30ck2040 FIND v(dout0_30) AT=1025.025n

.meas tran vdout0_31ck2040 FIND v(dout0_31) AT=1025.025n
