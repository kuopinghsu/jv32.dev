.meas tran vdout0_0ck40 FIND v(dout0_0) AT=25.025n

.meas tran vdout0_1ck40 FIND v(dout0_1) AT=25.025n

.meas tran vdout0_2ck40 FIND v(dout0_2) AT=25.025n

.meas tran vdout0_3ck40 FIND v(dout0_3) AT=25.025n

.meas tran vdout0_4ck40 FIND v(dout0_4) AT=25.025n

.meas tran vdout0_5ck40 FIND v(dout0_5) AT=25.025n

.meas tran vdout0_6ck40 FIND v(dout0_6) AT=25.025n

.meas tran vdout0_7ck40 FIND v(dout0_7) AT=25.025n

.meas tran vdout0_8ck40 FIND v(dout0_8) AT=25.025n

.meas tran vdout0_9ck40 FIND v(dout0_9) AT=25.025n

.meas tran vdout0_10ck40 FIND v(dout0_10) AT=25.025n

.meas tran vdout0_11ck40 FIND v(dout0_11) AT=25.025n

.meas tran vdout0_12ck40 FIND v(dout0_12) AT=25.025n

.meas tran vdout0_13ck40 FIND v(dout0_13) AT=25.025n

.meas tran vdout0_14ck40 FIND v(dout0_14) AT=25.025n

.meas tran vdout0_15ck40 FIND v(dout0_15) AT=25.025n

.meas tran vdout0_16ck40 FIND v(dout0_16) AT=25.025n

.meas tran vdout0_17ck40 FIND v(dout0_17) AT=25.025n

.meas tran vdout0_18ck40 FIND v(dout0_18) AT=25.025n

.meas tran vdout0_19ck40 FIND v(dout0_19) AT=25.025n

.meas tran vdout0_20ck40 FIND v(dout0_20) AT=25.025n

.meas tran vdout0_21ck40 FIND v(dout0_21) AT=25.025n

.meas tran vdout0_22ck40 FIND v(dout0_22) AT=25.025n

.meas tran vdout0_23ck40 FIND v(dout0_23) AT=25.025n

.meas tran vdout0_24ck40 FIND v(dout0_24) AT=25.025n

.meas tran vdout0_25ck40 FIND v(dout0_25) AT=25.025n

.meas tran vdout0_26ck40 FIND v(dout0_26) AT=25.025n

.meas tran vdout0_27ck40 FIND v(dout0_27) AT=25.025n

.meas tran vdout0_28ck40 FIND v(dout0_28) AT=25.025n

.meas tran vdout0_29ck40 FIND v(dout0_29) AT=25.025n

.meas tran vdout0_30ck40 FIND v(dout0_30) AT=25.025n

.meas tran vdout0_31ck40 FIND v(dout0_31) AT=25.025n

.meas tran vdout0_0ck50 FIND v(dout0_0) AT=30.025n

.meas tran vdout0_1ck50 FIND v(dout0_1) AT=30.025n

.meas tran vdout0_2ck50 FIND v(dout0_2) AT=30.025n

.meas tran vdout0_3ck50 FIND v(dout0_3) AT=30.025n

.meas tran vdout0_4ck50 FIND v(dout0_4) AT=30.025n

.meas tran vdout0_5ck50 FIND v(dout0_5) AT=30.025n

.meas tran vdout0_6ck50 FIND v(dout0_6) AT=30.025n

.meas tran vdout0_7ck50 FIND v(dout0_7) AT=30.025n

.meas tran vdout0_8ck50 FIND v(dout0_8) AT=30.025n

.meas tran vdout0_9ck50 FIND v(dout0_9) AT=30.025n

.meas tran vdout0_10ck50 FIND v(dout0_10) AT=30.025n

.meas tran vdout0_11ck50 FIND v(dout0_11) AT=30.025n

.meas tran vdout0_12ck50 FIND v(dout0_12) AT=30.025n

.meas tran vdout0_13ck50 FIND v(dout0_13) AT=30.025n

.meas tran vdout0_14ck50 FIND v(dout0_14) AT=30.025n

.meas tran vdout0_15ck50 FIND v(dout0_15) AT=30.025n

.meas tran vdout0_16ck50 FIND v(dout0_16) AT=30.025n

.meas tran vdout0_17ck50 FIND v(dout0_17) AT=30.025n

.meas tran vdout0_18ck50 FIND v(dout0_18) AT=30.025n

.meas tran vdout0_19ck50 FIND v(dout0_19) AT=30.025n

.meas tran vdout0_20ck50 FIND v(dout0_20) AT=30.025n

.meas tran vdout0_21ck50 FIND v(dout0_21) AT=30.025n

.meas tran vdout0_22ck50 FIND v(dout0_22) AT=30.025n

.meas tran vdout0_23ck50 FIND v(dout0_23) AT=30.025n

.meas tran vdout0_24ck50 FIND v(dout0_24) AT=30.025n

.meas tran vdout0_25ck50 FIND v(dout0_25) AT=30.025n

.meas tran vdout0_26ck50 FIND v(dout0_26) AT=30.025n

.meas tran vdout0_27ck50 FIND v(dout0_27) AT=30.025n

.meas tran vdout0_28ck50 FIND v(dout0_28) AT=30.025n

.meas tran vdout0_29ck50 FIND v(dout0_29) AT=30.025n

.meas tran vdout0_30ck50 FIND v(dout0_30) AT=30.025n

.meas tran vdout0_31ck50 FIND v(dout0_31) AT=30.025n

.meas tran vdout0_0ck60 FIND v(dout0_0) AT=35.025n

.meas tran vdout0_1ck60 FIND v(dout0_1) AT=35.025n

.meas tran vdout0_2ck60 FIND v(dout0_2) AT=35.025n

.meas tran vdout0_3ck60 FIND v(dout0_3) AT=35.025n

.meas tran vdout0_4ck60 FIND v(dout0_4) AT=35.025n

.meas tran vdout0_5ck60 FIND v(dout0_5) AT=35.025n

.meas tran vdout0_6ck60 FIND v(dout0_6) AT=35.025n

.meas tran vdout0_7ck60 FIND v(dout0_7) AT=35.025n

.meas tran vdout0_8ck60 FIND v(dout0_8) AT=35.025n

.meas tran vdout0_9ck60 FIND v(dout0_9) AT=35.025n

.meas tran vdout0_10ck60 FIND v(dout0_10) AT=35.025n

.meas tran vdout0_11ck60 FIND v(dout0_11) AT=35.025n

.meas tran vdout0_12ck60 FIND v(dout0_12) AT=35.025n

.meas tran vdout0_13ck60 FIND v(dout0_13) AT=35.025n

.meas tran vdout0_14ck60 FIND v(dout0_14) AT=35.025n

.meas tran vdout0_15ck60 FIND v(dout0_15) AT=35.025n

.meas tran vdout0_16ck60 FIND v(dout0_16) AT=35.025n

.meas tran vdout0_17ck60 FIND v(dout0_17) AT=35.025n

.meas tran vdout0_18ck60 FIND v(dout0_18) AT=35.025n

.meas tran vdout0_19ck60 FIND v(dout0_19) AT=35.025n

.meas tran vdout0_20ck60 FIND v(dout0_20) AT=35.025n

.meas tran vdout0_21ck60 FIND v(dout0_21) AT=35.025n

.meas tran vdout0_22ck60 FIND v(dout0_22) AT=35.025n

.meas tran vdout0_23ck60 FIND v(dout0_23) AT=35.025n

.meas tran vdout0_24ck60 FIND v(dout0_24) AT=35.025n

.meas tran vdout0_25ck60 FIND v(dout0_25) AT=35.025n

.meas tran vdout0_26ck60 FIND v(dout0_26) AT=35.025n

.meas tran vdout0_27ck60 FIND v(dout0_27) AT=35.025n

.meas tran vdout0_28ck60 FIND v(dout0_28) AT=35.025n

.meas tran vdout0_29ck60 FIND v(dout0_29) AT=35.025n

.meas tran vdout0_30ck60 FIND v(dout0_30) AT=35.025n

.meas tran vdout0_31ck60 FIND v(dout0_31) AT=35.025n

.meas tran vdout0_0ck80 FIND v(dout0_0) AT=45.025n

.meas tran vdout0_1ck80 FIND v(dout0_1) AT=45.025n

.meas tran vdout0_2ck80 FIND v(dout0_2) AT=45.025n

.meas tran vdout0_3ck80 FIND v(dout0_3) AT=45.025n

.meas tran vdout0_4ck80 FIND v(dout0_4) AT=45.025n

.meas tran vdout0_5ck80 FIND v(dout0_5) AT=45.025n

.meas tran vdout0_6ck80 FIND v(dout0_6) AT=45.025n

.meas tran vdout0_7ck80 FIND v(dout0_7) AT=45.025n

.meas tran vdout0_8ck80 FIND v(dout0_8) AT=45.025n

.meas tran vdout0_9ck80 FIND v(dout0_9) AT=45.025n

.meas tran vdout0_10ck80 FIND v(dout0_10) AT=45.025n

.meas tran vdout0_11ck80 FIND v(dout0_11) AT=45.025n

.meas tran vdout0_12ck80 FIND v(dout0_12) AT=45.025n

.meas tran vdout0_13ck80 FIND v(dout0_13) AT=45.025n

.meas tran vdout0_14ck80 FIND v(dout0_14) AT=45.025n

.meas tran vdout0_15ck80 FIND v(dout0_15) AT=45.025n

.meas tran vdout0_16ck80 FIND v(dout0_16) AT=45.025n

.meas tran vdout0_17ck80 FIND v(dout0_17) AT=45.025n

.meas tran vdout0_18ck80 FIND v(dout0_18) AT=45.025n

.meas tran vdout0_19ck80 FIND v(dout0_19) AT=45.025n

.meas tran vdout0_20ck80 FIND v(dout0_20) AT=45.025n

.meas tran vdout0_21ck80 FIND v(dout0_21) AT=45.025n

.meas tran vdout0_22ck80 FIND v(dout0_22) AT=45.025n

.meas tran vdout0_23ck80 FIND v(dout0_23) AT=45.025n

.meas tran vdout0_24ck80 FIND v(dout0_24) AT=45.025n

.meas tran vdout0_25ck80 FIND v(dout0_25) AT=45.025n

.meas tran vdout0_26ck80 FIND v(dout0_26) AT=45.025n

.meas tran vdout0_27ck80 FIND v(dout0_27) AT=45.025n

.meas tran vdout0_28ck80 FIND v(dout0_28) AT=45.025n

.meas tran vdout0_29ck80 FIND v(dout0_29) AT=45.025n

.meas tran vdout0_30ck80 FIND v(dout0_30) AT=45.025n

.meas tran vdout0_31ck80 FIND v(dout0_31) AT=45.025n

.meas tran vdout0_0ck140 FIND v(dout0_0) AT=75.025n

.meas tran vdout0_1ck140 FIND v(dout0_1) AT=75.025n

.meas tran vdout0_2ck140 FIND v(dout0_2) AT=75.025n

.meas tran vdout0_3ck140 FIND v(dout0_3) AT=75.025n

.meas tran vdout0_4ck140 FIND v(dout0_4) AT=75.025n

.meas tran vdout0_5ck140 FIND v(dout0_5) AT=75.025n

.meas tran vdout0_6ck140 FIND v(dout0_6) AT=75.025n

.meas tran vdout0_7ck140 FIND v(dout0_7) AT=75.025n

.meas tran vdout0_8ck140 FIND v(dout0_8) AT=75.025n

.meas tran vdout0_9ck140 FIND v(dout0_9) AT=75.025n

.meas tran vdout0_10ck140 FIND v(dout0_10) AT=75.025n

.meas tran vdout0_11ck140 FIND v(dout0_11) AT=75.025n

.meas tran vdout0_12ck140 FIND v(dout0_12) AT=75.025n

.meas tran vdout0_13ck140 FIND v(dout0_13) AT=75.025n

.meas tran vdout0_14ck140 FIND v(dout0_14) AT=75.025n

.meas tran vdout0_15ck140 FIND v(dout0_15) AT=75.025n

.meas tran vdout0_16ck140 FIND v(dout0_16) AT=75.025n

.meas tran vdout0_17ck140 FIND v(dout0_17) AT=75.025n

.meas tran vdout0_18ck140 FIND v(dout0_18) AT=75.025n

.meas tran vdout0_19ck140 FIND v(dout0_19) AT=75.025n

.meas tran vdout0_20ck140 FIND v(dout0_20) AT=75.025n

.meas tran vdout0_21ck140 FIND v(dout0_21) AT=75.025n

.meas tran vdout0_22ck140 FIND v(dout0_22) AT=75.025n

.meas tran vdout0_23ck140 FIND v(dout0_23) AT=75.025n

.meas tran vdout0_24ck140 FIND v(dout0_24) AT=75.025n

.meas tran vdout0_25ck140 FIND v(dout0_25) AT=75.025n

.meas tran vdout0_26ck140 FIND v(dout0_26) AT=75.025n

.meas tran vdout0_27ck140 FIND v(dout0_27) AT=75.025n

.meas tran vdout0_28ck140 FIND v(dout0_28) AT=75.025n

.meas tran vdout0_29ck140 FIND v(dout0_29) AT=75.025n

.meas tran vdout0_30ck140 FIND v(dout0_30) AT=75.025n

.meas tran vdout0_31ck140 FIND v(dout0_31) AT=75.025n

.meas tran vdout0_0ck170 FIND v(dout0_0) AT=90.025n

.meas tran vdout0_1ck170 FIND v(dout0_1) AT=90.025n

.meas tran vdout0_2ck170 FIND v(dout0_2) AT=90.025n

.meas tran vdout0_3ck170 FIND v(dout0_3) AT=90.025n

.meas tran vdout0_4ck170 FIND v(dout0_4) AT=90.025n

.meas tran vdout0_5ck170 FIND v(dout0_5) AT=90.025n

.meas tran vdout0_6ck170 FIND v(dout0_6) AT=90.025n

.meas tran vdout0_7ck170 FIND v(dout0_7) AT=90.025n

.meas tran vdout0_8ck170 FIND v(dout0_8) AT=90.025n

.meas tran vdout0_9ck170 FIND v(dout0_9) AT=90.025n

.meas tran vdout0_10ck170 FIND v(dout0_10) AT=90.025n

.meas tran vdout0_11ck170 FIND v(dout0_11) AT=90.025n

.meas tran vdout0_12ck170 FIND v(dout0_12) AT=90.025n

.meas tran vdout0_13ck170 FIND v(dout0_13) AT=90.025n

.meas tran vdout0_14ck170 FIND v(dout0_14) AT=90.025n

.meas tran vdout0_15ck170 FIND v(dout0_15) AT=90.025n

.meas tran vdout0_16ck170 FIND v(dout0_16) AT=90.025n

.meas tran vdout0_17ck170 FIND v(dout0_17) AT=90.025n

.meas tran vdout0_18ck170 FIND v(dout0_18) AT=90.025n

.meas tran vdout0_19ck170 FIND v(dout0_19) AT=90.025n

.meas tran vdout0_20ck170 FIND v(dout0_20) AT=90.025n

.meas tran vdout0_21ck170 FIND v(dout0_21) AT=90.025n

.meas tran vdout0_22ck170 FIND v(dout0_22) AT=90.025n

.meas tran vdout0_23ck170 FIND v(dout0_23) AT=90.025n

.meas tran vdout0_24ck170 FIND v(dout0_24) AT=90.025n

.meas tran vdout0_25ck170 FIND v(dout0_25) AT=90.025n

.meas tran vdout0_26ck170 FIND v(dout0_26) AT=90.025n

.meas tran vdout0_27ck170 FIND v(dout0_27) AT=90.025n

.meas tran vdout0_28ck170 FIND v(dout0_28) AT=90.025n

.meas tran vdout0_29ck170 FIND v(dout0_29) AT=90.025n

.meas tran vdout0_30ck170 FIND v(dout0_30) AT=90.025n

.meas tran vdout0_31ck170 FIND v(dout0_31) AT=90.025n

.meas tran vdout0_0ck180 FIND v(dout0_0) AT=95.025n

.meas tran vdout0_1ck180 FIND v(dout0_1) AT=95.025n

.meas tran vdout0_2ck180 FIND v(dout0_2) AT=95.025n

.meas tran vdout0_3ck180 FIND v(dout0_3) AT=95.025n

.meas tran vdout0_4ck180 FIND v(dout0_4) AT=95.025n

.meas tran vdout0_5ck180 FIND v(dout0_5) AT=95.025n

.meas tran vdout0_6ck180 FIND v(dout0_6) AT=95.025n

.meas tran vdout0_7ck180 FIND v(dout0_7) AT=95.025n

.meas tran vdout0_8ck180 FIND v(dout0_8) AT=95.025n

.meas tran vdout0_9ck180 FIND v(dout0_9) AT=95.025n

.meas tran vdout0_10ck180 FIND v(dout0_10) AT=95.025n

.meas tran vdout0_11ck180 FIND v(dout0_11) AT=95.025n

.meas tran vdout0_12ck180 FIND v(dout0_12) AT=95.025n

.meas tran vdout0_13ck180 FIND v(dout0_13) AT=95.025n

.meas tran vdout0_14ck180 FIND v(dout0_14) AT=95.025n

.meas tran vdout0_15ck180 FIND v(dout0_15) AT=95.025n

.meas tran vdout0_16ck180 FIND v(dout0_16) AT=95.025n

.meas tran vdout0_17ck180 FIND v(dout0_17) AT=95.025n

.meas tran vdout0_18ck180 FIND v(dout0_18) AT=95.025n

.meas tran vdout0_19ck180 FIND v(dout0_19) AT=95.025n

.meas tran vdout0_20ck180 FIND v(dout0_20) AT=95.025n

.meas tran vdout0_21ck180 FIND v(dout0_21) AT=95.025n

.meas tran vdout0_22ck180 FIND v(dout0_22) AT=95.025n

.meas tran vdout0_23ck180 FIND v(dout0_23) AT=95.025n

.meas tran vdout0_24ck180 FIND v(dout0_24) AT=95.025n

.meas tran vdout0_25ck180 FIND v(dout0_25) AT=95.025n

.meas tran vdout0_26ck180 FIND v(dout0_26) AT=95.025n

.meas tran vdout0_27ck180 FIND v(dout0_27) AT=95.025n

.meas tran vdout0_28ck180 FIND v(dout0_28) AT=95.025n

.meas tran vdout0_29ck180 FIND v(dout0_29) AT=95.025n

.meas tran vdout0_30ck180 FIND v(dout0_30) AT=95.025n

.meas tran vdout0_31ck180 FIND v(dout0_31) AT=95.025n

.meas tran vdout0_0ck190 FIND v(dout0_0) AT=100.025n

.meas tran vdout0_1ck190 FIND v(dout0_1) AT=100.025n

.meas tran vdout0_2ck190 FIND v(dout0_2) AT=100.025n

.meas tran vdout0_3ck190 FIND v(dout0_3) AT=100.025n

.meas tran vdout0_4ck190 FIND v(dout0_4) AT=100.025n

.meas tran vdout0_5ck190 FIND v(dout0_5) AT=100.025n

.meas tran vdout0_6ck190 FIND v(dout0_6) AT=100.025n

.meas tran vdout0_7ck190 FIND v(dout0_7) AT=100.025n

.meas tran vdout0_8ck190 FIND v(dout0_8) AT=100.025n

.meas tran vdout0_9ck190 FIND v(dout0_9) AT=100.025n

.meas tran vdout0_10ck190 FIND v(dout0_10) AT=100.025n

.meas tran vdout0_11ck190 FIND v(dout0_11) AT=100.025n

.meas tran vdout0_12ck190 FIND v(dout0_12) AT=100.025n

.meas tran vdout0_13ck190 FIND v(dout0_13) AT=100.025n

.meas tran vdout0_14ck190 FIND v(dout0_14) AT=100.025n

.meas tran vdout0_15ck190 FIND v(dout0_15) AT=100.025n

.meas tran vdout0_16ck190 FIND v(dout0_16) AT=100.025n

.meas tran vdout0_17ck190 FIND v(dout0_17) AT=100.025n

.meas tran vdout0_18ck190 FIND v(dout0_18) AT=100.025n

.meas tran vdout0_19ck190 FIND v(dout0_19) AT=100.025n

.meas tran vdout0_20ck190 FIND v(dout0_20) AT=100.025n

.meas tran vdout0_21ck190 FIND v(dout0_21) AT=100.025n

.meas tran vdout0_22ck190 FIND v(dout0_22) AT=100.025n

.meas tran vdout0_23ck190 FIND v(dout0_23) AT=100.025n

.meas tran vdout0_24ck190 FIND v(dout0_24) AT=100.025n

.meas tran vdout0_25ck190 FIND v(dout0_25) AT=100.025n

.meas tran vdout0_26ck190 FIND v(dout0_26) AT=100.025n

.meas tran vdout0_27ck190 FIND v(dout0_27) AT=100.025n

.meas tran vdout0_28ck190 FIND v(dout0_28) AT=100.025n

.meas tran vdout0_29ck190 FIND v(dout0_29) AT=100.025n

.meas tran vdout0_30ck190 FIND v(dout0_30) AT=100.025n

.meas tran vdout0_31ck190 FIND v(dout0_31) AT=100.025n

.meas tran vdout0_0ck200 FIND v(dout0_0) AT=105.025n

.meas tran vdout0_1ck200 FIND v(dout0_1) AT=105.025n

.meas tran vdout0_2ck200 FIND v(dout0_2) AT=105.025n

.meas tran vdout0_3ck200 FIND v(dout0_3) AT=105.025n

.meas tran vdout0_4ck200 FIND v(dout0_4) AT=105.025n

.meas tran vdout0_5ck200 FIND v(dout0_5) AT=105.025n

.meas tran vdout0_6ck200 FIND v(dout0_6) AT=105.025n

.meas tran vdout0_7ck200 FIND v(dout0_7) AT=105.025n

.meas tran vdout0_8ck200 FIND v(dout0_8) AT=105.025n

.meas tran vdout0_9ck200 FIND v(dout0_9) AT=105.025n

.meas tran vdout0_10ck200 FIND v(dout0_10) AT=105.025n

.meas tran vdout0_11ck200 FIND v(dout0_11) AT=105.025n

.meas tran vdout0_12ck200 FIND v(dout0_12) AT=105.025n

.meas tran vdout0_13ck200 FIND v(dout0_13) AT=105.025n

.meas tran vdout0_14ck200 FIND v(dout0_14) AT=105.025n

.meas tran vdout0_15ck200 FIND v(dout0_15) AT=105.025n

.meas tran vdout0_16ck200 FIND v(dout0_16) AT=105.025n

.meas tran vdout0_17ck200 FIND v(dout0_17) AT=105.025n

.meas tran vdout0_18ck200 FIND v(dout0_18) AT=105.025n

.meas tran vdout0_19ck200 FIND v(dout0_19) AT=105.025n

.meas tran vdout0_20ck200 FIND v(dout0_20) AT=105.025n

.meas tran vdout0_21ck200 FIND v(dout0_21) AT=105.025n

.meas tran vdout0_22ck200 FIND v(dout0_22) AT=105.025n

.meas tran vdout0_23ck200 FIND v(dout0_23) AT=105.025n

.meas tran vdout0_24ck200 FIND v(dout0_24) AT=105.025n

.meas tran vdout0_25ck200 FIND v(dout0_25) AT=105.025n

.meas tran vdout0_26ck200 FIND v(dout0_26) AT=105.025n

.meas tran vdout0_27ck200 FIND v(dout0_27) AT=105.025n

.meas tran vdout0_28ck200 FIND v(dout0_28) AT=105.025n

.meas tran vdout0_29ck200 FIND v(dout0_29) AT=105.025n

.meas tran vdout0_30ck200 FIND v(dout0_30) AT=105.025n

.meas tran vdout0_31ck200 FIND v(dout0_31) AT=105.025n

.meas tran vdout0_0ck220 FIND v(dout0_0) AT=115.025n

.meas tran vdout0_1ck220 FIND v(dout0_1) AT=115.025n

.meas tran vdout0_2ck220 FIND v(dout0_2) AT=115.025n

.meas tran vdout0_3ck220 FIND v(dout0_3) AT=115.025n

.meas tran vdout0_4ck220 FIND v(dout0_4) AT=115.025n

.meas tran vdout0_5ck220 FIND v(dout0_5) AT=115.025n

.meas tran vdout0_6ck220 FIND v(dout0_6) AT=115.025n

.meas tran vdout0_7ck220 FIND v(dout0_7) AT=115.025n

.meas tran vdout0_8ck220 FIND v(dout0_8) AT=115.025n

.meas tran vdout0_9ck220 FIND v(dout0_9) AT=115.025n

.meas tran vdout0_10ck220 FIND v(dout0_10) AT=115.025n

.meas tran vdout0_11ck220 FIND v(dout0_11) AT=115.025n

.meas tran vdout0_12ck220 FIND v(dout0_12) AT=115.025n

.meas tran vdout0_13ck220 FIND v(dout0_13) AT=115.025n

.meas tran vdout0_14ck220 FIND v(dout0_14) AT=115.025n

.meas tran vdout0_15ck220 FIND v(dout0_15) AT=115.025n

.meas tran vdout0_16ck220 FIND v(dout0_16) AT=115.025n

.meas tran vdout0_17ck220 FIND v(dout0_17) AT=115.025n

.meas tran vdout0_18ck220 FIND v(dout0_18) AT=115.025n

.meas tran vdout0_19ck220 FIND v(dout0_19) AT=115.025n

.meas tran vdout0_20ck220 FIND v(dout0_20) AT=115.025n

.meas tran vdout0_21ck220 FIND v(dout0_21) AT=115.025n

.meas tran vdout0_22ck220 FIND v(dout0_22) AT=115.025n

.meas tran vdout0_23ck220 FIND v(dout0_23) AT=115.025n

.meas tran vdout0_24ck220 FIND v(dout0_24) AT=115.025n

.meas tran vdout0_25ck220 FIND v(dout0_25) AT=115.025n

.meas tran vdout0_26ck220 FIND v(dout0_26) AT=115.025n

.meas tran vdout0_27ck220 FIND v(dout0_27) AT=115.025n

.meas tran vdout0_28ck220 FIND v(dout0_28) AT=115.025n

.meas tran vdout0_29ck220 FIND v(dout0_29) AT=115.025n

.meas tran vdout0_30ck220 FIND v(dout0_30) AT=115.025n

.meas tran vdout0_31ck220 FIND v(dout0_31) AT=115.025n

.meas tran vdout0_0ck240 FIND v(dout0_0) AT=125.025n

.meas tran vdout0_1ck240 FIND v(dout0_1) AT=125.025n

.meas tran vdout0_2ck240 FIND v(dout0_2) AT=125.025n

.meas tran vdout0_3ck240 FIND v(dout0_3) AT=125.025n

.meas tran vdout0_4ck240 FIND v(dout0_4) AT=125.025n

.meas tran vdout0_5ck240 FIND v(dout0_5) AT=125.025n

.meas tran vdout0_6ck240 FIND v(dout0_6) AT=125.025n

.meas tran vdout0_7ck240 FIND v(dout0_7) AT=125.025n

.meas tran vdout0_8ck240 FIND v(dout0_8) AT=125.025n

.meas tran vdout0_9ck240 FIND v(dout0_9) AT=125.025n

.meas tran vdout0_10ck240 FIND v(dout0_10) AT=125.025n

.meas tran vdout0_11ck240 FIND v(dout0_11) AT=125.025n

.meas tran vdout0_12ck240 FIND v(dout0_12) AT=125.025n

.meas tran vdout0_13ck240 FIND v(dout0_13) AT=125.025n

.meas tran vdout0_14ck240 FIND v(dout0_14) AT=125.025n

.meas tran vdout0_15ck240 FIND v(dout0_15) AT=125.025n

.meas tran vdout0_16ck240 FIND v(dout0_16) AT=125.025n

.meas tran vdout0_17ck240 FIND v(dout0_17) AT=125.025n

.meas tran vdout0_18ck240 FIND v(dout0_18) AT=125.025n

.meas tran vdout0_19ck240 FIND v(dout0_19) AT=125.025n

.meas tran vdout0_20ck240 FIND v(dout0_20) AT=125.025n

.meas tran vdout0_21ck240 FIND v(dout0_21) AT=125.025n

.meas tran vdout0_22ck240 FIND v(dout0_22) AT=125.025n

.meas tran vdout0_23ck240 FIND v(dout0_23) AT=125.025n

.meas tran vdout0_24ck240 FIND v(dout0_24) AT=125.025n

.meas tran vdout0_25ck240 FIND v(dout0_25) AT=125.025n

.meas tran vdout0_26ck240 FIND v(dout0_26) AT=125.025n

.meas tran vdout0_27ck240 FIND v(dout0_27) AT=125.025n

.meas tran vdout0_28ck240 FIND v(dout0_28) AT=125.025n

.meas tran vdout0_29ck240 FIND v(dout0_29) AT=125.025n

.meas tran vdout0_30ck240 FIND v(dout0_30) AT=125.025n

.meas tran vdout0_31ck240 FIND v(dout0_31) AT=125.025n

.meas tran vdout0_0ck250 FIND v(dout0_0) AT=130.025n

.meas tran vdout0_1ck250 FIND v(dout0_1) AT=130.025n

.meas tran vdout0_2ck250 FIND v(dout0_2) AT=130.025n

.meas tran vdout0_3ck250 FIND v(dout0_3) AT=130.025n

.meas tran vdout0_4ck250 FIND v(dout0_4) AT=130.025n

.meas tran vdout0_5ck250 FIND v(dout0_5) AT=130.025n

.meas tran vdout0_6ck250 FIND v(dout0_6) AT=130.025n

.meas tran vdout0_7ck250 FIND v(dout0_7) AT=130.025n

.meas tran vdout0_8ck250 FIND v(dout0_8) AT=130.025n

.meas tran vdout0_9ck250 FIND v(dout0_9) AT=130.025n

.meas tran vdout0_10ck250 FIND v(dout0_10) AT=130.025n

.meas tran vdout0_11ck250 FIND v(dout0_11) AT=130.025n

.meas tran vdout0_12ck250 FIND v(dout0_12) AT=130.025n

.meas tran vdout0_13ck250 FIND v(dout0_13) AT=130.025n

.meas tran vdout0_14ck250 FIND v(dout0_14) AT=130.025n

.meas tran vdout0_15ck250 FIND v(dout0_15) AT=130.025n

.meas tran vdout0_16ck250 FIND v(dout0_16) AT=130.025n

.meas tran vdout0_17ck250 FIND v(dout0_17) AT=130.025n

.meas tran vdout0_18ck250 FIND v(dout0_18) AT=130.025n

.meas tran vdout0_19ck250 FIND v(dout0_19) AT=130.025n

.meas tran vdout0_20ck250 FIND v(dout0_20) AT=130.025n

.meas tran vdout0_21ck250 FIND v(dout0_21) AT=130.025n

.meas tran vdout0_22ck250 FIND v(dout0_22) AT=130.025n

.meas tran vdout0_23ck250 FIND v(dout0_23) AT=130.025n

.meas tran vdout0_24ck250 FIND v(dout0_24) AT=130.025n

.meas tran vdout0_25ck250 FIND v(dout0_25) AT=130.025n

.meas tran vdout0_26ck250 FIND v(dout0_26) AT=130.025n

.meas tran vdout0_27ck250 FIND v(dout0_27) AT=130.025n

.meas tran vdout0_28ck250 FIND v(dout0_28) AT=130.025n

.meas tran vdout0_29ck250 FIND v(dout0_29) AT=130.025n

.meas tran vdout0_30ck250 FIND v(dout0_30) AT=130.025n

.meas tran vdout0_31ck250 FIND v(dout0_31) AT=130.025n

.meas tran vdout0_0ck320 FIND v(dout0_0) AT=165.025n

.meas tran vdout0_1ck320 FIND v(dout0_1) AT=165.025n

.meas tran vdout0_2ck320 FIND v(dout0_2) AT=165.025n

.meas tran vdout0_3ck320 FIND v(dout0_3) AT=165.025n

.meas tran vdout0_4ck320 FIND v(dout0_4) AT=165.025n

.meas tran vdout0_5ck320 FIND v(dout0_5) AT=165.025n

.meas tran vdout0_6ck320 FIND v(dout0_6) AT=165.025n

.meas tran vdout0_7ck320 FIND v(dout0_7) AT=165.025n

.meas tran vdout0_8ck320 FIND v(dout0_8) AT=165.025n

.meas tran vdout0_9ck320 FIND v(dout0_9) AT=165.025n

.meas tran vdout0_10ck320 FIND v(dout0_10) AT=165.025n

.meas tran vdout0_11ck320 FIND v(dout0_11) AT=165.025n

.meas tran vdout0_12ck320 FIND v(dout0_12) AT=165.025n

.meas tran vdout0_13ck320 FIND v(dout0_13) AT=165.025n

.meas tran vdout0_14ck320 FIND v(dout0_14) AT=165.025n

.meas tran vdout0_15ck320 FIND v(dout0_15) AT=165.025n

.meas tran vdout0_16ck320 FIND v(dout0_16) AT=165.025n

.meas tran vdout0_17ck320 FIND v(dout0_17) AT=165.025n

.meas tran vdout0_18ck320 FIND v(dout0_18) AT=165.025n

.meas tran vdout0_19ck320 FIND v(dout0_19) AT=165.025n

.meas tran vdout0_20ck320 FIND v(dout0_20) AT=165.025n

.meas tran vdout0_21ck320 FIND v(dout0_21) AT=165.025n

.meas tran vdout0_22ck320 FIND v(dout0_22) AT=165.025n

.meas tran vdout0_23ck320 FIND v(dout0_23) AT=165.025n

.meas tran vdout0_24ck320 FIND v(dout0_24) AT=165.025n

.meas tran vdout0_25ck320 FIND v(dout0_25) AT=165.025n

.meas tran vdout0_26ck320 FIND v(dout0_26) AT=165.025n

.meas tran vdout0_27ck320 FIND v(dout0_27) AT=165.025n

.meas tran vdout0_28ck320 FIND v(dout0_28) AT=165.025n

.meas tran vdout0_29ck320 FIND v(dout0_29) AT=165.025n

.meas tran vdout0_30ck320 FIND v(dout0_30) AT=165.025n

.meas tran vdout0_31ck320 FIND v(dout0_31) AT=165.025n

.meas tran vdout0_0ck340 FIND v(dout0_0) AT=175.025n

.meas tran vdout0_1ck340 FIND v(dout0_1) AT=175.025n

.meas tran vdout0_2ck340 FIND v(dout0_2) AT=175.025n

.meas tran vdout0_3ck340 FIND v(dout0_3) AT=175.025n

.meas tran vdout0_4ck340 FIND v(dout0_4) AT=175.025n

.meas tran vdout0_5ck340 FIND v(dout0_5) AT=175.025n

.meas tran vdout0_6ck340 FIND v(dout0_6) AT=175.025n

.meas tran vdout0_7ck340 FIND v(dout0_7) AT=175.025n

.meas tran vdout0_8ck340 FIND v(dout0_8) AT=175.025n

.meas tran vdout0_9ck340 FIND v(dout0_9) AT=175.025n

.meas tran vdout0_10ck340 FIND v(dout0_10) AT=175.025n

.meas tran vdout0_11ck340 FIND v(dout0_11) AT=175.025n

.meas tran vdout0_12ck340 FIND v(dout0_12) AT=175.025n

.meas tran vdout0_13ck340 FIND v(dout0_13) AT=175.025n

.meas tran vdout0_14ck340 FIND v(dout0_14) AT=175.025n

.meas tran vdout0_15ck340 FIND v(dout0_15) AT=175.025n

.meas tran vdout0_16ck340 FIND v(dout0_16) AT=175.025n

.meas tran vdout0_17ck340 FIND v(dout0_17) AT=175.025n

.meas tran vdout0_18ck340 FIND v(dout0_18) AT=175.025n

.meas tran vdout0_19ck340 FIND v(dout0_19) AT=175.025n

.meas tran vdout0_20ck340 FIND v(dout0_20) AT=175.025n

.meas tran vdout0_21ck340 FIND v(dout0_21) AT=175.025n

.meas tran vdout0_22ck340 FIND v(dout0_22) AT=175.025n

.meas tran vdout0_23ck340 FIND v(dout0_23) AT=175.025n

.meas tran vdout0_24ck340 FIND v(dout0_24) AT=175.025n

.meas tran vdout0_25ck340 FIND v(dout0_25) AT=175.025n

.meas tran vdout0_26ck340 FIND v(dout0_26) AT=175.025n

.meas tran vdout0_27ck340 FIND v(dout0_27) AT=175.025n

.meas tran vdout0_28ck340 FIND v(dout0_28) AT=175.025n

.meas tran vdout0_29ck340 FIND v(dout0_29) AT=175.025n

.meas tran vdout0_30ck340 FIND v(dout0_30) AT=175.025n

.meas tran vdout0_31ck340 FIND v(dout0_31) AT=175.025n

.meas tran vdout0_0ck380 FIND v(dout0_0) AT=195.025n

.meas tran vdout0_1ck380 FIND v(dout0_1) AT=195.025n

.meas tran vdout0_2ck380 FIND v(dout0_2) AT=195.025n

.meas tran vdout0_3ck380 FIND v(dout0_3) AT=195.025n

.meas tran vdout0_4ck380 FIND v(dout0_4) AT=195.025n

.meas tran vdout0_5ck380 FIND v(dout0_5) AT=195.025n

.meas tran vdout0_6ck380 FIND v(dout0_6) AT=195.025n

.meas tran vdout0_7ck380 FIND v(dout0_7) AT=195.025n

.meas tran vdout0_8ck380 FIND v(dout0_8) AT=195.025n

.meas tran vdout0_9ck380 FIND v(dout0_9) AT=195.025n

.meas tran vdout0_10ck380 FIND v(dout0_10) AT=195.025n

.meas tran vdout0_11ck380 FIND v(dout0_11) AT=195.025n

.meas tran vdout0_12ck380 FIND v(dout0_12) AT=195.025n

.meas tran vdout0_13ck380 FIND v(dout0_13) AT=195.025n

.meas tran vdout0_14ck380 FIND v(dout0_14) AT=195.025n

.meas tran vdout0_15ck380 FIND v(dout0_15) AT=195.025n

.meas tran vdout0_16ck380 FIND v(dout0_16) AT=195.025n

.meas tran vdout0_17ck380 FIND v(dout0_17) AT=195.025n

.meas tran vdout0_18ck380 FIND v(dout0_18) AT=195.025n

.meas tran vdout0_19ck380 FIND v(dout0_19) AT=195.025n

.meas tran vdout0_20ck380 FIND v(dout0_20) AT=195.025n

.meas tran vdout0_21ck380 FIND v(dout0_21) AT=195.025n

.meas tran vdout0_22ck380 FIND v(dout0_22) AT=195.025n

.meas tran vdout0_23ck380 FIND v(dout0_23) AT=195.025n

.meas tran vdout0_24ck380 FIND v(dout0_24) AT=195.025n

.meas tran vdout0_25ck380 FIND v(dout0_25) AT=195.025n

.meas tran vdout0_26ck380 FIND v(dout0_26) AT=195.025n

.meas tran vdout0_27ck380 FIND v(dout0_27) AT=195.025n

.meas tran vdout0_28ck380 FIND v(dout0_28) AT=195.025n

.meas tran vdout0_29ck380 FIND v(dout0_29) AT=195.025n

.meas tran vdout0_30ck380 FIND v(dout0_30) AT=195.025n

.meas tran vdout0_31ck380 FIND v(dout0_31) AT=195.025n

.meas tran vdout0_0ck400 FIND v(dout0_0) AT=205.025n

.meas tran vdout0_1ck400 FIND v(dout0_1) AT=205.025n

.meas tran vdout0_2ck400 FIND v(dout0_2) AT=205.025n

.meas tran vdout0_3ck400 FIND v(dout0_3) AT=205.025n

.meas tran vdout0_4ck400 FIND v(dout0_4) AT=205.025n

.meas tran vdout0_5ck400 FIND v(dout0_5) AT=205.025n

.meas tran vdout0_6ck400 FIND v(dout0_6) AT=205.025n

.meas tran vdout0_7ck400 FIND v(dout0_7) AT=205.025n

.meas tran vdout0_8ck400 FIND v(dout0_8) AT=205.025n

.meas tran vdout0_9ck400 FIND v(dout0_9) AT=205.025n

.meas tran vdout0_10ck400 FIND v(dout0_10) AT=205.025n

.meas tran vdout0_11ck400 FIND v(dout0_11) AT=205.025n

.meas tran vdout0_12ck400 FIND v(dout0_12) AT=205.025n

.meas tran vdout0_13ck400 FIND v(dout0_13) AT=205.025n

.meas tran vdout0_14ck400 FIND v(dout0_14) AT=205.025n

.meas tran vdout0_15ck400 FIND v(dout0_15) AT=205.025n

.meas tran vdout0_16ck400 FIND v(dout0_16) AT=205.025n

.meas tran vdout0_17ck400 FIND v(dout0_17) AT=205.025n

.meas tran vdout0_18ck400 FIND v(dout0_18) AT=205.025n

.meas tran vdout0_19ck400 FIND v(dout0_19) AT=205.025n

.meas tran vdout0_20ck400 FIND v(dout0_20) AT=205.025n

.meas tran vdout0_21ck400 FIND v(dout0_21) AT=205.025n

.meas tran vdout0_22ck400 FIND v(dout0_22) AT=205.025n

.meas tran vdout0_23ck400 FIND v(dout0_23) AT=205.025n

.meas tran vdout0_24ck400 FIND v(dout0_24) AT=205.025n

.meas tran vdout0_25ck400 FIND v(dout0_25) AT=205.025n

.meas tran vdout0_26ck400 FIND v(dout0_26) AT=205.025n

.meas tran vdout0_27ck400 FIND v(dout0_27) AT=205.025n

.meas tran vdout0_28ck400 FIND v(dout0_28) AT=205.025n

.meas tran vdout0_29ck400 FIND v(dout0_29) AT=205.025n

.meas tran vdout0_30ck400 FIND v(dout0_30) AT=205.025n

.meas tran vdout0_31ck400 FIND v(dout0_31) AT=205.025n

.meas tran vdout0_0ck410 FIND v(dout0_0) AT=210.025n

.meas tran vdout0_1ck410 FIND v(dout0_1) AT=210.025n

.meas tran vdout0_2ck410 FIND v(dout0_2) AT=210.025n

.meas tran vdout0_3ck410 FIND v(dout0_3) AT=210.025n

.meas tran vdout0_4ck410 FIND v(dout0_4) AT=210.025n

.meas tran vdout0_5ck410 FIND v(dout0_5) AT=210.025n

.meas tran vdout0_6ck410 FIND v(dout0_6) AT=210.025n

.meas tran vdout0_7ck410 FIND v(dout0_7) AT=210.025n

.meas tran vdout0_8ck410 FIND v(dout0_8) AT=210.025n

.meas tran vdout0_9ck410 FIND v(dout0_9) AT=210.025n

.meas tran vdout0_10ck410 FIND v(dout0_10) AT=210.025n

.meas tran vdout0_11ck410 FIND v(dout0_11) AT=210.025n

.meas tran vdout0_12ck410 FIND v(dout0_12) AT=210.025n

.meas tran vdout0_13ck410 FIND v(dout0_13) AT=210.025n

.meas tran vdout0_14ck410 FIND v(dout0_14) AT=210.025n

.meas tran vdout0_15ck410 FIND v(dout0_15) AT=210.025n

.meas tran vdout0_16ck410 FIND v(dout0_16) AT=210.025n

.meas tran vdout0_17ck410 FIND v(dout0_17) AT=210.025n

.meas tran vdout0_18ck410 FIND v(dout0_18) AT=210.025n

.meas tran vdout0_19ck410 FIND v(dout0_19) AT=210.025n

.meas tran vdout0_20ck410 FIND v(dout0_20) AT=210.025n

.meas tran vdout0_21ck410 FIND v(dout0_21) AT=210.025n

.meas tran vdout0_22ck410 FIND v(dout0_22) AT=210.025n

.meas tran vdout0_23ck410 FIND v(dout0_23) AT=210.025n

.meas tran vdout0_24ck410 FIND v(dout0_24) AT=210.025n

.meas tran vdout0_25ck410 FIND v(dout0_25) AT=210.025n

.meas tran vdout0_26ck410 FIND v(dout0_26) AT=210.025n

.meas tran vdout0_27ck410 FIND v(dout0_27) AT=210.025n

.meas tran vdout0_28ck410 FIND v(dout0_28) AT=210.025n

.meas tran vdout0_29ck410 FIND v(dout0_29) AT=210.025n

.meas tran vdout0_30ck410 FIND v(dout0_30) AT=210.025n

.meas tran vdout0_31ck410 FIND v(dout0_31) AT=210.025n

.meas tran vdout0_0ck450 FIND v(dout0_0) AT=230.025n

.meas tran vdout0_1ck450 FIND v(dout0_1) AT=230.025n

.meas tran vdout0_2ck450 FIND v(dout0_2) AT=230.025n

.meas tran vdout0_3ck450 FIND v(dout0_3) AT=230.025n

.meas tran vdout0_4ck450 FIND v(dout0_4) AT=230.025n

.meas tran vdout0_5ck450 FIND v(dout0_5) AT=230.025n

.meas tran vdout0_6ck450 FIND v(dout0_6) AT=230.025n

.meas tran vdout0_7ck450 FIND v(dout0_7) AT=230.025n

.meas tran vdout0_8ck450 FIND v(dout0_8) AT=230.025n

.meas tran vdout0_9ck450 FIND v(dout0_9) AT=230.025n

.meas tran vdout0_10ck450 FIND v(dout0_10) AT=230.025n

.meas tran vdout0_11ck450 FIND v(dout0_11) AT=230.025n

.meas tran vdout0_12ck450 FIND v(dout0_12) AT=230.025n

.meas tran vdout0_13ck450 FIND v(dout0_13) AT=230.025n

.meas tran vdout0_14ck450 FIND v(dout0_14) AT=230.025n

.meas tran vdout0_15ck450 FIND v(dout0_15) AT=230.025n

.meas tran vdout0_16ck450 FIND v(dout0_16) AT=230.025n

.meas tran vdout0_17ck450 FIND v(dout0_17) AT=230.025n

.meas tran vdout0_18ck450 FIND v(dout0_18) AT=230.025n

.meas tran vdout0_19ck450 FIND v(dout0_19) AT=230.025n

.meas tran vdout0_20ck450 FIND v(dout0_20) AT=230.025n

.meas tran vdout0_21ck450 FIND v(dout0_21) AT=230.025n

.meas tran vdout0_22ck450 FIND v(dout0_22) AT=230.025n

.meas tran vdout0_23ck450 FIND v(dout0_23) AT=230.025n

.meas tran vdout0_24ck450 FIND v(dout0_24) AT=230.025n

.meas tran vdout0_25ck450 FIND v(dout0_25) AT=230.025n

.meas tran vdout0_26ck450 FIND v(dout0_26) AT=230.025n

.meas tran vdout0_27ck450 FIND v(dout0_27) AT=230.025n

.meas tran vdout0_28ck450 FIND v(dout0_28) AT=230.025n

.meas tran vdout0_29ck450 FIND v(dout0_29) AT=230.025n

.meas tran vdout0_30ck450 FIND v(dout0_30) AT=230.025n

.meas tran vdout0_31ck450 FIND v(dout0_31) AT=230.025n

.meas tran vdout0_0ck470 FIND v(dout0_0) AT=240.025n

.meas tran vdout0_1ck470 FIND v(dout0_1) AT=240.025n

.meas tran vdout0_2ck470 FIND v(dout0_2) AT=240.025n

.meas tran vdout0_3ck470 FIND v(dout0_3) AT=240.025n

.meas tran vdout0_4ck470 FIND v(dout0_4) AT=240.025n

.meas tran vdout0_5ck470 FIND v(dout0_5) AT=240.025n

.meas tran vdout0_6ck470 FIND v(dout0_6) AT=240.025n

.meas tran vdout0_7ck470 FIND v(dout0_7) AT=240.025n

.meas tran vdout0_8ck470 FIND v(dout0_8) AT=240.025n

.meas tran vdout0_9ck470 FIND v(dout0_9) AT=240.025n

.meas tran vdout0_10ck470 FIND v(dout0_10) AT=240.025n

.meas tran vdout0_11ck470 FIND v(dout0_11) AT=240.025n

.meas tran vdout0_12ck470 FIND v(dout0_12) AT=240.025n

.meas tran vdout0_13ck470 FIND v(dout0_13) AT=240.025n

.meas tran vdout0_14ck470 FIND v(dout0_14) AT=240.025n

.meas tran vdout0_15ck470 FIND v(dout0_15) AT=240.025n

.meas tran vdout0_16ck470 FIND v(dout0_16) AT=240.025n

.meas tran vdout0_17ck470 FIND v(dout0_17) AT=240.025n

.meas tran vdout0_18ck470 FIND v(dout0_18) AT=240.025n

.meas tran vdout0_19ck470 FIND v(dout0_19) AT=240.025n

.meas tran vdout0_20ck470 FIND v(dout0_20) AT=240.025n

.meas tran vdout0_21ck470 FIND v(dout0_21) AT=240.025n

.meas tran vdout0_22ck470 FIND v(dout0_22) AT=240.025n

.meas tran vdout0_23ck470 FIND v(dout0_23) AT=240.025n

.meas tran vdout0_24ck470 FIND v(dout0_24) AT=240.025n

.meas tran vdout0_25ck470 FIND v(dout0_25) AT=240.025n

.meas tran vdout0_26ck470 FIND v(dout0_26) AT=240.025n

.meas tran vdout0_27ck470 FIND v(dout0_27) AT=240.025n

.meas tran vdout0_28ck470 FIND v(dout0_28) AT=240.025n

.meas tran vdout0_29ck470 FIND v(dout0_29) AT=240.025n

.meas tran vdout0_30ck470 FIND v(dout0_30) AT=240.025n

.meas tran vdout0_31ck470 FIND v(dout0_31) AT=240.025n

.meas tran vdout0_0ck480 FIND v(dout0_0) AT=245.025n

.meas tran vdout0_1ck480 FIND v(dout0_1) AT=245.025n

.meas tran vdout0_2ck480 FIND v(dout0_2) AT=245.025n

.meas tran vdout0_3ck480 FIND v(dout0_3) AT=245.025n

.meas tran vdout0_4ck480 FIND v(dout0_4) AT=245.025n

.meas tran vdout0_5ck480 FIND v(dout0_5) AT=245.025n

.meas tran vdout0_6ck480 FIND v(dout0_6) AT=245.025n

.meas tran vdout0_7ck480 FIND v(dout0_7) AT=245.025n

.meas tran vdout0_8ck480 FIND v(dout0_8) AT=245.025n

.meas tran vdout0_9ck480 FIND v(dout0_9) AT=245.025n

.meas tran vdout0_10ck480 FIND v(dout0_10) AT=245.025n

.meas tran vdout0_11ck480 FIND v(dout0_11) AT=245.025n

.meas tran vdout0_12ck480 FIND v(dout0_12) AT=245.025n

.meas tran vdout0_13ck480 FIND v(dout0_13) AT=245.025n

.meas tran vdout0_14ck480 FIND v(dout0_14) AT=245.025n

.meas tran vdout0_15ck480 FIND v(dout0_15) AT=245.025n

.meas tran vdout0_16ck480 FIND v(dout0_16) AT=245.025n

.meas tran vdout0_17ck480 FIND v(dout0_17) AT=245.025n

.meas tran vdout0_18ck480 FIND v(dout0_18) AT=245.025n

.meas tran vdout0_19ck480 FIND v(dout0_19) AT=245.025n

.meas tran vdout0_20ck480 FIND v(dout0_20) AT=245.025n

.meas tran vdout0_21ck480 FIND v(dout0_21) AT=245.025n

.meas tran vdout0_22ck480 FIND v(dout0_22) AT=245.025n

.meas tran vdout0_23ck480 FIND v(dout0_23) AT=245.025n

.meas tran vdout0_24ck480 FIND v(dout0_24) AT=245.025n

.meas tran vdout0_25ck480 FIND v(dout0_25) AT=245.025n

.meas tran vdout0_26ck480 FIND v(dout0_26) AT=245.025n

.meas tran vdout0_27ck480 FIND v(dout0_27) AT=245.025n

.meas tran vdout0_28ck480 FIND v(dout0_28) AT=245.025n

.meas tran vdout0_29ck480 FIND v(dout0_29) AT=245.025n

.meas tran vdout0_30ck480 FIND v(dout0_30) AT=245.025n

.meas tran vdout0_31ck480 FIND v(dout0_31) AT=245.025n

.meas tran vdout0_0ck500 FIND v(dout0_0) AT=255.025n

.meas tran vdout0_1ck500 FIND v(dout0_1) AT=255.025n

.meas tran vdout0_2ck500 FIND v(dout0_2) AT=255.025n

.meas tran vdout0_3ck500 FIND v(dout0_3) AT=255.025n

.meas tran vdout0_4ck500 FIND v(dout0_4) AT=255.025n

.meas tran vdout0_5ck500 FIND v(dout0_5) AT=255.025n

.meas tran vdout0_6ck500 FIND v(dout0_6) AT=255.025n

.meas tran vdout0_7ck500 FIND v(dout0_7) AT=255.025n

.meas tran vdout0_8ck500 FIND v(dout0_8) AT=255.025n

.meas tran vdout0_9ck500 FIND v(dout0_9) AT=255.025n

.meas tran vdout0_10ck500 FIND v(dout0_10) AT=255.025n

.meas tran vdout0_11ck500 FIND v(dout0_11) AT=255.025n

.meas tran vdout0_12ck500 FIND v(dout0_12) AT=255.025n

.meas tran vdout0_13ck500 FIND v(dout0_13) AT=255.025n

.meas tran vdout0_14ck500 FIND v(dout0_14) AT=255.025n

.meas tran vdout0_15ck500 FIND v(dout0_15) AT=255.025n

.meas tran vdout0_16ck500 FIND v(dout0_16) AT=255.025n

.meas tran vdout0_17ck500 FIND v(dout0_17) AT=255.025n

.meas tran vdout0_18ck500 FIND v(dout0_18) AT=255.025n

.meas tran vdout0_19ck500 FIND v(dout0_19) AT=255.025n

.meas tran vdout0_20ck500 FIND v(dout0_20) AT=255.025n

.meas tran vdout0_21ck500 FIND v(dout0_21) AT=255.025n

.meas tran vdout0_22ck500 FIND v(dout0_22) AT=255.025n

.meas tran vdout0_23ck500 FIND v(dout0_23) AT=255.025n

.meas tran vdout0_24ck500 FIND v(dout0_24) AT=255.025n

.meas tran vdout0_25ck500 FIND v(dout0_25) AT=255.025n

.meas tran vdout0_26ck500 FIND v(dout0_26) AT=255.025n

.meas tran vdout0_27ck500 FIND v(dout0_27) AT=255.025n

.meas tran vdout0_28ck500 FIND v(dout0_28) AT=255.025n

.meas tran vdout0_29ck500 FIND v(dout0_29) AT=255.025n

.meas tran vdout0_30ck500 FIND v(dout0_30) AT=255.025n

.meas tran vdout0_31ck500 FIND v(dout0_31) AT=255.025n

.meas tran vdout0_0ck510 FIND v(dout0_0) AT=260.025n

.meas tran vdout0_1ck510 FIND v(dout0_1) AT=260.025n

.meas tran vdout0_2ck510 FIND v(dout0_2) AT=260.025n

.meas tran vdout0_3ck510 FIND v(dout0_3) AT=260.025n

.meas tran vdout0_4ck510 FIND v(dout0_4) AT=260.025n

.meas tran vdout0_5ck510 FIND v(dout0_5) AT=260.025n

.meas tran vdout0_6ck510 FIND v(dout0_6) AT=260.025n

.meas tran vdout0_7ck510 FIND v(dout0_7) AT=260.025n

.meas tran vdout0_8ck510 FIND v(dout0_8) AT=260.025n

.meas tran vdout0_9ck510 FIND v(dout0_9) AT=260.025n

.meas tran vdout0_10ck510 FIND v(dout0_10) AT=260.025n

.meas tran vdout0_11ck510 FIND v(dout0_11) AT=260.025n

.meas tran vdout0_12ck510 FIND v(dout0_12) AT=260.025n

.meas tran vdout0_13ck510 FIND v(dout0_13) AT=260.025n

.meas tran vdout0_14ck510 FIND v(dout0_14) AT=260.025n

.meas tran vdout0_15ck510 FIND v(dout0_15) AT=260.025n

.meas tran vdout0_16ck510 FIND v(dout0_16) AT=260.025n

.meas tran vdout0_17ck510 FIND v(dout0_17) AT=260.025n

.meas tran vdout0_18ck510 FIND v(dout0_18) AT=260.025n

.meas tran vdout0_19ck510 FIND v(dout0_19) AT=260.025n

.meas tran vdout0_20ck510 FIND v(dout0_20) AT=260.025n

.meas tran vdout0_21ck510 FIND v(dout0_21) AT=260.025n

.meas tran vdout0_22ck510 FIND v(dout0_22) AT=260.025n

.meas tran vdout0_23ck510 FIND v(dout0_23) AT=260.025n

.meas tran vdout0_24ck510 FIND v(dout0_24) AT=260.025n

.meas tran vdout0_25ck510 FIND v(dout0_25) AT=260.025n

.meas tran vdout0_26ck510 FIND v(dout0_26) AT=260.025n

.meas tran vdout0_27ck510 FIND v(dout0_27) AT=260.025n

.meas tran vdout0_28ck510 FIND v(dout0_28) AT=260.025n

.meas tran vdout0_29ck510 FIND v(dout0_29) AT=260.025n

.meas tran vdout0_30ck510 FIND v(dout0_30) AT=260.025n

.meas tran vdout0_31ck510 FIND v(dout0_31) AT=260.025n

.meas tran vdout0_0ck560 FIND v(dout0_0) AT=285.025n

.meas tran vdout0_1ck560 FIND v(dout0_1) AT=285.025n

.meas tran vdout0_2ck560 FIND v(dout0_2) AT=285.025n

.meas tran vdout0_3ck560 FIND v(dout0_3) AT=285.025n

.meas tran vdout0_4ck560 FIND v(dout0_4) AT=285.025n

.meas tran vdout0_5ck560 FIND v(dout0_5) AT=285.025n

.meas tran vdout0_6ck560 FIND v(dout0_6) AT=285.025n

.meas tran vdout0_7ck560 FIND v(dout0_7) AT=285.025n

.meas tran vdout0_8ck560 FIND v(dout0_8) AT=285.025n

.meas tran vdout0_9ck560 FIND v(dout0_9) AT=285.025n

.meas tran vdout0_10ck560 FIND v(dout0_10) AT=285.025n

.meas tran vdout0_11ck560 FIND v(dout0_11) AT=285.025n

.meas tran vdout0_12ck560 FIND v(dout0_12) AT=285.025n

.meas tran vdout0_13ck560 FIND v(dout0_13) AT=285.025n

.meas tran vdout0_14ck560 FIND v(dout0_14) AT=285.025n

.meas tran vdout0_15ck560 FIND v(dout0_15) AT=285.025n

.meas tran vdout0_16ck560 FIND v(dout0_16) AT=285.025n

.meas tran vdout0_17ck560 FIND v(dout0_17) AT=285.025n

.meas tran vdout0_18ck560 FIND v(dout0_18) AT=285.025n

.meas tran vdout0_19ck560 FIND v(dout0_19) AT=285.025n

.meas tran vdout0_20ck560 FIND v(dout0_20) AT=285.025n

.meas tran vdout0_21ck560 FIND v(dout0_21) AT=285.025n

.meas tran vdout0_22ck560 FIND v(dout0_22) AT=285.025n

.meas tran vdout0_23ck560 FIND v(dout0_23) AT=285.025n

.meas tran vdout0_24ck560 FIND v(dout0_24) AT=285.025n

.meas tran vdout0_25ck560 FIND v(dout0_25) AT=285.025n

.meas tran vdout0_26ck560 FIND v(dout0_26) AT=285.025n

.meas tran vdout0_27ck560 FIND v(dout0_27) AT=285.025n

.meas tran vdout0_28ck560 FIND v(dout0_28) AT=285.025n

.meas tran vdout0_29ck560 FIND v(dout0_29) AT=285.025n

.meas tran vdout0_30ck560 FIND v(dout0_30) AT=285.025n

.meas tran vdout0_31ck560 FIND v(dout0_31) AT=285.025n

.meas tran vdout0_0ck570 FIND v(dout0_0) AT=290.025n

.meas tran vdout0_1ck570 FIND v(dout0_1) AT=290.025n

.meas tran vdout0_2ck570 FIND v(dout0_2) AT=290.025n

.meas tran vdout0_3ck570 FIND v(dout0_3) AT=290.025n

.meas tran vdout0_4ck570 FIND v(dout0_4) AT=290.025n

.meas tran vdout0_5ck570 FIND v(dout0_5) AT=290.025n

.meas tran vdout0_6ck570 FIND v(dout0_6) AT=290.025n

.meas tran vdout0_7ck570 FIND v(dout0_7) AT=290.025n

.meas tran vdout0_8ck570 FIND v(dout0_8) AT=290.025n

.meas tran vdout0_9ck570 FIND v(dout0_9) AT=290.025n

.meas tran vdout0_10ck570 FIND v(dout0_10) AT=290.025n

.meas tran vdout0_11ck570 FIND v(dout0_11) AT=290.025n

.meas tran vdout0_12ck570 FIND v(dout0_12) AT=290.025n

.meas tran vdout0_13ck570 FIND v(dout0_13) AT=290.025n

.meas tran vdout0_14ck570 FIND v(dout0_14) AT=290.025n

.meas tran vdout0_15ck570 FIND v(dout0_15) AT=290.025n

.meas tran vdout0_16ck570 FIND v(dout0_16) AT=290.025n

.meas tran vdout0_17ck570 FIND v(dout0_17) AT=290.025n

.meas tran vdout0_18ck570 FIND v(dout0_18) AT=290.025n

.meas tran vdout0_19ck570 FIND v(dout0_19) AT=290.025n

.meas tran vdout0_20ck570 FIND v(dout0_20) AT=290.025n

.meas tran vdout0_21ck570 FIND v(dout0_21) AT=290.025n

.meas tran vdout0_22ck570 FIND v(dout0_22) AT=290.025n

.meas tran vdout0_23ck570 FIND v(dout0_23) AT=290.025n

.meas tran vdout0_24ck570 FIND v(dout0_24) AT=290.025n

.meas tran vdout0_25ck570 FIND v(dout0_25) AT=290.025n

.meas tran vdout0_26ck570 FIND v(dout0_26) AT=290.025n

.meas tran vdout0_27ck570 FIND v(dout0_27) AT=290.025n

.meas tran vdout0_28ck570 FIND v(dout0_28) AT=290.025n

.meas tran vdout0_29ck570 FIND v(dout0_29) AT=290.025n

.meas tran vdout0_30ck570 FIND v(dout0_30) AT=290.025n

.meas tran vdout0_31ck570 FIND v(dout0_31) AT=290.025n

.meas tran vdout0_0ck580 FIND v(dout0_0) AT=295.025n

.meas tran vdout0_1ck580 FIND v(dout0_1) AT=295.025n

.meas tran vdout0_2ck580 FIND v(dout0_2) AT=295.025n

.meas tran vdout0_3ck580 FIND v(dout0_3) AT=295.025n

.meas tran vdout0_4ck580 FIND v(dout0_4) AT=295.025n

.meas tran vdout0_5ck580 FIND v(dout0_5) AT=295.025n

.meas tran vdout0_6ck580 FIND v(dout0_6) AT=295.025n

.meas tran vdout0_7ck580 FIND v(dout0_7) AT=295.025n

.meas tran vdout0_8ck580 FIND v(dout0_8) AT=295.025n

.meas tran vdout0_9ck580 FIND v(dout0_9) AT=295.025n

.meas tran vdout0_10ck580 FIND v(dout0_10) AT=295.025n

.meas tran vdout0_11ck580 FIND v(dout0_11) AT=295.025n

.meas tran vdout0_12ck580 FIND v(dout0_12) AT=295.025n

.meas tran vdout0_13ck580 FIND v(dout0_13) AT=295.025n

.meas tran vdout0_14ck580 FIND v(dout0_14) AT=295.025n

.meas tran vdout0_15ck580 FIND v(dout0_15) AT=295.025n

.meas tran vdout0_16ck580 FIND v(dout0_16) AT=295.025n

.meas tran vdout0_17ck580 FIND v(dout0_17) AT=295.025n

.meas tran vdout0_18ck580 FIND v(dout0_18) AT=295.025n

.meas tran vdout0_19ck580 FIND v(dout0_19) AT=295.025n

.meas tran vdout0_20ck580 FIND v(dout0_20) AT=295.025n

.meas tran vdout0_21ck580 FIND v(dout0_21) AT=295.025n

.meas tran vdout0_22ck580 FIND v(dout0_22) AT=295.025n

.meas tran vdout0_23ck580 FIND v(dout0_23) AT=295.025n

.meas tran vdout0_24ck580 FIND v(dout0_24) AT=295.025n

.meas tran vdout0_25ck580 FIND v(dout0_25) AT=295.025n

.meas tran vdout0_26ck580 FIND v(dout0_26) AT=295.025n

.meas tran vdout0_27ck580 FIND v(dout0_27) AT=295.025n

.meas tran vdout0_28ck580 FIND v(dout0_28) AT=295.025n

.meas tran vdout0_29ck580 FIND v(dout0_29) AT=295.025n

.meas tran vdout0_30ck580 FIND v(dout0_30) AT=295.025n

.meas tran vdout0_31ck580 FIND v(dout0_31) AT=295.025n

.meas tran vdout0_0ck600 FIND v(dout0_0) AT=305.025n

.meas tran vdout0_1ck600 FIND v(dout0_1) AT=305.025n

.meas tran vdout0_2ck600 FIND v(dout0_2) AT=305.025n

.meas tran vdout0_3ck600 FIND v(dout0_3) AT=305.025n

.meas tran vdout0_4ck600 FIND v(dout0_4) AT=305.025n

.meas tran vdout0_5ck600 FIND v(dout0_5) AT=305.025n

.meas tran vdout0_6ck600 FIND v(dout0_6) AT=305.025n

.meas tran vdout0_7ck600 FIND v(dout0_7) AT=305.025n

.meas tran vdout0_8ck600 FIND v(dout0_8) AT=305.025n

.meas tran vdout0_9ck600 FIND v(dout0_9) AT=305.025n

.meas tran vdout0_10ck600 FIND v(dout0_10) AT=305.025n

.meas tran vdout0_11ck600 FIND v(dout0_11) AT=305.025n

.meas tran vdout0_12ck600 FIND v(dout0_12) AT=305.025n

.meas tran vdout0_13ck600 FIND v(dout0_13) AT=305.025n

.meas tran vdout0_14ck600 FIND v(dout0_14) AT=305.025n

.meas tran vdout0_15ck600 FIND v(dout0_15) AT=305.025n

.meas tran vdout0_16ck600 FIND v(dout0_16) AT=305.025n

.meas tran vdout0_17ck600 FIND v(dout0_17) AT=305.025n

.meas tran vdout0_18ck600 FIND v(dout0_18) AT=305.025n

.meas tran vdout0_19ck600 FIND v(dout0_19) AT=305.025n

.meas tran vdout0_20ck600 FIND v(dout0_20) AT=305.025n

.meas tran vdout0_21ck600 FIND v(dout0_21) AT=305.025n

.meas tran vdout0_22ck600 FIND v(dout0_22) AT=305.025n

.meas tran vdout0_23ck600 FIND v(dout0_23) AT=305.025n

.meas tran vdout0_24ck600 FIND v(dout0_24) AT=305.025n

.meas tran vdout0_25ck600 FIND v(dout0_25) AT=305.025n

.meas tran vdout0_26ck600 FIND v(dout0_26) AT=305.025n

.meas tran vdout0_27ck600 FIND v(dout0_27) AT=305.025n

.meas tran vdout0_28ck600 FIND v(dout0_28) AT=305.025n

.meas tran vdout0_29ck600 FIND v(dout0_29) AT=305.025n

.meas tran vdout0_30ck600 FIND v(dout0_30) AT=305.025n

.meas tran vdout0_31ck600 FIND v(dout0_31) AT=305.025n

.meas tran vdout0_0ck610 FIND v(dout0_0) AT=310.025n

.meas tran vdout0_1ck610 FIND v(dout0_1) AT=310.025n

.meas tran vdout0_2ck610 FIND v(dout0_2) AT=310.025n

.meas tran vdout0_3ck610 FIND v(dout0_3) AT=310.025n

.meas tran vdout0_4ck610 FIND v(dout0_4) AT=310.025n

.meas tran vdout0_5ck610 FIND v(dout0_5) AT=310.025n

.meas tran vdout0_6ck610 FIND v(dout0_6) AT=310.025n

.meas tran vdout0_7ck610 FIND v(dout0_7) AT=310.025n

.meas tran vdout0_8ck610 FIND v(dout0_8) AT=310.025n

.meas tran vdout0_9ck610 FIND v(dout0_9) AT=310.025n

.meas tran vdout0_10ck610 FIND v(dout0_10) AT=310.025n

.meas tran vdout0_11ck610 FIND v(dout0_11) AT=310.025n

.meas tran vdout0_12ck610 FIND v(dout0_12) AT=310.025n

.meas tran vdout0_13ck610 FIND v(dout0_13) AT=310.025n

.meas tran vdout0_14ck610 FIND v(dout0_14) AT=310.025n

.meas tran vdout0_15ck610 FIND v(dout0_15) AT=310.025n

.meas tran vdout0_16ck610 FIND v(dout0_16) AT=310.025n

.meas tran vdout0_17ck610 FIND v(dout0_17) AT=310.025n

.meas tran vdout0_18ck610 FIND v(dout0_18) AT=310.025n

.meas tran vdout0_19ck610 FIND v(dout0_19) AT=310.025n

.meas tran vdout0_20ck610 FIND v(dout0_20) AT=310.025n

.meas tran vdout0_21ck610 FIND v(dout0_21) AT=310.025n

.meas tran vdout0_22ck610 FIND v(dout0_22) AT=310.025n

.meas tran vdout0_23ck610 FIND v(dout0_23) AT=310.025n

.meas tran vdout0_24ck610 FIND v(dout0_24) AT=310.025n

.meas tran vdout0_25ck610 FIND v(dout0_25) AT=310.025n

.meas tran vdout0_26ck610 FIND v(dout0_26) AT=310.025n

.meas tran vdout0_27ck610 FIND v(dout0_27) AT=310.025n

.meas tran vdout0_28ck610 FIND v(dout0_28) AT=310.025n

.meas tran vdout0_29ck610 FIND v(dout0_29) AT=310.025n

.meas tran vdout0_30ck610 FIND v(dout0_30) AT=310.025n

.meas tran vdout0_31ck610 FIND v(dout0_31) AT=310.025n

.meas tran vdout0_0ck620 FIND v(dout0_0) AT=315.025n

.meas tran vdout0_1ck620 FIND v(dout0_1) AT=315.025n

.meas tran vdout0_2ck620 FIND v(dout0_2) AT=315.025n

.meas tran vdout0_3ck620 FIND v(dout0_3) AT=315.025n

.meas tran vdout0_4ck620 FIND v(dout0_4) AT=315.025n

.meas tran vdout0_5ck620 FIND v(dout0_5) AT=315.025n

.meas tran vdout0_6ck620 FIND v(dout0_6) AT=315.025n

.meas tran vdout0_7ck620 FIND v(dout0_7) AT=315.025n

.meas tran vdout0_8ck620 FIND v(dout0_8) AT=315.025n

.meas tran vdout0_9ck620 FIND v(dout0_9) AT=315.025n

.meas tran vdout0_10ck620 FIND v(dout0_10) AT=315.025n

.meas tran vdout0_11ck620 FIND v(dout0_11) AT=315.025n

.meas tran vdout0_12ck620 FIND v(dout0_12) AT=315.025n

.meas tran vdout0_13ck620 FIND v(dout0_13) AT=315.025n

.meas tran vdout0_14ck620 FIND v(dout0_14) AT=315.025n

.meas tran vdout0_15ck620 FIND v(dout0_15) AT=315.025n

.meas tran vdout0_16ck620 FIND v(dout0_16) AT=315.025n

.meas tran vdout0_17ck620 FIND v(dout0_17) AT=315.025n

.meas tran vdout0_18ck620 FIND v(dout0_18) AT=315.025n

.meas tran vdout0_19ck620 FIND v(dout0_19) AT=315.025n

.meas tran vdout0_20ck620 FIND v(dout0_20) AT=315.025n

.meas tran vdout0_21ck620 FIND v(dout0_21) AT=315.025n

.meas tran vdout0_22ck620 FIND v(dout0_22) AT=315.025n

.meas tran vdout0_23ck620 FIND v(dout0_23) AT=315.025n

.meas tran vdout0_24ck620 FIND v(dout0_24) AT=315.025n

.meas tran vdout0_25ck620 FIND v(dout0_25) AT=315.025n

.meas tran vdout0_26ck620 FIND v(dout0_26) AT=315.025n

.meas tran vdout0_27ck620 FIND v(dout0_27) AT=315.025n

.meas tran vdout0_28ck620 FIND v(dout0_28) AT=315.025n

.meas tran vdout0_29ck620 FIND v(dout0_29) AT=315.025n

.meas tran vdout0_30ck620 FIND v(dout0_30) AT=315.025n

.meas tran vdout0_31ck620 FIND v(dout0_31) AT=315.025n

.meas tran vdout0_0ck680 FIND v(dout0_0) AT=345.025n

.meas tran vdout0_1ck680 FIND v(dout0_1) AT=345.025n

.meas tran vdout0_2ck680 FIND v(dout0_2) AT=345.025n

.meas tran vdout0_3ck680 FIND v(dout0_3) AT=345.025n

.meas tran vdout0_4ck680 FIND v(dout0_4) AT=345.025n

.meas tran vdout0_5ck680 FIND v(dout0_5) AT=345.025n

.meas tran vdout0_6ck680 FIND v(dout0_6) AT=345.025n

.meas tran vdout0_7ck680 FIND v(dout0_7) AT=345.025n

.meas tran vdout0_8ck680 FIND v(dout0_8) AT=345.025n

.meas tran vdout0_9ck680 FIND v(dout0_9) AT=345.025n

.meas tran vdout0_10ck680 FIND v(dout0_10) AT=345.025n

.meas tran vdout0_11ck680 FIND v(dout0_11) AT=345.025n

.meas tran vdout0_12ck680 FIND v(dout0_12) AT=345.025n

.meas tran vdout0_13ck680 FIND v(dout0_13) AT=345.025n

.meas tran vdout0_14ck680 FIND v(dout0_14) AT=345.025n

.meas tran vdout0_15ck680 FIND v(dout0_15) AT=345.025n

.meas tran vdout0_16ck680 FIND v(dout0_16) AT=345.025n

.meas tran vdout0_17ck680 FIND v(dout0_17) AT=345.025n

.meas tran vdout0_18ck680 FIND v(dout0_18) AT=345.025n

.meas tran vdout0_19ck680 FIND v(dout0_19) AT=345.025n

.meas tran vdout0_20ck680 FIND v(dout0_20) AT=345.025n

.meas tran vdout0_21ck680 FIND v(dout0_21) AT=345.025n

.meas tran vdout0_22ck680 FIND v(dout0_22) AT=345.025n

.meas tran vdout0_23ck680 FIND v(dout0_23) AT=345.025n

.meas tran vdout0_24ck680 FIND v(dout0_24) AT=345.025n

.meas tran vdout0_25ck680 FIND v(dout0_25) AT=345.025n

.meas tran vdout0_26ck680 FIND v(dout0_26) AT=345.025n

.meas tran vdout0_27ck680 FIND v(dout0_27) AT=345.025n

.meas tran vdout0_28ck680 FIND v(dout0_28) AT=345.025n

.meas tran vdout0_29ck680 FIND v(dout0_29) AT=345.025n

.meas tran vdout0_30ck680 FIND v(dout0_30) AT=345.025n

.meas tran vdout0_31ck680 FIND v(dout0_31) AT=345.025n

.meas tran vdout0_0ck710 FIND v(dout0_0) AT=360.025n

.meas tran vdout0_1ck710 FIND v(dout0_1) AT=360.025n

.meas tran vdout0_2ck710 FIND v(dout0_2) AT=360.025n

.meas tran vdout0_3ck710 FIND v(dout0_3) AT=360.025n

.meas tran vdout0_4ck710 FIND v(dout0_4) AT=360.025n

.meas tran vdout0_5ck710 FIND v(dout0_5) AT=360.025n

.meas tran vdout0_6ck710 FIND v(dout0_6) AT=360.025n

.meas tran vdout0_7ck710 FIND v(dout0_7) AT=360.025n

.meas tran vdout0_8ck710 FIND v(dout0_8) AT=360.025n

.meas tran vdout0_9ck710 FIND v(dout0_9) AT=360.025n

.meas tran vdout0_10ck710 FIND v(dout0_10) AT=360.025n

.meas tran vdout0_11ck710 FIND v(dout0_11) AT=360.025n

.meas tran vdout0_12ck710 FIND v(dout0_12) AT=360.025n

.meas tran vdout0_13ck710 FIND v(dout0_13) AT=360.025n

.meas tran vdout0_14ck710 FIND v(dout0_14) AT=360.025n

.meas tran vdout0_15ck710 FIND v(dout0_15) AT=360.025n

.meas tran vdout0_16ck710 FIND v(dout0_16) AT=360.025n

.meas tran vdout0_17ck710 FIND v(dout0_17) AT=360.025n

.meas tran vdout0_18ck710 FIND v(dout0_18) AT=360.025n

.meas tran vdout0_19ck710 FIND v(dout0_19) AT=360.025n

.meas tran vdout0_20ck710 FIND v(dout0_20) AT=360.025n

.meas tran vdout0_21ck710 FIND v(dout0_21) AT=360.025n

.meas tran vdout0_22ck710 FIND v(dout0_22) AT=360.025n

.meas tran vdout0_23ck710 FIND v(dout0_23) AT=360.025n

.meas tran vdout0_24ck710 FIND v(dout0_24) AT=360.025n

.meas tran vdout0_25ck710 FIND v(dout0_25) AT=360.025n

.meas tran vdout0_26ck710 FIND v(dout0_26) AT=360.025n

.meas tran vdout0_27ck710 FIND v(dout0_27) AT=360.025n

.meas tran vdout0_28ck710 FIND v(dout0_28) AT=360.025n

.meas tran vdout0_29ck710 FIND v(dout0_29) AT=360.025n

.meas tran vdout0_30ck710 FIND v(dout0_30) AT=360.025n

.meas tran vdout0_31ck710 FIND v(dout0_31) AT=360.025n

.meas tran vdout0_0ck770 FIND v(dout0_0) AT=390.025n

.meas tran vdout0_1ck770 FIND v(dout0_1) AT=390.025n

.meas tran vdout0_2ck770 FIND v(dout0_2) AT=390.025n

.meas tran vdout0_3ck770 FIND v(dout0_3) AT=390.025n

.meas tran vdout0_4ck770 FIND v(dout0_4) AT=390.025n

.meas tran vdout0_5ck770 FIND v(dout0_5) AT=390.025n

.meas tran vdout0_6ck770 FIND v(dout0_6) AT=390.025n

.meas tran vdout0_7ck770 FIND v(dout0_7) AT=390.025n

.meas tran vdout0_8ck770 FIND v(dout0_8) AT=390.025n

.meas tran vdout0_9ck770 FIND v(dout0_9) AT=390.025n

.meas tran vdout0_10ck770 FIND v(dout0_10) AT=390.025n

.meas tran vdout0_11ck770 FIND v(dout0_11) AT=390.025n

.meas tran vdout0_12ck770 FIND v(dout0_12) AT=390.025n

.meas tran vdout0_13ck770 FIND v(dout0_13) AT=390.025n

.meas tran vdout0_14ck770 FIND v(dout0_14) AT=390.025n

.meas tran vdout0_15ck770 FIND v(dout0_15) AT=390.025n

.meas tran vdout0_16ck770 FIND v(dout0_16) AT=390.025n

.meas tran vdout0_17ck770 FIND v(dout0_17) AT=390.025n

.meas tran vdout0_18ck770 FIND v(dout0_18) AT=390.025n

.meas tran vdout0_19ck770 FIND v(dout0_19) AT=390.025n

.meas tran vdout0_20ck770 FIND v(dout0_20) AT=390.025n

.meas tran vdout0_21ck770 FIND v(dout0_21) AT=390.025n

.meas tran vdout0_22ck770 FIND v(dout0_22) AT=390.025n

.meas tran vdout0_23ck770 FIND v(dout0_23) AT=390.025n

.meas tran vdout0_24ck770 FIND v(dout0_24) AT=390.025n

.meas tran vdout0_25ck770 FIND v(dout0_25) AT=390.025n

.meas tran vdout0_26ck770 FIND v(dout0_26) AT=390.025n

.meas tran vdout0_27ck770 FIND v(dout0_27) AT=390.025n

.meas tran vdout0_28ck770 FIND v(dout0_28) AT=390.025n

.meas tran vdout0_29ck770 FIND v(dout0_29) AT=390.025n

.meas tran vdout0_30ck770 FIND v(dout0_30) AT=390.025n

.meas tran vdout0_31ck770 FIND v(dout0_31) AT=390.025n

.meas tran vdout0_0ck780 FIND v(dout0_0) AT=395.025n

.meas tran vdout0_1ck780 FIND v(dout0_1) AT=395.025n

.meas tran vdout0_2ck780 FIND v(dout0_2) AT=395.025n

.meas tran vdout0_3ck780 FIND v(dout0_3) AT=395.025n

.meas tran vdout0_4ck780 FIND v(dout0_4) AT=395.025n

.meas tran vdout0_5ck780 FIND v(dout0_5) AT=395.025n

.meas tran vdout0_6ck780 FIND v(dout0_6) AT=395.025n

.meas tran vdout0_7ck780 FIND v(dout0_7) AT=395.025n

.meas tran vdout0_8ck780 FIND v(dout0_8) AT=395.025n

.meas tran vdout0_9ck780 FIND v(dout0_9) AT=395.025n

.meas tran vdout0_10ck780 FIND v(dout0_10) AT=395.025n

.meas tran vdout0_11ck780 FIND v(dout0_11) AT=395.025n

.meas tran vdout0_12ck780 FIND v(dout0_12) AT=395.025n

.meas tran vdout0_13ck780 FIND v(dout0_13) AT=395.025n

.meas tran vdout0_14ck780 FIND v(dout0_14) AT=395.025n

.meas tran vdout0_15ck780 FIND v(dout0_15) AT=395.025n

.meas tran vdout0_16ck780 FIND v(dout0_16) AT=395.025n

.meas tran vdout0_17ck780 FIND v(dout0_17) AT=395.025n

.meas tran vdout0_18ck780 FIND v(dout0_18) AT=395.025n

.meas tran vdout0_19ck780 FIND v(dout0_19) AT=395.025n

.meas tran vdout0_20ck780 FIND v(dout0_20) AT=395.025n

.meas tran vdout0_21ck780 FIND v(dout0_21) AT=395.025n

.meas tran vdout0_22ck780 FIND v(dout0_22) AT=395.025n

.meas tran vdout0_23ck780 FIND v(dout0_23) AT=395.025n

.meas tran vdout0_24ck780 FIND v(dout0_24) AT=395.025n

.meas tran vdout0_25ck780 FIND v(dout0_25) AT=395.025n

.meas tran vdout0_26ck780 FIND v(dout0_26) AT=395.025n

.meas tran vdout0_27ck780 FIND v(dout0_27) AT=395.025n

.meas tran vdout0_28ck780 FIND v(dout0_28) AT=395.025n

.meas tran vdout0_29ck780 FIND v(dout0_29) AT=395.025n

.meas tran vdout0_30ck780 FIND v(dout0_30) AT=395.025n

.meas tran vdout0_31ck780 FIND v(dout0_31) AT=395.025n

.meas tran vdout0_0ck790 FIND v(dout0_0) AT=400.025n

.meas tran vdout0_1ck790 FIND v(dout0_1) AT=400.025n

.meas tran vdout0_2ck790 FIND v(dout0_2) AT=400.025n

.meas tran vdout0_3ck790 FIND v(dout0_3) AT=400.025n

.meas tran vdout0_4ck790 FIND v(dout0_4) AT=400.025n

.meas tran vdout0_5ck790 FIND v(dout0_5) AT=400.025n

.meas tran vdout0_6ck790 FIND v(dout0_6) AT=400.025n

.meas tran vdout0_7ck790 FIND v(dout0_7) AT=400.025n

.meas tran vdout0_8ck790 FIND v(dout0_8) AT=400.025n

.meas tran vdout0_9ck790 FIND v(dout0_9) AT=400.025n

.meas tran vdout0_10ck790 FIND v(dout0_10) AT=400.025n

.meas tran vdout0_11ck790 FIND v(dout0_11) AT=400.025n

.meas tran vdout0_12ck790 FIND v(dout0_12) AT=400.025n

.meas tran vdout0_13ck790 FIND v(dout0_13) AT=400.025n

.meas tran vdout0_14ck790 FIND v(dout0_14) AT=400.025n

.meas tran vdout0_15ck790 FIND v(dout0_15) AT=400.025n

.meas tran vdout0_16ck790 FIND v(dout0_16) AT=400.025n

.meas tran vdout0_17ck790 FIND v(dout0_17) AT=400.025n

.meas tran vdout0_18ck790 FIND v(dout0_18) AT=400.025n

.meas tran vdout0_19ck790 FIND v(dout0_19) AT=400.025n

.meas tran vdout0_20ck790 FIND v(dout0_20) AT=400.025n

.meas tran vdout0_21ck790 FIND v(dout0_21) AT=400.025n

.meas tran vdout0_22ck790 FIND v(dout0_22) AT=400.025n

.meas tran vdout0_23ck790 FIND v(dout0_23) AT=400.025n

.meas tran vdout0_24ck790 FIND v(dout0_24) AT=400.025n

.meas tran vdout0_25ck790 FIND v(dout0_25) AT=400.025n

.meas tran vdout0_26ck790 FIND v(dout0_26) AT=400.025n

.meas tran vdout0_27ck790 FIND v(dout0_27) AT=400.025n

.meas tran vdout0_28ck790 FIND v(dout0_28) AT=400.025n

.meas tran vdout0_29ck790 FIND v(dout0_29) AT=400.025n

.meas tran vdout0_30ck790 FIND v(dout0_30) AT=400.025n

.meas tran vdout0_31ck790 FIND v(dout0_31) AT=400.025n

.meas tran vdout0_0ck830 FIND v(dout0_0) AT=420.025n

.meas tran vdout0_1ck830 FIND v(dout0_1) AT=420.025n

.meas tran vdout0_2ck830 FIND v(dout0_2) AT=420.025n

.meas tran vdout0_3ck830 FIND v(dout0_3) AT=420.025n

.meas tran vdout0_4ck830 FIND v(dout0_4) AT=420.025n

.meas tran vdout0_5ck830 FIND v(dout0_5) AT=420.025n

.meas tran vdout0_6ck830 FIND v(dout0_6) AT=420.025n

.meas tran vdout0_7ck830 FIND v(dout0_7) AT=420.025n

.meas tran vdout0_8ck830 FIND v(dout0_8) AT=420.025n

.meas tran vdout0_9ck830 FIND v(dout0_9) AT=420.025n

.meas tran vdout0_10ck830 FIND v(dout0_10) AT=420.025n

.meas tran vdout0_11ck830 FIND v(dout0_11) AT=420.025n

.meas tran vdout0_12ck830 FIND v(dout0_12) AT=420.025n

.meas tran vdout0_13ck830 FIND v(dout0_13) AT=420.025n

.meas tran vdout0_14ck830 FIND v(dout0_14) AT=420.025n

.meas tran vdout0_15ck830 FIND v(dout0_15) AT=420.025n

.meas tran vdout0_16ck830 FIND v(dout0_16) AT=420.025n

.meas tran vdout0_17ck830 FIND v(dout0_17) AT=420.025n

.meas tran vdout0_18ck830 FIND v(dout0_18) AT=420.025n

.meas tran vdout0_19ck830 FIND v(dout0_19) AT=420.025n

.meas tran vdout0_20ck830 FIND v(dout0_20) AT=420.025n

.meas tran vdout0_21ck830 FIND v(dout0_21) AT=420.025n

.meas tran vdout0_22ck830 FIND v(dout0_22) AT=420.025n

.meas tran vdout0_23ck830 FIND v(dout0_23) AT=420.025n

.meas tran vdout0_24ck830 FIND v(dout0_24) AT=420.025n

.meas tran vdout0_25ck830 FIND v(dout0_25) AT=420.025n

.meas tran vdout0_26ck830 FIND v(dout0_26) AT=420.025n

.meas tran vdout0_27ck830 FIND v(dout0_27) AT=420.025n

.meas tran vdout0_28ck830 FIND v(dout0_28) AT=420.025n

.meas tran vdout0_29ck830 FIND v(dout0_29) AT=420.025n

.meas tran vdout0_30ck830 FIND v(dout0_30) AT=420.025n

.meas tran vdout0_31ck830 FIND v(dout0_31) AT=420.025n

.meas tran vdout0_0ck840 FIND v(dout0_0) AT=425.025n

.meas tran vdout0_1ck840 FIND v(dout0_1) AT=425.025n

.meas tran vdout0_2ck840 FIND v(dout0_2) AT=425.025n

.meas tran vdout0_3ck840 FIND v(dout0_3) AT=425.025n

.meas tran vdout0_4ck840 FIND v(dout0_4) AT=425.025n

.meas tran vdout0_5ck840 FIND v(dout0_5) AT=425.025n

.meas tran vdout0_6ck840 FIND v(dout0_6) AT=425.025n

.meas tran vdout0_7ck840 FIND v(dout0_7) AT=425.025n

.meas tran vdout0_8ck840 FIND v(dout0_8) AT=425.025n

.meas tran vdout0_9ck840 FIND v(dout0_9) AT=425.025n

.meas tran vdout0_10ck840 FIND v(dout0_10) AT=425.025n

.meas tran vdout0_11ck840 FIND v(dout0_11) AT=425.025n

.meas tran vdout0_12ck840 FIND v(dout0_12) AT=425.025n

.meas tran vdout0_13ck840 FIND v(dout0_13) AT=425.025n

.meas tran vdout0_14ck840 FIND v(dout0_14) AT=425.025n

.meas tran vdout0_15ck840 FIND v(dout0_15) AT=425.025n

.meas tran vdout0_16ck840 FIND v(dout0_16) AT=425.025n

.meas tran vdout0_17ck840 FIND v(dout0_17) AT=425.025n

.meas tran vdout0_18ck840 FIND v(dout0_18) AT=425.025n

.meas tran vdout0_19ck840 FIND v(dout0_19) AT=425.025n

.meas tran vdout0_20ck840 FIND v(dout0_20) AT=425.025n

.meas tran vdout0_21ck840 FIND v(dout0_21) AT=425.025n

.meas tran vdout0_22ck840 FIND v(dout0_22) AT=425.025n

.meas tran vdout0_23ck840 FIND v(dout0_23) AT=425.025n

.meas tran vdout0_24ck840 FIND v(dout0_24) AT=425.025n

.meas tran vdout0_25ck840 FIND v(dout0_25) AT=425.025n

.meas tran vdout0_26ck840 FIND v(dout0_26) AT=425.025n

.meas tran vdout0_27ck840 FIND v(dout0_27) AT=425.025n

.meas tran vdout0_28ck840 FIND v(dout0_28) AT=425.025n

.meas tran vdout0_29ck840 FIND v(dout0_29) AT=425.025n

.meas tran vdout0_30ck840 FIND v(dout0_30) AT=425.025n

.meas tran vdout0_31ck840 FIND v(dout0_31) AT=425.025n

.meas tran vdout0_0ck850 FIND v(dout0_0) AT=430.025n

.meas tran vdout0_1ck850 FIND v(dout0_1) AT=430.025n

.meas tran vdout0_2ck850 FIND v(dout0_2) AT=430.025n

.meas tran vdout0_3ck850 FIND v(dout0_3) AT=430.025n

.meas tran vdout0_4ck850 FIND v(dout0_4) AT=430.025n

.meas tran vdout0_5ck850 FIND v(dout0_5) AT=430.025n

.meas tran vdout0_6ck850 FIND v(dout0_6) AT=430.025n

.meas tran vdout0_7ck850 FIND v(dout0_7) AT=430.025n

.meas tran vdout0_8ck850 FIND v(dout0_8) AT=430.025n

.meas tran vdout0_9ck850 FIND v(dout0_9) AT=430.025n

.meas tran vdout0_10ck850 FIND v(dout0_10) AT=430.025n

.meas tran vdout0_11ck850 FIND v(dout0_11) AT=430.025n

.meas tran vdout0_12ck850 FIND v(dout0_12) AT=430.025n

.meas tran vdout0_13ck850 FIND v(dout0_13) AT=430.025n

.meas tran vdout0_14ck850 FIND v(dout0_14) AT=430.025n

.meas tran vdout0_15ck850 FIND v(dout0_15) AT=430.025n

.meas tran vdout0_16ck850 FIND v(dout0_16) AT=430.025n

.meas tran vdout0_17ck850 FIND v(dout0_17) AT=430.025n

.meas tran vdout0_18ck850 FIND v(dout0_18) AT=430.025n

.meas tran vdout0_19ck850 FIND v(dout0_19) AT=430.025n

.meas tran vdout0_20ck850 FIND v(dout0_20) AT=430.025n

.meas tran vdout0_21ck850 FIND v(dout0_21) AT=430.025n

.meas tran vdout0_22ck850 FIND v(dout0_22) AT=430.025n

.meas tran vdout0_23ck850 FIND v(dout0_23) AT=430.025n

.meas tran vdout0_24ck850 FIND v(dout0_24) AT=430.025n

.meas tran vdout0_25ck850 FIND v(dout0_25) AT=430.025n

.meas tran vdout0_26ck850 FIND v(dout0_26) AT=430.025n

.meas tran vdout0_27ck850 FIND v(dout0_27) AT=430.025n

.meas tran vdout0_28ck850 FIND v(dout0_28) AT=430.025n

.meas tran vdout0_29ck850 FIND v(dout0_29) AT=430.025n

.meas tran vdout0_30ck850 FIND v(dout0_30) AT=430.025n

.meas tran vdout0_31ck850 FIND v(dout0_31) AT=430.025n

.meas tran vdout0_0ck860 FIND v(dout0_0) AT=435.025n

.meas tran vdout0_1ck860 FIND v(dout0_1) AT=435.025n

.meas tran vdout0_2ck860 FIND v(dout0_2) AT=435.025n

.meas tran vdout0_3ck860 FIND v(dout0_3) AT=435.025n

.meas tran vdout0_4ck860 FIND v(dout0_4) AT=435.025n

.meas tran vdout0_5ck860 FIND v(dout0_5) AT=435.025n

.meas tran vdout0_6ck860 FIND v(dout0_6) AT=435.025n

.meas tran vdout0_7ck860 FIND v(dout0_7) AT=435.025n

.meas tran vdout0_8ck860 FIND v(dout0_8) AT=435.025n

.meas tran vdout0_9ck860 FIND v(dout0_9) AT=435.025n

.meas tran vdout0_10ck860 FIND v(dout0_10) AT=435.025n

.meas tran vdout0_11ck860 FIND v(dout0_11) AT=435.025n

.meas tran vdout0_12ck860 FIND v(dout0_12) AT=435.025n

.meas tran vdout0_13ck860 FIND v(dout0_13) AT=435.025n

.meas tran vdout0_14ck860 FIND v(dout0_14) AT=435.025n

.meas tran vdout0_15ck860 FIND v(dout0_15) AT=435.025n

.meas tran vdout0_16ck860 FIND v(dout0_16) AT=435.025n

.meas tran vdout0_17ck860 FIND v(dout0_17) AT=435.025n

.meas tran vdout0_18ck860 FIND v(dout0_18) AT=435.025n

.meas tran vdout0_19ck860 FIND v(dout0_19) AT=435.025n

.meas tran vdout0_20ck860 FIND v(dout0_20) AT=435.025n

.meas tran vdout0_21ck860 FIND v(dout0_21) AT=435.025n

.meas tran vdout0_22ck860 FIND v(dout0_22) AT=435.025n

.meas tran vdout0_23ck860 FIND v(dout0_23) AT=435.025n

.meas tran vdout0_24ck860 FIND v(dout0_24) AT=435.025n

.meas tran vdout0_25ck860 FIND v(dout0_25) AT=435.025n

.meas tran vdout0_26ck860 FIND v(dout0_26) AT=435.025n

.meas tran vdout0_27ck860 FIND v(dout0_27) AT=435.025n

.meas tran vdout0_28ck860 FIND v(dout0_28) AT=435.025n

.meas tran vdout0_29ck860 FIND v(dout0_29) AT=435.025n

.meas tran vdout0_30ck860 FIND v(dout0_30) AT=435.025n

.meas tran vdout0_31ck860 FIND v(dout0_31) AT=435.025n

.meas tran vdout0_0ck900 FIND v(dout0_0) AT=455.025n

.meas tran vdout0_1ck900 FIND v(dout0_1) AT=455.025n

.meas tran vdout0_2ck900 FIND v(dout0_2) AT=455.025n

.meas tran vdout0_3ck900 FIND v(dout0_3) AT=455.025n

.meas tran vdout0_4ck900 FIND v(dout0_4) AT=455.025n

.meas tran vdout0_5ck900 FIND v(dout0_5) AT=455.025n

.meas tran vdout0_6ck900 FIND v(dout0_6) AT=455.025n

.meas tran vdout0_7ck900 FIND v(dout0_7) AT=455.025n

.meas tran vdout0_8ck900 FIND v(dout0_8) AT=455.025n

.meas tran vdout0_9ck900 FIND v(dout0_9) AT=455.025n

.meas tran vdout0_10ck900 FIND v(dout0_10) AT=455.025n

.meas tran vdout0_11ck900 FIND v(dout0_11) AT=455.025n

.meas tran vdout0_12ck900 FIND v(dout0_12) AT=455.025n

.meas tran vdout0_13ck900 FIND v(dout0_13) AT=455.025n

.meas tran vdout0_14ck900 FIND v(dout0_14) AT=455.025n

.meas tran vdout0_15ck900 FIND v(dout0_15) AT=455.025n

.meas tran vdout0_16ck900 FIND v(dout0_16) AT=455.025n

.meas tran vdout0_17ck900 FIND v(dout0_17) AT=455.025n

.meas tran vdout0_18ck900 FIND v(dout0_18) AT=455.025n

.meas tran vdout0_19ck900 FIND v(dout0_19) AT=455.025n

.meas tran vdout0_20ck900 FIND v(dout0_20) AT=455.025n

.meas tran vdout0_21ck900 FIND v(dout0_21) AT=455.025n

.meas tran vdout0_22ck900 FIND v(dout0_22) AT=455.025n

.meas tran vdout0_23ck900 FIND v(dout0_23) AT=455.025n

.meas tran vdout0_24ck900 FIND v(dout0_24) AT=455.025n

.meas tran vdout0_25ck900 FIND v(dout0_25) AT=455.025n

.meas tran vdout0_26ck900 FIND v(dout0_26) AT=455.025n

.meas tran vdout0_27ck900 FIND v(dout0_27) AT=455.025n

.meas tran vdout0_28ck900 FIND v(dout0_28) AT=455.025n

.meas tran vdout0_29ck900 FIND v(dout0_29) AT=455.025n

.meas tran vdout0_30ck900 FIND v(dout0_30) AT=455.025n

.meas tran vdout0_31ck900 FIND v(dout0_31) AT=455.025n

.meas tran vdout0_0ck930 FIND v(dout0_0) AT=470.025n

.meas tran vdout0_1ck930 FIND v(dout0_1) AT=470.025n

.meas tran vdout0_2ck930 FIND v(dout0_2) AT=470.025n

.meas tran vdout0_3ck930 FIND v(dout0_3) AT=470.025n

.meas tran vdout0_4ck930 FIND v(dout0_4) AT=470.025n

.meas tran vdout0_5ck930 FIND v(dout0_5) AT=470.025n

.meas tran vdout0_6ck930 FIND v(dout0_6) AT=470.025n

.meas tran vdout0_7ck930 FIND v(dout0_7) AT=470.025n

.meas tran vdout0_8ck930 FIND v(dout0_8) AT=470.025n

.meas tran vdout0_9ck930 FIND v(dout0_9) AT=470.025n

.meas tran vdout0_10ck930 FIND v(dout0_10) AT=470.025n

.meas tran vdout0_11ck930 FIND v(dout0_11) AT=470.025n

.meas tran vdout0_12ck930 FIND v(dout0_12) AT=470.025n

.meas tran vdout0_13ck930 FIND v(dout0_13) AT=470.025n

.meas tran vdout0_14ck930 FIND v(dout0_14) AT=470.025n

.meas tran vdout0_15ck930 FIND v(dout0_15) AT=470.025n

.meas tran vdout0_16ck930 FIND v(dout0_16) AT=470.025n

.meas tran vdout0_17ck930 FIND v(dout0_17) AT=470.025n

.meas tran vdout0_18ck930 FIND v(dout0_18) AT=470.025n

.meas tran vdout0_19ck930 FIND v(dout0_19) AT=470.025n

.meas tran vdout0_20ck930 FIND v(dout0_20) AT=470.025n

.meas tran vdout0_21ck930 FIND v(dout0_21) AT=470.025n

.meas tran vdout0_22ck930 FIND v(dout0_22) AT=470.025n

.meas tran vdout0_23ck930 FIND v(dout0_23) AT=470.025n

.meas tran vdout0_24ck930 FIND v(dout0_24) AT=470.025n

.meas tran vdout0_25ck930 FIND v(dout0_25) AT=470.025n

.meas tran vdout0_26ck930 FIND v(dout0_26) AT=470.025n

.meas tran vdout0_27ck930 FIND v(dout0_27) AT=470.025n

.meas tran vdout0_28ck930 FIND v(dout0_28) AT=470.025n

.meas tran vdout0_29ck930 FIND v(dout0_29) AT=470.025n

.meas tran vdout0_30ck930 FIND v(dout0_30) AT=470.025n

.meas tran vdout0_31ck930 FIND v(dout0_31) AT=470.025n

.meas tran vdout0_0ck960 FIND v(dout0_0) AT=485.025n

.meas tran vdout0_1ck960 FIND v(dout0_1) AT=485.025n

.meas tran vdout0_2ck960 FIND v(dout0_2) AT=485.025n

.meas tran vdout0_3ck960 FIND v(dout0_3) AT=485.025n

.meas tran vdout0_4ck960 FIND v(dout0_4) AT=485.025n

.meas tran vdout0_5ck960 FIND v(dout0_5) AT=485.025n

.meas tran vdout0_6ck960 FIND v(dout0_6) AT=485.025n

.meas tran vdout0_7ck960 FIND v(dout0_7) AT=485.025n

.meas tran vdout0_8ck960 FIND v(dout0_8) AT=485.025n

.meas tran vdout0_9ck960 FIND v(dout0_9) AT=485.025n

.meas tran vdout0_10ck960 FIND v(dout0_10) AT=485.025n

.meas tran vdout0_11ck960 FIND v(dout0_11) AT=485.025n

.meas tran vdout0_12ck960 FIND v(dout0_12) AT=485.025n

.meas tran vdout0_13ck960 FIND v(dout0_13) AT=485.025n

.meas tran vdout0_14ck960 FIND v(dout0_14) AT=485.025n

.meas tran vdout0_15ck960 FIND v(dout0_15) AT=485.025n

.meas tran vdout0_16ck960 FIND v(dout0_16) AT=485.025n

.meas tran vdout0_17ck960 FIND v(dout0_17) AT=485.025n

.meas tran vdout0_18ck960 FIND v(dout0_18) AT=485.025n

.meas tran vdout0_19ck960 FIND v(dout0_19) AT=485.025n

.meas tran vdout0_20ck960 FIND v(dout0_20) AT=485.025n

.meas tran vdout0_21ck960 FIND v(dout0_21) AT=485.025n

.meas tran vdout0_22ck960 FIND v(dout0_22) AT=485.025n

.meas tran vdout0_23ck960 FIND v(dout0_23) AT=485.025n

.meas tran vdout0_24ck960 FIND v(dout0_24) AT=485.025n

.meas tran vdout0_25ck960 FIND v(dout0_25) AT=485.025n

.meas tran vdout0_26ck960 FIND v(dout0_26) AT=485.025n

.meas tran vdout0_27ck960 FIND v(dout0_27) AT=485.025n

.meas tran vdout0_28ck960 FIND v(dout0_28) AT=485.025n

.meas tran vdout0_29ck960 FIND v(dout0_29) AT=485.025n

.meas tran vdout0_30ck960 FIND v(dout0_30) AT=485.025n

.meas tran vdout0_31ck960 FIND v(dout0_31) AT=485.025n

.meas tran vdout0_0ck1000 FIND v(dout0_0) AT=505.025n

.meas tran vdout0_1ck1000 FIND v(dout0_1) AT=505.025n

.meas tran vdout0_2ck1000 FIND v(dout0_2) AT=505.025n

.meas tran vdout0_3ck1000 FIND v(dout0_3) AT=505.025n

.meas tran vdout0_4ck1000 FIND v(dout0_4) AT=505.025n

.meas tran vdout0_5ck1000 FIND v(dout0_5) AT=505.025n

.meas tran vdout0_6ck1000 FIND v(dout0_6) AT=505.025n

.meas tran vdout0_7ck1000 FIND v(dout0_7) AT=505.025n

.meas tran vdout0_8ck1000 FIND v(dout0_8) AT=505.025n

.meas tran vdout0_9ck1000 FIND v(dout0_9) AT=505.025n

.meas tran vdout0_10ck1000 FIND v(dout0_10) AT=505.025n

.meas tran vdout0_11ck1000 FIND v(dout0_11) AT=505.025n

.meas tran vdout0_12ck1000 FIND v(dout0_12) AT=505.025n

.meas tran vdout0_13ck1000 FIND v(dout0_13) AT=505.025n

.meas tran vdout0_14ck1000 FIND v(dout0_14) AT=505.025n

.meas tran vdout0_15ck1000 FIND v(dout0_15) AT=505.025n

.meas tran vdout0_16ck1000 FIND v(dout0_16) AT=505.025n

.meas tran vdout0_17ck1000 FIND v(dout0_17) AT=505.025n

.meas tran vdout0_18ck1000 FIND v(dout0_18) AT=505.025n

.meas tran vdout0_19ck1000 FIND v(dout0_19) AT=505.025n

.meas tran vdout0_20ck1000 FIND v(dout0_20) AT=505.025n

.meas tran vdout0_21ck1000 FIND v(dout0_21) AT=505.025n

.meas tran vdout0_22ck1000 FIND v(dout0_22) AT=505.025n

.meas tran vdout0_23ck1000 FIND v(dout0_23) AT=505.025n

.meas tran vdout0_24ck1000 FIND v(dout0_24) AT=505.025n

.meas tran vdout0_25ck1000 FIND v(dout0_25) AT=505.025n

.meas tran vdout0_26ck1000 FIND v(dout0_26) AT=505.025n

.meas tran vdout0_27ck1000 FIND v(dout0_27) AT=505.025n

.meas tran vdout0_28ck1000 FIND v(dout0_28) AT=505.025n

.meas tran vdout0_29ck1000 FIND v(dout0_29) AT=505.025n

.meas tran vdout0_30ck1000 FIND v(dout0_30) AT=505.025n

.meas tran vdout0_31ck1000 FIND v(dout0_31) AT=505.025n

.meas tran vdout0_0ck1050 FIND v(dout0_0) AT=530.025n

.meas tran vdout0_1ck1050 FIND v(dout0_1) AT=530.025n

.meas tran vdout0_2ck1050 FIND v(dout0_2) AT=530.025n

.meas tran vdout0_3ck1050 FIND v(dout0_3) AT=530.025n

.meas tran vdout0_4ck1050 FIND v(dout0_4) AT=530.025n

.meas tran vdout0_5ck1050 FIND v(dout0_5) AT=530.025n

.meas tran vdout0_6ck1050 FIND v(dout0_6) AT=530.025n

.meas tran vdout0_7ck1050 FIND v(dout0_7) AT=530.025n

.meas tran vdout0_8ck1050 FIND v(dout0_8) AT=530.025n

.meas tran vdout0_9ck1050 FIND v(dout0_9) AT=530.025n

.meas tran vdout0_10ck1050 FIND v(dout0_10) AT=530.025n

.meas tran vdout0_11ck1050 FIND v(dout0_11) AT=530.025n

.meas tran vdout0_12ck1050 FIND v(dout0_12) AT=530.025n

.meas tran vdout0_13ck1050 FIND v(dout0_13) AT=530.025n

.meas tran vdout0_14ck1050 FIND v(dout0_14) AT=530.025n

.meas tran vdout0_15ck1050 FIND v(dout0_15) AT=530.025n

.meas tran vdout0_16ck1050 FIND v(dout0_16) AT=530.025n

.meas tran vdout0_17ck1050 FIND v(dout0_17) AT=530.025n

.meas tran vdout0_18ck1050 FIND v(dout0_18) AT=530.025n

.meas tran vdout0_19ck1050 FIND v(dout0_19) AT=530.025n

.meas tran vdout0_20ck1050 FIND v(dout0_20) AT=530.025n

.meas tran vdout0_21ck1050 FIND v(dout0_21) AT=530.025n

.meas tran vdout0_22ck1050 FIND v(dout0_22) AT=530.025n

.meas tran vdout0_23ck1050 FIND v(dout0_23) AT=530.025n

.meas tran vdout0_24ck1050 FIND v(dout0_24) AT=530.025n

.meas tran vdout0_25ck1050 FIND v(dout0_25) AT=530.025n

.meas tran vdout0_26ck1050 FIND v(dout0_26) AT=530.025n

.meas tran vdout0_27ck1050 FIND v(dout0_27) AT=530.025n

.meas tran vdout0_28ck1050 FIND v(dout0_28) AT=530.025n

.meas tran vdout0_29ck1050 FIND v(dout0_29) AT=530.025n

.meas tran vdout0_30ck1050 FIND v(dout0_30) AT=530.025n

.meas tran vdout0_31ck1050 FIND v(dout0_31) AT=530.025n

.meas tran vdout0_0ck1060 FIND v(dout0_0) AT=535.025n

.meas tran vdout0_1ck1060 FIND v(dout0_1) AT=535.025n

.meas tran vdout0_2ck1060 FIND v(dout0_2) AT=535.025n

.meas tran vdout0_3ck1060 FIND v(dout0_3) AT=535.025n

.meas tran vdout0_4ck1060 FIND v(dout0_4) AT=535.025n

.meas tran vdout0_5ck1060 FIND v(dout0_5) AT=535.025n

.meas tran vdout0_6ck1060 FIND v(dout0_6) AT=535.025n

.meas tran vdout0_7ck1060 FIND v(dout0_7) AT=535.025n

.meas tran vdout0_8ck1060 FIND v(dout0_8) AT=535.025n

.meas tran vdout0_9ck1060 FIND v(dout0_9) AT=535.025n

.meas tran vdout0_10ck1060 FIND v(dout0_10) AT=535.025n

.meas tran vdout0_11ck1060 FIND v(dout0_11) AT=535.025n

.meas tran vdout0_12ck1060 FIND v(dout0_12) AT=535.025n

.meas tran vdout0_13ck1060 FIND v(dout0_13) AT=535.025n

.meas tran vdout0_14ck1060 FIND v(dout0_14) AT=535.025n

.meas tran vdout0_15ck1060 FIND v(dout0_15) AT=535.025n

.meas tran vdout0_16ck1060 FIND v(dout0_16) AT=535.025n

.meas tran vdout0_17ck1060 FIND v(dout0_17) AT=535.025n

.meas tran vdout0_18ck1060 FIND v(dout0_18) AT=535.025n

.meas tran vdout0_19ck1060 FIND v(dout0_19) AT=535.025n

.meas tran vdout0_20ck1060 FIND v(dout0_20) AT=535.025n

.meas tran vdout0_21ck1060 FIND v(dout0_21) AT=535.025n

.meas tran vdout0_22ck1060 FIND v(dout0_22) AT=535.025n

.meas tran vdout0_23ck1060 FIND v(dout0_23) AT=535.025n

.meas tran vdout0_24ck1060 FIND v(dout0_24) AT=535.025n

.meas tran vdout0_25ck1060 FIND v(dout0_25) AT=535.025n

.meas tran vdout0_26ck1060 FIND v(dout0_26) AT=535.025n

.meas tran vdout0_27ck1060 FIND v(dout0_27) AT=535.025n

.meas tran vdout0_28ck1060 FIND v(dout0_28) AT=535.025n

.meas tran vdout0_29ck1060 FIND v(dout0_29) AT=535.025n

.meas tran vdout0_30ck1060 FIND v(dout0_30) AT=535.025n

.meas tran vdout0_31ck1060 FIND v(dout0_31) AT=535.025n

.meas tran vdout0_0ck1070 FIND v(dout0_0) AT=540.025n

.meas tran vdout0_1ck1070 FIND v(dout0_1) AT=540.025n

.meas tran vdout0_2ck1070 FIND v(dout0_2) AT=540.025n

.meas tran vdout0_3ck1070 FIND v(dout0_3) AT=540.025n

.meas tran vdout0_4ck1070 FIND v(dout0_4) AT=540.025n

.meas tran vdout0_5ck1070 FIND v(dout0_5) AT=540.025n

.meas tran vdout0_6ck1070 FIND v(dout0_6) AT=540.025n

.meas tran vdout0_7ck1070 FIND v(dout0_7) AT=540.025n

.meas tran vdout0_8ck1070 FIND v(dout0_8) AT=540.025n

.meas tran vdout0_9ck1070 FIND v(dout0_9) AT=540.025n

.meas tran vdout0_10ck1070 FIND v(dout0_10) AT=540.025n

.meas tran vdout0_11ck1070 FIND v(dout0_11) AT=540.025n

.meas tran vdout0_12ck1070 FIND v(dout0_12) AT=540.025n

.meas tran vdout0_13ck1070 FIND v(dout0_13) AT=540.025n

.meas tran vdout0_14ck1070 FIND v(dout0_14) AT=540.025n

.meas tran vdout0_15ck1070 FIND v(dout0_15) AT=540.025n

.meas tran vdout0_16ck1070 FIND v(dout0_16) AT=540.025n

.meas tran vdout0_17ck1070 FIND v(dout0_17) AT=540.025n

.meas tran vdout0_18ck1070 FIND v(dout0_18) AT=540.025n

.meas tran vdout0_19ck1070 FIND v(dout0_19) AT=540.025n

.meas tran vdout0_20ck1070 FIND v(dout0_20) AT=540.025n

.meas tran vdout0_21ck1070 FIND v(dout0_21) AT=540.025n

.meas tran vdout0_22ck1070 FIND v(dout0_22) AT=540.025n

.meas tran vdout0_23ck1070 FIND v(dout0_23) AT=540.025n

.meas tran vdout0_24ck1070 FIND v(dout0_24) AT=540.025n

.meas tran vdout0_25ck1070 FIND v(dout0_25) AT=540.025n

.meas tran vdout0_26ck1070 FIND v(dout0_26) AT=540.025n

.meas tran vdout0_27ck1070 FIND v(dout0_27) AT=540.025n

.meas tran vdout0_28ck1070 FIND v(dout0_28) AT=540.025n

.meas tran vdout0_29ck1070 FIND v(dout0_29) AT=540.025n

.meas tran vdout0_30ck1070 FIND v(dout0_30) AT=540.025n

.meas tran vdout0_31ck1070 FIND v(dout0_31) AT=540.025n

.meas tran vdout0_0ck1120 FIND v(dout0_0) AT=565.025n

.meas tran vdout0_1ck1120 FIND v(dout0_1) AT=565.025n

.meas tran vdout0_2ck1120 FIND v(dout0_2) AT=565.025n

.meas tran vdout0_3ck1120 FIND v(dout0_3) AT=565.025n

.meas tran vdout0_4ck1120 FIND v(dout0_4) AT=565.025n

.meas tran vdout0_5ck1120 FIND v(dout0_5) AT=565.025n

.meas tran vdout0_6ck1120 FIND v(dout0_6) AT=565.025n

.meas tran vdout0_7ck1120 FIND v(dout0_7) AT=565.025n

.meas tran vdout0_8ck1120 FIND v(dout0_8) AT=565.025n

.meas tran vdout0_9ck1120 FIND v(dout0_9) AT=565.025n

.meas tran vdout0_10ck1120 FIND v(dout0_10) AT=565.025n

.meas tran vdout0_11ck1120 FIND v(dout0_11) AT=565.025n

.meas tran vdout0_12ck1120 FIND v(dout0_12) AT=565.025n

.meas tran vdout0_13ck1120 FIND v(dout0_13) AT=565.025n

.meas tran vdout0_14ck1120 FIND v(dout0_14) AT=565.025n

.meas tran vdout0_15ck1120 FIND v(dout0_15) AT=565.025n

.meas tran vdout0_16ck1120 FIND v(dout0_16) AT=565.025n

.meas tran vdout0_17ck1120 FIND v(dout0_17) AT=565.025n

.meas tran vdout0_18ck1120 FIND v(dout0_18) AT=565.025n

.meas tran vdout0_19ck1120 FIND v(dout0_19) AT=565.025n

.meas tran vdout0_20ck1120 FIND v(dout0_20) AT=565.025n

.meas tran vdout0_21ck1120 FIND v(dout0_21) AT=565.025n

.meas tran vdout0_22ck1120 FIND v(dout0_22) AT=565.025n

.meas tran vdout0_23ck1120 FIND v(dout0_23) AT=565.025n

.meas tran vdout0_24ck1120 FIND v(dout0_24) AT=565.025n

.meas tran vdout0_25ck1120 FIND v(dout0_25) AT=565.025n

.meas tran vdout0_26ck1120 FIND v(dout0_26) AT=565.025n

.meas tran vdout0_27ck1120 FIND v(dout0_27) AT=565.025n

.meas tran vdout0_28ck1120 FIND v(dout0_28) AT=565.025n

.meas tran vdout0_29ck1120 FIND v(dout0_29) AT=565.025n

.meas tran vdout0_30ck1120 FIND v(dout0_30) AT=565.025n

.meas tran vdout0_31ck1120 FIND v(dout0_31) AT=565.025n

.meas tran vdout0_0ck1130 FIND v(dout0_0) AT=570.025n

.meas tran vdout0_1ck1130 FIND v(dout0_1) AT=570.025n

.meas tran vdout0_2ck1130 FIND v(dout0_2) AT=570.025n

.meas tran vdout0_3ck1130 FIND v(dout0_3) AT=570.025n

.meas tran vdout0_4ck1130 FIND v(dout0_4) AT=570.025n

.meas tran vdout0_5ck1130 FIND v(dout0_5) AT=570.025n

.meas tran vdout0_6ck1130 FIND v(dout0_6) AT=570.025n

.meas tran vdout0_7ck1130 FIND v(dout0_7) AT=570.025n

.meas tran vdout0_8ck1130 FIND v(dout0_8) AT=570.025n

.meas tran vdout0_9ck1130 FIND v(dout0_9) AT=570.025n

.meas tran vdout0_10ck1130 FIND v(dout0_10) AT=570.025n

.meas tran vdout0_11ck1130 FIND v(dout0_11) AT=570.025n

.meas tran vdout0_12ck1130 FIND v(dout0_12) AT=570.025n

.meas tran vdout0_13ck1130 FIND v(dout0_13) AT=570.025n

.meas tran vdout0_14ck1130 FIND v(dout0_14) AT=570.025n

.meas tran vdout0_15ck1130 FIND v(dout0_15) AT=570.025n

.meas tran vdout0_16ck1130 FIND v(dout0_16) AT=570.025n

.meas tran vdout0_17ck1130 FIND v(dout0_17) AT=570.025n

.meas tran vdout0_18ck1130 FIND v(dout0_18) AT=570.025n

.meas tran vdout0_19ck1130 FIND v(dout0_19) AT=570.025n

.meas tran vdout0_20ck1130 FIND v(dout0_20) AT=570.025n

.meas tran vdout0_21ck1130 FIND v(dout0_21) AT=570.025n

.meas tran vdout0_22ck1130 FIND v(dout0_22) AT=570.025n

.meas tran vdout0_23ck1130 FIND v(dout0_23) AT=570.025n

.meas tran vdout0_24ck1130 FIND v(dout0_24) AT=570.025n

.meas tran vdout0_25ck1130 FIND v(dout0_25) AT=570.025n

.meas tran vdout0_26ck1130 FIND v(dout0_26) AT=570.025n

.meas tran vdout0_27ck1130 FIND v(dout0_27) AT=570.025n

.meas tran vdout0_28ck1130 FIND v(dout0_28) AT=570.025n

.meas tran vdout0_29ck1130 FIND v(dout0_29) AT=570.025n

.meas tran vdout0_30ck1130 FIND v(dout0_30) AT=570.025n

.meas tran vdout0_31ck1130 FIND v(dout0_31) AT=570.025n

.meas tran vdout0_0ck1140 FIND v(dout0_0) AT=575.025n

.meas tran vdout0_1ck1140 FIND v(dout0_1) AT=575.025n

.meas tran vdout0_2ck1140 FIND v(dout0_2) AT=575.025n

.meas tran vdout0_3ck1140 FIND v(dout0_3) AT=575.025n

.meas tran vdout0_4ck1140 FIND v(dout0_4) AT=575.025n

.meas tran vdout0_5ck1140 FIND v(dout0_5) AT=575.025n

.meas tran vdout0_6ck1140 FIND v(dout0_6) AT=575.025n

.meas tran vdout0_7ck1140 FIND v(dout0_7) AT=575.025n

.meas tran vdout0_8ck1140 FIND v(dout0_8) AT=575.025n

.meas tran vdout0_9ck1140 FIND v(dout0_9) AT=575.025n

.meas tran vdout0_10ck1140 FIND v(dout0_10) AT=575.025n

.meas tran vdout0_11ck1140 FIND v(dout0_11) AT=575.025n

.meas tran vdout0_12ck1140 FIND v(dout0_12) AT=575.025n

.meas tran vdout0_13ck1140 FIND v(dout0_13) AT=575.025n

.meas tran vdout0_14ck1140 FIND v(dout0_14) AT=575.025n

.meas tran vdout0_15ck1140 FIND v(dout0_15) AT=575.025n

.meas tran vdout0_16ck1140 FIND v(dout0_16) AT=575.025n

.meas tran vdout0_17ck1140 FIND v(dout0_17) AT=575.025n

.meas tran vdout0_18ck1140 FIND v(dout0_18) AT=575.025n

.meas tran vdout0_19ck1140 FIND v(dout0_19) AT=575.025n

.meas tran vdout0_20ck1140 FIND v(dout0_20) AT=575.025n

.meas tran vdout0_21ck1140 FIND v(dout0_21) AT=575.025n

.meas tran vdout0_22ck1140 FIND v(dout0_22) AT=575.025n

.meas tran vdout0_23ck1140 FIND v(dout0_23) AT=575.025n

.meas tran vdout0_24ck1140 FIND v(dout0_24) AT=575.025n

.meas tran vdout0_25ck1140 FIND v(dout0_25) AT=575.025n

.meas tran vdout0_26ck1140 FIND v(dout0_26) AT=575.025n

.meas tran vdout0_27ck1140 FIND v(dout0_27) AT=575.025n

.meas tran vdout0_28ck1140 FIND v(dout0_28) AT=575.025n

.meas tran vdout0_29ck1140 FIND v(dout0_29) AT=575.025n

.meas tran vdout0_30ck1140 FIND v(dout0_30) AT=575.025n

.meas tran vdout0_31ck1140 FIND v(dout0_31) AT=575.025n

.meas tran vdout0_0ck1180 FIND v(dout0_0) AT=595.025n

.meas tran vdout0_1ck1180 FIND v(dout0_1) AT=595.025n

.meas tran vdout0_2ck1180 FIND v(dout0_2) AT=595.025n

.meas tran vdout0_3ck1180 FIND v(dout0_3) AT=595.025n

.meas tran vdout0_4ck1180 FIND v(dout0_4) AT=595.025n

.meas tran vdout0_5ck1180 FIND v(dout0_5) AT=595.025n

.meas tran vdout0_6ck1180 FIND v(dout0_6) AT=595.025n

.meas tran vdout0_7ck1180 FIND v(dout0_7) AT=595.025n

.meas tran vdout0_8ck1180 FIND v(dout0_8) AT=595.025n

.meas tran vdout0_9ck1180 FIND v(dout0_9) AT=595.025n

.meas tran vdout0_10ck1180 FIND v(dout0_10) AT=595.025n

.meas tran vdout0_11ck1180 FIND v(dout0_11) AT=595.025n

.meas tran vdout0_12ck1180 FIND v(dout0_12) AT=595.025n

.meas tran vdout0_13ck1180 FIND v(dout0_13) AT=595.025n

.meas tran vdout0_14ck1180 FIND v(dout0_14) AT=595.025n

.meas tran vdout0_15ck1180 FIND v(dout0_15) AT=595.025n

.meas tran vdout0_16ck1180 FIND v(dout0_16) AT=595.025n

.meas tran vdout0_17ck1180 FIND v(dout0_17) AT=595.025n

.meas tran vdout0_18ck1180 FIND v(dout0_18) AT=595.025n

.meas tran vdout0_19ck1180 FIND v(dout0_19) AT=595.025n

.meas tran vdout0_20ck1180 FIND v(dout0_20) AT=595.025n

.meas tran vdout0_21ck1180 FIND v(dout0_21) AT=595.025n

.meas tran vdout0_22ck1180 FIND v(dout0_22) AT=595.025n

.meas tran vdout0_23ck1180 FIND v(dout0_23) AT=595.025n

.meas tran vdout0_24ck1180 FIND v(dout0_24) AT=595.025n

.meas tran vdout0_25ck1180 FIND v(dout0_25) AT=595.025n

.meas tran vdout0_26ck1180 FIND v(dout0_26) AT=595.025n

.meas tran vdout0_27ck1180 FIND v(dout0_27) AT=595.025n

.meas tran vdout0_28ck1180 FIND v(dout0_28) AT=595.025n

.meas tran vdout0_29ck1180 FIND v(dout0_29) AT=595.025n

.meas tran vdout0_30ck1180 FIND v(dout0_30) AT=595.025n

.meas tran vdout0_31ck1180 FIND v(dout0_31) AT=595.025n

.meas tran vdout0_0ck1200 FIND v(dout0_0) AT=605.025n

.meas tran vdout0_1ck1200 FIND v(dout0_1) AT=605.025n

.meas tran vdout0_2ck1200 FIND v(dout0_2) AT=605.025n

.meas tran vdout0_3ck1200 FIND v(dout0_3) AT=605.025n

.meas tran vdout0_4ck1200 FIND v(dout0_4) AT=605.025n

.meas tran vdout0_5ck1200 FIND v(dout0_5) AT=605.025n

.meas tran vdout0_6ck1200 FIND v(dout0_6) AT=605.025n

.meas tran vdout0_7ck1200 FIND v(dout0_7) AT=605.025n

.meas tran vdout0_8ck1200 FIND v(dout0_8) AT=605.025n

.meas tran vdout0_9ck1200 FIND v(dout0_9) AT=605.025n

.meas tran vdout0_10ck1200 FIND v(dout0_10) AT=605.025n

.meas tran vdout0_11ck1200 FIND v(dout0_11) AT=605.025n

.meas tran vdout0_12ck1200 FIND v(dout0_12) AT=605.025n

.meas tran vdout0_13ck1200 FIND v(dout0_13) AT=605.025n

.meas tran vdout0_14ck1200 FIND v(dout0_14) AT=605.025n

.meas tran vdout0_15ck1200 FIND v(dout0_15) AT=605.025n

.meas tran vdout0_16ck1200 FIND v(dout0_16) AT=605.025n

.meas tran vdout0_17ck1200 FIND v(dout0_17) AT=605.025n

.meas tran vdout0_18ck1200 FIND v(dout0_18) AT=605.025n

.meas tran vdout0_19ck1200 FIND v(dout0_19) AT=605.025n

.meas tran vdout0_20ck1200 FIND v(dout0_20) AT=605.025n

.meas tran vdout0_21ck1200 FIND v(dout0_21) AT=605.025n

.meas tran vdout0_22ck1200 FIND v(dout0_22) AT=605.025n

.meas tran vdout0_23ck1200 FIND v(dout0_23) AT=605.025n

.meas tran vdout0_24ck1200 FIND v(dout0_24) AT=605.025n

.meas tran vdout0_25ck1200 FIND v(dout0_25) AT=605.025n

.meas tran vdout0_26ck1200 FIND v(dout0_26) AT=605.025n

.meas tran vdout0_27ck1200 FIND v(dout0_27) AT=605.025n

.meas tran vdout0_28ck1200 FIND v(dout0_28) AT=605.025n

.meas tran vdout0_29ck1200 FIND v(dout0_29) AT=605.025n

.meas tran vdout0_30ck1200 FIND v(dout0_30) AT=605.025n

.meas tran vdout0_31ck1200 FIND v(dout0_31) AT=605.025n

.meas tran vdout0_0ck1250 FIND v(dout0_0) AT=630.025n

.meas tran vdout0_1ck1250 FIND v(dout0_1) AT=630.025n

.meas tran vdout0_2ck1250 FIND v(dout0_2) AT=630.025n

.meas tran vdout0_3ck1250 FIND v(dout0_3) AT=630.025n

.meas tran vdout0_4ck1250 FIND v(dout0_4) AT=630.025n

.meas tran vdout0_5ck1250 FIND v(dout0_5) AT=630.025n

.meas tran vdout0_6ck1250 FIND v(dout0_6) AT=630.025n

.meas tran vdout0_7ck1250 FIND v(dout0_7) AT=630.025n

.meas tran vdout0_8ck1250 FIND v(dout0_8) AT=630.025n

.meas tran vdout0_9ck1250 FIND v(dout0_9) AT=630.025n

.meas tran vdout0_10ck1250 FIND v(dout0_10) AT=630.025n

.meas tran vdout0_11ck1250 FIND v(dout0_11) AT=630.025n

.meas tran vdout0_12ck1250 FIND v(dout0_12) AT=630.025n

.meas tran vdout0_13ck1250 FIND v(dout0_13) AT=630.025n

.meas tran vdout0_14ck1250 FIND v(dout0_14) AT=630.025n

.meas tran vdout0_15ck1250 FIND v(dout0_15) AT=630.025n

.meas tran vdout0_16ck1250 FIND v(dout0_16) AT=630.025n

.meas tran vdout0_17ck1250 FIND v(dout0_17) AT=630.025n

.meas tran vdout0_18ck1250 FIND v(dout0_18) AT=630.025n

.meas tran vdout0_19ck1250 FIND v(dout0_19) AT=630.025n

.meas tran vdout0_20ck1250 FIND v(dout0_20) AT=630.025n

.meas tran vdout0_21ck1250 FIND v(dout0_21) AT=630.025n

.meas tran vdout0_22ck1250 FIND v(dout0_22) AT=630.025n

.meas tran vdout0_23ck1250 FIND v(dout0_23) AT=630.025n

.meas tran vdout0_24ck1250 FIND v(dout0_24) AT=630.025n

.meas tran vdout0_25ck1250 FIND v(dout0_25) AT=630.025n

.meas tran vdout0_26ck1250 FIND v(dout0_26) AT=630.025n

.meas tran vdout0_27ck1250 FIND v(dout0_27) AT=630.025n

.meas tran vdout0_28ck1250 FIND v(dout0_28) AT=630.025n

.meas tran vdout0_29ck1250 FIND v(dout0_29) AT=630.025n

.meas tran vdout0_30ck1250 FIND v(dout0_30) AT=630.025n

.meas tran vdout0_31ck1250 FIND v(dout0_31) AT=630.025n

.meas tran vdout0_0ck1310 FIND v(dout0_0) AT=660.025n

.meas tran vdout0_1ck1310 FIND v(dout0_1) AT=660.025n

.meas tran vdout0_2ck1310 FIND v(dout0_2) AT=660.025n

.meas tran vdout0_3ck1310 FIND v(dout0_3) AT=660.025n

.meas tran vdout0_4ck1310 FIND v(dout0_4) AT=660.025n

.meas tran vdout0_5ck1310 FIND v(dout0_5) AT=660.025n

.meas tran vdout0_6ck1310 FIND v(dout0_6) AT=660.025n

.meas tran vdout0_7ck1310 FIND v(dout0_7) AT=660.025n

.meas tran vdout0_8ck1310 FIND v(dout0_8) AT=660.025n

.meas tran vdout0_9ck1310 FIND v(dout0_9) AT=660.025n

.meas tran vdout0_10ck1310 FIND v(dout0_10) AT=660.025n

.meas tran vdout0_11ck1310 FIND v(dout0_11) AT=660.025n

.meas tran vdout0_12ck1310 FIND v(dout0_12) AT=660.025n

.meas tran vdout0_13ck1310 FIND v(dout0_13) AT=660.025n

.meas tran vdout0_14ck1310 FIND v(dout0_14) AT=660.025n

.meas tran vdout0_15ck1310 FIND v(dout0_15) AT=660.025n

.meas tran vdout0_16ck1310 FIND v(dout0_16) AT=660.025n

.meas tran vdout0_17ck1310 FIND v(dout0_17) AT=660.025n

.meas tran vdout0_18ck1310 FIND v(dout0_18) AT=660.025n

.meas tran vdout0_19ck1310 FIND v(dout0_19) AT=660.025n

.meas tran vdout0_20ck1310 FIND v(dout0_20) AT=660.025n

.meas tran vdout0_21ck1310 FIND v(dout0_21) AT=660.025n

.meas tran vdout0_22ck1310 FIND v(dout0_22) AT=660.025n

.meas tran vdout0_23ck1310 FIND v(dout0_23) AT=660.025n

.meas tran vdout0_24ck1310 FIND v(dout0_24) AT=660.025n

.meas tran vdout0_25ck1310 FIND v(dout0_25) AT=660.025n

.meas tran vdout0_26ck1310 FIND v(dout0_26) AT=660.025n

.meas tran vdout0_27ck1310 FIND v(dout0_27) AT=660.025n

.meas tran vdout0_28ck1310 FIND v(dout0_28) AT=660.025n

.meas tran vdout0_29ck1310 FIND v(dout0_29) AT=660.025n

.meas tran vdout0_30ck1310 FIND v(dout0_30) AT=660.025n

.meas tran vdout0_31ck1310 FIND v(dout0_31) AT=660.025n

.meas tran vdout0_0ck1320 FIND v(dout0_0) AT=665.025n

.meas tran vdout0_1ck1320 FIND v(dout0_1) AT=665.025n

.meas tran vdout0_2ck1320 FIND v(dout0_2) AT=665.025n

.meas tran vdout0_3ck1320 FIND v(dout0_3) AT=665.025n

.meas tran vdout0_4ck1320 FIND v(dout0_4) AT=665.025n

.meas tran vdout0_5ck1320 FIND v(dout0_5) AT=665.025n

.meas tran vdout0_6ck1320 FIND v(dout0_6) AT=665.025n

.meas tran vdout0_7ck1320 FIND v(dout0_7) AT=665.025n

.meas tran vdout0_8ck1320 FIND v(dout0_8) AT=665.025n

.meas tran vdout0_9ck1320 FIND v(dout0_9) AT=665.025n

.meas tran vdout0_10ck1320 FIND v(dout0_10) AT=665.025n

.meas tran vdout0_11ck1320 FIND v(dout0_11) AT=665.025n

.meas tran vdout0_12ck1320 FIND v(dout0_12) AT=665.025n

.meas tran vdout0_13ck1320 FIND v(dout0_13) AT=665.025n

.meas tran vdout0_14ck1320 FIND v(dout0_14) AT=665.025n

.meas tran vdout0_15ck1320 FIND v(dout0_15) AT=665.025n

.meas tran vdout0_16ck1320 FIND v(dout0_16) AT=665.025n

.meas tran vdout0_17ck1320 FIND v(dout0_17) AT=665.025n

.meas tran vdout0_18ck1320 FIND v(dout0_18) AT=665.025n

.meas tran vdout0_19ck1320 FIND v(dout0_19) AT=665.025n

.meas tran vdout0_20ck1320 FIND v(dout0_20) AT=665.025n

.meas tran vdout0_21ck1320 FIND v(dout0_21) AT=665.025n

.meas tran vdout0_22ck1320 FIND v(dout0_22) AT=665.025n

.meas tran vdout0_23ck1320 FIND v(dout0_23) AT=665.025n

.meas tran vdout0_24ck1320 FIND v(dout0_24) AT=665.025n

.meas tran vdout0_25ck1320 FIND v(dout0_25) AT=665.025n

.meas tran vdout0_26ck1320 FIND v(dout0_26) AT=665.025n

.meas tran vdout0_27ck1320 FIND v(dout0_27) AT=665.025n

.meas tran vdout0_28ck1320 FIND v(dout0_28) AT=665.025n

.meas tran vdout0_29ck1320 FIND v(dout0_29) AT=665.025n

.meas tran vdout0_30ck1320 FIND v(dout0_30) AT=665.025n

.meas tran vdout0_31ck1320 FIND v(dout0_31) AT=665.025n

.meas tran vdout0_0ck1340 FIND v(dout0_0) AT=675.025n

.meas tran vdout0_1ck1340 FIND v(dout0_1) AT=675.025n

.meas tran vdout0_2ck1340 FIND v(dout0_2) AT=675.025n

.meas tran vdout0_3ck1340 FIND v(dout0_3) AT=675.025n

.meas tran vdout0_4ck1340 FIND v(dout0_4) AT=675.025n

.meas tran vdout0_5ck1340 FIND v(dout0_5) AT=675.025n

.meas tran vdout0_6ck1340 FIND v(dout0_6) AT=675.025n

.meas tran vdout0_7ck1340 FIND v(dout0_7) AT=675.025n

.meas tran vdout0_8ck1340 FIND v(dout0_8) AT=675.025n

.meas tran vdout0_9ck1340 FIND v(dout0_9) AT=675.025n

.meas tran vdout0_10ck1340 FIND v(dout0_10) AT=675.025n

.meas tran vdout0_11ck1340 FIND v(dout0_11) AT=675.025n

.meas tran vdout0_12ck1340 FIND v(dout0_12) AT=675.025n

.meas tran vdout0_13ck1340 FIND v(dout0_13) AT=675.025n

.meas tran vdout0_14ck1340 FIND v(dout0_14) AT=675.025n

.meas tran vdout0_15ck1340 FIND v(dout0_15) AT=675.025n

.meas tran vdout0_16ck1340 FIND v(dout0_16) AT=675.025n

.meas tran vdout0_17ck1340 FIND v(dout0_17) AT=675.025n

.meas tran vdout0_18ck1340 FIND v(dout0_18) AT=675.025n

.meas tran vdout0_19ck1340 FIND v(dout0_19) AT=675.025n

.meas tran vdout0_20ck1340 FIND v(dout0_20) AT=675.025n

.meas tran vdout0_21ck1340 FIND v(dout0_21) AT=675.025n

.meas tran vdout0_22ck1340 FIND v(dout0_22) AT=675.025n

.meas tran vdout0_23ck1340 FIND v(dout0_23) AT=675.025n

.meas tran vdout0_24ck1340 FIND v(dout0_24) AT=675.025n

.meas tran vdout0_25ck1340 FIND v(dout0_25) AT=675.025n

.meas tran vdout0_26ck1340 FIND v(dout0_26) AT=675.025n

.meas tran vdout0_27ck1340 FIND v(dout0_27) AT=675.025n

.meas tran vdout0_28ck1340 FIND v(dout0_28) AT=675.025n

.meas tran vdout0_29ck1340 FIND v(dout0_29) AT=675.025n

.meas tran vdout0_30ck1340 FIND v(dout0_30) AT=675.025n

.meas tran vdout0_31ck1340 FIND v(dout0_31) AT=675.025n

.meas tran vdout0_0ck1350 FIND v(dout0_0) AT=680.025n

.meas tran vdout0_1ck1350 FIND v(dout0_1) AT=680.025n

.meas tran vdout0_2ck1350 FIND v(dout0_2) AT=680.025n

.meas tran vdout0_3ck1350 FIND v(dout0_3) AT=680.025n

.meas tran vdout0_4ck1350 FIND v(dout0_4) AT=680.025n

.meas tran vdout0_5ck1350 FIND v(dout0_5) AT=680.025n

.meas tran vdout0_6ck1350 FIND v(dout0_6) AT=680.025n

.meas tran vdout0_7ck1350 FIND v(dout0_7) AT=680.025n

.meas tran vdout0_8ck1350 FIND v(dout0_8) AT=680.025n

.meas tran vdout0_9ck1350 FIND v(dout0_9) AT=680.025n

.meas tran vdout0_10ck1350 FIND v(dout0_10) AT=680.025n

.meas tran vdout0_11ck1350 FIND v(dout0_11) AT=680.025n

.meas tran vdout0_12ck1350 FIND v(dout0_12) AT=680.025n

.meas tran vdout0_13ck1350 FIND v(dout0_13) AT=680.025n

.meas tran vdout0_14ck1350 FIND v(dout0_14) AT=680.025n

.meas tran vdout0_15ck1350 FIND v(dout0_15) AT=680.025n

.meas tran vdout0_16ck1350 FIND v(dout0_16) AT=680.025n

.meas tran vdout0_17ck1350 FIND v(dout0_17) AT=680.025n

.meas tran vdout0_18ck1350 FIND v(dout0_18) AT=680.025n

.meas tran vdout0_19ck1350 FIND v(dout0_19) AT=680.025n

.meas tran vdout0_20ck1350 FIND v(dout0_20) AT=680.025n

.meas tran vdout0_21ck1350 FIND v(dout0_21) AT=680.025n

.meas tran vdout0_22ck1350 FIND v(dout0_22) AT=680.025n

.meas tran vdout0_23ck1350 FIND v(dout0_23) AT=680.025n

.meas tran vdout0_24ck1350 FIND v(dout0_24) AT=680.025n

.meas tran vdout0_25ck1350 FIND v(dout0_25) AT=680.025n

.meas tran vdout0_26ck1350 FIND v(dout0_26) AT=680.025n

.meas tran vdout0_27ck1350 FIND v(dout0_27) AT=680.025n

.meas tran vdout0_28ck1350 FIND v(dout0_28) AT=680.025n

.meas tran vdout0_29ck1350 FIND v(dout0_29) AT=680.025n

.meas tran vdout0_30ck1350 FIND v(dout0_30) AT=680.025n

.meas tran vdout0_31ck1350 FIND v(dout0_31) AT=680.025n

.meas tran vdout0_0ck1380 FIND v(dout0_0) AT=695.025n

.meas tran vdout0_1ck1380 FIND v(dout0_1) AT=695.025n

.meas tran vdout0_2ck1380 FIND v(dout0_2) AT=695.025n

.meas tran vdout0_3ck1380 FIND v(dout0_3) AT=695.025n

.meas tran vdout0_4ck1380 FIND v(dout0_4) AT=695.025n

.meas tran vdout0_5ck1380 FIND v(dout0_5) AT=695.025n

.meas tran vdout0_6ck1380 FIND v(dout0_6) AT=695.025n

.meas tran vdout0_7ck1380 FIND v(dout0_7) AT=695.025n

.meas tran vdout0_8ck1380 FIND v(dout0_8) AT=695.025n

.meas tran vdout0_9ck1380 FIND v(dout0_9) AT=695.025n

.meas tran vdout0_10ck1380 FIND v(dout0_10) AT=695.025n

.meas tran vdout0_11ck1380 FIND v(dout0_11) AT=695.025n

.meas tran vdout0_12ck1380 FIND v(dout0_12) AT=695.025n

.meas tran vdout0_13ck1380 FIND v(dout0_13) AT=695.025n

.meas tran vdout0_14ck1380 FIND v(dout0_14) AT=695.025n

.meas tran vdout0_15ck1380 FIND v(dout0_15) AT=695.025n

.meas tran vdout0_16ck1380 FIND v(dout0_16) AT=695.025n

.meas tran vdout0_17ck1380 FIND v(dout0_17) AT=695.025n

.meas tran vdout0_18ck1380 FIND v(dout0_18) AT=695.025n

.meas tran vdout0_19ck1380 FIND v(dout0_19) AT=695.025n

.meas tran vdout0_20ck1380 FIND v(dout0_20) AT=695.025n

.meas tran vdout0_21ck1380 FIND v(dout0_21) AT=695.025n

.meas tran vdout0_22ck1380 FIND v(dout0_22) AT=695.025n

.meas tran vdout0_23ck1380 FIND v(dout0_23) AT=695.025n

.meas tran vdout0_24ck1380 FIND v(dout0_24) AT=695.025n

.meas tran vdout0_25ck1380 FIND v(dout0_25) AT=695.025n

.meas tran vdout0_26ck1380 FIND v(dout0_26) AT=695.025n

.meas tran vdout0_27ck1380 FIND v(dout0_27) AT=695.025n

.meas tran vdout0_28ck1380 FIND v(dout0_28) AT=695.025n

.meas tran vdout0_29ck1380 FIND v(dout0_29) AT=695.025n

.meas tran vdout0_30ck1380 FIND v(dout0_30) AT=695.025n

.meas tran vdout0_31ck1380 FIND v(dout0_31) AT=695.025n

.meas tran vdout0_0ck1390 FIND v(dout0_0) AT=700.025n

.meas tran vdout0_1ck1390 FIND v(dout0_1) AT=700.025n

.meas tran vdout0_2ck1390 FIND v(dout0_2) AT=700.025n

.meas tran vdout0_3ck1390 FIND v(dout0_3) AT=700.025n

.meas tran vdout0_4ck1390 FIND v(dout0_4) AT=700.025n

.meas tran vdout0_5ck1390 FIND v(dout0_5) AT=700.025n

.meas tran vdout0_6ck1390 FIND v(dout0_6) AT=700.025n

.meas tran vdout0_7ck1390 FIND v(dout0_7) AT=700.025n

.meas tran vdout0_8ck1390 FIND v(dout0_8) AT=700.025n

.meas tran vdout0_9ck1390 FIND v(dout0_9) AT=700.025n

.meas tran vdout0_10ck1390 FIND v(dout0_10) AT=700.025n

.meas tran vdout0_11ck1390 FIND v(dout0_11) AT=700.025n

.meas tran vdout0_12ck1390 FIND v(dout0_12) AT=700.025n

.meas tran vdout0_13ck1390 FIND v(dout0_13) AT=700.025n

.meas tran vdout0_14ck1390 FIND v(dout0_14) AT=700.025n

.meas tran vdout0_15ck1390 FIND v(dout0_15) AT=700.025n

.meas tran vdout0_16ck1390 FIND v(dout0_16) AT=700.025n

.meas tran vdout0_17ck1390 FIND v(dout0_17) AT=700.025n

.meas tran vdout0_18ck1390 FIND v(dout0_18) AT=700.025n

.meas tran vdout0_19ck1390 FIND v(dout0_19) AT=700.025n

.meas tran vdout0_20ck1390 FIND v(dout0_20) AT=700.025n

.meas tran vdout0_21ck1390 FIND v(dout0_21) AT=700.025n

.meas tran vdout0_22ck1390 FIND v(dout0_22) AT=700.025n

.meas tran vdout0_23ck1390 FIND v(dout0_23) AT=700.025n

.meas tran vdout0_24ck1390 FIND v(dout0_24) AT=700.025n

.meas tran vdout0_25ck1390 FIND v(dout0_25) AT=700.025n

.meas tran vdout0_26ck1390 FIND v(dout0_26) AT=700.025n

.meas tran vdout0_27ck1390 FIND v(dout0_27) AT=700.025n

.meas tran vdout0_28ck1390 FIND v(dout0_28) AT=700.025n

.meas tran vdout0_29ck1390 FIND v(dout0_29) AT=700.025n

.meas tran vdout0_30ck1390 FIND v(dout0_30) AT=700.025n

.meas tran vdout0_31ck1390 FIND v(dout0_31) AT=700.025n

.meas tran vdout0_0ck1420 FIND v(dout0_0) AT=715.025n

.meas tran vdout0_1ck1420 FIND v(dout0_1) AT=715.025n

.meas tran vdout0_2ck1420 FIND v(dout0_2) AT=715.025n

.meas tran vdout0_3ck1420 FIND v(dout0_3) AT=715.025n

.meas tran vdout0_4ck1420 FIND v(dout0_4) AT=715.025n

.meas tran vdout0_5ck1420 FIND v(dout0_5) AT=715.025n

.meas tran vdout0_6ck1420 FIND v(dout0_6) AT=715.025n

.meas tran vdout0_7ck1420 FIND v(dout0_7) AT=715.025n

.meas tran vdout0_8ck1420 FIND v(dout0_8) AT=715.025n

.meas tran vdout0_9ck1420 FIND v(dout0_9) AT=715.025n

.meas tran vdout0_10ck1420 FIND v(dout0_10) AT=715.025n

.meas tran vdout0_11ck1420 FIND v(dout0_11) AT=715.025n

.meas tran vdout0_12ck1420 FIND v(dout0_12) AT=715.025n

.meas tran vdout0_13ck1420 FIND v(dout0_13) AT=715.025n

.meas tran vdout0_14ck1420 FIND v(dout0_14) AT=715.025n

.meas tran vdout0_15ck1420 FIND v(dout0_15) AT=715.025n

.meas tran vdout0_16ck1420 FIND v(dout0_16) AT=715.025n

.meas tran vdout0_17ck1420 FIND v(dout0_17) AT=715.025n

.meas tran vdout0_18ck1420 FIND v(dout0_18) AT=715.025n

.meas tran vdout0_19ck1420 FIND v(dout0_19) AT=715.025n

.meas tran vdout0_20ck1420 FIND v(dout0_20) AT=715.025n

.meas tran vdout0_21ck1420 FIND v(dout0_21) AT=715.025n

.meas tran vdout0_22ck1420 FIND v(dout0_22) AT=715.025n

.meas tran vdout0_23ck1420 FIND v(dout0_23) AT=715.025n

.meas tran vdout0_24ck1420 FIND v(dout0_24) AT=715.025n

.meas tran vdout0_25ck1420 FIND v(dout0_25) AT=715.025n

.meas tran vdout0_26ck1420 FIND v(dout0_26) AT=715.025n

.meas tran vdout0_27ck1420 FIND v(dout0_27) AT=715.025n

.meas tran vdout0_28ck1420 FIND v(dout0_28) AT=715.025n

.meas tran vdout0_29ck1420 FIND v(dout0_29) AT=715.025n

.meas tran vdout0_30ck1420 FIND v(dout0_30) AT=715.025n

.meas tran vdout0_31ck1420 FIND v(dout0_31) AT=715.025n

.meas tran vdout0_0ck1430 FIND v(dout0_0) AT=720.025n

.meas tran vdout0_1ck1430 FIND v(dout0_1) AT=720.025n

.meas tran vdout0_2ck1430 FIND v(dout0_2) AT=720.025n

.meas tran vdout0_3ck1430 FIND v(dout0_3) AT=720.025n

.meas tran vdout0_4ck1430 FIND v(dout0_4) AT=720.025n

.meas tran vdout0_5ck1430 FIND v(dout0_5) AT=720.025n

.meas tran vdout0_6ck1430 FIND v(dout0_6) AT=720.025n

.meas tran vdout0_7ck1430 FIND v(dout0_7) AT=720.025n

.meas tran vdout0_8ck1430 FIND v(dout0_8) AT=720.025n

.meas tran vdout0_9ck1430 FIND v(dout0_9) AT=720.025n

.meas tran vdout0_10ck1430 FIND v(dout0_10) AT=720.025n

.meas tran vdout0_11ck1430 FIND v(dout0_11) AT=720.025n

.meas tran vdout0_12ck1430 FIND v(dout0_12) AT=720.025n

.meas tran vdout0_13ck1430 FIND v(dout0_13) AT=720.025n

.meas tran vdout0_14ck1430 FIND v(dout0_14) AT=720.025n

.meas tran vdout0_15ck1430 FIND v(dout0_15) AT=720.025n

.meas tran vdout0_16ck1430 FIND v(dout0_16) AT=720.025n

.meas tran vdout0_17ck1430 FIND v(dout0_17) AT=720.025n

.meas tran vdout0_18ck1430 FIND v(dout0_18) AT=720.025n

.meas tran vdout0_19ck1430 FIND v(dout0_19) AT=720.025n

.meas tran vdout0_20ck1430 FIND v(dout0_20) AT=720.025n

.meas tran vdout0_21ck1430 FIND v(dout0_21) AT=720.025n

.meas tran vdout0_22ck1430 FIND v(dout0_22) AT=720.025n

.meas tran vdout0_23ck1430 FIND v(dout0_23) AT=720.025n

.meas tran vdout0_24ck1430 FIND v(dout0_24) AT=720.025n

.meas tran vdout0_25ck1430 FIND v(dout0_25) AT=720.025n

.meas tran vdout0_26ck1430 FIND v(dout0_26) AT=720.025n

.meas tran vdout0_27ck1430 FIND v(dout0_27) AT=720.025n

.meas tran vdout0_28ck1430 FIND v(dout0_28) AT=720.025n

.meas tran vdout0_29ck1430 FIND v(dout0_29) AT=720.025n

.meas tran vdout0_30ck1430 FIND v(dout0_30) AT=720.025n

.meas tran vdout0_31ck1430 FIND v(dout0_31) AT=720.025n

.meas tran vdout0_0ck1450 FIND v(dout0_0) AT=730.025n

.meas tran vdout0_1ck1450 FIND v(dout0_1) AT=730.025n

.meas tran vdout0_2ck1450 FIND v(dout0_2) AT=730.025n

.meas tran vdout0_3ck1450 FIND v(dout0_3) AT=730.025n

.meas tran vdout0_4ck1450 FIND v(dout0_4) AT=730.025n

.meas tran vdout0_5ck1450 FIND v(dout0_5) AT=730.025n

.meas tran vdout0_6ck1450 FIND v(dout0_6) AT=730.025n

.meas tran vdout0_7ck1450 FIND v(dout0_7) AT=730.025n

.meas tran vdout0_8ck1450 FIND v(dout0_8) AT=730.025n

.meas tran vdout0_9ck1450 FIND v(dout0_9) AT=730.025n

.meas tran vdout0_10ck1450 FIND v(dout0_10) AT=730.025n

.meas tran vdout0_11ck1450 FIND v(dout0_11) AT=730.025n

.meas tran vdout0_12ck1450 FIND v(dout0_12) AT=730.025n

.meas tran vdout0_13ck1450 FIND v(dout0_13) AT=730.025n

.meas tran vdout0_14ck1450 FIND v(dout0_14) AT=730.025n

.meas tran vdout0_15ck1450 FIND v(dout0_15) AT=730.025n

.meas tran vdout0_16ck1450 FIND v(dout0_16) AT=730.025n

.meas tran vdout0_17ck1450 FIND v(dout0_17) AT=730.025n

.meas tran vdout0_18ck1450 FIND v(dout0_18) AT=730.025n

.meas tran vdout0_19ck1450 FIND v(dout0_19) AT=730.025n

.meas tran vdout0_20ck1450 FIND v(dout0_20) AT=730.025n

.meas tran vdout0_21ck1450 FIND v(dout0_21) AT=730.025n

.meas tran vdout0_22ck1450 FIND v(dout0_22) AT=730.025n

.meas tran vdout0_23ck1450 FIND v(dout0_23) AT=730.025n

.meas tran vdout0_24ck1450 FIND v(dout0_24) AT=730.025n

.meas tran vdout0_25ck1450 FIND v(dout0_25) AT=730.025n

.meas tran vdout0_26ck1450 FIND v(dout0_26) AT=730.025n

.meas tran vdout0_27ck1450 FIND v(dout0_27) AT=730.025n

.meas tran vdout0_28ck1450 FIND v(dout0_28) AT=730.025n

.meas tran vdout0_29ck1450 FIND v(dout0_29) AT=730.025n

.meas tran vdout0_30ck1450 FIND v(dout0_30) AT=730.025n

.meas tran vdout0_31ck1450 FIND v(dout0_31) AT=730.025n

.meas tran vdout0_0ck1470 FIND v(dout0_0) AT=740.025n

.meas tran vdout0_1ck1470 FIND v(dout0_1) AT=740.025n

.meas tran vdout0_2ck1470 FIND v(dout0_2) AT=740.025n

.meas tran vdout0_3ck1470 FIND v(dout0_3) AT=740.025n

.meas tran vdout0_4ck1470 FIND v(dout0_4) AT=740.025n

.meas tran vdout0_5ck1470 FIND v(dout0_5) AT=740.025n

.meas tran vdout0_6ck1470 FIND v(dout0_6) AT=740.025n

.meas tran vdout0_7ck1470 FIND v(dout0_7) AT=740.025n

.meas tran vdout0_8ck1470 FIND v(dout0_8) AT=740.025n

.meas tran vdout0_9ck1470 FIND v(dout0_9) AT=740.025n

.meas tran vdout0_10ck1470 FIND v(dout0_10) AT=740.025n

.meas tran vdout0_11ck1470 FIND v(dout0_11) AT=740.025n

.meas tran vdout0_12ck1470 FIND v(dout0_12) AT=740.025n

.meas tran vdout0_13ck1470 FIND v(dout0_13) AT=740.025n

.meas tran vdout0_14ck1470 FIND v(dout0_14) AT=740.025n

.meas tran vdout0_15ck1470 FIND v(dout0_15) AT=740.025n

.meas tran vdout0_16ck1470 FIND v(dout0_16) AT=740.025n

.meas tran vdout0_17ck1470 FIND v(dout0_17) AT=740.025n

.meas tran vdout0_18ck1470 FIND v(dout0_18) AT=740.025n

.meas tran vdout0_19ck1470 FIND v(dout0_19) AT=740.025n

.meas tran vdout0_20ck1470 FIND v(dout0_20) AT=740.025n

.meas tran vdout0_21ck1470 FIND v(dout0_21) AT=740.025n

.meas tran vdout0_22ck1470 FIND v(dout0_22) AT=740.025n

.meas tran vdout0_23ck1470 FIND v(dout0_23) AT=740.025n

.meas tran vdout0_24ck1470 FIND v(dout0_24) AT=740.025n

.meas tran vdout0_25ck1470 FIND v(dout0_25) AT=740.025n

.meas tran vdout0_26ck1470 FIND v(dout0_26) AT=740.025n

.meas tran vdout0_27ck1470 FIND v(dout0_27) AT=740.025n

.meas tran vdout0_28ck1470 FIND v(dout0_28) AT=740.025n

.meas tran vdout0_29ck1470 FIND v(dout0_29) AT=740.025n

.meas tran vdout0_30ck1470 FIND v(dout0_30) AT=740.025n

.meas tran vdout0_31ck1470 FIND v(dout0_31) AT=740.025n

.meas tran vdout0_0ck1480 FIND v(dout0_0) AT=745.025n

.meas tran vdout0_1ck1480 FIND v(dout0_1) AT=745.025n

.meas tran vdout0_2ck1480 FIND v(dout0_2) AT=745.025n

.meas tran vdout0_3ck1480 FIND v(dout0_3) AT=745.025n

.meas tran vdout0_4ck1480 FIND v(dout0_4) AT=745.025n

.meas tran vdout0_5ck1480 FIND v(dout0_5) AT=745.025n

.meas tran vdout0_6ck1480 FIND v(dout0_6) AT=745.025n

.meas tran vdout0_7ck1480 FIND v(dout0_7) AT=745.025n

.meas tran vdout0_8ck1480 FIND v(dout0_8) AT=745.025n

.meas tran vdout0_9ck1480 FIND v(dout0_9) AT=745.025n

.meas tran vdout0_10ck1480 FIND v(dout0_10) AT=745.025n

.meas tran vdout0_11ck1480 FIND v(dout0_11) AT=745.025n

.meas tran vdout0_12ck1480 FIND v(dout0_12) AT=745.025n

.meas tran vdout0_13ck1480 FIND v(dout0_13) AT=745.025n

.meas tran vdout0_14ck1480 FIND v(dout0_14) AT=745.025n

.meas tran vdout0_15ck1480 FIND v(dout0_15) AT=745.025n

.meas tran vdout0_16ck1480 FIND v(dout0_16) AT=745.025n

.meas tran vdout0_17ck1480 FIND v(dout0_17) AT=745.025n

.meas tran vdout0_18ck1480 FIND v(dout0_18) AT=745.025n

.meas tran vdout0_19ck1480 FIND v(dout0_19) AT=745.025n

.meas tran vdout0_20ck1480 FIND v(dout0_20) AT=745.025n

.meas tran vdout0_21ck1480 FIND v(dout0_21) AT=745.025n

.meas tran vdout0_22ck1480 FIND v(dout0_22) AT=745.025n

.meas tran vdout0_23ck1480 FIND v(dout0_23) AT=745.025n

.meas tran vdout0_24ck1480 FIND v(dout0_24) AT=745.025n

.meas tran vdout0_25ck1480 FIND v(dout0_25) AT=745.025n

.meas tran vdout0_26ck1480 FIND v(dout0_26) AT=745.025n

.meas tran vdout0_27ck1480 FIND v(dout0_27) AT=745.025n

.meas tran vdout0_28ck1480 FIND v(dout0_28) AT=745.025n

.meas tran vdout0_29ck1480 FIND v(dout0_29) AT=745.025n

.meas tran vdout0_30ck1480 FIND v(dout0_30) AT=745.025n

.meas tran vdout0_31ck1480 FIND v(dout0_31) AT=745.025n

.meas tran vdout0_0ck1490 FIND v(dout0_0) AT=750.025n

.meas tran vdout0_1ck1490 FIND v(dout0_1) AT=750.025n

.meas tran vdout0_2ck1490 FIND v(dout0_2) AT=750.025n

.meas tran vdout0_3ck1490 FIND v(dout0_3) AT=750.025n

.meas tran vdout0_4ck1490 FIND v(dout0_4) AT=750.025n

.meas tran vdout0_5ck1490 FIND v(dout0_5) AT=750.025n

.meas tran vdout0_6ck1490 FIND v(dout0_6) AT=750.025n

.meas tran vdout0_7ck1490 FIND v(dout0_7) AT=750.025n

.meas tran vdout0_8ck1490 FIND v(dout0_8) AT=750.025n

.meas tran vdout0_9ck1490 FIND v(dout0_9) AT=750.025n

.meas tran vdout0_10ck1490 FIND v(dout0_10) AT=750.025n

.meas tran vdout0_11ck1490 FIND v(dout0_11) AT=750.025n

.meas tran vdout0_12ck1490 FIND v(dout0_12) AT=750.025n

.meas tran vdout0_13ck1490 FIND v(dout0_13) AT=750.025n

.meas tran vdout0_14ck1490 FIND v(dout0_14) AT=750.025n

.meas tran vdout0_15ck1490 FIND v(dout0_15) AT=750.025n

.meas tran vdout0_16ck1490 FIND v(dout0_16) AT=750.025n

.meas tran vdout0_17ck1490 FIND v(dout0_17) AT=750.025n

.meas tran vdout0_18ck1490 FIND v(dout0_18) AT=750.025n

.meas tran vdout0_19ck1490 FIND v(dout0_19) AT=750.025n

.meas tran vdout0_20ck1490 FIND v(dout0_20) AT=750.025n

.meas tran vdout0_21ck1490 FIND v(dout0_21) AT=750.025n

.meas tran vdout0_22ck1490 FIND v(dout0_22) AT=750.025n

.meas tran vdout0_23ck1490 FIND v(dout0_23) AT=750.025n

.meas tran vdout0_24ck1490 FIND v(dout0_24) AT=750.025n

.meas tran vdout0_25ck1490 FIND v(dout0_25) AT=750.025n

.meas tran vdout0_26ck1490 FIND v(dout0_26) AT=750.025n

.meas tran vdout0_27ck1490 FIND v(dout0_27) AT=750.025n

.meas tran vdout0_28ck1490 FIND v(dout0_28) AT=750.025n

.meas tran vdout0_29ck1490 FIND v(dout0_29) AT=750.025n

.meas tran vdout0_30ck1490 FIND v(dout0_30) AT=750.025n

.meas tran vdout0_31ck1490 FIND v(dout0_31) AT=750.025n

.meas tran vdout0_0ck1500 FIND v(dout0_0) AT=755.025n

.meas tran vdout0_1ck1500 FIND v(dout0_1) AT=755.025n

.meas tran vdout0_2ck1500 FIND v(dout0_2) AT=755.025n

.meas tran vdout0_3ck1500 FIND v(dout0_3) AT=755.025n

.meas tran vdout0_4ck1500 FIND v(dout0_4) AT=755.025n

.meas tran vdout0_5ck1500 FIND v(dout0_5) AT=755.025n

.meas tran vdout0_6ck1500 FIND v(dout0_6) AT=755.025n

.meas tran vdout0_7ck1500 FIND v(dout0_7) AT=755.025n

.meas tran vdout0_8ck1500 FIND v(dout0_8) AT=755.025n

.meas tran vdout0_9ck1500 FIND v(dout0_9) AT=755.025n

.meas tran vdout0_10ck1500 FIND v(dout0_10) AT=755.025n

.meas tran vdout0_11ck1500 FIND v(dout0_11) AT=755.025n

.meas tran vdout0_12ck1500 FIND v(dout0_12) AT=755.025n

.meas tran vdout0_13ck1500 FIND v(dout0_13) AT=755.025n

.meas tran vdout0_14ck1500 FIND v(dout0_14) AT=755.025n

.meas tran vdout0_15ck1500 FIND v(dout0_15) AT=755.025n

.meas tran vdout0_16ck1500 FIND v(dout0_16) AT=755.025n

.meas tran vdout0_17ck1500 FIND v(dout0_17) AT=755.025n

.meas tran vdout0_18ck1500 FIND v(dout0_18) AT=755.025n

.meas tran vdout0_19ck1500 FIND v(dout0_19) AT=755.025n

.meas tran vdout0_20ck1500 FIND v(dout0_20) AT=755.025n

.meas tran vdout0_21ck1500 FIND v(dout0_21) AT=755.025n

.meas tran vdout0_22ck1500 FIND v(dout0_22) AT=755.025n

.meas tran vdout0_23ck1500 FIND v(dout0_23) AT=755.025n

.meas tran vdout0_24ck1500 FIND v(dout0_24) AT=755.025n

.meas tran vdout0_25ck1500 FIND v(dout0_25) AT=755.025n

.meas tran vdout0_26ck1500 FIND v(dout0_26) AT=755.025n

.meas tran vdout0_27ck1500 FIND v(dout0_27) AT=755.025n

.meas tran vdout0_28ck1500 FIND v(dout0_28) AT=755.025n

.meas tran vdout0_29ck1500 FIND v(dout0_29) AT=755.025n

.meas tran vdout0_30ck1500 FIND v(dout0_30) AT=755.025n

.meas tran vdout0_31ck1500 FIND v(dout0_31) AT=755.025n

.meas tran vdout0_0ck1520 FIND v(dout0_0) AT=765.025n

.meas tran vdout0_1ck1520 FIND v(dout0_1) AT=765.025n

.meas tran vdout0_2ck1520 FIND v(dout0_2) AT=765.025n

.meas tran vdout0_3ck1520 FIND v(dout0_3) AT=765.025n

.meas tran vdout0_4ck1520 FIND v(dout0_4) AT=765.025n

.meas tran vdout0_5ck1520 FIND v(dout0_5) AT=765.025n

.meas tran vdout0_6ck1520 FIND v(dout0_6) AT=765.025n

.meas tran vdout0_7ck1520 FIND v(dout0_7) AT=765.025n

.meas tran vdout0_8ck1520 FIND v(dout0_8) AT=765.025n

.meas tran vdout0_9ck1520 FIND v(dout0_9) AT=765.025n

.meas tran vdout0_10ck1520 FIND v(dout0_10) AT=765.025n

.meas tran vdout0_11ck1520 FIND v(dout0_11) AT=765.025n

.meas tran vdout0_12ck1520 FIND v(dout0_12) AT=765.025n

.meas tran vdout0_13ck1520 FIND v(dout0_13) AT=765.025n

.meas tran vdout0_14ck1520 FIND v(dout0_14) AT=765.025n

.meas tran vdout0_15ck1520 FIND v(dout0_15) AT=765.025n

.meas tran vdout0_16ck1520 FIND v(dout0_16) AT=765.025n

.meas tran vdout0_17ck1520 FIND v(dout0_17) AT=765.025n

.meas tran vdout0_18ck1520 FIND v(dout0_18) AT=765.025n

.meas tran vdout0_19ck1520 FIND v(dout0_19) AT=765.025n

.meas tran vdout0_20ck1520 FIND v(dout0_20) AT=765.025n

.meas tran vdout0_21ck1520 FIND v(dout0_21) AT=765.025n

.meas tran vdout0_22ck1520 FIND v(dout0_22) AT=765.025n

.meas tran vdout0_23ck1520 FIND v(dout0_23) AT=765.025n

.meas tran vdout0_24ck1520 FIND v(dout0_24) AT=765.025n

.meas tran vdout0_25ck1520 FIND v(dout0_25) AT=765.025n

.meas tran vdout0_26ck1520 FIND v(dout0_26) AT=765.025n

.meas tran vdout0_27ck1520 FIND v(dout0_27) AT=765.025n

.meas tran vdout0_28ck1520 FIND v(dout0_28) AT=765.025n

.meas tran vdout0_29ck1520 FIND v(dout0_29) AT=765.025n

.meas tran vdout0_30ck1520 FIND v(dout0_30) AT=765.025n

.meas tran vdout0_31ck1520 FIND v(dout0_31) AT=765.025n

.meas tran vdout0_0ck1540 FIND v(dout0_0) AT=775.025n

.meas tran vdout0_1ck1540 FIND v(dout0_1) AT=775.025n

.meas tran vdout0_2ck1540 FIND v(dout0_2) AT=775.025n

.meas tran vdout0_3ck1540 FIND v(dout0_3) AT=775.025n

.meas tran vdout0_4ck1540 FIND v(dout0_4) AT=775.025n

.meas tran vdout0_5ck1540 FIND v(dout0_5) AT=775.025n

.meas tran vdout0_6ck1540 FIND v(dout0_6) AT=775.025n

.meas tran vdout0_7ck1540 FIND v(dout0_7) AT=775.025n

.meas tran vdout0_8ck1540 FIND v(dout0_8) AT=775.025n

.meas tran vdout0_9ck1540 FIND v(dout0_9) AT=775.025n

.meas tran vdout0_10ck1540 FIND v(dout0_10) AT=775.025n

.meas tran vdout0_11ck1540 FIND v(dout0_11) AT=775.025n

.meas tran vdout0_12ck1540 FIND v(dout0_12) AT=775.025n

.meas tran vdout0_13ck1540 FIND v(dout0_13) AT=775.025n

.meas tran vdout0_14ck1540 FIND v(dout0_14) AT=775.025n

.meas tran vdout0_15ck1540 FIND v(dout0_15) AT=775.025n

.meas tran vdout0_16ck1540 FIND v(dout0_16) AT=775.025n

.meas tran vdout0_17ck1540 FIND v(dout0_17) AT=775.025n

.meas tran vdout0_18ck1540 FIND v(dout0_18) AT=775.025n

.meas tran vdout0_19ck1540 FIND v(dout0_19) AT=775.025n

.meas tran vdout0_20ck1540 FIND v(dout0_20) AT=775.025n

.meas tran vdout0_21ck1540 FIND v(dout0_21) AT=775.025n

.meas tran vdout0_22ck1540 FIND v(dout0_22) AT=775.025n

.meas tran vdout0_23ck1540 FIND v(dout0_23) AT=775.025n

.meas tran vdout0_24ck1540 FIND v(dout0_24) AT=775.025n

.meas tran vdout0_25ck1540 FIND v(dout0_25) AT=775.025n

.meas tran vdout0_26ck1540 FIND v(dout0_26) AT=775.025n

.meas tran vdout0_27ck1540 FIND v(dout0_27) AT=775.025n

.meas tran vdout0_28ck1540 FIND v(dout0_28) AT=775.025n

.meas tran vdout0_29ck1540 FIND v(dout0_29) AT=775.025n

.meas tran vdout0_30ck1540 FIND v(dout0_30) AT=775.025n

.meas tran vdout0_31ck1540 FIND v(dout0_31) AT=775.025n

.meas tran vdout0_0ck1550 FIND v(dout0_0) AT=780.025n

.meas tran vdout0_1ck1550 FIND v(dout0_1) AT=780.025n

.meas tran vdout0_2ck1550 FIND v(dout0_2) AT=780.025n

.meas tran vdout0_3ck1550 FIND v(dout0_3) AT=780.025n

.meas tran vdout0_4ck1550 FIND v(dout0_4) AT=780.025n

.meas tran vdout0_5ck1550 FIND v(dout0_5) AT=780.025n

.meas tran vdout0_6ck1550 FIND v(dout0_6) AT=780.025n

.meas tran vdout0_7ck1550 FIND v(dout0_7) AT=780.025n

.meas tran vdout0_8ck1550 FIND v(dout0_8) AT=780.025n

.meas tran vdout0_9ck1550 FIND v(dout0_9) AT=780.025n

.meas tran vdout0_10ck1550 FIND v(dout0_10) AT=780.025n

.meas tran vdout0_11ck1550 FIND v(dout0_11) AT=780.025n

.meas tran vdout0_12ck1550 FIND v(dout0_12) AT=780.025n

.meas tran vdout0_13ck1550 FIND v(dout0_13) AT=780.025n

.meas tran vdout0_14ck1550 FIND v(dout0_14) AT=780.025n

.meas tran vdout0_15ck1550 FIND v(dout0_15) AT=780.025n

.meas tran vdout0_16ck1550 FIND v(dout0_16) AT=780.025n

.meas tran vdout0_17ck1550 FIND v(dout0_17) AT=780.025n

.meas tran vdout0_18ck1550 FIND v(dout0_18) AT=780.025n

.meas tran vdout0_19ck1550 FIND v(dout0_19) AT=780.025n

.meas tran vdout0_20ck1550 FIND v(dout0_20) AT=780.025n

.meas tran vdout0_21ck1550 FIND v(dout0_21) AT=780.025n

.meas tran vdout0_22ck1550 FIND v(dout0_22) AT=780.025n

.meas tran vdout0_23ck1550 FIND v(dout0_23) AT=780.025n

.meas tran vdout0_24ck1550 FIND v(dout0_24) AT=780.025n

.meas tran vdout0_25ck1550 FIND v(dout0_25) AT=780.025n

.meas tran vdout0_26ck1550 FIND v(dout0_26) AT=780.025n

.meas tran vdout0_27ck1550 FIND v(dout0_27) AT=780.025n

.meas tran vdout0_28ck1550 FIND v(dout0_28) AT=780.025n

.meas tran vdout0_29ck1550 FIND v(dout0_29) AT=780.025n

.meas tran vdout0_30ck1550 FIND v(dout0_30) AT=780.025n

.meas tran vdout0_31ck1550 FIND v(dout0_31) AT=780.025n

.meas tran vdout0_0ck1580 FIND v(dout0_0) AT=795.025n

.meas tran vdout0_1ck1580 FIND v(dout0_1) AT=795.025n

.meas tran vdout0_2ck1580 FIND v(dout0_2) AT=795.025n

.meas tran vdout0_3ck1580 FIND v(dout0_3) AT=795.025n

.meas tran vdout0_4ck1580 FIND v(dout0_4) AT=795.025n

.meas tran vdout0_5ck1580 FIND v(dout0_5) AT=795.025n

.meas tran vdout0_6ck1580 FIND v(dout0_6) AT=795.025n

.meas tran vdout0_7ck1580 FIND v(dout0_7) AT=795.025n

.meas tran vdout0_8ck1580 FIND v(dout0_8) AT=795.025n

.meas tran vdout0_9ck1580 FIND v(dout0_9) AT=795.025n

.meas tran vdout0_10ck1580 FIND v(dout0_10) AT=795.025n

.meas tran vdout0_11ck1580 FIND v(dout0_11) AT=795.025n

.meas tran vdout0_12ck1580 FIND v(dout0_12) AT=795.025n

.meas tran vdout0_13ck1580 FIND v(dout0_13) AT=795.025n

.meas tran vdout0_14ck1580 FIND v(dout0_14) AT=795.025n

.meas tran vdout0_15ck1580 FIND v(dout0_15) AT=795.025n

.meas tran vdout0_16ck1580 FIND v(dout0_16) AT=795.025n

.meas tran vdout0_17ck1580 FIND v(dout0_17) AT=795.025n

.meas tran vdout0_18ck1580 FIND v(dout0_18) AT=795.025n

.meas tran vdout0_19ck1580 FIND v(dout0_19) AT=795.025n

.meas tran vdout0_20ck1580 FIND v(dout0_20) AT=795.025n

.meas tran vdout0_21ck1580 FIND v(dout0_21) AT=795.025n

.meas tran vdout0_22ck1580 FIND v(dout0_22) AT=795.025n

.meas tran vdout0_23ck1580 FIND v(dout0_23) AT=795.025n

.meas tran vdout0_24ck1580 FIND v(dout0_24) AT=795.025n

.meas tran vdout0_25ck1580 FIND v(dout0_25) AT=795.025n

.meas tran vdout0_26ck1580 FIND v(dout0_26) AT=795.025n

.meas tran vdout0_27ck1580 FIND v(dout0_27) AT=795.025n

.meas tran vdout0_28ck1580 FIND v(dout0_28) AT=795.025n

.meas tran vdout0_29ck1580 FIND v(dout0_29) AT=795.025n

.meas tran vdout0_30ck1580 FIND v(dout0_30) AT=795.025n

.meas tran vdout0_31ck1580 FIND v(dout0_31) AT=795.025n

.meas tran vdout0_0ck1600 FIND v(dout0_0) AT=805.025n

.meas tran vdout0_1ck1600 FIND v(dout0_1) AT=805.025n

.meas tran vdout0_2ck1600 FIND v(dout0_2) AT=805.025n

.meas tran vdout0_3ck1600 FIND v(dout0_3) AT=805.025n

.meas tran vdout0_4ck1600 FIND v(dout0_4) AT=805.025n

.meas tran vdout0_5ck1600 FIND v(dout0_5) AT=805.025n

.meas tran vdout0_6ck1600 FIND v(dout0_6) AT=805.025n

.meas tran vdout0_7ck1600 FIND v(dout0_7) AT=805.025n

.meas tran vdout0_8ck1600 FIND v(dout0_8) AT=805.025n

.meas tran vdout0_9ck1600 FIND v(dout0_9) AT=805.025n

.meas tran vdout0_10ck1600 FIND v(dout0_10) AT=805.025n

.meas tran vdout0_11ck1600 FIND v(dout0_11) AT=805.025n

.meas tran vdout0_12ck1600 FIND v(dout0_12) AT=805.025n

.meas tran vdout0_13ck1600 FIND v(dout0_13) AT=805.025n

.meas tran vdout0_14ck1600 FIND v(dout0_14) AT=805.025n

.meas tran vdout0_15ck1600 FIND v(dout0_15) AT=805.025n

.meas tran vdout0_16ck1600 FIND v(dout0_16) AT=805.025n

.meas tran vdout0_17ck1600 FIND v(dout0_17) AT=805.025n

.meas tran vdout0_18ck1600 FIND v(dout0_18) AT=805.025n

.meas tran vdout0_19ck1600 FIND v(dout0_19) AT=805.025n

.meas tran vdout0_20ck1600 FIND v(dout0_20) AT=805.025n

.meas tran vdout0_21ck1600 FIND v(dout0_21) AT=805.025n

.meas tran vdout0_22ck1600 FIND v(dout0_22) AT=805.025n

.meas tran vdout0_23ck1600 FIND v(dout0_23) AT=805.025n

.meas tran vdout0_24ck1600 FIND v(dout0_24) AT=805.025n

.meas tran vdout0_25ck1600 FIND v(dout0_25) AT=805.025n

.meas tran vdout0_26ck1600 FIND v(dout0_26) AT=805.025n

.meas tran vdout0_27ck1600 FIND v(dout0_27) AT=805.025n

.meas tran vdout0_28ck1600 FIND v(dout0_28) AT=805.025n

.meas tran vdout0_29ck1600 FIND v(dout0_29) AT=805.025n

.meas tran vdout0_30ck1600 FIND v(dout0_30) AT=805.025n

.meas tran vdout0_31ck1600 FIND v(dout0_31) AT=805.025n

.meas tran vdout0_0ck1620 FIND v(dout0_0) AT=815.025n

.meas tran vdout0_1ck1620 FIND v(dout0_1) AT=815.025n

.meas tran vdout0_2ck1620 FIND v(dout0_2) AT=815.025n

.meas tran vdout0_3ck1620 FIND v(dout0_3) AT=815.025n

.meas tran vdout0_4ck1620 FIND v(dout0_4) AT=815.025n

.meas tran vdout0_5ck1620 FIND v(dout0_5) AT=815.025n

.meas tran vdout0_6ck1620 FIND v(dout0_6) AT=815.025n

.meas tran vdout0_7ck1620 FIND v(dout0_7) AT=815.025n

.meas tran vdout0_8ck1620 FIND v(dout0_8) AT=815.025n

.meas tran vdout0_9ck1620 FIND v(dout0_9) AT=815.025n

.meas tran vdout0_10ck1620 FIND v(dout0_10) AT=815.025n

.meas tran vdout0_11ck1620 FIND v(dout0_11) AT=815.025n

.meas tran vdout0_12ck1620 FIND v(dout0_12) AT=815.025n

.meas tran vdout0_13ck1620 FIND v(dout0_13) AT=815.025n

.meas tran vdout0_14ck1620 FIND v(dout0_14) AT=815.025n

.meas tran vdout0_15ck1620 FIND v(dout0_15) AT=815.025n

.meas tran vdout0_16ck1620 FIND v(dout0_16) AT=815.025n

.meas tran vdout0_17ck1620 FIND v(dout0_17) AT=815.025n

.meas tran vdout0_18ck1620 FIND v(dout0_18) AT=815.025n

.meas tran vdout0_19ck1620 FIND v(dout0_19) AT=815.025n

.meas tran vdout0_20ck1620 FIND v(dout0_20) AT=815.025n

.meas tran vdout0_21ck1620 FIND v(dout0_21) AT=815.025n

.meas tran vdout0_22ck1620 FIND v(dout0_22) AT=815.025n

.meas tran vdout0_23ck1620 FIND v(dout0_23) AT=815.025n

.meas tran vdout0_24ck1620 FIND v(dout0_24) AT=815.025n

.meas tran vdout0_25ck1620 FIND v(dout0_25) AT=815.025n

.meas tran vdout0_26ck1620 FIND v(dout0_26) AT=815.025n

.meas tran vdout0_27ck1620 FIND v(dout0_27) AT=815.025n

.meas tran vdout0_28ck1620 FIND v(dout0_28) AT=815.025n

.meas tran vdout0_29ck1620 FIND v(dout0_29) AT=815.025n

.meas tran vdout0_30ck1620 FIND v(dout0_30) AT=815.025n

.meas tran vdout0_31ck1620 FIND v(dout0_31) AT=815.025n

.meas tran vdout0_0ck1640 FIND v(dout0_0) AT=825.025n

.meas tran vdout0_1ck1640 FIND v(dout0_1) AT=825.025n

.meas tran vdout0_2ck1640 FIND v(dout0_2) AT=825.025n

.meas tran vdout0_3ck1640 FIND v(dout0_3) AT=825.025n

.meas tran vdout0_4ck1640 FIND v(dout0_4) AT=825.025n

.meas tran vdout0_5ck1640 FIND v(dout0_5) AT=825.025n

.meas tran vdout0_6ck1640 FIND v(dout0_6) AT=825.025n

.meas tran vdout0_7ck1640 FIND v(dout0_7) AT=825.025n

.meas tran vdout0_8ck1640 FIND v(dout0_8) AT=825.025n

.meas tran vdout0_9ck1640 FIND v(dout0_9) AT=825.025n

.meas tran vdout0_10ck1640 FIND v(dout0_10) AT=825.025n

.meas tran vdout0_11ck1640 FIND v(dout0_11) AT=825.025n

.meas tran vdout0_12ck1640 FIND v(dout0_12) AT=825.025n

.meas tran vdout0_13ck1640 FIND v(dout0_13) AT=825.025n

.meas tran vdout0_14ck1640 FIND v(dout0_14) AT=825.025n

.meas tran vdout0_15ck1640 FIND v(dout0_15) AT=825.025n

.meas tran vdout0_16ck1640 FIND v(dout0_16) AT=825.025n

.meas tran vdout0_17ck1640 FIND v(dout0_17) AT=825.025n

.meas tran vdout0_18ck1640 FIND v(dout0_18) AT=825.025n

.meas tran vdout0_19ck1640 FIND v(dout0_19) AT=825.025n

.meas tran vdout0_20ck1640 FIND v(dout0_20) AT=825.025n

.meas tran vdout0_21ck1640 FIND v(dout0_21) AT=825.025n

.meas tran vdout0_22ck1640 FIND v(dout0_22) AT=825.025n

.meas tran vdout0_23ck1640 FIND v(dout0_23) AT=825.025n

.meas tran vdout0_24ck1640 FIND v(dout0_24) AT=825.025n

.meas tran vdout0_25ck1640 FIND v(dout0_25) AT=825.025n

.meas tran vdout0_26ck1640 FIND v(dout0_26) AT=825.025n

.meas tran vdout0_27ck1640 FIND v(dout0_27) AT=825.025n

.meas tran vdout0_28ck1640 FIND v(dout0_28) AT=825.025n

.meas tran vdout0_29ck1640 FIND v(dout0_29) AT=825.025n

.meas tran vdout0_30ck1640 FIND v(dout0_30) AT=825.025n

.meas tran vdout0_31ck1640 FIND v(dout0_31) AT=825.025n

.meas tran vdout0_0ck1680 FIND v(dout0_0) AT=845.025n

.meas tran vdout0_1ck1680 FIND v(dout0_1) AT=845.025n

.meas tran vdout0_2ck1680 FIND v(dout0_2) AT=845.025n

.meas tran vdout0_3ck1680 FIND v(dout0_3) AT=845.025n

.meas tran vdout0_4ck1680 FIND v(dout0_4) AT=845.025n

.meas tran vdout0_5ck1680 FIND v(dout0_5) AT=845.025n

.meas tran vdout0_6ck1680 FIND v(dout0_6) AT=845.025n

.meas tran vdout0_7ck1680 FIND v(dout0_7) AT=845.025n

.meas tran vdout0_8ck1680 FIND v(dout0_8) AT=845.025n

.meas tran vdout0_9ck1680 FIND v(dout0_9) AT=845.025n

.meas tran vdout0_10ck1680 FIND v(dout0_10) AT=845.025n

.meas tran vdout0_11ck1680 FIND v(dout0_11) AT=845.025n

.meas tran vdout0_12ck1680 FIND v(dout0_12) AT=845.025n

.meas tran vdout0_13ck1680 FIND v(dout0_13) AT=845.025n

.meas tran vdout0_14ck1680 FIND v(dout0_14) AT=845.025n

.meas tran vdout0_15ck1680 FIND v(dout0_15) AT=845.025n

.meas tran vdout0_16ck1680 FIND v(dout0_16) AT=845.025n

.meas tran vdout0_17ck1680 FIND v(dout0_17) AT=845.025n

.meas tran vdout0_18ck1680 FIND v(dout0_18) AT=845.025n

.meas tran vdout0_19ck1680 FIND v(dout0_19) AT=845.025n

.meas tran vdout0_20ck1680 FIND v(dout0_20) AT=845.025n

.meas tran vdout0_21ck1680 FIND v(dout0_21) AT=845.025n

.meas tran vdout0_22ck1680 FIND v(dout0_22) AT=845.025n

.meas tran vdout0_23ck1680 FIND v(dout0_23) AT=845.025n

.meas tran vdout0_24ck1680 FIND v(dout0_24) AT=845.025n

.meas tran vdout0_25ck1680 FIND v(dout0_25) AT=845.025n

.meas tran vdout0_26ck1680 FIND v(dout0_26) AT=845.025n

.meas tran vdout0_27ck1680 FIND v(dout0_27) AT=845.025n

.meas tran vdout0_28ck1680 FIND v(dout0_28) AT=845.025n

.meas tran vdout0_29ck1680 FIND v(dout0_29) AT=845.025n

.meas tran vdout0_30ck1680 FIND v(dout0_30) AT=845.025n

.meas tran vdout0_31ck1680 FIND v(dout0_31) AT=845.025n

.meas tran vdout0_0ck1690 FIND v(dout0_0) AT=850.025n

.meas tran vdout0_1ck1690 FIND v(dout0_1) AT=850.025n

.meas tran vdout0_2ck1690 FIND v(dout0_2) AT=850.025n

.meas tran vdout0_3ck1690 FIND v(dout0_3) AT=850.025n

.meas tran vdout0_4ck1690 FIND v(dout0_4) AT=850.025n

.meas tran vdout0_5ck1690 FIND v(dout0_5) AT=850.025n

.meas tran vdout0_6ck1690 FIND v(dout0_6) AT=850.025n

.meas tran vdout0_7ck1690 FIND v(dout0_7) AT=850.025n

.meas tran vdout0_8ck1690 FIND v(dout0_8) AT=850.025n

.meas tran vdout0_9ck1690 FIND v(dout0_9) AT=850.025n

.meas tran vdout0_10ck1690 FIND v(dout0_10) AT=850.025n

.meas tran vdout0_11ck1690 FIND v(dout0_11) AT=850.025n

.meas tran vdout0_12ck1690 FIND v(dout0_12) AT=850.025n

.meas tran vdout0_13ck1690 FIND v(dout0_13) AT=850.025n

.meas tran vdout0_14ck1690 FIND v(dout0_14) AT=850.025n

.meas tran vdout0_15ck1690 FIND v(dout0_15) AT=850.025n

.meas tran vdout0_16ck1690 FIND v(dout0_16) AT=850.025n

.meas tran vdout0_17ck1690 FIND v(dout0_17) AT=850.025n

.meas tran vdout0_18ck1690 FIND v(dout0_18) AT=850.025n

.meas tran vdout0_19ck1690 FIND v(dout0_19) AT=850.025n

.meas tran vdout0_20ck1690 FIND v(dout0_20) AT=850.025n

.meas tran vdout0_21ck1690 FIND v(dout0_21) AT=850.025n

.meas tran vdout0_22ck1690 FIND v(dout0_22) AT=850.025n

.meas tran vdout0_23ck1690 FIND v(dout0_23) AT=850.025n

.meas tran vdout0_24ck1690 FIND v(dout0_24) AT=850.025n

.meas tran vdout0_25ck1690 FIND v(dout0_25) AT=850.025n

.meas tran vdout0_26ck1690 FIND v(dout0_26) AT=850.025n

.meas tran vdout0_27ck1690 FIND v(dout0_27) AT=850.025n

.meas tran vdout0_28ck1690 FIND v(dout0_28) AT=850.025n

.meas tran vdout0_29ck1690 FIND v(dout0_29) AT=850.025n

.meas tran vdout0_30ck1690 FIND v(dout0_30) AT=850.025n

.meas tran vdout0_31ck1690 FIND v(dout0_31) AT=850.025n

.meas tran vdout0_0ck1710 FIND v(dout0_0) AT=860.025n

.meas tran vdout0_1ck1710 FIND v(dout0_1) AT=860.025n

.meas tran vdout0_2ck1710 FIND v(dout0_2) AT=860.025n

.meas tran vdout0_3ck1710 FIND v(dout0_3) AT=860.025n

.meas tran vdout0_4ck1710 FIND v(dout0_4) AT=860.025n

.meas tran vdout0_5ck1710 FIND v(dout0_5) AT=860.025n

.meas tran vdout0_6ck1710 FIND v(dout0_6) AT=860.025n

.meas tran vdout0_7ck1710 FIND v(dout0_7) AT=860.025n

.meas tran vdout0_8ck1710 FIND v(dout0_8) AT=860.025n

.meas tran vdout0_9ck1710 FIND v(dout0_9) AT=860.025n

.meas tran vdout0_10ck1710 FIND v(dout0_10) AT=860.025n

.meas tran vdout0_11ck1710 FIND v(dout0_11) AT=860.025n

.meas tran vdout0_12ck1710 FIND v(dout0_12) AT=860.025n

.meas tran vdout0_13ck1710 FIND v(dout0_13) AT=860.025n

.meas tran vdout0_14ck1710 FIND v(dout0_14) AT=860.025n

.meas tran vdout0_15ck1710 FIND v(dout0_15) AT=860.025n

.meas tran vdout0_16ck1710 FIND v(dout0_16) AT=860.025n

.meas tran vdout0_17ck1710 FIND v(dout0_17) AT=860.025n

.meas tran vdout0_18ck1710 FIND v(dout0_18) AT=860.025n

.meas tran vdout0_19ck1710 FIND v(dout0_19) AT=860.025n

.meas tran vdout0_20ck1710 FIND v(dout0_20) AT=860.025n

.meas tran vdout0_21ck1710 FIND v(dout0_21) AT=860.025n

.meas tran vdout0_22ck1710 FIND v(dout0_22) AT=860.025n

.meas tran vdout0_23ck1710 FIND v(dout0_23) AT=860.025n

.meas tran vdout0_24ck1710 FIND v(dout0_24) AT=860.025n

.meas tran vdout0_25ck1710 FIND v(dout0_25) AT=860.025n

.meas tran vdout0_26ck1710 FIND v(dout0_26) AT=860.025n

.meas tran vdout0_27ck1710 FIND v(dout0_27) AT=860.025n

.meas tran vdout0_28ck1710 FIND v(dout0_28) AT=860.025n

.meas tran vdout0_29ck1710 FIND v(dout0_29) AT=860.025n

.meas tran vdout0_30ck1710 FIND v(dout0_30) AT=860.025n

.meas tran vdout0_31ck1710 FIND v(dout0_31) AT=860.025n

.meas tran vdout0_0ck1750 FIND v(dout0_0) AT=880.025n

.meas tran vdout0_1ck1750 FIND v(dout0_1) AT=880.025n

.meas tran vdout0_2ck1750 FIND v(dout0_2) AT=880.025n

.meas tran vdout0_3ck1750 FIND v(dout0_3) AT=880.025n

.meas tran vdout0_4ck1750 FIND v(dout0_4) AT=880.025n

.meas tran vdout0_5ck1750 FIND v(dout0_5) AT=880.025n

.meas tran vdout0_6ck1750 FIND v(dout0_6) AT=880.025n

.meas tran vdout0_7ck1750 FIND v(dout0_7) AT=880.025n

.meas tran vdout0_8ck1750 FIND v(dout0_8) AT=880.025n

.meas tran vdout0_9ck1750 FIND v(dout0_9) AT=880.025n

.meas tran vdout0_10ck1750 FIND v(dout0_10) AT=880.025n

.meas tran vdout0_11ck1750 FIND v(dout0_11) AT=880.025n

.meas tran vdout0_12ck1750 FIND v(dout0_12) AT=880.025n

.meas tran vdout0_13ck1750 FIND v(dout0_13) AT=880.025n

.meas tran vdout0_14ck1750 FIND v(dout0_14) AT=880.025n

.meas tran vdout0_15ck1750 FIND v(dout0_15) AT=880.025n

.meas tran vdout0_16ck1750 FIND v(dout0_16) AT=880.025n

.meas tran vdout0_17ck1750 FIND v(dout0_17) AT=880.025n

.meas tran vdout0_18ck1750 FIND v(dout0_18) AT=880.025n

.meas tran vdout0_19ck1750 FIND v(dout0_19) AT=880.025n

.meas tran vdout0_20ck1750 FIND v(dout0_20) AT=880.025n

.meas tran vdout0_21ck1750 FIND v(dout0_21) AT=880.025n

.meas tran vdout0_22ck1750 FIND v(dout0_22) AT=880.025n

.meas tran vdout0_23ck1750 FIND v(dout0_23) AT=880.025n

.meas tran vdout0_24ck1750 FIND v(dout0_24) AT=880.025n

.meas tran vdout0_25ck1750 FIND v(dout0_25) AT=880.025n

.meas tran vdout0_26ck1750 FIND v(dout0_26) AT=880.025n

.meas tran vdout0_27ck1750 FIND v(dout0_27) AT=880.025n

.meas tran vdout0_28ck1750 FIND v(dout0_28) AT=880.025n

.meas tran vdout0_29ck1750 FIND v(dout0_29) AT=880.025n

.meas tran vdout0_30ck1750 FIND v(dout0_30) AT=880.025n

.meas tran vdout0_31ck1750 FIND v(dout0_31) AT=880.025n

.meas tran vdout0_0ck1760 FIND v(dout0_0) AT=885.025n

.meas tran vdout0_1ck1760 FIND v(dout0_1) AT=885.025n

.meas tran vdout0_2ck1760 FIND v(dout0_2) AT=885.025n

.meas tran vdout0_3ck1760 FIND v(dout0_3) AT=885.025n

.meas tran vdout0_4ck1760 FIND v(dout0_4) AT=885.025n

.meas tran vdout0_5ck1760 FIND v(dout0_5) AT=885.025n

.meas tran vdout0_6ck1760 FIND v(dout0_6) AT=885.025n

.meas tran vdout0_7ck1760 FIND v(dout0_7) AT=885.025n

.meas tran vdout0_8ck1760 FIND v(dout0_8) AT=885.025n

.meas tran vdout0_9ck1760 FIND v(dout0_9) AT=885.025n

.meas tran vdout0_10ck1760 FIND v(dout0_10) AT=885.025n

.meas tran vdout0_11ck1760 FIND v(dout0_11) AT=885.025n

.meas tran vdout0_12ck1760 FIND v(dout0_12) AT=885.025n

.meas tran vdout0_13ck1760 FIND v(dout0_13) AT=885.025n

.meas tran vdout0_14ck1760 FIND v(dout0_14) AT=885.025n

.meas tran vdout0_15ck1760 FIND v(dout0_15) AT=885.025n

.meas tran vdout0_16ck1760 FIND v(dout0_16) AT=885.025n

.meas tran vdout0_17ck1760 FIND v(dout0_17) AT=885.025n

.meas tran vdout0_18ck1760 FIND v(dout0_18) AT=885.025n

.meas tran vdout0_19ck1760 FIND v(dout0_19) AT=885.025n

.meas tran vdout0_20ck1760 FIND v(dout0_20) AT=885.025n

.meas tran vdout0_21ck1760 FIND v(dout0_21) AT=885.025n

.meas tran vdout0_22ck1760 FIND v(dout0_22) AT=885.025n

.meas tran vdout0_23ck1760 FIND v(dout0_23) AT=885.025n

.meas tran vdout0_24ck1760 FIND v(dout0_24) AT=885.025n

.meas tran vdout0_25ck1760 FIND v(dout0_25) AT=885.025n

.meas tran vdout0_26ck1760 FIND v(dout0_26) AT=885.025n

.meas tran vdout0_27ck1760 FIND v(dout0_27) AT=885.025n

.meas tran vdout0_28ck1760 FIND v(dout0_28) AT=885.025n

.meas tran vdout0_29ck1760 FIND v(dout0_29) AT=885.025n

.meas tran vdout0_30ck1760 FIND v(dout0_30) AT=885.025n

.meas tran vdout0_31ck1760 FIND v(dout0_31) AT=885.025n

.meas tran vdout0_0ck1770 FIND v(dout0_0) AT=890.025n

.meas tran vdout0_1ck1770 FIND v(dout0_1) AT=890.025n

.meas tran vdout0_2ck1770 FIND v(dout0_2) AT=890.025n

.meas tran vdout0_3ck1770 FIND v(dout0_3) AT=890.025n

.meas tran vdout0_4ck1770 FIND v(dout0_4) AT=890.025n

.meas tran vdout0_5ck1770 FIND v(dout0_5) AT=890.025n

.meas tran vdout0_6ck1770 FIND v(dout0_6) AT=890.025n

.meas tran vdout0_7ck1770 FIND v(dout0_7) AT=890.025n

.meas tran vdout0_8ck1770 FIND v(dout0_8) AT=890.025n

.meas tran vdout0_9ck1770 FIND v(dout0_9) AT=890.025n

.meas tran vdout0_10ck1770 FIND v(dout0_10) AT=890.025n

.meas tran vdout0_11ck1770 FIND v(dout0_11) AT=890.025n

.meas tran vdout0_12ck1770 FIND v(dout0_12) AT=890.025n

.meas tran vdout0_13ck1770 FIND v(dout0_13) AT=890.025n

.meas tran vdout0_14ck1770 FIND v(dout0_14) AT=890.025n

.meas tran vdout0_15ck1770 FIND v(dout0_15) AT=890.025n

.meas tran vdout0_16ck1770 FIND v(dout0_16) AT=890.025n

.meas tran vdout0_17ck1770 FIND v(dout0_17) AT=890.025n

.meas tran vdout0_18ck1770 FIND v(dout0_18) AT=890.025n

.meas tran vdout0_19ck1770 FIND v(dout0_19) AT=890.025n

.meas tran vdout0_20ck1770 FIND v(dout0_20) AT=890.025n

.meas tran vdout0_21ck1770 FIND v(dout0_21) AT=890.025n

.meas tran vdout0_22ck1770 FIND v(dout0_22) AT=890.025n

.meas tran vdout0_23ck1770 FIND v(dout0_23) AT=890.025n

.meas tran vdout0_24ck1770 FIND v(dout0_24) AT=890.025n

.meas tran vdout0_25ck1770 FIND v(dout0_25) AT=890.025n

.meas tran vdout0_26ck1770 FIND v(dout0_26) AT=890.025n

.meas tran vdout0_27ck1770 FIND v(dout0_27) AT=890.025n

.meas tran vdout0_28ck1770 FIND v(dout0_28) AT=890.025n

.meas tran vdout0_29ck1770 FIND v(dout0_29) AT=890.025n

.meas tran vdout0_30ck1770 FIND v(dout0_30) AT=890.025n

.meas tran vdout0_31ck1770 FIND v(dout0_31) AT=890.025n

.meas tran vdout0_0ck1780 FIND v(dout0_0) AT=895.025n

.meas tran vdout0_1ck1780 FIND v(dout0_1) AT=895.025n

.meas tran vdout0_2ck1780 FIND v(dout0_2) AT=895.025n

.meas tran vdout0_3ck1780 FIND v(dout0_3) AT=895.025n

.meas tran vdout0_4ck1780 FIND v(dout0_4) AT=895.025n

.meas tran vdout0_5ck1780 FIND v(dout0_5) AT=895.025n

.meas tran vdout0_6ck1780 FIND v(dout0_6) AT=895.025n

.meas tran vdout0_7ck1780 FIND v(dout0_7) AT=895.025n

.meas tran vdout0_8ck1780 FIND v(dout0_8) AT=895.025n

.meas tran vdout0_9ck1780 FIND v(dout0_9) AT=895.025n

.meas tran vdout0_10ck1780 FIND v(dout0_10) AT=895.025n

.meas tran vdout0_11ck1780 FIND v(dout0_11) AT=895.025n

.meas tran vdout0_12ck1780 FIND v(dout0_12) AT=895.025n

.meas tran vdout0_13ck1780 FIND v(dout0_13) AT=895.025n

.meas tran vdout0_14ck1780 FIND v(dout0_14) AT=895.025n

.meas tran vdout0_15ck1780 FIND v(dout0_15) AT=895.025n

.meas tran vdout0_16ck1780 FIND v(dout0_16) AT=895.025n

.meas tran vdout0_17ck1780 FIND v(dout0_17) AT=895.025n

.meas tran vdout0_18ck1780 FIND v(dout0_18) AT=895.025n

.meas tran vdout0_19ck1780 FIND v(dout0_19) AT=895.025n

.meas tran vdout0_20ck1780 FIND v(dout0_20) AT=895.025n

.meas tran vdout0_21ck1780 FIND v(dout0_21) AT=895.025n

.meas tran vdout0_22ck1780 FIND v(dout0_22) AT=895.025n

.meas tran vdout0_23ck1780 FIND v(dout0_23) AT=895.025n

.meas tran vdout0_24ck1780 FIND v(dout0_24) AT=895.025n

.meas tran vdout0_25ck1780 FIND v(dout0_25) AT=895.025n

.meas tran vdout0_26ck1780 FIND v(dout0_26) AT=895.025n

.meas tran vdout0_27ck1780 FIND v(dout0_27) AT=895.025n

.meas tran vdout0_28ck1780 FIND v(dout0_28) AT=895.025n

.meas tran vdout0_29ck1780 FIND v(dout0_29) AT=895.025n

.meas tran vdout0_30ck1780 FIND v(dout0_30) AT=895.025n

.meas tran vdout0_31ck1780 FIND v(dout0_31) AT=895.025n

.meas tran vdout0_0ck1790 FIND v(dout0_0) AT=900.025n

.meas tran vdout0_1ck1790 FIND v(dout0_1) AT=900.025n

.meas tran vdout0_2ck1790 FIND v(dout0_2) AT=900.025n

.meas tran vdout0_3ck1790 FIND v(dout0_3) AT=900.025n

.meas tran vdout0_4ck1790 FIND v(dout0_4) AT=900.025n

.meas tran vdout0_5ck1790 FIND v(dout0_5) AT=900.025n

.meas tran vdout0_6ck1790 FIND v(dout0_6) AT=900.025n

.meas tran vdout0_7ck1790 FIND v(dout0_7) AT=900.025n

.meas tran vdout0_8ck1790 FIND v(dout0_8) AT=900.025n

.meas tran vdout0_9ck1790 FIND v(dout0_9) AT=900.025n

.meas tran vdout0_10ck1790 FIND v(dout0_10) AT=900.025n

.meas tran vdout0_11ck1790 FIND v(dout0_11) AT=900.025n

.meas tran vdout0_12ck1790 FIND v(dout0_12) AT=900.025n

.meas tran vdout0_13ck1790 FIND v(dout0_13) AT=900.025n

.meas tran vdout0_14ck1790 FIND v(dout0_14) AT=900.025n

.meas tran vdout0_15ck1790 FIND v(dout0_15) AT=900.025n

.meas tran vdout0_16ck1790 FIND v(dout0_16) AT=900.025n

.meas tran vdout0_17ck1790 FIND v(dout0_17) AT=900.025n

.meas tran vdout0_18ck1790 FIND v(dout0_18) AT=900.025n

.meas tran vdout0_19ck1790 FIND v(dout0_19) AT=900.025n

.meas tran vdout0_20ck1790 FIND v(dout0_20) AT=900.025n

.meas tran vdout0_21ck1790 FIND v(dout0_21) AT=900.025n

.meas tran vdout0_22ck1790 FIND v(dout0_22) AT=900.025n

.meas tran vdout0_23ck1790 FIND v(dout0_23) AT=900.025n

.meas tran vdout0_24ck1790 FIND v(dout0_24) AT=900.025n

.meas tran vdout0_25ck1790 FIND v(dout0_25) AT=900.025n

.meas tran vdout0_26ck1790 FIND v(dout0_26) AT=900.025n

.meas tran vdout0_27ck1790 FIND v(dout0_27) AT=900.025n

.meas tran vdout0_28ck1790 FIND v(dout0_28) AT=900.025n

.meas tran vdout0_29ck1790 FIND v(dout0_29) AT=900.025n

.meas tran vdout0_30ck1790 FIND v(dout0_30) AT=900.025n

.meas tran vdout0_31ck1790 FIND v(dout0_31) AT=900.025n

.meas tran vdout0_0ck1800 FIND v(dout0_0) AT=905.025n

.meas tran vdout0_1ck1800 FIND v(dout0_1) AT=905.025n

.meas tran vdout0_2ck1800 FIND v(dout0_2) AT=905.025n

.meas tran vdout0_3ck1800 FIND v(dout0_3) AT=905.025n

.meas tran vdout0_4ck1800 FIND v(dout0_4) AT=905.025n

.meas tran vdout0_5ck1800 FIND v(dout0_5) AT=905.025n

.meas tran vdout0_6ck1800 FIND v(dout0_6) AT=905.025n

.meas tran vdout0_7ck1800 FIND v(dout0_7) AT=905.025n

.meas tran vdout0_8ck1800 FIND v(dout0_8) AT=905.025n

.meas tran vdout0_9ck1800 FIND v(dout0_9) AT=905.025n

.meas tran vdout0_10ck1800 FIND v(dout0_10) AT=905.025n

.meas tran vdout0_11ck1800 FIND v(dout0_11) AT=905.025n

.meas tran vdout0_12ck1800 FIND v(dout0_12) AT=905.025n

.meas tran vdout0_13ck1800 FIND v(dout0_13) AT=905.025n

.meas tran vdout0_14ck1800 FIND v(dout0_14) AT=905.025n

.meas tran vdout0_15ck1800 FIND v(dout0_15) AT=905.025n

.meas tran vdout0_16ck1800 FIND v(dout0_16) AT=905.025n

.meas tran vdout0_17ck1800 FIND v(dout0_17) AT=905.025n

.meas tran vdout0_18ck1800 FIND v(dout0_18) AT=905.025n

.meas tran vdout0_19ck1800 FIND v(dout0_19) AT=905.025n

.meas tran vdout0_20ck1800 FIND v(dout0_20) AT=905.025n

.meas tran vdout0_21ck1800 FIND v(dout0_21) AT=905.025n

.meas tran vdout0_22ck1800 FIND v(dout0_22) AT=905.025n

.meas tran vdout0_23ck1800 FIND v(dout0_23) AT=905.025n

.meas tran vdout0_24ck1800 FIND v(dout0_24) AT=905.025n

.meas tran vdout0_25ck1800 FIND v(dout0_25) AT=905.025n

.meas tran vdout0_26ck1800 FIND v(dout0_26) AT=905.025n

.meas tran vdout0_27ck1800 FIND v(dout0_27) AT=905.025n

.meas tran vdout0_28ck1800 FIND v(dout0_28) AT=905.025n

.meas tran vdout0_29ck1800 FIND v(dout0_29) AT=905.025n

.meas tran vdout0_30ck1800 FIND v(dout0_30) AT=905.025n

.meas tran vdout0_31ck1800 FIND v(dout0_31) AT=905.025n

.meas tran vdout0_0ck1830 FIND v(dout0_0) AT=920.025n

.meas tran vdout0_1ck1830 FIND v(dout0_1) AT=920.025n

.meas tran vdout0_2ck1830 FIND v(dout0_2) AT=920.025n

.meas tran vdout0_3ck1830 FIND v(dout0_3) AT=920.025n

.meas tran vdout0_4ck1830 FIND v(dout0_4) AT=920.025n

.meas tran vdout0_5ck1830 FIND v(dout0_5) AT=920.025n

.meas tran vdout0_6ck1830 FIND v(dout0_6) AT=920.025n

.meas tran vdout0_7ck1830 FIND v(dout0_7) AT=920.025n

.meas tran vdout0_8ck1830 FIND v(dout0_8) AT=920.025n

.meas tran vdout0_9ck1830 FIND v(dout0_9) AT=920.025n

.meas tran vdout0_10ck1830 FIND v(dout0_10) AT=920.025n

.meas tran vdout0_11ck1830 FIND v(dout0_11) AT=920.025n

.meas tran vdout0_12ck1830 FIND v(dout0_12) AT=920.025n

.meas tran vdout0_13ck1830 FIND v(dout0_13) AT=920.025n

.meas tran vdout0_14ck1830 FIND v(dout0_14) AT=920.025n

.meas tran vdout0_15ck1830 FIND v(dout0_15) AT=920.025n

.meas tran vdout0_16ck1830 FIND v(dout0_16) AT=920.025n

.meas tran vdout0_17ck1830 FIND v(dout0_17) AT=920.025n

.meas tran vdout0_18ck1830 FIND v(dout0_18) AT=920.025n

.meas tran vdout0_19ck1830 FIND v(dout0_19) AT=920.025n

.meas tran vdout0_20ck1830 FIND v(dout0_20) AT=920.025n

.meas tran vdout0_21ck1830 FIND v(dout0_21) AT=920.025n

.meas tran vdout0_22ck1830 FIND v(dout0_22) AT=920.025n

.meas tran vdout0_23ck1830 FIND v(dout0_23) AT=920.025n

.meas tran vdout0_24ck1830 FIND v(dout0_24) AT=920.025n

.meas tran vdout0_25ck1830 FIND v(dout0_25) AT=920.025n

.meas tran vdout0_26ck1830 FIND v(dout0_26) AT=920.025n

.meas tran vdout0_27ck1830 FIND v(dout0_27) AT=920.025n

.meas tran vdout0_28ck1830 FIND v(dout0_28) AT=920.025n

.meas tran vdout0_29ck1830 FIND v(dout0_29) AT=920.025n

.meas tran vdout0_30ck1830 FIND v(dout0_30) AT=920.025n

.meas tran vdout0_31ck1830 FIND v(dout0_31) AT=920.025n

.meas tran vdout0_0ck1920 FIND v(dout0_0) AT=965.025n

.meas tran vdout0_1ck1920 FIND v(dout0_1) AT=965.025n

.meas tran vdout0_2ck1920 FIND v(dout0_2) AT=965.025n

.meas tran vdout0_3ck1920 FIND v(dout0_3) AT=965.025n

.meas tran vdout0_4ck1920 FIND v(dout0_4) AT=965.025n

.meas tran vdout0_5ck1920 FIND v(dout0_5) AT=965.025n

.meas tran vdout0_6ck1920 FIND v(dout0_6) AT=965.025n

.meas tran vdout0_7ck1920 FIND v(dout0_7) AT=965.025n

.meas tran vdout0_8ck1920 FIND v(dout0_8) AT=965.025n

.meas tran vdout0_9ck1920 FIND v(dout0_9) AT=965.025n

.meas tran vdout0_10ck1920 FIND v(dout0_10) AT=965.025n

.meas tran vdout0_11ck1920 FIND v(dout0_11) AT=965.025n

.meas tran vdout0_12ck1920 FIND v(dout0_12) AT=965.025n

.meas tran vdout0_13ck1920 FIND v(dout0_13) AT=965.025n

.meas tran vdout0_14ck1920 FIND v(dout0_14) AT=965.025n

.meas tran vdout0_15ck1920 FIND v(dout0_15) AT=965.025n

.meas tran vdout0_16ck1920 FIND v(dout0_16) AT=965.025n

.meas tran vdout0_17ck1920 FIND v(dout0_17) AT=965.025n

.meas tran vdout0_18ck1920 FIND v(dout0_18) AT=965.025n

.meas tran vdout0_19ck1920 FIND v(dout0_19) AT=965.025n

.meas tran vdout0_20ck1920 FIND v(dout0_20) AT=965.025n

.meas tran vdout0_21ck1920 FIND v(dout0_21) AT=965.025n

.meas tran vdout0_22ck1920 FIND v(dout0_22) AT=965.025n

.meas tran vdout0_23ck1920 FIND v(dout0_23) AT=965.025n

.meas tran vdout0_24ck1920 FIND v(dout0_24) AT=965.025n

.meas tran vdout0_25ck1920 FIND v(dout0_25) AT=965.025n

.meas tran vdout0_26ck1920 FIND v(dout0_26) AT=965.025n

.meas tran vdout0_27ck1920 FIND v(dout0_27) AT=965.025n

.meas tran vdout0_28ck1920 FIND v(dout0_28) AT=965.025n

.meas tran vdout0_29ck1920 FIND v(dout0_29) AT=965.025n

.meas tran vdout0_30ck1920 FIND v(dout0_30) AT=965.025n

.meas tran vdout0_31ck1920 FIND v(dout0_31) AT=965.025n

.meas tran vdout0_0ck1930 FIND v(dout0_0) AT=970.025n

.meas tran vdout0_1ck1930 FIND v(dout0_1) AT=970.025n

.meas tran vdout0_2ck1930 FIND v(dout0_2) AT=970.025n

.meas tran vdout0_3ck1930 FIND v(dout0_3) AT=970.025n

.meas tran vdout0_4ck1930 FIND v(dout0_4) AT=970.025n

.meas tran vdout0_5ck1930 FIND v(dout0_5) AT=970.025n

.meas tran vdout0_6ck1930 FIND v(dout0_6) AT=970.025n

.meas tran vdout0_7ck1930 FIND v(dout0_7) AT=970.025n

.meas tran vdout0_8ck1930 FIND v(dout0_8) AT=970.025n

.meas tran vdout0_9ck1930 FIND v(dout0_9) AT=970.025n

.meas tran vdout0_10ck1930 FIND v(dout0_10) AT=970.025n

.meas tran vdout0_11ck1930 FIND v(dout0_11) AT=970.025n

.meas tran vdout0_12ck1930 FIND v(dout0_12) AT=970.025n

.meas tran vdout0_13ck1930 FIND v(dout0_13) AT=970.025n

.meas tran vdout0_14ck1930 FIND v(dout0_14) AT=970.025n

.meas tran vdout0_15ck1930 FIND v(dout0_15) AT=970.025n

.meas tran vdout0_16ck1930 FIND v(dout0_16) AT=970.025n

.meas tran vdout0_17ck1930 FIND v(dout0_17) AT=970.025n

.meas tran vdout0_18ck1930 FIND v(dout0_18) AT=970.025n

.meas tran vdout0_19ck1930 FIND v(dout0_19) AT=970.025n

.meas tran vdout0_20ck1930 FIND v(dout0_20) AT=970.025n

.meas tran vdout0_21ck1930 FIND v(dout0_21) AT=970.025n

.meas tran vdout0_22ck1930 FIND v(dout0_22) AT=970.025n

.meas tran vdout0_23ck1930 FIND v(dout0_23) AT=970.025n

.meas tran vdout0_24ck1930 FIND v(dout0_24) AT=970.025n

.meas tran vdout0_25ck1930 FIND v(dout0_25) AT=970.025n

.meas tran vdout0_26ck1930 FIND v(dout0_26) AT=970.025n

.meas tran vdout0_27ck1930 FIND v(dout0_27) AT=970.025n

.meas tran vdout0_28ck1930 FIND v(dout0_28) AT=970.025n

.meas tran vdout0_29ck1930 FIND v(dout0_29) AT=970.025n

.meas tran vdout0_30ck1930 FIND v(dout0_30) AT=970.025n

.meas tran vdout0_31ck1930 FIND v(dout0_31) AT=970.025n

.meas tran vdout0_0ck1940 FIND v(dout0_0) AT=975.025n

.meas tran vdout0_1ck1940 FIND v(dout0_1) AT=975.025n

.meas tran vdout0_2ck1940 FIND v(dout0_2) AT=975.025n

.meas tran vdout0_3ck1940 FIND v(dout0_3) AT=975.025n

.meas tran vdout0_4ck1940 FIND v(dout0_4) AT=975.025n

.meas tran vdout0_5ck1940 FIND v(dout0_5) AT=975.025n

.meas tran vdout0_6ck1940 FIND v(dout0_6) AT=975.025n

.meas tran vdout0_7ck1940 FIND v(dout0_7) AT=975.025n

.meas tran vdout0_8ck1940 FIND v(dout0_8) AT=975.025n

.meas tran vdout0_9ck1940 FIND v(dout0_9) AT=975.025n

.meas tran vdout0_10ck1940 FIND v(dout0_10) AT=975.025n

.meas tran vdout0_11ck1940 FIND v(dout0_11) AT=975.025n

.meas tran vdout0_12ck1940 FIND v(dout0_12) AT=975.025n

.meas tran vdout0_13ck1940 FIND v(dout0_13) AT=975.025n

.meas tran vdout0_14ck1940 FIND v(dout0_14) AT=975.025n

.meas tran vdout0_15ck1940 FIND v(dout0_15) AT=975.025n

.meas tran vdout0_16ck1940 FIND v(dout0_16) AT=975.025n

.meas tran vdout0_17ck1940 FIND v(dout0_17) AT=975.025n

.meas tran vdout0_18ck1940 FIND v(dout0_18) AT=975.025n

.meas tran vdout0_19ck1940 FIND v(dout0_19) AT=975.025n

.meas tran vdout0_20ck1940 FIND v(dout0_20) AT=975.025n

.meas tran vdout0_21ck1940 FIND v(dout0_21) AT=975.025n

.meas tran vdout0_22ck1940 FIND v(dout0_22) AT=975.025n

.meas tran vdout0_23ck1940 FIND v(dout0_23) AT=975.025n

.meas tran vdout0_24ck1940 FIND v(dout0_24) AT=975.025n

.meas tran vdout0_25ck1940 FIND v(dout0_25) AT=975.025n

.meas tran vdout0_26ck1940 FIND v(dout0_26) AT=975.025n

.meas tran vdout0_27ck1940 FIND v(dout0_27) AT=975.025n

.meas tran vdout0_28ck1940 FIND v(dout0_28) AT=975.025n

.meas tran vdout0_29ck1940 FIND v(dout0_29) AT=975.025n

.meas tran vdout0_30ck1940 FIND v(dout0_30) AT=975.025n

.meas tran vdout0_31ck1940 FIND v(dout0_31) AT=975.025n

.meas tran vdout0_0ck1960 FIND v(dout0_0) AT=985.025n

.meas tran vdout0_1ck1960 FIND v(dout0_1) AT=985.025n

.meas tran vdout0_2ck1960 FIND v(dout0_2) AT=985.025n

.meas tran vdout0_3ck1960 FIND v(dout0_3) AT=985.025n

.meas tran vdout0_4ck1960 FIND v(dout0_4) AT=985.025n

.meas tran vdout0_5ck1960 FIND v(dout0_5) AT=985.025n

.meas tran vdout0_6ck1960 FIND v(dout0_6) AT=985.025n

.meas tran vdout0_7ck1960 FIND v(dout0_7) AT=985.025n

.meas tran vdout0_8ck1960 FIND v(dout0_8) AT=985.025n

.meas tran vdout0_9ck1960 FIND v(dout0_9) AT=985.025n

.meas tran vdout0_10ck1960 FIND v(dout0_10) AT=985.025n

.meas tran vdout0_11ck1960 FIND v(dout0_11) AT=985.025n

.meas tran vdout0_12ck1960 FIND v(dout0_12) AT=985.025n

.meas tran vdout0_13ck1960 FIND v(dout0_13) AT=985.025n

.meas tran vdout0_14ck1960 FIND v(dout0_14) AT=985.025n

.meas tran vdout0_15ck1960 FIND v(dout0_15) AT=985.025n

.meas tran vdout0_16ck1960 FIND v(dout0_16) AT=985.025n

.meas tran vdout0_17ck1960 FIND v(dout0_17) AT=985.025n

.meas tran vdout0_18ck1960 FIND v(dout0_18) AT=985.025n

.meas tran vdout0_19ck1960 FIND v(dout0_19) AT=985.025n

.meas tran vdout0_20ck1960 FIND v(dout0_20) AT=985.025n

.meas tran vdout0_21ck1960 FIND v(dout0_21) AT=985.025n

.meas tran vdout0_22ck1960 FIND v(dout0_22) AT=985.025n

.meas tran vdout0_23ck1960 FIND v(dout0_23) AT=985.025n

.meas tran vdout0_24ck1960 FIND v(dout0_24) AT=985.025n

.meas tran vdout0_25ck1960 FIND v(dout0_25) AT=985.025n

.meas tran vdout0_26ck1960 FIND v(dout0_26) AT=985.025n

.meas tran vdout0_27ck1960 FIND v(dout0_27) AT=985.025n

.meas tran vdout0_28ck1960 FIND v(dout0_28) AT=985.025n

.meas tran vdout0_29ck1960 FIND v(dout0_29) AT=985.025n

.meas tran vdout0_30ck1960 FIND v(dout0_30) AT=985.025n

.meas tran vdout0_31ck1960 FIND v(dout0_31) AT=985.025n

.meas tran vdout0_0ck1990 FIND v(dout0_0) AT=1000.025n

.meas tran vdout0_1ck1990 FIND v(dout0_1) AT=1000.025n

.meas tran vdout0_2ck1990 FIND v(dout0_2) AT=1000.025n

.meas tran vdout0_3ck1990 FIND v(dout0_3) AT=1000.025n

.meas tran vdout0_4ck1990 FIND v(dout0_4) AT=1000.025n

.meas tran vdout0_5ck1990 FIND v(dout0_5) AT=1000.025n

.meas tran vdout0_6ck1990 FIND v(dout0_6) AT=1000.025n

.meas tran vdout0_7ck1990 FIND v(dout0_7) AT=1000.025n

.meas tran vdout0_8ck1990 FIND v(dout0_8) AT=1000.025n

.meas tran vdout0_9ck1990 FIND v(dout0_9) AT=1000.025n

.meas tran vdout0_10ck1990 FIND v(dout0_10) AT=1000.025n

.meas tran vdout0_11ck1990 FIND v(dout0_11) AT=1000.025n

.meas tran vdout0_12ck1990 FIND v(dout0_12) AT=1000.025n

.meas tran vdout0_13ck1990 FIND v(dout0_13) AT=1000.025n

.meas tran vdout0_14ck1990 FIND v(dout0_14) AT=1000.025n

.meas tran vdout0_15ck1990 FIND v(dout0_15) AT=1000.025n

.meas tran vdout0_16ck1990 FIND v(dout0_16) AT=1000.025n

.meas tran vdout0_17ck1990 FIND v(dout0_17) AT=1000.025n

.meas tran vdout0_18ck1990 FIND v(dout0_18) AT=1000.025n

.meas tran vdout0_19ck1990 FIND v(dout0_19) AT=1000.025n

.meas tran vdout0_20ck1990 FIND v(dout0_20) AT=1000.025n

.meas tran vdout0_21ck1990 FIND v(dout0_21) AT=1000.025n

.meas tran vdout0_22ck1990 FIND v(dout0_22) AT=1000.025n

.meas tran vdout0_23ck1990 FIND v(dout0_23) AT=1000.025n

.meas tran vdout0_24ck1990 FIND v(dout0_24) AT=1000.025n

.meas tran vdout0_25ck1990 FIND v(dout0_25) AT=1000.025n

.meas tran vdout0_26ck1990 FIND v(dout0_26) AT=1000.025n

.meas tran vdout0_27ck1990 FIND v(dout0_27) AT=1000.025n

.meas tran vdout0_28ck1990 FIND v(dout0_28) AT=1000.025n

.meas tran vdout0_29ck1990 FIND v(dout0_29) AT=1000.025n

.meas tran vdout0_30ck1990 FIND v(dout0_30) AT=1000.025n

.meas tran vdout0_31ck1990 FIND v(dout0_31) AT=1000.025n

.meas tran vdout0_0ck2010 FIND v(dout0_0) AT=1010.025n

.meas tran vdout0_1ck2010 FIND v(dout0_1) AT=1010.025n

.meas tran vdout0_2ck2010 FIND v(dout0_2) AT=1010.025n

.meas tran vdout0_3ck2010 FIND v(dout0_3) AT=1010.025n

.meas tran vdout0_4ck2010 FIND v(dout0_4) AT=1010.025n

.meas tran vdout0_5ck2010 FIND v(dout0_5) AT=1010.025n

.meas tran vdout0_6ck2010 FIND v(dout0_6) AT=1010.025n

.meas tran vdout0_7ck2010 FIND v(dout0_7) AT=1010.025n

.meas tran vdout0_8ck2010 FIND v(dout0_8) AT=1010.025n

.meas tran vdout0_9ck2010 FIND v(dout0_9) AT=1010.025n

.meas tran vdout0_10ck2010 FIND v(dout0_10) AT=1010.025n

.meas tran vdout0_11ck2010 FIND v(dout0_11) AT=1010.025n

.meas tran vdout0_12ck2010 FIND v(dout0_12) AT=1010.025n

.meas tran vdout0_13ck2010 FIND v(dout0_13) AT=1010.025n

.meas tran vdout0_14ck2010 FIND v(dout0_14) AT=1010.025n

.meas tran vdout0_15ck2010 FIND v(dout0_15) AT=1010.025n

.meas tran vdout0_16ck2010 FIND v(dout0_16) AT=1010.025n

.meas tran vdout0_17ck2010 FIND v(dout0_17) AT=1010.025n

.meas tran vdout0_18ck2010 FIND v(dout0_18) AT=1010.025n

.meas tran vdout0_19ck2010 FIND v(dout0_19) AT=1010.025n

.meas tran vdout0_20ck2010 FIND v(dout0_20) AT=1010.025n

.meas tran vdout0_21ck2010 FIND v(dout0_21) AT=1010.025n

.meas tran vdout0_22ck2010 FIND v(dout0_22) AT=1010.025n

.meas tran vdout0_23ck2010 FIND v(dout0_23) AT=1010.025n

.meas tran vdout0_24ck2010 FIND v(dout0_24) AT=1010.025n

.meas tran vdout0_25ck2010 FIND v(dout0_25) AT=1010.025n

.meas tran vdout0_26ck2010 FIND v(dout0_26) AT=1010.025n

.meas tran vdout0_27ck2010 FIND v(dout0_27) AT=1010.025n

.meas tran vdout0_28ck2010 FIND v(dout0_28) AT=1010.025n

.meas tran vdout0_29ck2010 FIND v(dout0_29) AT=1010.025n

.meas tran vdout0_30ck2010 FIND v(dout0_30) AT=1010.025n

.meas tran vdout0_31ck2010 FIND v(dout0_31) AT=1010.025n

.meas tran vdout0_0ck2030 FIND v(dout0_0) AT=1020.025n

.meas tran vdout0_1ck2030 FIND v(dout0_1) AT=1020.025n

.meas tran vdout0_2ck2030 FIND v(dout0_2) AT=1020.025n

.meas tran vdout0_3ck2030 FIND v(dout0_3) AT=1020.025n

.meas tran vdout0_4ck2030 FIND v(dout0_4) AT=1020.025n

.meas tran vdout0_5ck2030 FIND v(dout0_5) AT=1020.025n

.meas tran vdout0_6ck2030 FIND v(dout0_6) AT=1020.025n

.meas tran vdout0_7ck2030 FIND v(dout0_7) AT=1020.025n

.meas tran vdout0_8ck2030 FIND v(dout0_8) AT=1020.025n

.meas tran vdout0_9ck2030 FIND v(dout0_9) AT=1020.025n

.meas tran vdout0_10ck2030 FIND v(dout0_10) AT=1020.025n

.meas tran vdout0_11ck2030 FIND v(dout0_11) AT=1020.025n

.meas tran vdout0_12ck2030 FIND v(dout0_12) AT=1020.025n

.meas tran vdout0_13ck2030 FIND v(dout0_13) AT=1020.025n

.meas tran vdout0_14ck2030 FIND v(dout0_14) AT=1020.025n

.meas tran vdout0_15ck2030 FIND v(dout0_15) AT=1020.025n

.meas tran vdout0_16ck2030 FIND v(dout0_16) AT=1020.025n

.meas tran vdout0_17ck2030 FIND v(dout0_17) AT=1020.025n

.meas tran vdout0_18ck2030 FIND v(dout0_18) AT=1020.025n

.meas tran vdout0_19ck2030 FIND v(dout0_19) AT=1020.025n

.meas tran vdout0_20ck2030 FIND v(dout0_20) AT=1020.025n

.meas tran vdout0_21ck2030 FIND v(dout0_21) AT=1020.025n

.meas tran vdout0_22ck2030 FIND v(dout0_22) AT=1020.025n

.meas tran vdout0_23ck2030 FIND v(dout0_23) AT=1020.025n

.meas tran vdout0_24ck2030 FIND v(dout0_24) AT=1020.025n

.meas tran vdout0_25ck2030 FIND v(dout0_25) AT=1020.025n

.meas tran vdout0_26ck2030 FIND v(dout0_26) AT=1020.025n

.meas tran vdout0_27ck2030 FIND v(dout0_27) AT=1020.025n

.meas tran vdout0_28ck2030 FIND v(dout0_28) AT=1020.025n

.meas tran vdout0_29ck2030 FIND v(dout0_29) AT=1020.025n

.meas tran vdout0_30ck2030 FIND v(dout0_30) AT=1020.025n

.meas tran vdout0_31ck2030 FIND v(dout0_31) AT=1020.025n

.meas tran vdout0_0ck2040 FIND v(dout0_0) AT=1025.025n

.meas tran vdout0_1ck2040 FIND v(dout0_1) AT=1025.025n

.meas tran vdout0_2ck2040 FIND v(dout0_2) AT=1025.025n

.meas tran vdout0_3ck2040 FIND v(dout0_3) AT=1025.025n

.meas tran vdout0_4ck2040 FIND v(dout0_4) AT=1025.025n

.meas tran vdout0_5ck2040 FIND v(dout0_5) AT=1025.025n

.meas tran vdout0_6ck2040 FIND v(dout0_6) AT=1025.025n

.meas tran vdout0_7ck2040 FIND v(dout0_7) AT=1025.025n

.meas tran vdout0_8ck2040 FIND v(dout0_8) AT=1025.025n

.meas tran vdout0_9ck2040 FIND v(dout0_9) AT=1025.025n

.meas tran vdout0_10ck2040 FIND v(dout0_10) AT=1025.025n

.meas tran vdout0_11ck2040 FIND v(dout0_11) AT=1025.025n

.meas tran vdout0_12ck2040 FIND v(dout0_12) AT=1025.025n

.meas tran vdout0_13ck2040 FIND v(dout0_13) AT=1025.025n

.meas tran vdout0_14ck2040 FIND v(dout0_14) AT=1025.025n

.meas tran vdout0_15ck2040 FIND v(dout0_15) AT=1025.025n

.meas tran vdout0_16ck2040 FIND v(dout0_16) AT=1025.025n

.meas tran vdout0_17ck2040 FIND v(dout0_17) AT=1025.025n

.meas tran vdout0_18ck2040 FIND v(dout0_18) AT=1025.025n

.meas tran vdout0_19ck2040 FIND v(dout0_19) AT=1025.025n

.meas tran vdout0_20ck2040 FIND v(dout0_20) AT=1025.025n

.meas tran vdout0_21ck2040 FIND v(dout0_21) AT=1025.025n

.meas tran vdout0_22ck2040 FIND v(dout0_22) AT=1025.025n

.meas tran vdout0_23ck2040 FIND v(dout0_23) AT=1025.025n

.meas tran vdout0_24ck2040 FIND v(dout0_24) AT=1025.025n

.meas tran vdout0_25ck2040 FIND v(dout0_25) AT=1025.025n

.meas tran vdout0_26ck2040 FIND v(dout0_26) AT=1025.025n

.meas tran vdout0_27ck2040 FIND v(dout0_27) AT=1025.025n

.meas tran vdout0_28ck2040 FIND v(dout0_28) AT=1025.025n

.meas tran vdout0_29ck2040 FIND v(dout0_29) AT=1025.025n

.meas tran vdout0_30ck2040 FIND v(dout0_30) AT=1025.025n

.meas tran vdout0_31ck2040 FIND v(dout0_31) AT=1025.025n
