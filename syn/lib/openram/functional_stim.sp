* Functional test stimulus file for 5ns period

* TT process corner
.include "/home/kuoping/opt/OpenRAM/technology/freepdk45/models/tran_models/models_nom/PMOS_VTG.inc"
.include "/home/kuoping/opt/OpenRAM/technology/freepdk45/models/tran_models/models_nom/NMOS_VTG.inc"
.include "/tmp/openram_kuoping_219438_temp/sram.sp"

* Global Power Supplies
Vvdd vdd 0 1.1

*Nodes gnd and 0 are the same global ground node in ngspice/hspice/xa. Otherwise, this source may be needed.
*Vgnd gnd 0 0.0

* Instantiation of the SRAM
Xsram_1rw_1024x64 din0_0 din0_1 din0_2 din0_3 din0_4 din0_5 din0_6 din0_7 din0_8 din0_9 din0_10 din0_11 din0_12 din0_13 din0_14 din0_15 din0_16 din0_17 din0_18 din0_19 din0_20 din0_21 din0_22 din0_23 din0_24 din0_25 din0_26 din0_27 din0_28 din0_29 din0_30 din0_31 din0_32 din0_33 din0_34 din0_35 din0_36 din0_37 din0_38 din0_39 din0_40 din0_41 din0_42 din0_43 din0_44 din0_45 din0_46 din0_47 din0_48 din0_49 din0_50 din0_51 din0_52 din0_53 din0_54 din0_55 din0_56 din0_57 din0_58 din0_59 din0_60 din0_61 din0_62 din0_63 a0_0 a0_1 a0_2 a0_3 a0_4 a0_5 a0_6 a0_7 a0_8 a0_9 CSB0 WEB0 clk0 WMASK0_0 WMASK0_1 WMASK0_2 WMASK0_3 WMASK0_4 WMASK0_5 WMASK0_6 WMASK0_7 dout0_0 dout0_1 dout0_2 dout0_3 dout0_4 dout0_5 dout0_6 dout0_7 dout0_8 dout0_9 dout0_10 dout0_11 dout0_12 dout0_13 dout0_14 dout0_15 dout0_16 dout0_17 dout0_18 dout0_19 dout0_20 dout0_21 dout0_22 dout0_23 dout0_24 dout0_25 dout0_26 dout0_27 dout0_28 dout0_29 dout0_30 dout0_31 dout0_32 dout0_33 dout0_34 dout0_35 dout0_36 dout0_37 dout0_38 dout0_39 dout0_40 dout0_41 dout0_42 dout0_43 dout0_44 dout0_45 dout0_46 dout0_47 dout0_48 dout0_49 dout0_50 dout0_51 dout0_52 dout0_53 dout0_54 dout0_55 dout0_56 dout0_57 dout0_58 dout0_59 dout0_60 dout0_61 dout0_62 dout0_63 vdd gnd sram_1rw_1024x64

* SRAM output loads
CD00 dout0_0  0 0.8364f
CD01 dout0_1  0 0.8364f
CD02 dout0_2  0 0.8364f
CD03 dout0_3  0 0.8364f
CD04 dout0_4  0 0.8364f
CD05 dout0_5  0 0.8364f
CD06 dout0_6  0 0.8364f
CD07 dout0_7  0 0.8364f
CD08 dout0_8  0 0.8364f
CD09 dout0_9  0 0.8364f
CD010 dout0_10  0 0.8364f
CD011 dout0_11  0 0.8364f
CD012 dout0_12  0 0.8364f
CD013 dout0_13  0 0.8364f
CD014 dout0_14  0 0.8364f
CD015 dout0_15  0 0.8364f
CD016 dout0_16  0 0.8364f
CD017 dout0_17  0 0.8364f
CD018 dout0_18  0 0.8364f
CD019 dout0_19  0 0.8364f
CD020 dout0_20  0 0.8364f
CD021 dout0_21  0 0.8364f
CD022 dout0_22  0 0.8364f
CD023 dout0_23  0 0.8364f
CD024 dout0_24  0 0.8364f
CD025 dout0_25  0 0.8364f
CD026 dout0_26  0 0.8364f
CD027 dout0_27  0 0.8364f
CD028 dout0_28  0 0.8364f
CD029 dout0_29  0 0.8364f
CD030 dout0_30  0 0.8364f
CD031 dout0_31  0 0.8364f
CD032 dout0_32  0 0.8364f
CD033 dout0_33  0 0.8364f
CD034 dout0_34  0 0.8364f
CD035 dout0_35  0 0.8364f
CD036 dout0_36  0 0.8364f
CD037 dout0_37  0 0.8364f
CD038 dout0_38  0 0.8364f
CD039 dout0_39  0 0.8364f
CD040 dout0_40  0 0.8364f
CD041 dout0_41  0 0.8364f
CD042 dout0_42  0 0.8364f
CD043 dout0_43  0 0.8364f
CD044 dout0_44  0 0.8364f
CD045 dout0_45  0 0.8364f
CD046 dout0_46  0 0.8364f
CD047 dout0_47  0 0.8364f
CD048 dout0_48  0 0.8364f
CD049 dout0_49  0 0.8364f
CD050 dout0_50  0 0.8364f
CD051 dout0_51  0 0.8364f
CD052 dout0_52  0 0.8364f
CD053 dout0_53  0 0.8364f
CD054 dout0_54  0 0.8364f
CD055 dout0_55  0 0.8364f
CD056 dout0_56  0 0.8364f
CD057 dout0_57  0 0.8364f
CD058 dout0_58  0 0.8364f
CD059 dout0_59  0 0.8364f
CD060 dout0_60  0 0.8364f
CD061 dout0_61  0 0.8364f
CD062 dout0_62  0 0.8364f
CD063 dout0_63  0 0.8364f

* Important signals for debug
* bl:	xsram:xbank0:bl_0_0
* br:	xsram:xbank0:br_0_0
* s_en:	xsram:s_en
* q:	xsram:xbank0:xbitcell_array:xbitcell_array:xbit_r0_c0.Q
* qbar:	xsram:xbank0:xbitcell_array:xbitcell_array:xbit_r0_c0.Q_bar

* Sequence of operations
*	Idle during cycle 0 (0ns - 5ns)
*	Writing 1010000000010000111110100011111111101110011001011111010101011100  to  address 1111111110 (from port 0) during cycle 1 (5ns - 10ns)
*	Writing 0101000110100001010010100010110011101011000101101010100000010100  to  address 1111111110 (from port 0) during cycle 2 (10ns - 15ns)
*	Writing 1010111101010010000111100111110000111010110111101000010010100100  to  address 0000000001 (from port 0) during cycle 3 (15ns - 20ns)
*	Reading 0101000110100001010010100010110011101011000101101010100000010100 from address 1111111110 (from port 0) during cycle 4 (20ns - 25ns)
*	Writing 0111100000011001000111010100011000110100110100010110111011010010  to  address 0000000001 (from port 0) during cycle 6 (30ns - 35ns)
*	Writing (partial) 1010100100000011010100000110100111001100100110110000001000100010  to  address 1111111110 with mask bit 10101010 (from port 0) during cycle 8 (40ns - 45ns)
*	Writing (partial) 1010101011010010111011100110111000110101111110010011111011001001  to  address 0000000001 with mask bit 00010001 (from port 0) during cycle 9 (45ns - 50ns)
*	Reading 0111100000011001000111010110111000110100110100010110111011001001 from address 0000000001 (from port 0) during cycle 10 (50ns - 55ns)
*	Reading 0111100000011001000111010110111000110100110100010110111011001001 from address 0000000001 (from port 0) during cycle 11 (55ns - 60ns)
*	Writing (partial) 0100001110000101101110101011110111010011101110110110000111000101  to  address 1111111110 with mask bit 11101001 (from port 0) during cycle 12 (60ns - 65ns)
*	Writing (partial) 0100101010011011011000001101101001011100111010111110001100111011  to  address 1111111110 with mask bit 10110010 (from port 0) during cycle 13 (65ns - 70ns)
*	Reading 0100101010000101011000001101101011010011000101101110001111000101 from address 1111111110 (from port 0) during cycle 14 (70ns - 75ns)
*	Reading 0100101010000101011000001101101011010011000101101110001111000101 from address 1111111110 (from port 0) during cycle 15 (75ns - 80ns)
*	Writing (partial) 0001111001000000111000011110100100010001000001000011001001000011  to  address 1111111110 with mask bit 11010111 (from port 0) during cycle 18 (90ns - 95ns)
*	Writing (partial) 0111101111100101100010100010011111011011101100001001000001001101  to  address 1111111110 with mask bit 01101111 (from port 0) during cycle 20 (100ns - 105ns)
*	Reading 0001111011100101100010101110100111011011101100001001000001001101 from address 1111111110 (from port 0) during cycle 22 (110ns - 115ns)
*	Reading 0001111011100101100010101110100111011011101100001001000001001101 from address 1111111110 (from port 0) during cycle 25 (125ns - 130ns)
*	Reading 0111100000011001000111010110111000110100110100010110111011001001 from address 0000000001 (from port 0) during cycle 26 (130ns - 135ns)
*	Writing 1100011100001110010010110011100000101001011000001010101101000110  to  address 0000000001 (from port 0) during cycle 27 (135ns - 140ns)
*	Writing (partial) 0000101100110000100100101001010101100100101100100010111100001001  to  address 1111111110 with mask bit 01010100 (from port 0) during cycle 28 (140ns - 145ns)
*	Reading 0001111000110000100010101001010111011011101100101001000001001101 from address 1111111110 (from port 0) during cycle 30 (150ns - 155ns)
*	Reading 1100011100001110010010110011100000101001011000001010101101000110 from address 0000000001 (from port 0) during cycle 31 (155ns - 160ns)
*	Reading 1100011100001110010010110011100000101001011000001010101101000110 from address 0000000001 (from port 0) during cycle 32 (160ns - 165ns)
*	Reading 0001111000110000100010101001010111011011101100101001000001001101 from address 1111111110 (from port 0) during cycle 33 (165ns - 170ns)
*	Writing (partial) 0111110110100011000001011000101001000000101011100010111011010011  to  address 0000000001 with mask bit 00101100 (from port 0) during cycle 34 (170ns - 175ns)
*	Reading 0001111000110000100010101001010111011011101100101001000001001101 from address 1111111110 (from port 0) during cycle 36 (180ns - 185ns)
*	Writing 1110011111001111010011010010011110000101100101000110011001001011  to  address 0000000001 (from port 0) during cycle 37 (185ns - 190ns)
*	Reading 0001111000110000100010101001010111011011101100101001000001001101 from address 1111111110 (from port 0) during cycle 38 (190ns - 195ns)
*	Reading 0001111000110000100010101001010111011011101100101001000001001101 from address 1111111110 (from port 0) during cycle 39 (195ns - 200ns)
*	Writing (partial) 0111001110000010100011111100010111111110101100101100111001100001  to  address 0000000001 with mask bit 00011001 (from port 0) during cycle 40 (200ns - 205ns)
*	Writing (partial) 0101110101011110101100110001100000111100001111111101011000100100  to  address 1111111110 with mask bit 01000111 (from port 0) during cycle 42 (210ns - 215ns)
*	Reading 1110011111001111010011011100010111111110100101000110011001100001 from address 0000000001 (from port 0) during cycle 43 (215ns - 220ns)
*	Writing (partial) 1110011000101101000000111100010011000011011111011001101110100101  to  address 1111111110 with mask bit 11100000 (from port 0) during cycle 44 (220ns - 225ns)
*	Reading 1110011000101101000000111001010111011011001111111101011000100100 from address 1111111110 (from port 0) during cycle 45 (225ns - 230ns)
*	Writing (partial) 1110111011001000110110110100001101010110011001110010101101000011  to  address 1111111110 with mask bit 00000101 (from port 0) during cycle 46 (230ns - 235ns)
*	Reading 1110011111001111010011011100010111111110100101000110011001100001 from address 0000000001 (from port 0) during cycle 47 (235ns - 240ns)
*	Writing 0010010100111001101100010110101101101111110000011010111111000001  to  address 0000000000 (from port 0) during cycle 48 (240ns - 245ns)
*	Reading 0010010100111001101100010110101101101111110000011010111111000001 from address 0000000000 (from port 0) during cycle 49 (245ns - 250ns)
*	Reading 0010010100111001101100010110101101101111110000011010111111000001 from address 0000000000 (from port 0) during cycle 50 (250ns - 255ns)
*	Writing (partial) 1111101101111010111000100000010011010011100010011101011000100101  to  address 1111111110 with mask bit 00001111 (from port 0) during cycle 51 (255ns - 260ns)
*	Writing (partial) 0101100110010111101000001110100000001001000010001001100100111101  to  address 1111111110 with mask bit 10111111 (from port 0) during cycle 53 (265ns - 270ns)
*	Reading 0101100100101101101000001110100000001001000010001001100100111101 from address 1111111110 (from port 0) during cycle 55 (275ns - 280ns)
*	Writing 0110000101000100111110010110001100101011110000111111000111000011  to  address 0000000000 (from port 0) during cycle 56 (280ns - 285ns)
*	Reading 0101100100101101101000001110100000001001000010001001100100111101 from address 1111111110 (from port 0) during cycle 57 (285ns - 290ns)
*	Reading 0101100100101101101000001110100000001001000010001001100100111101 from address 1111111110 (from port 0) during cycle 59 (295ns - 300ns)
*	Writing (partial) 0100101100001000010000111110000011000010011111111010001000110111  to  address 0000000000 with mask bit 11001101 (from port 0) during cycle 60 (300ns - 305ns)
*	Writing 1111100111001110011101101110111101000101011110100100001111010001  to  address 1111111101 (from port 0) during cycle 63 (315ns - 320ns)
*	Reading 1111100111001110011101101110111101000101011110100100001111010001 from address 1111111101 (from port 0) during cycle 64 (320ns - 325ns)
*	Writing 1010110100010101000110001001001101111100111111111101001000010110  to  address 0000000000 (from port 0) during cycle 66 (330ns - 335ns)
*	Writing 1011110001010110010100001011000110001100101001001111011111011100  to  address 1111111110 (from port 0) during cycle 67 (335ns - 340ns)
*	Writing (partial) 0111011101110100110010010001011010000111000110111001001100011100  to  address 0000000001 with mask bit 00001101 (from port 0) during cycle 68 (340ns - 345ns)
*	Reading 1111100111001110011101101110111101000101011110100100001111010001 from address 1111111101 (from port 0) during cycle 71 (355ns - 360ns)
*	Writing (partial) 0011101110010010101101000011100001100010000010011010101111001010  to  address 0000000000 with mask bit 01110010 (from port 0) during cycle 72 (360ns - 365ns)
*	Reading 1010110110010010101101000011100001111100111111111010101100010110 from address 0000000000 (from port 0) during cycle 73 (365ns - 370ns)
*	Reading 1010110110010010101101000011100001111100111111111010101100010110 from address 0000000000 (from port 0) during cycle 74 (370ns - 375ns)
*	Reading 1010110110010010101101000011100001111100111111111010101100010110 from address 0000000000 (from port 0) during cycle 76 (380ns - 385ns)
*	Reading 1011110001010110010100001011000110001100101001001111011111011100 from address 1111111110 (from port 0) during cycle 78 (390ns - 395ns)
*	Writing 0010000011101110010011000010011110010100001100000000110110111100  to  address 1111111101 (from port 0) during cycle 79 (395ns - 400ns)
*	Writing (partial) 0110011000010111100010011110000011100000011111011110011011100011  to  address 1111111101 with mask bit 11110100 (from port 0) during cycle 80 (400ns - 405ns)
*	Reading 0110011000010111100010011110000010010100011111010000110110111100 from address 1111111101 (from port 0) during cycle 81 (405ns - 410ns)
*	Writing 1010101111100011011011001100110101010100010000001011110001111110  to  address 0000000001 (from port 0) during cycle 82 (410ns - 415ns)
*	Writing (partial) 0001100000100100101110011100111110011001001000000110000011000001  to  address 1111111110 with mask bit 01000110 (from port 0) during cycle 83 (415ns - 420ns)
*	Writing (partial) 1011110001001011110010101010000011100110111110010000000110110011  to  address 0000000001 with mask bit 01101101 (from port 0) during cycle 84 (420ns - 425ns)
*	Writing (partial) 1111101011010101001011010000111001101111110101011111001000101110  to  address 1111111110 with mask bit 11111110 (from port 0) during cycle 85 (425ns - 430ns)
*	Writing (partial) 1100101010111101101010110001110010010011100010000001011100000010  to  address 0000000001 with mask bit 11110100 (from port 0) during cycle 86 (430ns - 435ns)
*	Writing (partial) 0111010001111001000011110101111100110111101010000010011110111010  to  address 1111111101 with mask bit 11000110 (from port 0) during cycle 90 (450ns - 455ns)
*	Reading 1111101011010101001011010000111001101111110101011111001011011100 from address 1111111110 (from port 0) during cycle 91 (455ns - 460ns)
*	Writing (partial) 0011010101000110101101001010011100010011111001000110110001001101  to  address 1111111101 with mask bit 10001100 (from port 0) during cycle 92 (460ns - 465ns)
*	Writing 0000011110101001001010001001001011101110100100111110111110011100  to  address 1111111101 (from port 0) during cycle 93 (465ns - 470ns)
*	Writing 0111110111100101000110101001001010100111011101000010000011101110  to  address 1111111110 (from port 0) during cycle 94 (470ns - 475ns)
*	Writing 0001000100110100111101101000101111111011011110011001000110001101  to  address 0000000000 (from port 0) during cycle 96 (480ns - 485ns)
*	Reading 0111110111100101000110101001001010100111011101000010000011101110 from address 1111111110 (from port 0) during cycle 98 (490ns - 495ns)
*	Writing (partial) 0011111001001010011001101101101001101111011001010100111101101100  to  address 1111111101 with mask bit 11010111 (from port 0) during cycle 99 (495ns - 500ns)
*	Writing (partial) 1011011101001011010111111010111010100010110101111011110011010000  to  address 1111111101 with mask bit 00011001 (from port 0) during cycle 100 (500ns - 505ns)
*	Writing 1110000111111111010001001001000110101111101100100011111101001100  to  address 0000000001 (from port 0) during cycle 101 (505ns - 510ns)
*	Writing 1100011101010110110110110110001010000000010111101100101000111100  to  address 0000000000 (from port 0) during cycle 102 (510ns - 515ns)
*	Writing 1010110011000101011100110111000111010111000100101011100011110101  to  address 0000000000 (from port 0) during cycle 103 (515ns - 520ns)
*	Reading 0111110111100101000110101001001010100111011101000010000011101110 from address 1111111110 (from port 0) during cycle 104 (520ns - 525ns)
*	Reading 0111110111100101000110101001001010100111011101000010000011101110 from address 1111111110 (from port 0) during cycle 106 (530ns - 535ns)
*	Writing (partial) 1010011000111110011011001011111110101110001110100001001011101100  to  address 1111111110 with mask bit 11010110 (from port 0) during cycle 107 (535ns - 540ns)
*	Writing 0110000000110110010011110001110110001001001110010110111101110011  to  address 1111111110 (from port 0) during cycle 108 (540ns - 545ns)
*	Reading 1010110011000101011100110111000111010111000100101011100011110101 from address 0000000000 (from port 0) during cycle 110 (550ns - 555ns)
*	Writing 0100110000110101111100100110100111110101011001100101000100001111  to  address 0000000001 (from port 0) during cycle 111 (555ns - 560ns)
*	Reading 0011111001001010001010001010111010100010011001010100111111010000 from address 1111111101 (from port 0) during cycle 112 (560ns - 565ns)
*	Reading 0110000000110110010011110001110110001001001110010110111101110011 from address 1111111110 (from port 0) during cycle 113 (565ns - 570ns)
*	Writing 1010001011111110001100011110111110111100100011100101010011001101  to  address 1111111101 (from port 0) during cycle 115 (575ns - 580ns)
*	Reading 1010001011111110001100011110111110111100100011100101010011001101 from address 1111111101 (from port 0) during cycle 116 (580ns - 585ns)
*	Reading 0110000000110110010011110001110110001001001110010110111101110011 from address 1111111110 (from port 0) during cycle 117 (585ns - 590ns)
*	Reading 0100110000110101111100100110100111110101011001100101000100001111 from address 0000000001 (from port 0) during cycle 118 (590ns - 595ns)
*	Reading 1010001011111110001100011110111110111100100011100101010011001101 from address 1111111101 (from port 0) during cycle 119 (595ns - 600ns)
*	Reading 0110000000110110010011110001110110001001001110010110111101110011 from address 1111111110 (from port 0) during cycle 120 (600ns - 605ns)
*	Reading 0100110000110101111100100110100111110101011001100101000100001111 from address 0000000001 (from port 0) during cycle 121 (605ns - 610ns)
*	Reading 1010001011111110001100011110111110111100100011100101010011001101 from address 1111111101 (from port 0) during cycle 122 (610ns - 615ns)
*	Reading 1010001011111110001100011110111110111100100011100101010011001101 from address 1111111101 (from port 0) during cycle 124 (620ns - 625ns)
*	Writing (partial) 0100011010011011000001011010111100100001010101111001011001010010  to  address 0000000001 with mask bit 00011000 (from port 0) during cycle 126 (630ns - 635ns)
*	Writing 0100101010101001010000101111100100011100111100110101110010101000  to  address 0000000001 (from port 0) during cycle 127 (635ns - 640ns)
*	Writing (partial) 0101110111011101111000011101110110111111100100111010010000110000  to  address 1111111101 with mask bit 00101110 (from port 0) during cycle 128 (640ns - 645ns)
*	Reading 0100101010101001010000101111100100011100111100110101110010101000 from address 0000000001 (from port 0) during cycle 129 (645ns - 650ns)
*	Reading 1010001011111110111000011110111110111111100100111010010011001101 from address 1111111101 (from port 0) during cycle 130 (650ns - 655ns)
*	Writing (partial) 1011001010100111110100001110000010011011011111110011000100000011  to  address 1111111110 with mask bit 00110011 (from port 0) during cycle 131 (655ns - 660ns)
*	Writing (partial) 0001011111011001010011010110010000101110000011110000001111101000  to  address 1111111110 with mask bit 00000101 (from port 0) during cycle 132 (660ns - 665ns)
*	Writing (partial) 1101000111011110111011001010000110100110111111110001001011111000  to  address 1111111101 with mask bit 10100111 (from port 0) during cycle 134 (670ns - 675ns)
*	Reading 1101000111111110111011001110111110111111111111110001001011111000 from address 1111111101 (from port 0) during cycle 135 (675ns - 680ns)
*	Reading 0110000000110110110100001110000010001001000011110011000111101000 from address 1111111110 (from port 0) during cycle 136 (680ns - 685ns)
*	Reading 0100101010101001010000101111100100011100111100110101110010101000 from address 0000000001 (from port 0) during cycle 137 (685ns - 690ns)
*	Reading 1010110011000101011100110111000111010111000100101011100011110101 from address 0000000000 (from port 0) during cycle 138 (690ns - 695ns)
*	Reading 1101000111111110111011001110111110111111111111110001001011111000 from address 1111111101 (from port 0) during cycle 139 (695ns - 700ns)
*	Writing 0110001100000001010111100000001101111100110000011010110000010001  to  address 0000000001 (from port 0) during cycle 141 (705ns - 710ns)
*	Writing 0110111010101010101011100101011000110000111101101100000001101011  to  address 1111111101 (from port 0) during cycle 142 (710ns - 715ns)
*	Writing (partial) 1101110100000011011111001111010010000110101111110101111100110011  to  address 1111111101 with mask bit 00101001 (from port 0) during cycle 143 (715ns - 720ns)
*	Reading 1010110011000101011100110111000111010111000100101011100011110101 from address 0000000000 (from port 0) during cycle 144 (720ns - 725ns)
*	Reading 0110111010101010011111000101011010000110111101101100000000110011 from address 1111111101 (from port 0) during cycle 145 (725ns - 730ns)
*	Writing 0100100010000010010110011001111111100000110101111010011011100010  to  address 0000000000 (from port 0) during cycle 147 (735ns - 740ns)
*	Writing (partial) 1011100110010101000100001110001000010000011110000011101111101101  to  address 1111111110 with mask bit 11011100 (from port 0) during cycle 148 (740ns - 745ns)
*	Reading 0110001100000001010111100000001101111100110000011010110000010001 from address 0000000001 (from port 0) during cycle 149 (745ns - 750ns)
*	Writing (partial) 0100110001100000000100111100001110110011110010001101010000000010  to  address 1111111110 with mask bit 00101001 (from port 0) during cycle 151 (755ns - 760ns)
*	Reading 0100100010000010010110011001111111100000110101111010011011100010 from address 0000000000 (from port 0) during cycle 152 (760ns - 765ns)
*	Reading 0100100010000010010110011001111111100000110101111010011011100010 from address 0000000000 (from port 0) during cycle 153 (765ns - 770ns)
*	Writing 1101100111100100101100111100101011000110010001011010000111001100  to  address 0000000000 (from port 0) during cycle 154 (770ns - 775ns)
*	Writing (partial) 1110111000110010001101010101001110100000001010011001100110000010  to  address 0000000001 with mask bit 10000100 (from port 0) during cycle 155 (775ns - 780ns)
*	Reading 1101100111100100101100111100101011000110010001011010000111001100 from address 0000000000 (from port 0) during cycle 156 (780ns - 785ns)
*	Writing 1011000111000110010100101111101010111100001011110010011100111011  to  address 0000000000 (from port 0) during cycle 157 (785ns - 790ns)
*	Writing 1011001010110110100011111001010111001100000000010001010001101001  to  address 0000000000 (from port 0) during cycle 158 (790ns - 795ns)
*	Reading 1011001010110110100011111001010111001100000000010001010001101001 from address 0000000000 (from port 0) during cycle 161 (805ns - 810ns)
*	Reading 1011100110010101000100111110001010110011011110000011000100000010 from address 1111111110 (from port 0) during cycle 162 (810ns - 815ns)
*	Reading 1011001010110110100011111001010111001100000000010001010001101001 from address 0000000000 (from port 0) during cycle 163 (815ns - 820ns)
*	Writing (partial) 0011010011011011100111010101110100000010010001010100100011110101  to  address 1111111101 with mask bit 00000101 (from port 0) during cycle 164 (820ns - 825ns)
*	Reading 1011001010110110100011111001010111001100000000010001010001101001 from address 0000000000 (from port 0) during cycle 165 (825ns - 830ns)
*	Writing (partial) 1010000110111001101010111010100001110001101111010010010110001111  to  address 0000000001 with mask bit 10100010 (from port 0) during cycle 166 (830ns - 835ns)
*	Writing 1001000000100000011111010100110001000111111010000000001010100000  to  address 0000000001 (from port 0) during cycle 167 (835ns - 840ns)
*	Reading 1011100110010101000100111110001010110011011110000011000100000010 from address 1111111110 (from port 0) during cycle 168 (840ns - 845ns)
*	Reading 1011100110010101000100111110001010110011011110000011000100000010 from address 1111111110 (from port 0) during cycle 169 (845ns - 850ns)
*	Writing 0000100011110001111101011110010011000101100011010110100110101010  to  address 0000000000 (from port 0) during cycle 171 (855ns - 860ns)
*	Writing 0110100001001110111010111001010111100111010100001011000110111111  to  address 0000000001 (from port 0) during cycle 172 (860ns - 865ns)
*	Writing 1010011001111100001000011101101101110010001100101000101100010110  to  address 0000000000 (from port 0) during cycle 173 (865ns - 870ns)
*	Writing (partial) 0111101101111010011000100010000000100011111100001001010010000100  to  address 1111111101 with mask bit 10101010 (from port 0) during cycle 174 (870ns - 875ns)
*	Writing 0111010011100001000111010001111111101111110110000000001101001111  to  address 1111111110 (from port 0) during cycle 175 (875ns - 880ns)
*	Writing 1101110001110010010111101010000000100010000010100010110011101111  to  address 0000000001 (from port 0) during cycle 176 (880ns - 885ns)
*	Writing (partial) 0000010011100000001011011110110001000001101101111111010010011101  to  address 1111111110 with mask bit 10101101 (from port 0) during cycle 177 (885ns - 890ns)
*	Reading 1010011001111100001000011101101101110010001100101000101100010110 from address 0000000000 (from port 0) during cycle 178 (890ns - 895ns)
*	Reading 0000010011100001001011010001111101000001101101110000001110011101 from address 1111111110 (from port 0) during cycle 181 (905ns - 910ns)
*	Writing 0101101010110001110101011111110111101011110111000111001010110101  to  address 1111111101 (from port 0) during cycle 182 (910ns - 915ns)
*	Reading 0101101010110001110101011111110111101011110111000111001010110101 from address 1111111101 (from port 0) during cycle 183 (915ns - 920ns)
*	Reading 0000010011100001001011010001111101000001101101110000001110011101 from address 1111111110 (from port 0) during cycle 184 (920ns - 925ns)
*	Reading 1010011001111100001000011101101101110010001100101000101100010110 from address 0000000000 (from port 0) during cycle 185 (925ns - 930ns)
*	Writing 1100101011111110101001010001011000110101111010001101001001000110  to  address 1111111110 (from port 0) during cycle 186 (930ns - 935ns)
*	Writing 1000000110110100000011111001111010011001100101100001000000101000  to  address 0000000001 (from port 0) during cycle 187 (935ns - 940ns)
*	Writing 1110111111101101000001011000101010011101111110011101000101110100  to  address 0000000000 (from port 0) during cycle 188 (940ns - 945ns)
*	Writing 1001110100111101100000111110101000111101101001001111001011011001  to  address 0000000001 (from port 0) during cycle 191 (955ns - 960ns)
*	Writing (partial) 1111011110110011101001100100111111011110010101001000110110100111  to  address 0000000000 with mask bit 01001010 (from port 0) during cycle 193 (965ns - 970ns)
*	Reading 1001110100111101100000111110101000111101101001001111001011011001 from address 0000000001 (from port 0) during cycle 195 (975ns - 980ns)
*	Writing (partial) 0000100111001010110110011101000111000001100101010110101100011100  to  address 1111111101 with mask bit 10010100 (from port 0) during cycle 196 (980ns - 985ns)
*	Writing 0100101011000000000110000111000010001011110101010011001111110010  to  address 0000000000 (from port 0) during cycle 197 (985ns - 990ns)
*	Writing 1110110001110001010001101101000011000001000100001101101001110000  to  address 0000000001 (from port 0) during cycle 199 (995ns - 1000ns)
*	Writing 0111100000110001000111001000011010101001011011111111100110011101  to  address 0000000000 (from port 0) during cycle 200 (1000ns - 1005ns)
*	Reading 1100101011111110101001010001011000110101111010001101001001000110 from address 1111111110 (from port 0) during cycle 201 (1005ns - 1010ns)
*	Reading 1110110001110001010001101101000011000001000100001101101001110000 from address 0000000001 (from port 0) during cycle 202 (1010ns - 1015ns)
*	Reading 1110110001110001010001101101000011000001000100001101101001110000 from address 0000000001 (from port 0) during cycle 203 (1015ns - 1020ns)
*	Writing 0111110110110110000001111001101010101001011010100101001001100101  to  address 1111111110 (from port 0) during cycle 204 (1020ns - 1025ns)
*	Idle during cycle 205 (1025ns - 1030ns)

* Generation of data and address signals
* (time, data): [(0, 0), (5, 0), (10, 0), (15, 0), (20, 0), (25, 0), (30, 0), (35, 0), (40, 0), (45, 1), (50, 1), (55, 1), (60, 1), (65, 1), (70, 1), (75, 1), (80, 1), (85, 1), (90, 1), (95, 1), (100, 1), (105, 1), (110, 1), (115, 1), (120, 1), (125, 1), (130, 1), (135, 0), (140, 1), (145, 1), (150, 1), (155, 1), (160, 1), (165, 1), (170, 1), (175, 1), (180, 1), (185, 1), (190, 1), (195, 1), (200, 1), (205, 1), (210, 0), (215, 0), (220, 1), (225, 1), (230, 1), (235, 1), (240, 1), (245, 1), (250, 1), (255, 1), (260, 1), (265, 1), (270, 1), (275, 1), (280, 1), (285, 1), (290, 1), (295, 1), (300, 1), (305, 1), (310, 1), (315, 1), (320, 1), (325, 1), (330, 0), (335, 0), (340, 0), (345, 0), (350, 0), (355, 0), (360, 0), (365, 0), (370, 0), (375, 0), (380, 0), (385, 0), (390, 0), (395, 0), (400, 1), (405, 1), (410, 0), (415, 1), (420, 1), (425, 0), (430, 0), (435, 0), (440, 0), (445, 0), (450, 0), (455, 0), (460, 1), (465, 0), (470, 0), (475, 0), (480, 1), (485, 1), (490, 1), (495, 0), (500, 0), (505, 0), (510, 0), (515, 1), (520, 1), (525, 1), (530, 1), (535, 0), (540, 1), (545, 1), (550, 1), (555, 1), (560, 1), (565, 1), (570, 1), (575, 1), (580, 1), (585, 1), (590, 1), (595, 1), (600, 1), (605, 1), (610, 1), (615, 1), (620, 1), (625, 1), (630, 0), (635, 0), (640, 0), (645, 0), (650, 0), (655, 1), (660, 0), (665, 0), (670, 0), (675, 0), (680, 0), (685, 0), (690, 0), (695, 0), (700, 0), (705, 1), (710, 1), (715, 1), (720, 1), (725, 1), (730, 1), (735, 0), (740, 1), (745, 1), (750, 1), (755, 0), (760, 0), (765, 0), (770, 0), (775, 0), (780, 0), (785, 1), (790, 1), (795, 1), (800, 1), (805, 1), (810, 1), (815, 1), (820, 1), (825, 1), (830, 1), (835, 0), (840, 0), (845, 0), (850, 0), (855, 0), (860, 1), (865, 0), (870, 0), (875, 1), (880, 1), (885, 1), (890, 1), (895, 1), (900, 1), (905, 1), (910, 1), (915, 1), (920, 1), (925, 1), (930, 0), (935, 0), (940, 0), (945, 0), (950, 0), (955, 1), (960, 1), (965, 1), (970, 1), (975, 1), (980, 0), (985, 0), (990, 0), (995, 0), (1000, 1), (1005, 1), (1010, 1), (1015, 1), (1020, 1), (1025, 1)]
Vdin0_0  din0_0  0 PWL (0n 0.0v 4.745n 0.0v 4.755n 0.0v 9.745n 0.0v 9.755n 0.0v 14.745n 0.0v 14.755n 0.0v 19.745n 0.0v 19.755n 0.0v 24.745n 0.0v 24.755n 0.0v 29.745n 0.0v 29.755n 0.0v 34.745n 0.0v 34.755n 0.0v 39.745n 0.0v 39.755n 0.0v 44.745n 0.0v 44.755n 1.1v 49.745n 1.1v 49.755n 1.1v 54.745n 1.1v 54.755n 1.1v 59.745n 1.1v 59.755n 1.1v 64.745n 1.1v 64.755n 1.1v 69.745n 1.1v 69.755n 1.1v 74.745n 1.1v 74.755n 1.1v 79.745n 1.1v 79.755n 1.1v 84.745n 1.1v 84.755n 1.1v 89.745n 1.1v 89.755n 1.1v 94.745n 1.1v 94.755n 1.1v 99.745n 1.1v 99.755n 1.1v 104.745n 1.1v 104.755n 1.1v 109.745n 1.1v 109.755n 1.1v 114.745n 1.1v 114.755n 1.1v 119.745n 1.1v 119.755n 1.1v 124.745n 1.1v 124.755n 1.1v 129.745n 1.1v 129.755n 1.1v 134.745n 1.1v 134.755n 0.0v 139.745n 0.0v 139.755n 1.1v 144.745n 1.1v 144.755n 1.1v 149.745n 1.1v 149.755n 1.1v 154.745n 1.1v 154.755n 1.1v 159.745n 1.1v 159.755n 1.1v 164.745n 1.1v 164.755n 1.1v 169.745n 1.1v 169.755n 1.1v 174.745n 1.1v 174.755n 1.1v 179.745n 1.1v 179.755n 1.1v 184.745n 1.1v 184.755n 1.1v 189.745n 1.1v 189.755n 1.1v 194.745n 1.1v 194.755n 1.1v 199.745n 1.1v 199.755n 1.1v 204.745n 1.1v 204.755n 1.1v 209.745n 1.1v 209.755n 0.0v 214.745n 0.0v 214.755n 0.0v 219.745n 0.0v 219.755n 1.1v 224.745n 1.1v 224.755n 1.1v 229.745n 1.1v 229.755n 1.1v 234.745n 1.1v 234.755n 1.1v 239.745n 1.1v 239.755n 1.1v 244.745n 1.1v 244.755n 1.1v 249.745n 1.1v 249.755n 1.1v 254.745n 1.1v 254.755n 1.1v 259.745n 1.1v 259.755n 1.1v 264.745n 1.1v 264.755n 1.1v 269.745n 1.1v 269.755n 1.1v 274.745n 1.1v 274.755n 1.1v 279.745n 1.1v 279.755n 1.1v 284.745n 1.1v 284.755n 1.1v 289.745n 1.1v 289.755n 1.1v 294.745n 1.1v 294.755n 1.1v 299.745n 1.1v 299.755n 1.1v 304.745n 1.1v 304.755n 1.1v 309.745n 1.1v 309.755n 1.1v 314.745n 1.1v 314.755n 1.1v 319.745n 1.1v 319.755n 1.1v 324.745n 1.1v 324.755n 1.1v 329.745n 1.1v 329.755n 0.0v 334.745n 0.0v 334.755n 0.0v 339.745n 0.0v 339.755n 0.0v 344.745n 0.0v 344.755n 0.0v 349.745n 0.0v 349.755n 0.0v 354.745n 0.0v 354.755n 0.0v 359.745n 0.0v 359.755n 0.0v 364.745n 0.0v 364.755n 0.0v 369.745n 0.0v 369.755n 0.0v 374.745n 0.0v 374.755n 0.0v 379.745n 0.0v 379.755n 0.0v 384.745n 0.0v 384.755n 0.0v 389.745n 0.0v 389.755n 0.0v 394.745n 0.0v 394.755n 0.0v 399.745n 0.0v 399.755n 1.1v 404.745n 1.1v 404.755n 1.1v 409.745n 1.1v 409.755n 0.0v 414.745n 0.0v 414.755n 1.1v 419.745n 1.1v 419.755n 1.1v 424.745n 1.1v 424.755n 0.0v 429.745n 0.0v 429.755n 0.0v 434.745n 0.0v 434.755n 0.0v 439.745n 0.0v 439.755n 0.0v 444.745n 0.0v 444.755n 0.0v 449.745n 0.0v 449.755n 0.0v 454.745n 0.0v 454.755n 0.0v 459.745n 0.0v 459.755n 1.1v 464.745n 1.1v 464.755n 0.0v 469.745n 0.0v 469.755n 0.0v 474.745n 0.0v 474.755n 0.0v 479.745n 0.0v 479.755n 1.1v 484.745n 1.1v 484.755n 1.1v 489.745n 1.1v 489.755n 1.1v 494.745n 1.1v 494.755n 0.0v 499.745n 0.0v 499.755n 0.0v 504.745n 0.0v 504.755n 0.0v 509.745n 0.0v 509.755n 0.0v 514.745n 0.0v 514.755n 1.1v 519.745n 1.1v 519.755n 1.1v 524.745n 1.1v 524.755n 1.1v 529.745n 1.1v 529.755n 1.1v 534.745n 1.1v 534.755n 0.0v 539.745n 0.0v 539.755n 1.1v 544.745n 1.1v 544.755n 1.1v 549.745n 1.1v 549.755n 1.1v 554.745n 1.1v 554.755n 1.1v 559.745n 1.1v 559.755n 1.1v 564.745n 1.1v 564.755n 1.1v 569.745n 1.1v 569.755n 1.1v 574.745n 1.1v 574.755n 1.1v 579.745n 1.1v 579.755n 1.1v 584.745n 1.1v 584.755n 1.1v 589.745n 1.1v 589.755n 1.1v 594.745n 1.1v 594.755n 1.1v 599.745n 1.1v 599.755n 1.1v 604.745n 1.1v 604.755n 1.1v 609.745n 1.1v 609.755n 1.1v 614.745n 1.1v 614.755n 1.1v 619.745n 1.1v 619.755n 1.1v 624.745n 1.1v 624.755n 1.1v 629.745n 1.1v 629.755n 0.0v 634.745n 0.0v 634.755n 0.0v 639.745n 0.0v 639.755n 0.0v 644.745n 0.0v 644.755n 0.0v 649.745n 0.0v 649.755n 0.0v 654.745n 0.0v 654.755n 1.1v 659.745n 1.1v 659.755n 0.0v 664.745n 0.0v 664.755n 0.0v 669.745n 0.0v 669.755n 0.0v 674.745n 0.0v 674.755n 0.0v 679.745n 0.0v 679.755n 0.0v 684.745n 0.0v 684.755n 0.0v 689.745n 0.0v 689.755n 0.0v 694.745n 0.0v 694.755n 0.0v 699.745n 0.0v 699.755n 0.0v 704.745n 0.0v 704.755n 1.1v 709.745n 1.1v 709.755n 1.1v 714.745n 1.1v 714.755n 1.1v 719.745n 1.1v 719.755n 1.1v 724.745n 1.1v 724.755n 1.1v 729.745n 1.1v 729.755n 1.1v 734.745n 1.1v 734.755n 0.0v 739.745n 0.0v 739.755n 1.1v 744.745n 1.1v 744.755n 1.1v 749.745n 1.1v 749.755n 1.1v 754.745n 1.1v 754.755n 0.0v 759.745n 0.0v 759.755n 0.0v 764.745n 0.0v 764.755n 0.0v 769.745n 0.0v 769.755n 0.0v 774.745n 0.0v 774.755n 0.0v 779.745n 0.0v 779.755n 0.0v 784.745n 0.0v 784.755n 1.1v 789.745n 1.1v 789.755n 1.1v 794.745n 1.1v 794.755n 1.1v 799.745n 1.1v 799.755n 1.1v 804.745n 1.1v 804.755n 1.1v 809.745n 1.1v 809.755n 1.1v 814.745n 1.1v 814.755n 1.1v 819.745n 1.1v 819.755n 1.1v 824.745n 1.1v 824.755n 1.1v 829.745n 1.1v 829.755n 1.1v 834.745n 1.1v 834.755n 0.0v 839.745n 0.0v 839.755n 0.0v 844.745n 0.0v 844.755n 0.0v 849.745n 0.0v 849.755n 0.0v 854.745n 0.0v 854.755n 0.0v 859.745n 0.0v 859.755n 1.1v 864.745n 1.1v 864.755n 0.0v 869.745n 0.0v 869.755n 0.0v 874.745n 0.0v 874.755n 1.1v 879.745n 1.1v 879.755n 1.1v 884.745n 1.1v 884.755n 1.1v 889.745n 1.1v 889.755n 1.1v 894.745n 1.1v 894.755n 1.1v 899.745n 1.1v 899.755n 1.1v 904.745n 1.1v 904.755n 1.1v 909.745n 1.1v 909.755n 1.1v 914.745n 1.1v 914.755n 1.1v 919.745n 1.1v 919.755n 1.1v 924.745n 1.1v 924.755n 1.1v 929.745n 1.1v 929.755n 0.0v 934.745n 0.0v 934.755n 0.0v 939.745n 0.0v 939.755n 0.0v 944.745n 0.0v 944.755n 0.0v 949.745n 0.0v 949.755n 0.0v 954.745n 0.0v 954.755n 1.1v 959.745n 1.1v 959.755n 1.1v 964.745n 1.1v 964.755n 1.1v 969.745n 1.1v 969.755n 1.1v 974.745n 1.1v 974.755n 1.1v 979.745n 1.1v 979.755n 0.0v 984.745n 0.0v 984.755n 0.0v 989.745n 0.0v 989.755n 0.0v 994.745n 0.0v 994.755n 0.0v 999.745n 0.0v 999.755n 1.1v 1004.745n 1.1v 1004.755n 1.1v 1009.745n 1.1v 1009.755n 1.1v 1014.745n 1.1v 1014.755n 1.1v 1019.745n 1.1v 1019.755n 1.1v 1024.745n 1.1v 1024.755n 1.1v )
* (time, data): [(0, 0), (5, 0), (10, 0), (15, 0), (20, 0), (25, 0), (30, 1), (35, 1), (40, 1), (45, 0), (50, 0), (55, 0), (60, 0), (65, 1), (70, 1), (75, 1), (80, 1), (85, 1), (90, 1), (95, 1), (100, 0), (105, 0), (110, 0), (115, 0), (120, 0), (125, 0), (130, 0), (135, 1), (140, 0), (145, 0), (150, 0), (155, 0), (160, 0), (165, 0), (170, 1), (175, 1), (180, 1), (185, 1), (190, 1), (195, 1), (200, 0), (205, 0), (210, 0), (215, 0), (220, 0), (225, 0), (230, 1), (235, 1), (240, 0), (245, 0), (250, 0), (255, 0), (260, 0), (265, 0), (270, 0), (275, 0), (280, 1), (285, 1), (290, 1), (295, 1), (300, 1), (305, 1), (310, 1), (315, 0), (320, 0), (325, 0), (330, 1), (335, 0), (340, 0), (345, 0), (350, 0), (355, 0), (360, 1), (365, 1), (370, 1), (375, 1), (380, 1), (385, 1), (390, 1), (395, 0), (400, 1), (405, 1), (410, 1), (415, 0), (420, 1), (425, 1), (430, 1), (435, 1), (440, 1), (445, 1), (450, 1), (455, 1), (460, 0), (465, 0), (470, 1), (475, 1), (480, 0), (485, 0), (490, 0), (495, 0), (500, 0), (505, 0), (510, 0), (515, 0), (520, 0), (525, 0), (530, 0), (535, 0), (540, 1), (545, 1), (550, 1), (555, 1), (560, 1), (565, 1), (570, 1), (575, 0), (580, 0), (585, 0), (590, 0), (595, 0), (600, 0), (605, 0), (610, 0), (615, 0), (620, 0), (625, 0), (630, 1), (635, 0), (640, 0), (645, 0), (650, 0), (655, 1), (660, 0), (665, 0), (670, 0), (675, 0), (680, 0), (685, 0), (690, 0), (695, 0), (700, 0), (705, 0), (710, 1), (715, 1), (720, 1), (725, 1), (730, 1), (735, 1), (740, 0), (745, 0), (750, 0), (755, 1), (760, 1), (765, 1), (770, 0), (775, 1), (780, 1), (785, 1), (790, 0), (795, 0), (800, 0), (805, 0), (810, 0), (815, 0), (820, 0), (825, 0), (830, 1), (835, 0), (840, 0), (845, 0), (850, 0), (855, 1), (860, 1), (865, 1), (870, 0), (875, 1), (880, 1), (885, 0), (890, 0), (895, 0), (900, 0), (905, 0), (910, 0), (915, 0), (920, 0), (925, 0), (930, 1), (935, 0), (940, 0), (945, 0), (950, 0), (955, 0), (960, 0), (965, 1), (970, 1), (975, 1), (980, 0), (985, 1), (990, 1), (995, 0), (1000, 0), (1005, 0), (1010, 0), (1015, 0), (1020, 0), (1025, 0)]
Vdin0_1  din0_1  0 PWL (0n 0.0v 4.745n 0.0v 4.755n 0.0v 9.745n 0.0v 9.755n 0.0v 14.745n 0.0v 14.755n 0.0v 19.745n 0.0v 19.755n 0.0v 24.745n 0.0v 24.755n 0.0v 29.745n 0.0v 29.755n 1.1v 34.745n 1.1v 34.755n 1.1v 39.745n 1.1v 39.755n 1.1v 44.745n 1.1v 44.755n 0.0v 49.745n 0.0v 49.755n 0.0v 54.745n 0.0v 54.755n 0.0v 59.745n 0.0v 59.755n 0.0v 64.745n 0.0v 64.755n 1.1v 69.745n 1.1v 69.755n 1.1v 74.745n 1.1v 74.755n 1.1v 79.745n 1.1v 79.755n 1.1v 84.745n 1.1v 84.755n 1.1v 89.745n 1.1v 89.755n 1.1v 94.745n 1.1v 94.755n 1.1v 99.745n 1.1v 99.755n 0.0v 104.745n 0.0v 104.755n 0.0v 109.745n 0.0v 109.755n 0.0v 114.745n 0.0v 114.755n 0.0v 119.745n 0.0v 119.755n 0.0v 124.745n 0.0v 124.755n 0.0v 129.745n 0.0v 129.755n 0.0v 134.745n 0.0v 134.755n 1.1v 139.745n 1.1v 139.755n 0.0v 144.745n 0.0v 144.755n 0.0v 149.745n 0.0v 149.755n 0.0v 154.745n 0.0v 154.755n 0.0v 159.745n 0.0v 159.755n 0.0v 164.745n 0.0v 164.755n 0.0v 169.745n 0.0v 169.755n 1.1v 174.745n 1.1v 174.755n 1.1v 179.745n 1.1v 179.755n 1.1v 184.745n 1.1v 184.755n 1.1v 189.745n 1.1v 189.755n 1.1v 194.745n 1.1v 194.755n 1.1v 199.745n 1.1v 199.755n 0.0v 204.745n 0.0v 204.755n 0.0v 209.745n 0.0v 209.755n 0.0v 214.745n 0.0v 214.755n 0.0v 219.745n 0.0v 219.755n 0.0v 224.745n 0.0v 224.755n 0.0v 229.745n 0.0v 229.755n 1.1v 234.745n 1.1v 234.755n 1.1v 239.745n 1.1v 239.755n 0.0v 244.745n 0.0v 244.755n 0.0v 249.745n 0.0v 249.755n 0.0v 254.745n 0.0v 254.755n 0.0v 259.745n 0.0v 259.755n 0.0v 264.745n 0.0v 264.755n 0.0v 269.745n 0.0v 269.755n 0.0v 274.745n 0.0v 274.755n 0.0v 279.745n 0.0v 279.755n 1.1v 284.745n 1.1v 284.755n 1.1v 289.745n 1.1v 289.755n 1.1v 294.745n 1.1v 294.755n 1.1v 299.745n 1.1v 299.755n 1.1v 304.745n 1.1v 304.755n 1.1v 309.745n 1.1v 309.755n 1.1v 314.745n 1.1v 314.755n 0.0v 319.745n 0.0v 319.755n 0.0v 324.745n 0.0v 324.755n 0.0v 329.745n 0.0v 329.755n 1.1v 334.745n 1.1v 334.755n 0.0v 339.745n 0.0v 339.755n 0.0v 344.745n 0.0v 344.755n 0.0v 349.745n 0.0v 349.755n 0.0v 354.745n 0.0v 354.755n 0.0v 359.745n 0.0v 359.755n 1.1v 364.745n 1.1v 364.755n 1.1v 369.745n 1.1v 369.755n 1.1v 374.745n 1.1v 374.755n 1.1v 379.745n 1.1v 379.755n 1.1v 384.745n 1.1v 384.755n 1.1v 389.745n 1.1v 389.755n 1.1v 394.745n 1.1v 394.755n 0.0v 399.745n 0.0v 399.755n 1.1v 404.745n 1.1v 404.755n 1.1v 409.745n 1.1v 409.755n 1.1v 414.745n 1.1v 414.755n 0.0v 419.745n 0.0v 419.755n 1.1v 424.745n 1.1v 424.755n 1.1v 429.745n 1.1v 429.755n 1.1v 434.745n 1.1v 434.755n 1.1v 439.745n 1.1v 439.755n 1.1v 444.745n 1.1v 444.755n 1.1v 449.745n 1.1v 449.755n 1.1v 454.745n 1.1v 454.755n 1.1v 459.745n 1.1v 459.755n 0.0v 464.745n 0.0v 464.755n 0.0v 469.745n 0.0v 469.755n 1.1v 474.745n 1.1v 474.755n 1.1v 479.745n 1.1v 479.755n 0.0v 484.745n 0.0v 484.755n 0.0v 489.745n 0.0v 489.755n 0.0v 494.745n 0.0v 494.755n 0.0v 499.745n 0.0v 499.755n 0.0v 504.745n 0.0v 504.755n 0.0v 509.745n 0.0v 509.755n 0.0v 514.745n 0.0v 514.755n 0.0v 519.745n 0.0v 519.755n 0.0v 524.745n 0.0v 524.755n 0.0v 529.745n 0.0v 529.755n 0.0v 534.745n 0.0v 534.755n 0.0v 539.745n 0.0v 539.755n 1.1v 544.745n 1.1v 544.755n 1.1v 549.745n 1.1v 549.755n 1.1v 554.745n 1.1v 554.755n 1.1v 559.745n 1.1v 559.755n 1.1v 564.745n 1.1v 564.755n 1.1v 569.745n 1.1v 569.755n 1.1v 574.745n 1.1v 574.755n 0.0v 579.745n 0.0v 579.755n 0.0v 584.745n 0.0v 584.755n 0.0v 589.745n 0.0v 589.755n 0.0v 594.745n 0.0v 594.755n 0.0v 599.745n 0.0v 599.755n 0.0v 604.745n 0.0v 604.755n 0.0v 609.745n 0.0v 609.755n 0.0v 614.745n 0.0v 614.755n 0.0v 619.745n 0.0v 619.755n 0.0v 624.745n 0.0v 624.755n 0.0v 629.745n 0.0v 629.755n 1.1v 634.745n 1.1v 634.755n 0.0v 639.745n 0.0v 639.755n 0.0v 644.745n 0.0v 644.755n 0.0v 649.745n 0.0v 649.755n 0.0v 654.745n 0.0v 654.755n 1.1v 659.745n 1.1v 659.755n 0.0v 664.745n 0.0v 664.755n 0.0v 669.745n 0.0v 669.755n 0.0v 674.745n 0.0v 674.755n 0.0v 679.745n 0.0v 679.755n 0.0v 684.745n 0.0v 684.755n 0.0v 689.745n 0.0v 689.755n 0.0v 694.745n 0.0v 694.755n 0.0v 699.745n 0.0v 699.755n 0.0v 704.745n 0.0v 704.755n 0.0v 709.745n 0.0v 709.755n 1.1v 714.745n 1.1v 714.755n 1.1v 719.745n 1.1v 719.755n 1.1v 724.745n 1.1v 724.755n 1.1v 729.745n 1.1v 729.755n 1.1v 734.745n 1.1v 734.755n 1.1v 739.745n 1.1v 739.755n 0.0v 744.745n 0.0v 744.755n 0.0v 749.745n 0.0v 749.755n 0.0v 754.745n 0.0v 754.755n 1.1v 759.745n 1.1v 759.755n 1.1v 764.745n 1.1v 764.755n 1.1v 769.745n 1.1v 769.755n 0.0v 774.745n 0.0v 774.755n 1.1v 779.745n 1.1v 779.755n 1.1v 784.745n 1.1v 784.755n 1.1v 789.745n 1.1v 789.755n 0.0v 794.745n 0.0v 794.755n 0.0v 799.745n 0.0v 799.755n 0.0v 804.745n 0.0v 804.755n 0.0v 809.745n 0.0v 809.755n 0.0v 814.745n 0.0v 814.755n 0.0v 819.745n 0.0v 819.755n 0.0v 824.745n 0.0v 824.755n 0.0v 829.745n 0.0v 829.755n 1.1v 834.745n 1.1v 834.755n 0.0v 839.745n 0.0v 839.755n 0.0v 844.745n 0.0v 844.755n 0.0v 849.745n 0.0v 849.755n 0.0v 854.745n 0.0v 854.755n 1.1v 859.745n 1.1v 859.755n 1.1v 864.745n 1.1v 864.755n 1.1v 869.745n 1.1v 869.755n 0.0v 874.745n 0.0v 874.755n 1.1v 879.745n 1.1v 879.755n 1.1v 884.745n 1.1v 884.755n 0.0v 889.745n 0.0v 889.755n 0.0v 894.745n 0.0v 894.755n 0.0v 899.745n 0.0v 899.755n 0.0v 904.745n 0.0v 904.755n 0.0v 909.745n 0.0v 909.755n 0.0v 914.745n 0.0v 914.755n 0.0v 919.745n 0.0v 919.755n 0.0v 924.745n 0.0v 924.755n 0.0v 929.745n 0.0v 929.755n 1.1v 934.745n 1.1v 934.755n 0.0v 939.745n 0.0v 939.755n 0.0v 944.745n 0.0v 944.755n 0.0v 949.745n 0.0v 949.755n 0.0v 954.745n 0.0v 954.755n 0.0v 959.745n 0.0v 959.755n 0.0v 964.745n 0.0v 964.755n 1.1v 969.745n 1.1v 969.755n 1.1v 974.745n 1.1v 974.755n 1.1v 979.745n 1.1v 979.755n 0.0v 984.745n 0.0v 984.755n 1.1v 989.745n 1.1v 989.755n 1.1v 994.745n 1.1v 994.755n 0.0v 999.745n 0.0v 999.755n 0.0v 1004.745n 0.0v 1004.755n 0.0v 1009.745n 0.0v 1009.755n 0.0v 1014.745n 0.0v 1014.755n 0.0v 1019.745n 0.0v 1019.755n 0.0v 1024.745n 0.0v 1024.755n 0.0v )
* (time, data): [(0, 0), (5, 1), (10, 1), (15, 1), (20, 1), (25, 1), (30, 0), (35, 0), (40, 0), (45, 0), (50, 0), (55, 0), (60, 1), (65, 0), (70, 0), (75, 0), (80, 0), (85, 0), (90, 0), (95, 0), (100, 1), (105, 1), (110, 1), (115, 1), (120, 1), (125, 1), (130, 1), (135, 1), (140, 0), (145, 0), (150, 0), (155, 0), (160, 0), (165, 0), (170, 0), (175, 0), (180, 0), (185, 0), (190, 0), (195, 0), (200, 0), (205, 0), (210, 1), (215, 1), (220, 1), (225, 1), (230, 0), (235, 0), (240, 0), (245, 0), (250, 0), (255, 1), (260, 1), (265, 1), (270, 1), (275, 1), (280, 0), (285, 0), (290, 0), (295, 0), (300, 1), (305, 1), (310, 1), (315, 0), (320, 0), (325, 0), (330, 1), (335, 1), (340, 1), (345, 1), (350, 1), (355, 1), (360, 0), (365, 0), (370, 0), (375, 0), (380, 0), (385, 0), (390, 0), (395, 1), (400, 0), (405, 0), (410, 1), (415, 0), (420, 0), (425, 1), (430, 0), (435, 0), (440, 0), (445, 0), (450, 0), (455, 0), (460, 1), (465, 1), (470, 1), (475, 1), (480, 1), (485, 1), (490, 1), (495, 1), (500, 0), (505, 1), (510, 1), (515, 1), (520, 1), (525, 1), (530, 1), (535, 1), (540, 0), (545, 0), (550, 0), (555, 1), (560, 1), (565, 1), (570, 1), (575, 1), (580, 1), (585, 1), (590, 1), (595, 1), (600, 1), (605, 1), (610, 1), (615, 1), (620, 1), (625, 1), (630, 0), (635, 0), (640, 0), (645, 0), (650, 0), (655, 0), (660, 0), (665, 0), (670, 0), (675, 0), (680, 0), (685, 0), (690, 0), (695, 0), (700, 0), (705, 0), (710, 0), (715, 0), (720, 0), (725, 0), (730, 0), (735, 0), (740, 1), (745, 1), (750, 1), (755, 0), (760, 0), (765, 0), (770, 1), (775, 0), (780, 0), (785, 0), (790, 0), (795, 0), (800, 0), (805, 0), (810, 0), (815, 0), (820, 1), (825, 1), (830, 1), (835, 0), (840, 0), (845, 0), (850, 0), (855, 0), (860, 1), (865, 1), (870, 1), (875, 1), (880, 1), (885, 1), (890, 1), (895, 1), (900, 1), (905, 1), (910, 1), (915, 1), (920, 1), (925, 1), (930, 1), (935, 0), (940, 1), (945, 1), (950, 1), (955, 0), (960, 0), (965, 1), (970, 1), (975, 1), (980, 1), (985, 0), (990, 0), (995, 0), (1000, 1), (1005, 1), (1010, 1), (1015, 1), (1020, 1), (1025, 1)]
Vdin0_2  din0_2  0 PWL (0n 0.0v 4.745n 0.0v 4.755n 1.1v 9.745n 1.1v 9.755n 1.1v 14.745n 1.1v 14.755n 1.1v 19.745n 1.1v 19.755n 1.1v 24.745n 1.1v 24.755n 1.1v 29.745n 1.1v 29.755n 0.0v 34.745n 0.0v 34.755n 0.0v 39.745n 0.0v 39.755n 0.0v 44.745n 0.0v 44.755n 0.0v 49.745n 0.0v 49.755n 0.0v 54.745n 0.0v 54.755n 0.0v 59.745n 0.0v 59.755n 1.1v 64.745n 1.1v 64.755n 0.0v 69.745n 0.0v 69.755n 0.0v 74.745n 0.0v 74.755n 0.0v 79.745n 0.0v 79.755n 0.0v 84.745n 0.0v 84.755n 0.0v 89.745n 0.0v 89.755n 0.0v 94.745n 0.0v 94.755n 0.0v 99.745n 0.0v 99.755n 1.1v 104.745n 1.1v 104.755n 1.1v 109.745n 1.1v 109.755n 1.1v 114.745n 1.1v 114.755n 1.1v 119.745n 1.1v 119.755n 1.1v 124.745n 1.1v 124.755n 1.1v 129.745n 1.1v 129.755n 1.1v 134.745n 1.1v 134.755n 1.1v 139.745n 1.1v 139.755n 0.0v 144.745n 0.0v 144.755n 0.0v 149.745n 0.0v 149.755n 0.0v 154.745n 0.0v 154.755n 0.0v 159.745n 0.0v 159.755n 0.0v 164.745n 0.0v 164.755n 0.0v 169.745n 0.0v 169.755n 0.0v 174.745n 0.0v 174.755n 0.0v 179.745n 0.0v 179.755n 0.0v 184.745n 0.0v 184.755n 0.0v 189.745n 0.0v 189.755n 0.0v 194.745n 0.0v 194.755n 0.0v 199.745n 0.0v 199.755n 0.0v 204.745n 0.0v 204.755n 0.0v 209.745n 0.0v 209.755n 1.1v 214.745n 1.1v 214.755n 1.1v 219.745n 1.1v 219.755n 1.1v 224.745n 1.1v 224.755n 1.1v 229.745n 1.1v 229.755n 0.0v 234.745n 0.0v 234.755n 0.0v 239.745n 0.0v 239.755n 0.0v 244.745n 0.0v 244.755n 0.0v 249.745n 0.0v 249.755n 0.0v 254.745n 0.0v 254.755n 1.1v 259.745n 1.1v 259.755n 1.1v 264.745n 1.1v 264.755n 1.1v 269.745n 1.1v 269.755n 1.1v 274.745n 1.1v 274.755n 1.1v 279.745n 1.1v 279.755n 0.0v 284.745n 0.0v 284.755n 0.0v 289.745n 0.0v 289.755n 0.0v 294.745n 0.0v 294.755n 0.0v 299.745n 0.0v 299.755n 1.1v 304.745n 1.1v 304.755n 1.1v 309.745n 1.1v 309.755n 1.1v 314.745n 1.1v 314.755n 0.0v 319.745n 0.0v 319.755n 0.0v 324.745n 0.0v 324.755n 0.0v 329.745n 0.0v 329.755n 1.1v 334.745n 1.1v 334.755n 1.1v 339.745n 1.1v 339.755n 1.1v 344.745n 1.1v 344.755n 1.1v 349.745n 1.1v 349.755n 1.1v 354.745n 1.1v 354.755n 1.1v 359.745n 1.1v 359.755n 0.0v 364.745n 0.0v 364.755n 0.0v 369.745n 0.0v 369.755n 0.0v 374.745n 0.0v 374.755n 0.0v 379.745n 0.0v 379.755n 0.0v 384.745n 0.0v 384.755n 0.0v 389.745n 0.0v 389.755n 0.0v 394.745n 0.0v 394.755n 1.1v 399.745n 1.1v 399.755n 0.0v 404.745n 0.0v 404.755n 0.0v 409.745n 0.0v 409.755n 1.1v 414.745n 1.1v 414.755n 0.0v 419.745n 0.0v 419.755n 0.0v 424.745n 0.0v 424.755n 1.1v 429.745n 1.1v 429.755n 0.0v 434.745n 0.0v 434.755n 0.0v 439.745n 0.0v 439.755n 0.0v 444.745n 0.0v 444.755n 0.0v 449.745n 0.0v 449.755n 0.0v 454.745n 0.0v 454.755n 0.0v 459.745n 0.0v 459.755n 1.1v 464.745n 1.1v 464.755n 1.1v 469.745n 1.1v 469.755n 1.1v 474.745n 1.1v 474.755n 1.1v 479.745n 1.1v 479.755n 1.1v 484.745n 1.1v 484.755n 1.1v 489.745n 1.1v 489.755n 1.1v 494.745n 1.1v 494.755n 1.1v 499.745n 1.1v 499.755n 0.0v 504.745n 0.0v 504.755n 1.1v 509.745n 1.1v 509.755n 1.1v 514.745n 1.1v 514.755n 1.1v 519.745n 1.1v 519.755n 1.1v 524.745n 1.1v 524.755n 1.1v 529.745n 1.1v 529.755n 1.1v 534.745n 1.1v 534.755n 1.1v 539.745n 1.1v 539.755n 0.0v 544.745n 0.0v 544.755n 0.0v 549.745n 0.0v 549.755n 0.0v 554.745n 0.0v 554.755n 1.1v 559.745n 1.1v 559.755n 1.1v 564.745n 1.1v 564.755n 1.1v 569.745n 1.1v 569.755n 1.1v 574.745n 1.1v 574.755n 1.1v 579.745n 1.1v 579.755n 1.1v 584.745n 1.1v 584.755n 1.1v 589.745n 1.1v 589.755n 1.1v 594.745n 1.1v 594.755n 1.1v 599.745n 1.1v 599.755n 1.1v 604.745n 1.1v 604.755n 1.1v 609.745n 1.1v 609.755n 1.1v 614.745n 1.1v 614.755n 1.1v 619.745n 1.1v 619.755n 1.1v 624.745n 1.1v 624.755n 1.1v 629.745n 1.1v 629.755n 0.0v 634.745n 0.0v 634.755n 0.0v 639.745n 0.0v 639.755n 0.0v 644.745n 0.0v 644.755n 0.0v 649.745n 0.0v 649.755n 0.0v 654.745n 0.0v 654.755n 0.0v 659.745n 0.0v 659.755n 0.0v 664.745n 0.0v 664.755n 0.0v 669.745n 0.0v 669.755n 0.0v 674.745n 0.0v 674.755n 0.0v 679.745n 0.0v 679.755n 0.0v 684.745n 0.0v 684.755n 0.0v 689.745n 0.0v 689.755n 0.0v 694.745n 0.0v 694.755n 0.0v 699.745n 0.0v 699.755n 0.0v 704.745n 0.0v 704.755n 0.0v 709.745n 0.0v 709.755n 0.0v 714.745n 0.0v 714.755n 0.0v 719.745n 0.0v 719.755n 0.0v 724.745n 0.0v 724.755n 0.0v 729.745n 0.0v 729.755n 0.0v 734.745n 0.0v 734.755n 0.0v 739.745n 0.0v 739.755n 1.1v 744.745n 1.1v 744.755n 1.1v 749.745n 1.1v 749.755n 1.1v 754.745n 1.1v 754.755n 0.0v 759.745n 0.0v 759.755n 0.0v 764.745n 0.0v 764.755n 0.0v 769.745n 0.0v 769.755n 1.1v 774.745n 1.1v 774.755n 0.0v 779.745n 0.0v 779.755n 0.0v 784.745n 0.0v 784.755n 0.0v 789.745n 0.0v 789.755n 0.0v 794.745n 0.0v 794.755n 0.0v 799.745n 0.0v 799.755n 0.0v 804.745n 0.0v 804.755n 0.0v 809.745n 0.0v 809.755n 0.0v 814.745n 0.0v 814.755n 0.0v 819.745n 0.0v 819.755n 1.1v 824.745n 1.1v 824.755n 1.1v 829.745n 1.1v 829.755n 1.1v 834.745n 1.1v 834.755n 0.0v 839.745n 0.0v 839.755n 0.0v 844.745n 0.0v 844.755n 0.0v 849.745n 0.0v 849.755n 0.0v 854.745n 0.0v 854.755n 0.0v 859.745n 0.0v 859.755n 1.1v 864.745n 1.1v 864.755n 1.1v 869.745n 1.1v 869.755n 1.1v 874.745n 1.1v 874.755n 1.1v 879.745n 1.1v 879.755n 1.1v 884.745n 1.1v 884.755n 1.1v 889.745n 1.1v 889.755n 1.1v 894.745n 1.1v 894.755n 1.1v 899.745n 1.1v 899.755n 1.1v 904.745n 1.1v 904.755n 1.1v 909.745n 1.1v 909.755n 1.1v 914.745n 1.1v 914.755n 1.1v 919.745n 1.1v 919.755n 1.1v 924.745n 1.1v 924.755n 1.1v 929.745n 1.1v 929.755n 1.1v 934.745n 1.1v 934.755n 0.0v 939.745n 0.0v 939.755n 1.1v 944.745n 1.1v 944.755n 1.1v 949.745n 1.1v 949.755n 1.1v 954.745n 1.1v 954.755n 0.0v 959.745n 0.0v 959.755n 0.0v 964.745n 0.0v 964.755n 1.1v 969.745n 1.1v 969.755n 1.1v 974.745n 1.1v 974.755n 1.1v 979.745n 1.1v 979.755n 1.1v 984.745n 1.1v 984.755n 0.0v 989.745n 0.0v 989.755n 0.0v 994.745n 0.0v 994.755n 0.0v 999.745n 0.0v 999.755n 1.1v 1004.745n 1.1v 1004.755n 1.1v 1009.745n 1.1v 1009.755n 1.1v 1014.745n 1.1v 1014.755n 1.1v 1019.745n 1.1v 1019.755n 1.1v 1024.745n 1.1v 1024.755n 1.1v )
* (time, data): [(0, 0), (5, 1), (10, 0), (15, 0), (20, 0), (25, 0), (30, 0), (35, 0), (40, 0), (45, 1), (50, 1), (55, 1), (60, 0), (65, 1), (70, 1), (75, 1), (80, 1), (85, 1), (90, 0), (95, 0), (100, 1), (105, 1), (110, 1), (115, 1), (120, 1), (125, 1), (130, 1), (135, 0), (140, 1), (145, 1), (150, 1), (155, 1), (160, 1), (165, 1), (170, 0), (175, 0), (180, 0), (185, 1), (190, 1), (195, 1), (200, 0), (205, 0), (210, 0), (215, 0), (220, 0), (225, 0), (230, 0), (235, 0), (240, 0), (245, 0), (250, 0), (255, 0), (260, 0), (265, 1), (270, 1), (275, 1), (280, 0), (285, 0), (290, 0), (295, 0), (300, 0), (305, 0), (310, 0), (315, 0), (320, 0), (325, 0), (330, 0), (335, 1), (340, 1), (345, 1), (350, 1), (355, 1), (360, 1), (365, 1), (370, 1), (375, 1), (380, 1), (385, 1), (390, 1), (395, 1), (400, 0), (405, 0), (410, 1), (415, 0), (420, 0), (425, 1), (430, 0), (435, 0), (440, 0), (445, 0), (450, 1), (455, 1), (460, 1), (465, 1), (470, 1), (475, 1), (480, 1), (485, 1), (490, 1), (495, 1), (500, 0), (505, 1), (510, 1), (515, 0), (520, 0), (525, 0), (530, 0), (535, 1), (540, 0), (545, 0), (550, 0), (555, 1), (560, 1), (565, 1), (570, 1), (575, 1), (580, 1), (585, 1), (590, 1), (595, 1), (600, 1), (605, 1), (610, 1), (615, 1), (620, 1), (625, 1), (630, 0), (635, 1), (640, 0), (645, 0), (650, 0), (655, 0), (660, 1), (665, 1), (670, 1), (675, 1), (680, 1), (685, 1), (690, 1), (695, 1), (700, 1), (705, 0), (710, 1), (715, 0), (720, 0), (725, 0), (730, 0), (735, 0), (740, 1), (745, 1), (750, 1), (755, 0), (760, 0), (765, 0), (770, 1), (775, 0), (780, 0), (785, 1), (790, 1), (795, 1), (800, 1), (805, 1), (810, 1), (815, 1), (820, 0), (825, 0), (830, 1), (835, 0), (840, 0), (845, 0), (850, 0), (855, 1), (860, 1), (865, 0), (870, 0), (875, 1), (880, 1), (885, 1), (890, 1), (895, 1), (900, 1), (905, 1), (910, 0), (915, 0), (920, 0), (925, 0), (930, 0), (935, 1), (940, 0), (945, 0), (950, 0), (955, 1), (960, 1), (965, 0), (970, 0), (975, 0), (980, 1), (985, 0), (990, 0), (995, 0), (1000, 1), (1005, 1), (1010, 1), (1015, 1), (1020, 0), (1025, 0)]
Vdin0_3  din0_3  0 PWL (0n 0.0v 4.745n 0.0v 4.755n 1.1v 9.745n 1.1v 9.755n 0.0v 14.745n 0.0v 14.755n 0.0v 19.745n 0.0v 19.755n 0.0v 24.745n 0.0v 24.755n 0.0v 29.745n 0.0v 29.755n 0.0v 34.745n 0.0v 34.755n 0.0v 39.745n 0.0v 39.755n 0.0v 44.745n 0.0v 44.755n 1.1v 49.745n 1.1v 49.755n 1.1v 54.745n 1.1v 54.755n 1.1v 59.745n 1.1v 59.755n 0.0v 64.745n 0.0v 64.755n 1.1v 69.745n 1.1v 69.755n 1.1v 74.745n 1.1v 74.755n 1.1v 79.745n 1.1v 79.755n 1.1v 84.745n 1.1v 84.755n 1.1v 89.745n 1.1v 89.755n 0.0v 94.745n 0.0v 94.755n 0.0v 99.745n 0.0v 99.755n 1.1v 104.745n 1.1v 104.755n 1.1v 109.745n 1.1v 109.755n 1.1v 114.745n 1.1v 114.755n 1.1v 119.745n 1.1v 119.755n 1.1v 124.745n 1.1v 124.755n 1.1v 129.745n 1.1v 129.755n 1.1v 134.745n 1.1v 134.755n 0.0v 139.745n 0.0v 139.755n 1.1v 144.745n 1.1v 144.755n 1.1v 149.745n 1.1v 149.755n 1.1v 154.745n 1.1v 154.755n 1.1v 159.745n 1.1v 159.755n 1.1v 164.745n 1.1v 164.755n 1.1v 169.745n 1.1v 169.755n 0.0v 174.745n 0.0v 174.755n 0.0v 179.745n 0.0v 179.755n 0.0v 184.745n 0.0v 184.755n 1.1v 189.745n 1.1v 189.755n 1.1v 194.745n 1.1v 194.755n 1.1v 199.745n 1.1v 199.755n 0.0v 204.745n 0.0v 204.755n 0.0v 209.745n 0.0v 209.755n 0.0v 214.745n 0.0v 214.755n 0.0v 219.745n 0.0v 219.755n 0.0v 224.745n 0.0v 224.755n 0.0v 229.745n 0.0v 229.755n 0.0v 234.745n 0.0v 234.755n 0.0v 239.745n 0.0v 239.755n 0.0v 244.745n 0.0v 244.755n 0.0v 249.745n 0.0v 249.755n 0.0v 254.745n 0.0v 254.755n 0.0v 259.745n 0.0v 259.755n 0.0v 264.745n 0.0v 264.755n 1.1v 269.745n 1.1v 269.755n 1.1v 274.745n 1.1v 274.755n 1.1v 279.745n 1.1v 279.755n 0.0v 284.745n 0.0v 284.755n 0.0v 289.745n 0.0v 289.755n 0.0v 294.745n 0.0v 294.755n 0.0v 299.745n 0.0v 299.755n 0.0v 304.745n 0.0v 304.755n 0.0v 309.745n 0.0v 309.755n 0.0v 314.745n 0.0v 314.755n 0.0v 319.745n 0.0v 319.755n 0.0v 324.745n 0.0v 324.755n 0.0v 329.745n 0.0v 329.755n 0.0v 334.745n 0.0v 334.755n 1.1v 339.745n 1.1v 339.755n 1.1v 344.745n 1.1v 344.755n 1.1v 349.745n 1.1v 349.755n 1.1v 354.745n 1.1v 354.755n 1.1v 359.745n 1.1v 359.755n 1.1v 364.745n 1.1v 364.755n 1.1v 369.745n 1.1v 369.755n 1.1v 374.745n 1.1v 374.755n 1.1v 379.745n 1.1v 379.755n 1.1v 384.745n 1.1v 384.755n 1.1v 389.745n 1.1v 389.755n 1.1v 394.745n 1.1v 394.755n 1.1v 399.745n 1.1v 399.755n 0.0v 404.745n 0.0v 404.755n 0.0v 409.745n 0.0v 409.755n 1.1v 414.745n 1.1v 414.755n 0.0v 419.745n 0.0v 419.755n 0.0v 424.745n 0.0v 424.755n 1.1v 429.745n 1.1v 429.755n 0.0v 434.745n 0.0v 434.755n 0.0v 439.745n 0.0v 439.755n 0.0v 444.745n 0.0v 444.755n 0.0v 449.745n 0.0v 449.755n 1.1v 454.745n 1.1v 454.755n 1.1v 459.745n 1.1v 459.755n 1.1v 464.745n 1.1v 464.755n 1.1v 469.745n 1.1v 469.755n 1.1v 474.745n 1.1v 474.755n 1.1v 479.745n 1.1v 479.755n 1.1v 484.745n 1.1v 484.755n 1.1v 489.745n 1.1v 489.755n 1.1v 494.745n 1.1v 494.755n 1.1v 499.745n 1.1v 499.755n 0.0v 504.745n 0.0v 504.755n 1.1v 509.745n 1.1v 509.755n 1.1v 514.745n 1.1v 514.755n 0.0v 519.745n 0.0v 519.755n 0.0v 524.745n 0.0v 524.755n 0.0v 529.745n 0.0v 529.755n 0.0v 534.745n 0.0v 534.755n 1.1v 539.745n 1.1v 539.755n 0.0v 544.745n 0.0v 544.755n 0.0v 549.745n 0.0v 549.755n 0.0v 554.745n 0.0v 554.755n 1.1v 559.745n 1.1v 559.755n 1.1v 564.745n 1.1v 564.755n 1.1v 569.745n 1.1v 569.755n 1.1v 574.745n 1.1v 574.755n 1.1v 579.745n 1.1v 579.755n 1.1v 584.745n 1.1v 584.755n 1.1v 589.745n 1.1v 589.755n 1.1v 594.745n 1.1v 594.755n 1.1v 599.745n 1.1v 599.755n 1.1v 604.745n 1.1v 604.755n 1.1v 609.745n 1.1v 609.755n 1.1v 614.745n 1.1v 614.755n 1.1v 619.745n 1.1v 619.755n 1.1v 624.745n 1.1v 624.755n 1.1v 629.745n 1.1v 629.755n 0.0v 634.745n 0.0v 634.755n 1.1v 639.745n 1.1v 639.755n 0.0v 644.745n 0.0v 644.755n 0.0v 649.745n 0.0v 649.755n 0.0v 654.745n 0.0v 654.755n 0.0v 659.745n 0.0v 659.755n 1.1v 664.745n 1.1v 664.755n 1.1v 669.745n 1.1v 669.755n 1.1v 674.745n 1.1v 674.755n 1.1v 679.745n 1.1v 679.755n 1.1v 684.745n 1.1v 684.755n 1.1v 689.745n 1.1v 689.755n 1.1v 694.745n 1.1v 694.755n 1.1v 699.745n 1.1v 699.755n 1.1v 704.745n 1.1v 704.755n 0.0v 709.745n 0.0v 709.755n 1.1v 714.745n 1.1v 714.755n 0.0v 719.745n 0.0v 719.755n 0.0v 724.745n 0.0v 724.755n 0.0v 729.745n 0.0v 729.755n 0.0v 734.745n 0.0v 734.755n 0.0v 739.745n 0.0v 739.755n 1.1v 744.745n 1.1v 744.755n 1.1v 749.745n 1.1v 749.755n 1.1v 754.745n 1.1v 754.755n 0.0v 759.745n 0.0v 759.755n 0.0v 764.745n 0.0v 764.755n 0.0v 769.745n 0.0v 769.755n 1.1v 774.745n 1.1v 774.755n 0.0v 779.745n 0.0v 779.755n 0.0v 784.745n 0.0v 784.755n 1.1v 789.745n 1.1v 789.755n 1.1v 794.745n 1.1v 794.755n 1.1v 799.745n 1.1v 799.755n 1.1v 804.745n 1.1v 804.755n 1.1v 809.745n 1.1v 809.755n 1.1v 814.745n 1.1v 814.755n 1.1v 819.745n 1.1v 819.755n 0.0v 824.745n 0.0v 824.755n 0.0v 829.745n 0.0v 829.755n 1.1v 834.745n 1.1v 834.755n 0.0v 839.745n 0.0v 839.755n 0.0v 844.745n 0.0v 844.755n 0.0v 849.745n 0.0v 849.755n 0.0v 854.745n 0.0v 854.755n 1.1v 859.745n 1.1v 859.755n 1.1v 864.745n 1.1v 864.755n 0.0v 869.745n 0.0v 869.755n 0.0v 874.745n 0.0v 874.755n 1.1v 879.745n 1.1v 879.755n 1.1v 884.745n 1.1v 884.755n 1.1v 889.745n 1.1v 889.755n 1.1v 894.745n 1.1v 894.755n 1.1v 899.745n 1.1v 899.755n 1.1v 904.745n 1.1v 904.755n 1.1v 909.745n 1.1v 909.755n 0.0v 914.745n 0.0v 914.755n 0.0v 919.745n 0.0v 919.755n 0.0v 924.745n 0.0v 924.755n 0.0v 929.745n 0.0v 929.755n 0.0v 934.745n 0.0v 934.755n 1.1v 939.745n 1.1v 939.755n 0.0v 944.745n 0.0v 944.755n 0.0v 949.745n 0.0v 949.755n 0.0v 954.745n 0.0v 954.755n 1.1v 959.745n 1.1v 959.755n 1.1v 964.745n 1.1v 964.755n 0.0v 969.745n 0.0v 969.755n 0.0v 974.745n 0.0v 974.755n 0.0v 979.745n 0.0v 979.755n 1.1v 984.745n 1.1v 984.755n 0.0v 989.745n 0.0v 989.755n 0.0v 994.745n 0.0v 994.755n 0.0v 999.745n 0.0v 999.755n 1.1v 1004.745n 1.1v 1004.755n 1.1v 1009.745n 1.1v 1009.755n 1.1v 1014.745n 1.1v 1014.755n 1.1v 1019.745n 1.1v 1019.755n 0.0v 1024.745n 0.0v 1024.755n 0.0v )
* (time, data): [(0, 0), (5, 1), (10, 1), (15, 0), (20, 0), (25, 0), (30, 1), (35, 1), (40, 0), (45, 0), (50, 0), (55, 0), (60, 0), (65, 1), (70, 1), (75, 1), (80, 1), (85, 1), (90, 0), (95, 0), (100, 0), (105, 0), (110, 0), (115, 0), (120, 0), (125, 0), (130, 0), (135, 0), (140, 0), (145, 0), (150, 0), (155, 0), (160, 0), (165, 0), (170, 1), (175, 1), (180, 1), (185, 0), (190, 0), (195, 0), (200, 0), (205, 0), (210, 0), (215, 0), (220, 0), (225, 0), (230, 0), (235, 0), (240, 0), (245, 0), (250, 0), (255, 0), (260, 0), (265, 1), (270, 1), (275, 1), (280, 0), (285, 0), (290, 0), (295, 0), (300, 1), (305, 1), (310, 1), (315, 1), (320, 1), (325, 1), (330, 1), (335, 1), (340, 1), (345, 1), (350, 1), (355, 1), (360, 0), (365, 0), (370, 0), (375, 0), (380, 0), (385, 0), (390, 0), (395, 1), (400, 0), (405, 0), (410, 1), (415, 0), (420, 1), (425, 0), (430, 0), (435, 0), (440, 0), (445, 0), (450, 1), (455, 1), (460, 0), (465, 1), (470, 0), (475, 0), (480, 0), (485, 0), (490, 0), (495, 0), (500, 1), (505, 0), (510, 1), (515, 1), (520, 1), (525, 1), (530, 1), (535, 0), (540, 1), (545, 1), (550, 1), (555, 0), (560, 0), (565, 0), (570, 0), (575, 0), (580, 0), (585, 0), (590, 0), (595, 0), (600, 0), (605, 0), (610, 0), (615, 0), (620, 0), (625, 0), (630, 1), (635, 0), (640, 1), (645, 1), (650, 1), (655, 0), (660, 0), (665, 0), (670, 1), (675, 1), (680, 1), (685, 1), (690, 1), (695, 1), (700, 1), (705, 1), (710, 0), (715, 1), (720, 1), (725, 1), (730, 1), (735, 0), (740, 0), (745, 0), (750, 0), (755, 0), (760, 0), (765, 0), (770, 0), (775, 0), (780, 0), (785, 1), (790, 0), (795, 0), (800, 0), (805, 0), (810, 0), (815, 0), (820, 1), (825, 1), (830, 0), (835, 0), (840, 0), (845, 0), (850, 0), (855, 0), (860, 1), (865, 1), (870, 0), (875, 0), (880, 0), (885, 1), (890, 1), (895, 1), (900, 1), (905, 1), (910, 1), (915, 1), (920, 1), (925, 1), (930, 0), (935, 0), (940, 1), (945, 1), (950, 1), (955, 1), (960, 1), (965, 0), (970, 0), (975, 0), (980, 1), (985, 1), (990, 1), (995, 1), (1000, 1), (1005, 1), (1010, 1), (1015, 1), (1020, 0), (1025, 0)]
Vdin0_4  din0_4  0 PWL (0n 0.0v 4.745n 0.0v 4.755n 1.1v 9.745n 1.1v 9.755n 1.1v 14.745n 1.1v 14.755n 0.0v 19.745n 0.0v 19.755n 0.0v 24.745n 0.0v 24.755n 0.0v 29.745n 0.0v 29.755n 1.1v 34.745n 1.1v 34.755n 1.1v 39.745n 1.1v 39.755n 0.0v 44.745n 0.0v 44.755n 0.0v 49.745n 0.0v 49.755n 0.0v 54.745n 0.0v 54.755n 0.0v 59.745n 0.0v 59.755n 0.0v 64.745n 0.0v 64.755n 1.1v 69.745n 1.1v 69.755n 1.1v 74.745n 1.1v 74.755n 1.1v 79.745n 1.1v 79.755n 1.1v 84.745n 1.1v 84.755n 1.1v 89.745n 1.1v 89.755n 0.0v 94.745n 0.0v 94.755n 0.0v 99.745n 0.0v 99.755n 0.0v 104.745n 0.0v 104.755n 0.0v 109.745n 0.0v 109.755n 0.0v 114.745n 0.0v 114.755n 0.0v 119.745n 0.0v 119.755n 0.0v 124.745n 0.0v 124.755n 0.0v 129.745n 0.0v 129.755n 0.0v 134.745n 0.0v 134.755n 0.0v 139.745n 0.0v 139.755n 0.0v 144.745n 0.0v 144.755n 0.0v 149.745n 0.0v 149.755n 0.0v 154.745n 0.0v 154.755n 0.0v 159.745n 0.0v 159.755n 0.0v 164.745n 0.0v 164.755n 0.0v 169.745n 0.0v 169.755n 1.1v 174.745n 1.1v 174.755n 1.1v 179.745n 1.1v 179.755n 1.1v 184.745n 1.1v 184.755n 0.0v 189.745n 0.0v 189.755n 0.0v 194.745n 0.0v 194.755n 0.0v 199.745n 0.0v 199.755n 0.0v 204.745n 0.0v 204.755n 0.0v 209.745n 0.0v 209.755n 0.0v 214.745n 0.0v 214.755n 0.0v 219.745n 0.0v 219.755n 0.0v 224.745n 0.0v 224.755n 0.0v 229.745n 0.0v 229.755n 0.0v 234.745n 0.0v 234.755n 0.0v 239.745n 0.0v 239.755n 0.0v 244.745n 0.0v 244.755n 0.0v 249.745n 0.0v 249.755n 0.0v 254.745n 0.0v 254.755n 0.0v 259.745n 0.0v 259.755n 0.0v 264.745n 0.0v 264.755n 1.1v 269.745n 1.1v 269.755n 1.1v 274.745n 1.1v 274.755n 1.1v 279.745n 1.1v 279.755n 0.0v 284.745n 0.0v 284.755n 0.0v 289.745n 0.0v 289.755n 0.0v 294.745n 0.0v 294.755n 0.0v 299.745n 0.0v 299.755n 1.1v 304.745n 1.1v 304.755n 1.1v 309.745n 1.1v 309.755n 1.1v 314.745n 1.1v 314.755n 1.1v 319.745n 1.1v 319.755n 1.1v 324.745n 1.1v 324.755n 1.1v 329.745n 1.1v 329.755n 1.1v 334.745n 1.1v 334.755n 1.1v 339.745n 1.1v 339.755n 1.1v 344.745n 1.1v 344.755n 1.1v 349.745n 1.1v 349.755n 1.1v 354.745n 1.1v 354.755n 1.1v 359.745n 1.1v 359.755n 0.0v 364.745n 0.0v 364.755n 0.0v 369.745n 0.0v 369.755n 0.0v 374.745n 0.0v 374.755n 0.0v 379.745n 0.0v 379.755n 0.0v 384.745n 0.0v 384.755n 0.0v 389.745n 0.0v 389.755n 0.0v 394.745n 0.0v 394.755n 1.1v 399.745n 1.1v 399.755n 0.0v 404.745n 0.0v 404.755n 0.0v 409.745n 0.0v 409.755n 1.1v 414.745n 1.1v 414.755n 0.0v 419.745n 0.0v 419.755n 1.1v 424.745n 1.1v 424.755n 0.0v 429.745n 0.0v 429.755n 0.0v 434.745n 0.0v 434.755n 0.0v 439.745n 0.0v 439.755n 0.0v 444.745n 0.0v 444.755n 0.0v 449.745n 0.0v 449.755n 1.1v 454.745n 1.1v 454.755n 1.1v 459.745n 1.1v 459.755n 0.0v 464.745n 0.0v 464.755n 1.1v 469.745n 1.1v 469.755n 0.0v 474.745n 0.0v 474.755n 0.0v 479.745n 0.0v 479.755n 0.0v 484.745n 0.0v 484.755n 0.0v 489.745n 0.0v 489.755n 0.0v 494.745n 0.0v 494.755n 0.0v 499.745n 0.0v 499.755n 1.1v 504.745n 1.1v 504.755n 0.0v 509.745n 0.0v 509.755n 1.1v 514.745n 1.1v 514.755n 1.1v 519.745n 1.1v 519.755n 1.1v 524.745n 1.1v 524.755n 1.1v 529.745n 1.1v 529.755n 1.1v 534.745n 1.1v 534.755n 0.0v 539.745n 0.0v 539.755n 1.1v 544.745n 1.1v 544.755n 1.1v 549.745n 1.1v 549.755n 1.1v 554.745n 1.1v 554.755n 0.0v 559.745n 0.0v 559.755n 0.0v 564.745n 0.0v 564.755n 0.0v 569.745n 0.0v 569.755n 0.0v 574.745n 0.0v 574.755n 0.0v 579.745n 0.0v 579.755n 0.0v 584.745n 0.0v 584.755n 0.0v 589.745n 0.0v 589.755n 0.0v 594.745n 0.0v 594.755n 0.0v 599.745n 0.0v 599.755n 0.0v 604.745n 0.0v 604.755n 0.0v 609.745n 0.0v 609.755n 0.0v 614.745n 0.0v 614.755n 0.0v 619.745n 0.0v 619.755n 0.0v 624.745n 0.0v 624.755n 0.0v 629.745n 0.0v 629.755n 1.1v 634.745n 1.1v 634.755n 0.0v 639.745n 0.0v 639.755n 1.1v 644.745n 1.1v 644.755n 1.1v 649.745n 1.1v 649.755n 1.1v 654.745n 1.1v 654.755n 0.0v 659.745n 0.0v 659.755n 0.0v 664.745n 0.0v 664.755n 0.0v 669.745n 0.0v 669.755n 1.1v 674.745n 1.1v 674.755n 1.1v 679.745n 1.1v 679.755n 1.1v 684.745n 1.1v 684.755n 1.1v 689.745n 1.1v 689.755n 1.1v 694.745n 1.1v 694.755n 1.1v 699.745n 1.1v 699.755n 1.1v 704.745n 1.1v 704.755n 1.1v 709.745n 1.1v 709.755n 0.0v 714.745n 0.0v 714.755n 1.1v 719.745n 1.1v 719.755n 1.1v 724.745n 1.1v 724.755n 1.1v 729.745n 1.1v 729.755n 1.1v 734.745n 1.1v 734.755n 0.0v 739.745n 0.0v 739.755n 0.0v 744.745n 0.0v 744.755n 0.0v 749.745n 0.0v 749.755n 0.0v 754.745n 0.0v 754.755n 0.0v 759.745n 0.0v 759.755n 0.0v 764.745n 0.0v 764.755n 0.0v 769.745n 0.0v 769.755n 0.0v 774.745n 0.0v 774.755n 0.0v 779.745n 0.0v 779.755n 0.0v 784.745n 0.0v 784.755n 1.1v 789.745n 1.1v 789.755n 0.0v 794.745n 0.0v 794.755n 0.0v 799.745n 0.0v 799.755n 0.0v 804.745n 0.0v 804.755n 0.0v 809.745n 0.0v 809.755n 0.0v 814.745n 0.0v 814.755n 0.0v 819.745n 0.0v 819.755n 1.1v 824.745n 1.1v 824.755n 1.1v 829.745n 1.1v 829.755n 0.0v 834.745n 0.0v 834.755n 0.0v 839.745n 0.0v 839.755n 0.0v 844.745n 0.0v 844.755n 0.0v 849.745n 0.0v 849.755n 0.0v 854.745n 0.0v 854.755n 0.0v 859.745n 0.0v 859.755n 1.1v 864.745n 1.1v 864.755n 1.1v 869.745n 1.1v 869.755n 0.0v 874.745n 0.0v 874.755n 0.0v 879.745n 0.0v 879.755n 0.0v 884.745n 0.0v 884.755n 1.1v 889.745n 1.1v 889.755n 1.1v 894.745n 1.1v 894.755n 1.1v 899.745n 1.1v 899.755n 1.1v 904.745n 1.1v 904.755n 1.1v 909.745n 1.1v 909.755n 1.1v 914.745n 1.1v 914.755n 1.1v 919.745n 1.1v 919.755n 1.1v 924.745n 1.1v 924.755n 1.1v 929.745n 1.1v 929.755n 0.0v 934.745n 0.0v 934.755n 0.0v 939.745n 0.0v 939.755n 1.1v 944.745n 1.1v 944.755n 1.1v 949.745n 1.1v 949.755n 1.1v 954.745n 1.1v 954.755n 1.1v 959.745n 1.1v 959.755n 1.1v 964.745n 1.1v 964.755n 0.0v 969.745n 0.0v 969.755n 0.0v 974.745n 0.0v 974.755n 0.0v 979.745n 0.0v 979.755n 1.1v 984.745n 1.1v 984.755n 1.1v 989.745n 1.1v 989.755n 1.1v 994.745n 1.1v 994.755n 1.1v 999.745n 1.1v 999.755n 1.1v 1004.745n 1.1v 1004.755n 1.1v 1009.745n 1.1v 1009.755n 1.1v 1014.745n 1.1v 1014.755n 1.1v 1019.745n 1.1v 1019.755n 0.0v 1024.745n 0.0v 1024.755n 0.0v )
* (time, data): [(0, 0), (5, 0), (10, 0), (15, 1), (20, 1), (25, 1), (30, 0), (35, 0), (40, 1), (45, 0), (50, 0), (55, 0), (60, 0), (65, 1), (70, 1), (75, 1), (80, 1), (85, 1), (90, 0), (95, 0), (100, 0), (105, 0), (110, 0), (115, 0), (120, 0), (125, 0), (130, 0), (135, 0), (140, 0), (145, 0), (150, 0), (155, 0), (160, 0), (165, 0), (170, 0), (175, 0), (180, 0), (185, 0), (190, 0), (195, 0), (200, 1), (205, 1), (210, 1), (215, 1), (220, 1), (225, 1), (230, 0), (235, 0), (240, 0), (245, 0), (250, 0), (255, 1), (260, 1), (265, 1), (270, 1), (275, 1), (280, 0), (285, 0), (290, 0), (295, 0), (300, 1), (305, 1), (310, 1), (315, 0), (320, 0), (325, 0), (330, 0), (335, 0), (340, 0), (345, 0), (350, 0), (355, 0), (360, 0), (365, 0), (370, 0), (375, 0), (380, 0), (385, 0), (390, 0), (395, 1), (400, 1), (405, 1), (410, 1), (415, 0), (420, 1), (425, 1), (430, 0), (435, 0), (440, 0), (445, 0), (450, 1), (455, 1), (460, 0), (465, 0), (470, 1), (475, 1), (480, 0), (485, 0), (490, 0), (495, 1), (500, 0), (505, 0), (510, 1), (515, 1), (520, 1), (525, 1), (530, 1), (535, 1), (540, 1), (545, 1), (550, 1), (555, 0), (560, 0), (565, 0), (570, 0), (575, 0), (580, 0), (585, 0), (590, 0), (595, 0), (600, 0), (605, 0), (610, 0), (615, 0), (620, 0), (625, 0), (630, 0), (635, 1), (640, 1), (645, 1), (650, 1), (655, 0), (660, 1), (665, 1), (670, 1), (675, 1), (680, 1), (685, 1), (690, 1), (695, 1), (700, 1), (705, 0), (710, 1), (715, 1), (720, 1), (725, 1), (730, 1), (735, 1), (740, 1), (745, 1), (750, 1), (755, 0), (760, 0), (765, 0), (770, 0), (775, 0), (780, 0), (785, 1), (790, 1), (795, 1), (800, 1), (805, 1), (810, 1), (815, 1), (820, 1), (825, 1), (830, 0), (835, 1), (840, 1), (845, 1), (850, 1), (855, 1), (860, 1), (865, 0), (870, 0), (875, 0), (880, 1), (885, 0), (890, 0), (895, 0), (900, 0), (905, 0), (910, 1), (915, 1), (920, 1), (925, 1), (930, 0), (935, 1), (940, 1), (945, 1), (950, 1), (955, 0), (960, 0), (965, 1), (970, 1), (975, 1), (980, 0), (985, 1), (990, 1), (995, 1), (1000, 0), (1005, 0), (1010, 0), (1015, 0), (1020, 1), (1025, 1)]
Vdin0_5  din0_5  0 PWL (0n 0.0v 4.745n 0.0v 4.755n 0.0v 9.745n 0.0v 9.755n 0.0v 14.745n 0.0v 14.755n 1.1v 19.745n 1.1v 19.755n 1.1v 24.745n 1.1v 24.755n 1.1v 29.745n 1.1v 29.755n 0.0v 34.745n 0.0v 34.755n 0.0v 39.745n 0.0v 39.755n 1.1v 44.745n 1.1v 44.755n 0.0v 49.745n 0.0v 49.755n 0.0v 54.745n 0.0v 54.755n 0.0v 59.745n 0.0v 59.755n 0.0v 64.745n 0.0v 64.755n 1.1v 69.745n 1.1v 69.755n 1.1v 74.745n 1.1v 74.755n 1.1v 79.745n 1.1v 79.755n 1.1v 84.745n 1.1v 84.755n 1.1v 89.745n 1.1v 89.755n 0.0v 94.745n 0.0v 94.755n 0.0v 99.745n 0.0v 99.755n 0.0v 104.745n 0.0v 104.755n 0.0v 109.745n 0.0v 109.755n 0.0v 114.745n 0.0v 114.755n 0.0v 119.745n 0.0v 119.755n 0.0v 124.745n 0.0v 124.755n 0.0v 129.745n 0.0v 129.755n 0.0v 134.745n 0.0v 134.755n 0.0v 139.745n 0.0v 139.755n 0.0v 144.745n 0.0v 144.755n 0.0v 149.745n 0.0v 149.755n 0.0v 154.745n 0.0v 154.755n 0.0v 159.745n 0.0v 159.755n 0.0v 164.745n 0.0v 164.755n 0.0v 169.745n 0.0v 169.755n 0.0v 174.745n 0.0v 174.755n 0.0v 179.745n 0.0v 179.755n 0.0v 184.745n 0.0v 184.755n 0.0v 189.745n 0.0v 189.755n 0.0v 194.745n 0.0v 194.755n 0.0v 199.745n 0.0v 199.755n 1.1v 204.745n 1.1v 204.755n 1.1v 209.745n 1.1v 209.755n 1.1v 214.745n 1.1v 214.755n 1.1v 219.745n 1.1v 219.755n 1.1v 224.745n 1.1v 224.755n 1.1v 229.745n 1.1v 229.755n 0.0v 234.745n 0.0v 234.755n 0.0v 239.745n 0.0v 239.755n 0.0v 244.745n 0.0v 244.755n 0.0v 249.745n 0.0v 249.755n 0.0v 254.745n 0.0v 254.755n 1.1v 259.745n 1.1v 259.755n 1.1v 264.745n 1.1v 264.755n 1.1v 269.745n 1.1v 269.755n 1.1v 274.745n 1.1v 274.755n 1.1v 279.745n 1.1v 279.755n 0.0v 284.745n 0.0v 284.755n 0.0v 289.745n 0.0v 289.755n 0.0v 294.745n 0.0v 294.755n 0.0v 299.745n 0.0v 299.755n 1.1v 304.745n 1.1v 304.755n 1.1v 309.745n 1.1v 309.755n 1.1v 314.745n 1.1v 314.755n 0.0v 319.745n 0.0v 319.755n 0.0v 324.745n 0.0v 324.755n 0.0v 329.745n 0.0v 329.755n 0.0v 334.745n 0.0v 334.755n 0.0v 339.745n 0.0v 339.755n 0.0v 344.745n 0.0v 344.755n 0.0v 349.745n 0.0v 349.755n 0.0v 354.745n 0.0v 354.755n 0.0v 359.745n 0.0v 359.755n 0.0v 364.745n 0.0v 364.755n 0.0v 369.745n 0.0v 369.755n 0.0v 374.745n 0.0v 374.755n 0.0v 379.745n 0.0v 379.755n 0.0v 384.745n 0.0v 384.755n 0.0v 389.745n 0.0v 389.755n 0.0v 394.745n 0.0v 394.755n 1.1v 399.745n 1.1v 399.755n 1.1v 404.745n 1.1v 404.755n 1.1v 409.745n 1.1v 409.755n 1.1v 414.745n 1.1v 414.755n 0.0v 419.745n 0.0v 419.755n 1.1v 424.745n 1.1v 424.755n 1.1v 429.745n 1.1v 429.755n 0.0v 434.745n 0.0v 434.755n 0.0v 439.745n 0.0v 439.755n 0.0v 444.745n 0.0v 444.755n 0.0v 449.745n 0.0v 449.755n 1.1v 454.745n 1.1v 454.755n 1.1v 459.745n 1.1v 459.755n 0.0v 464.745n 0.0v 464.755n 0.0v 469.745n 0.0v 469.755n 1.1v 474.745n 1.1v 474.755n 1.1v 479.745n 1.1v 479.755n 0.0v 484.745n 0.0v 484.755n 0.0v 489.745n 0.0v 489.755n 0.0v 494.745n 0.0v 494.755n 1.1v 499.745n 1.1v 499.755n 0.0v 504.745n 0.0v 504.755n 0.0v 509.745n 0.0v 509.755n 1.1v 514.745n 1.1v 514.755n 1.1v 519.745n 1.1v 519.755n 1.1v 524.745n 1.1v 524.755n 1.1v 529.745n 1.1v 529.755n 1.1v 534.745n 1.1v 534.755n 1.1v 539.745n 1.1v 539.755n 1.1v 544.745n 1.1v 544.755n 1.1v 549.745n 1.1v 549.755n 1.1v 554.745n 1.1v 554.755n 0.0v 559.745n 0.0v 559.755n 0.0v 564.745n 0.0v 564.755n 0.0v 569.745n 0.0v 569.755n 0.0v 574.745n 0.0v 574.755n 0.0v 579.745n 0.0v 579.755n 0.0v 584.745n 0.0v 584.755n 0.0v 589.745n 0.0v 589.755n 0.0v 594.745n 0.0v 594.755n 0.0v 599.745n 0.0v 599.755n 0.0v 604.745n 0.0v 604.755n 0.0v 609.745n 0.0v 609.755n 0.0v 614.745n 0.0v 614.755n 0.0v 619.745n 0.0v 619.755n 0.0v 624.745n 0.0v 624.755n 0.0v 629.745n 0.0v 629.755n 0.0v 634.745n 0.0v 634.755n 1.1v 639.745n 1.1v 639.755n 1.1v 644.745n 1.1v 644.755n 1.1v 649.745n 1.1v 649.755n 1.1v 654.745n 1.1v 654.755n 0.0v 659.745n 0.0v 659.755n 1.1v 664.745n 1.1v 664.755n 1.1v 669.745n 1.1v 669.755n 1.1v 674.745n 1.1v 674.755n 1.1v 679.745n 1.1v 679.755n 1.1v 684.745n 1.1v 684.755n 1.1v 689.745n 1.1v 689.755n 1.1v 694.745n 1.1v 694.755n 1.1v 699.745n 1.1v 699.755n 1.1v 704.745n 1.1v 704.755n 0.0v 709.745n 0.0v 709.755n 1.1v 714.745n 1.1v 714.755n 1.1v 719.745n 1.1v 719.755n 1.1v 724.745n 1.1v 724.755n 1.1v 729.745n 1.1v 729.755n 1.1v 734.745n 1.1v 734.755n 1.1v 739.745n 1.1v 739.755n 1.1v 744.745n 1.1v 744.755n 1.1v 749.745n 1.1v 749.755n 1.1v 754.745n 1.1v 754.755n 0.0v 759.745n 0.0v 759.755n 0.0v 764.745n 0.0v 764.755n 0.0v 769.745n 0.0v 769.755n 0.0v 774.745n 0.0v 774.755n 0.0v 779.745n 0.0v 779.755n 0.0v 784.745n 0.0v 784.755n 1.1v 789.745n 1.1v 789.755n 1.1v 794.745n 1.1v 794.755n 1.1v 799.745n 1.1v 799.755n 1.1v 804.745n 1.1v 804.755n 1.1v 809.745n 1.1v 809.755n 1.1v 814.745n 1.1v 814.755n 1.1v 819.745n 1.1v 819.755n 1.1v 824.745n 1.1v 824.755n 1.1v 829.745n 1.1v 829.755n 0.0v 834.745n 0.0v 834.755n 1.1v 839.745n 1.1v 839.755n 1.1v 844.745n 1.1v 844.755n 1.1v 849.745n 1.1v 849.755n 1.1v 854.745n 1.1v 854.755n 1.1v 859.745n 1.1v 859.755n 1.1v 864.745n 1.1v 864.755n 0.0v 869.745n 0.0v 869.755n 0.0v 874.745n 0.0v 874.755n 0.0v 879.745n 0.0v 879.755n 1.1v 884.745n 1.1v 884.755n 0.0v 889.745n 0.0v 889.755n 0.0v 894.745n 0.0v 894.755n 0.0v 899.745n 0.0v 899.755n 0.0v 904.745n 0.0v 904.755n 0.0v 909.745n 0.0v 909.755n 1.1v 914.745n 1.1v 914.755n 1.1v 919.745n 1.1v 919.755n 1.1v 924.745n 1.1v 924.755n 1.1v 929.745n 1.1v 929.755n 0.0v 934.745n 0.0v 934.755n 1.1v 939.745n 1.1v 939.755n 1.1v 944.745n 1.1v 944.755n 1.1v 949.745n 1.1v 949.755n 1.1v 954.745n 1.1v 954.755n 0.0v 959.745n 0.0v 959.755n 0.0v 964.745n 0.0v 964.755n 1.1v 969.745n 1.1v 969.755n 1.1v 974.745n 1.1v 974.755n 1.1v 979.745n 1.1v 979.755n 0.0v 984.745n 0.0v 984.755n 1.1v 989.745n 1.1v 989.755n 1.1v 994.745n 1.1v 994.755n 1.1v 999.745n 1.1v 999.755n 0.0v 1004.745n 0.0v 1004.755n 0.0v 1009.745n 0.0v 1009.755n 0.0v 1014.745n 0.0v 1014.755n 0.0v 1019.745n 0.0v 1019.755n 1.1v 1024.745n 1.1v 1024.755n 1.1v )
* (time, data): [(0, 0), (5, 1), (10, 0), (15, 0), (20, 0), (25, 0), (30, 1), (35, 1), (40, 0), (45, 1), (50, 1), (55, 1), (60, 1), (65, 0), (70, 0), (75, 0), (80, 0), (85, 0), (90, 1), (95, 1), (100, 1), (105, 1), (110, 1), (115, 1), (120, 1), (125, 1), (130, 1), (135, 1), (140, 0), (145, 0), (150, 0), (155, 0), (160, 0), (165, 0), (170, 1), (175, 1), (180, 1), (185, 1), (190, 1), (195, 1), (200, 1), (205, 1), (210, 0), (215, 0), (220, 0), (225, 0), (230, 1), (235, 1), (240, 1), (245, 1), (250, 1), (255, 0), (260, 0), (265, 0), (270, 0), (275, 0), (280, 1), (285, 1), (290, 1), (295, 1), (300, 0), (305, 0), (310, 0), (315, 1), (320, 1), (325, 1), (330, 0), (335, 1), (340, 0), (345, 0), (350, 0), (355, 0), (360, 1), (365, 1), (370, 1), (375, 1), (380, 1), (385, 1), (390, 1), (395, 0), (400, 1), (405, 1), (410, 1), (415, 1), (420, 0), (425, 0), (430, 0), (435, 0), (440, 0), (445, 0), (450, 0), (455, 0), (460, 1), (465, 0), (470, 1), (475, 1), (480, 0), (485, 0), (490, 0), (495, 1), (500, 1), (505, 1), (510, 0), (515, 1), (520, 1), (525, 1), (530, 1), (535, 1), (540, 1), (545, 1), (550, 1), (555, 0), (560, 0), (565, 0), (570, 0), (575, 1), (580, 1), (585, 1), (590, 1), (595, 1), (600, 1), (605, 1), (610, 1), (615, 1), (620, 1), (625, 1), (630, 1), (635, 0), (640, 0), (645, 0), (650, 0), (655, 0), (660, 1), (665, 1), (670, 1), (675, 1), (680, 1), (685, 1), (690, 1), (695, 1), (700, 1), (705, 0), (710, 1), (715, 0), (720, 0), (725, 0), (730, 0), (735, 1), (740, 1), (745, 1), (750, 1), (755, 0), (760, 0), (765, 0), (770, 1), (775, 0), (780, 0), (785, 0), (790, 1), (795, 1), (800, 1), (805, 1), (810, 1), (815, 1), (820, 1), (825, 1), (830, 0), (835, 0), (840, 0), (845, 0), (850, 0), (855, 0), (860, 0), (865, 0), (870, 0), (875, 1), (880, 1), (885, 0), (890, 0), (895, 0), (900, 0), (905, 0), (910, 0), (915, 0), (920, 0), (925, 0), (930, 1), (935, 0), (940, 1), (945, 1), (950, 1), (955, 1), (960, 1), (965, 0), (970, 0), (975, 0), (980, 0), (985, 1), (990, 1), (995, 1), (1000, 0), (1005, 0), (1010, 0), (1015, 0), (1020, 1), (1025, 1)]
Vdin0_6  din0_6  0 PWL (0n 0.0v 4.745n 0.0v 4.755n 1.1v 9.745n 1.1v 9.755n 0.0v 14.745n 0.0v 14.755n 0.0v 19.745n 0.0v 19.755n 0.0v 24.745n 0.0v 24.755n 0.0v 29.745n 0.0v 29.755n 1.1v 34.745n 1.1v 34.755n 1.1v 39.745n 1.1v 39.755n 0.0v 44.745n 0.0v 44.755n 1.1v 49.745n 1.1v 49.755n 1.1v 54.745n 1.1v 54.755n 1.1v 59.745n 1.1v 59.755n 1.1v 64.745n 1.1v 64.755n 0.0v 69.745n 0.0v 69.755n 0.0v 74.745n 0.0v 74.755n 0.0v 79.745n 0.0v 79.755n 0.0v 84.745n 0.0v 84.755n 0.0v 89.745n 0.0v 89.755n 1.1v 94.745n 1.1v 94.755n 1.1v 99.745n 1.1v 99.755n 1.1v 104.745n 1.1v 104.755n 1.1v 109.745n 1.1v 109.755n 1.1v 114.745n 1.1v 114.755n 1.1v 119.745n 1.1v 119.755n 1.1v 124.745n 1.1v 124.755n 1.1v 129.745n 1.1v 129.755n 1.1v 134.745n 1.1v 134.755n 1.1v 139.745n 1.1v 139.755n 0.0v 144.745n 0.0v 144.755n 0.0v 149.745n 0.0v 149.755n 0.0v 154.745n 0.0v 154.755n 0.0v 159.745n 0.0v 159.755n 0.0v 164.745n 0.0v 164.755n 0.0v 169.745n 0.0v 169.755n 1.1v 174.745n 1.1v 174.755n 1.1v 179.745n 1.1v 179.755n 1.1v 184.745n 1.1v 184.755n 1.1v 189.745n 1.1v 189.755n 1.1v 194.745n 1.1v 194.755n 1.1v 199.745n 1.1v 199.755n 1.1v 204.745n 1.1v 204.755n 1.1v 209.745n 1.1v 209.755n 0.0v 214.745n 0.0v 214.755n 0.0v 219.745n 0.0v 219.755n 0.0v 224.745n 0.0v 224.755n 0.0v 229.745n 0.0v 229.755n 1.1v 234.745n 1.1v 234.755n 1.1v 239.745n 1.1v 239.755n 1.1v 244.745n 1.1v 244.755n 1.1v 249.745n 1.1v 249.755n 1.1v 254.745n 1.1v 254.755n 0.0v 259.745n 0.0v 259.755n 0.0v 264.745n 0.0v 264.755n 0.0v 269.745n 0.0v 269.755n 0.0v 274.745n 0.0v 274.755n 0.0v 279.745n 0.0v 279.755n 1.1v 284.745n 1.1v 284.755n 1.1v 289.745n 1.1v 289.755n 1.1v 294.745n 1.1v 294.755n 1.1v 299.745n 1.1v 299.755n 0.0v 304.745n 0.0v 304.755n 0.0v 309.745n 0.0v 309.755n 0.0v 314.745n 0.0v 314.755n 1.1v 319.745n 1.1v 319.755n 1.1v 324.745n 1.1v 324.755n 1.1v 329.745n 1.1v 329.755n 0.0v 334.745n 0.0v 334.755n 1.1v 339.745n 1.1v 339.755n 0.0v 344.745n 0.0v 344.755n 0.0v 349.745n 0.0v 349.755n 0.0v 354.745n 0.0v 354.755n 0.0v 359.745n 0.0v 359.755n 1.1v 364.745n 1.1v 364.755n 1.1v 369.745n 1.1v 369.755n 1.1v 374.745n 1.1v 374.755n 1.1v 379.745n 1.1v 379.755n 1.1v 384.745n 1.1v 384.755n 1.1v 389.745n 1.1v 389.755n 1.1v 394.745n 1.1v 394.755n 0.0v 399.745n 0.0v 399.755n 1.1v 404.745n 1.1v 404.755n 1.1v 409.745n 1.1v 409.755n 1.1v 414.745n 1.1v 414.755n 1.1v 419.745n 1.1v 419.755n 0.0v 424.745n 0.0v 424.755n 0.0v 429.745n 0.0v 429.755n 0.0v 434.745n 0.0v 434.755n 0.0v 439.745n 0.0v 439.755n 0.0v 444.745n 0.0v 444.755n 0.0v 449.745n 0.0v 449.755n 0.0v 454.745n 0.0v 454.755n 0.0v 459.745n 0.0v 459.755n 1.1v 464.745n 1.1v 464.755n 0.0v 469.745n 0.0v 469.755n 1.1v 474.745n 1.1v 474.755n 1.1v 479.745n 1.1v 479.755n 0.0v 484.745n 0.0v 484.755n 0.0v 489.745n 0.0v 489.755n 0.0v 494.745n 0.0v 494.755n 1.1v 499.745n 1.1v 499.755n 1.1v 504.745n 1.1v 504.755n 1.1v 509.745n 1.1v 509.755n 0.0v 514.745n 0.0v 514.755n 1.1v 519.745n 1.1v 519.755n 1.1v 524.745n 1.1v 524.755n 1.1v 529.745n 1.1v 529.755n 1.1v 534.745n 1.1v 534.755n 1.1v 539.745n 1.1v 539.755n 1.1v 544.745n 1.1v 544.755n 1.1v 549.745n 1.1v 549.755n 1.1v 554.745n 1.1v 554.755n 0.0v 559.745n 0.0v 559.755n 0.0v 564.745n 0.0v 564.755n 0.0v 569.745n 0.0v 569.755n 0.0v 574.745n 0.0v 574.755n 1.1v 579.745n 1.1v 579.755n 1.1v 584.745n 1.1v 584.755n 1.1v 589.745n 1.1v 589.755n 1.1v 594.745n 1.1v 594.755n 1.1v 599.745n 1.1v 599.755n 1.1v 604.745n 1.1v 604.755n 1.1v 609.745n 1.1v 609.755n 1.1v 614.745n 1.1v 614.755n 1.1v 619.745n 1.1v 619.755n 1.1v 624.745n 1.1v 624.755n 1.1v 629.745n 1.1v 629.755n 1.1v 634.745n 1.1v 634.755n 0.0v 639.745n 0.0v 639.755n 0.0v 644.745n 0.0v 644.755n 0.0v 649.745n 0.0v 649.755n 0.0v 654.745n 0.0v 654.755n 0.0v 659.745n 0.0v 659.755n 1.1v 664.745n 1.1v 664.755n 1.1v 669.745n 1.1v 669.755n 1.1v 674.745n 1.1v 674.755n 1.1v 679.745n 1.1v 679.755n 1.1v 684.745n 1.1v 684.755n 1.1v 689.745n 1.1v 689.755n 1.1v 694.745n 1.1v 694.755n 1.1v 699.745n 1.1v 699.755n 1.1v 704.745n 1.1v 704.755n 0.0v 709.745n 0.0v 709.755n 1.1v 714.745n 1.1v 714.755n 0.0v 719.745n 0.0v 719.755n 0.0v 724.745n 0.0v 724.755n 0.0v 729.745n 0.0v 729.755n 0.0v 734.745n 0.0v 734.755n 1.1v 739.745n 1.1v 739.755n 1.1v 744.745n 1.1v 744.755n 1.1v 749.745n 1.1v 749.755n 1.1v 754.745n 1.1v 754.755n 0.0v 759.745n 0.0v 759.755n 0.0v 764.745n 0.0v 764.755n 0.0v 769.745n 0.0v 769.755n 1.1v 774.745n 1.1v 774.755n 0.0v 779.745n 0.0v 779.755n 0.0v 784.745n 0.0v 784.755n 0.0v 789.745n 0.0v 789.755n 1.1v 794.745n 1.1v 794.755n 1.1v 799.745n 1.1v 799.755n 1.1v 804.745n 1.1v 804.755n 1.1v 809.745n 1.1v 809.755n 1.1v 814.745n 1.1v 814.755n 1.1v 819.745n 1.1v 819.755n 1.1v 824.745n 1.1v 824.755n 1.1v 829.745n 1.1v 829.755n 0.0v 834.745n 0.0v 834.755n 0.0v 839.745n 0.0v 839.755n 0.0v 844.745n 0.0v 844.755n 0.0v 849.745n 0.0v 849.755n 0.0v 854.745n 0.0v 854.755n 0.0v 859.745n 0.0v 859.755n 0.0v 864.745n 0.0v 864.755n 0.0v 869.745n 0.0v 869.755n 0.0v 874.745n 0.0v 874.755n 1.1v 879.745n 1.1v 879.755n 1.1v 884.745n 1.1v 884.755n 0.0v 889.745n 0.0v 889.755n 0.0v 894.745n 0.0v 894.755n 0.0v 899.745n 0.0v 899.755n 0.0v 904.745n 0.0v 904.755n 0.0v 909.745n 0.0v 909.755n 0.0v 914.745n 0.0v 914.755n 0.0v 919.745n 0.0v 919.755n 0.0v 924.745n 0.0v 924.755n 0.0v 929.745n 0.0v 929.755n 1.1v 934.745n 1.1v 934.755n 0.0v 939.745n 0.0v 939.755n 1.1v 944.745n 1.1v 944.755n 1.1v 949.745n 1.1v 949.755n 1.1v 954.745n 1.1v 954.755n 1.1v 959.745n 1.1v 959.755n 1.1v 964.745n 1.1v 964.755n 0.0v 969.745n 0.0v 969.755n 0.0v 974.745n 0.0v 974.755n 0.0v 979.745n 0.0v 979.755n 0.0v 984.745n 0.0v 984.755n 1.1v 989.745n 1.1v 989.755n 1.1v 994.745n 1.1v 994.755n 1.1v 999.745n 1.1v 999.755n 0.0v 1004.745n 0.0v 1004.755n 0.0v 1009.745n 0.0v 1009.755n 0.0v 1014.745n 0.0v 1014.755n 0.0v 1019.745n 0.0v 1019.755n 1.1v 1024.745n 1.1v 1024.755n 1.1v )
* (time, data): [(0, 0), (5, 0), (10, 0), (15, 1), (20, 1), (25, 1), (30, 1), (35, 1), (40, 0), (45, 1), (50, 1), (55, 1), (60, 1), (65, 0), (70, 0), (75, 0), (80, 0), (85, 0), (90, 0), (95, 0), (100, 0), (105, 0), (110, 0), (115, 0), (120, 0), (125, 0), (130, 0), (135, 0), (140, 0), (145, 0), (150, 0), (155, 0), (160, 0), (165, 0), (170, 1), (175, 1), (180, 1), (185, 0), (190, 0), (195, 0), (200, 0), (205, 0), (210, 0), (215, 0), (220, 1), (225, 1), (230, 0), (235, 0), (240, 1), (245, 1), (250, 1), (255, 0), (260, 0), (265, 0), (270, 0), (275, 0), (280, 1), (285, 1), (290, 1), (295, 1), (300, 0), (305, 0), (310, 0), (315, 1), (320, 1), (325, 1), (330, 0), (335, 1), (340, 0), (345, 0), (350, 0), (355, 0), (360, 1), (365, 1), (370, 1), (375, 1), (380, 1), (385, 1), (390, 1), (395, 1), (400, 1), (405, 1), (410, 0), (415, 1), (420, 1), (425, 0), (430, 0), (435, 0), (440, 0), (445, 0), (450, 1), (455, 1), (460, 0), (465, 1), (470, 1), (475, 1), (480, 1), (485, 1), (490, 1), (495, 0), (500, 1), (505, 0), (510, 0), (515, 1), (520, 1), (525, 1), (530, 1), (535, 1), (540, 0), (545, 0), (550, 0), (555, 0), (560, 0), (565, 0), (570, 0), (575, 1), (580, 1), (585, 1), (590, 1), (595, 1), (600, 1), (605, 1), (610, 1), (615, 1), (620, 1), (625, 1), (630, 0), (635, 1), (640, 0), (645, 0), (650, 0), (655, 0), (660, 1), (665, 1), (670, 1), (675, 1), (680, 1), (685, 1), (690, 1), (695, 1), (700, 1), (705, 0), (710, 0), (715, 0), (720, 0), (725, 0), (730, 0), (735, 1), (740, 1), (745, 1), (750, 1), (755, 0), (760, 0), (765, 0), (770, 1), (775, 1), (780, 1), (785, 0), (790, 0), (795, 0), (800, 0), (805, 0), (810, 0), (815, 0), (820, 1), (825, 1), (830, 1), (835, 1), (840, 1), (845, 1), (850, 1), (855, 1), (860, 1), (865, 0), (870, 1), (875, 0), (880, 1), (885, 1), (890, 1), (895, 1), (900, 1), (905, 1), (910, 1), (915, 1), (920, 1), (925, 1), (930, 0), (935, 0), (940, 0), (945, 0), (950, 0), (955, 1), (960, 1), (965, 1), (970, 1), (975, 1), (980, 0), (985, 1), (990, 1), (995, 0), (1000, 1), (1005, 1), (1010, 1), (1015, 1), (1020, 0), (1025, 0)]
Vdin0_7  din0_7  0 PWL (0n 0.0v 4.745n 0.0v 4.755n 0.0v 9.745n 0.0v 9.755n 0.0v 14.745n 0.0v 14.755n 1.1v 19.745n 1.1v 19.755n 1.1v 24.745n 1.1v 24.755n 1.1v 29.745n 1.1v 29.755n 1.1v 34.745n 1.1v 34.755n 1.1v 39.745n 1.1v 39.755n 0.0v 44.745n 0.0v 44.755n 1.1v 49.745n 1.1v 49.755n 1.1v 54.745n 1.1v 54.755n 1.1v 59.745n 1.1v 59.755n 1.1v 64.745n 1.1v 64.755n 0.0v 69.745n 0.0v 69.755n 0.0v 74.745n 0.0v 74.755n 0.0v 79.745n 0.0v 79.755n 0.0v 84.745n 0.0v 84.755n 0.0v 89.745n 0.0v 89.755n 0.0v 94.745n 0.0v 94.755n 0.0v 99.745n 0.0v 99.755n 0.0v 104.745n 0.0v 104.755n 0.0v 109.745n 0.0v 109.755n 0.0v 114.745n 0.0v 114.755n 0.0v 119.745n 0.0v 119.755n 0.0v 124.745n 0.0v 124.755n 0.0v 129.745n 0.0v 129.755n 0.0v 134.745n 0.0v 134.755n 0.0v 139.745n 0.0v 139.755n 0.0v 144.745n 0.0v 144.755n 0.0v 149.745n 0.0v 149.755n 0.0v 154.745n 0.0v 154.755n 0.0v 159.745n 0.0v 159.755n 0.0v 164.745n 0.0v 164.755n 0.0v 169.745n 0.0v 169.755n 1.1v 174.745n 1.1v 174.755n 1.1v 179.745n 1.1v 179.755n 1.1v 184.745n 1.1v 184.755n 0.0v 189.745n 0.0v 189.755n 0.0v 194.745n 0.0v 194.755n 0.0v 199.745n 0.0v 199.755n 0.0v 204.745n 0.0v 204.755n 0.0v 209.745n 0.0v 209.755n 0.0v 214.745n 0.0v 214.755n 0.0v 219.745n 0.0v 219.755n 1.1v 224.745n 1.1v 224.755n 1.1v 229.745n 1.1v 229.755n 0.0v 234.745n 0.0v 234.755n 0.0v 239.745n 0.0v 239.755n 1.1v 244.745n 1.1v 244.755n 1.1v 249.745n 1.1v 249.755n 1.1v 254.745n 1.1v 254.755n 0.0v 259.745n 0.0v 259.755n 0.0v 264.745n 0.0v 264.755n 0.0v 269.745n 0.0v 269.755n 0.0v 274.745n 0.0v 274.755n 0.0v 279.745n 0.0v 279.755n 1.1v 284.745n 1.1v 284.755n 1.1v 289.745n 1.1v 289.755n 1.1v 294.745n 1.1v 294.755n 1.1v 299.745n 1.1v 299.755n 0.0v 304.745n 0.0v 304.755n 0.0v 309.745n 0.0v 309.755n 0.0v 314.745n 0.0v 314.755n 1.1v 319.745n 1.1v 319.755n 1.1v 324.745n 1.1v 324.755n 1.1v 329.745n 1.1v 329.755n 0.0v 334.745n 0.0v 334.755n 1.1v 339.745n 1.1v 339.755n 0.0v 344.745n 0.0v 344.755n 0.0v 349.745n 0.0v 349.755n 0.0v 354.745n 0.0v 354.755n 0.0v 359.745n 0.0v 359.755n 1.1v 364.745n 1.1v 364.755n 1.1v 369.745n 1.1v 369.755n 1.1v 374.745n 1.1v 374.755n 1.1v 379.745n 1.1v 379.755n 1.1v 384.745n 1.1v 384.755n 1.1v 389.745n 1.1v 389.755n 1.1v 394.745n 1.1v 394.755n 1.1v 399.745n 1.1v 399.755n 1.1v 404.745n 1.1v 404.755n 1.1v 409.745n 1.1v 409.755n 0.0v 414.745n 0.0v 414.755n 1.1v 419.745n 1.1v 419.755n 1.1v 424.745n 1.1v 424.755n 0.0v 429.745n 0.0v 429.755n 0.0v 434.745n 0.0v 434.755n 0.0v 439.745n 0.0v 439.755n 0.0v 444.745n 0.0v 444.755n 0.0v 449.745n 0.0v 449.755n 1.1v 454.745n 1.1v 454.755n 1.1v 459.745n 1.1v 459.755n 0.0v 464.745n 0.0v 464.755n 1.1v 469.745n 1.1v 469.755n 1.1v 474.745n 1.1v 474.755n 1.1v 479.745n 1.1v 479.755n 1.1v 484.745n 1.1v 484.755n 1.1v 489.745n 1.1v 489.755n 1.1v 494.745n 1.1v 494.755n 0.0v 499.745n 0.0v 499.755n 1.1v 504.745n 1.1v 504.755n 0.0v 509.745n 0.0v 509.755n 0.0v 514.745n 0.0v 514.755n 1.1v 519.745n 1.1v 519.755n 1.1v 524.745n 1.1v 524.755n 1.1v 529.745n 1.1v 529.755n 1.1v 534.745n 1.1v 534.755n 1.1v 539.745n 1.1v 539.755n 0.0v 544.745n 0.0v 544.755n 0.0v 549.745n 0.0v 549.755n 0.0v 554.745n 0.0v 554.755n 0.0v 559.745n 0.0v 559.755n 0.0v 564.745n 0.0v 564.755n 0.0v 569.745n 0.0v 569.755n 0.0v 574.745n 0.0v 574.755n 1.1v 579.745n 1.1v 579.755n 1.1v 584.745n 1.1v 584.755n 1.1v 589.745n 1.1v 589.755n 1.1v 594.745n 1.1v 594.755n 1.1v 599.745n 1.1v 599.755n 1.1v 604.745n 1.1v 604.755n 1.1v 609.745n 1.1v 609.755n 1.1v 614.745n 1.1v 614.755n 1.1v 619.745n 1.1v 619.755n 1.1v 624.745n 1.1v 624.755n 1.1v 629.745n 1.1v 629.755n 0.0v 634.745n 0.0v 634.755n 1.1v 639.745n 1.1v 639.755n 0.0v 644.745n 0.0v 644.755n 0.0v 649.745n 0.0v 649.755n 0.0v 654.745n 0.0v 654.755n 0.0v 659.745n 0.0v 659.755n 1.1v 664.745n 1.1v 664.755n 1.1v 669.745n 1.1v 669.755n 1.1v 674.745n 1.1v 674.755n 1.1v 679.745n 1.1v 679.755n 1.1v 684.745n 1.1v 684.755n 1.1v 689.745n 1.1v 689.755n 1.1v 694.745n 1.1v 694.755n 1.1v 699.745n 1.1v 699.755n 1.1v 704.745n 1.1v 704.755n 0.0v 709.745n 0.0v 709.755n 0.0v 714.745n 0.0v 714.755n 0.0v 719.745n 0.0v 719.755n 0.0v 724.745n 0.0v 724.755n 0.0v 729.745n 0.0v 729.755n 0.0v 734.745n 0.0v 734.755n 1.1v 739.745n 1.1v 739.755n 1.1v 744.745n 1.1v 744.755n 1.1v 749.745n 1.1v 749.755n 1.1v 754.745n 1.1v 754.755n 0.0v 759.745n 0.0v 759.755n 0.0v 764.745n 0.0v 764.755n 0.0v 769.745n 0.0v 769.755n 1.1v 774.745n 1.1v 774.755n 1.1v 779.745n 1.1v 779.755n 1.1v 784.745n 1.1v 784.755n 0.0v 789.745n 0.0v 789.755n 0.0v 794.745n 0.0v 794.755n 0.0v 799.745n 0.0v 799.755n 0.0v 804.745n 0.0v 804.755n 0.0v 809.745n 0.0v 809.755n 0.0v 814.745n 0.0v 814.755n 0.0v 819.745n 0.0v 819.755n 1.1v 824.745n 1.1v 824.755n 1.1v 829.745n 1.1v 829.755n 1.1v 834.745n 1.1v 834.755n 1.1v 839.745n 1.1v 839.755n 1.1v 844.745n 1.1v 844.755n 1.1v 849.745n 1.1v 849.755n 1.1v 854.745n 1.1v 854.755n 1.1v 859.745n 1.1v 859.755n 1.1v 864.745n 1.1v 864.755n 0.0v 869.745n 0.0v 869.755n 1.1v 874.745n 1.1v 874.755n 0.0v 879.745n 0.0v 879.755n 1.1v 884.745n 1.1v 884.755n 1.1v 889.745n 1.1v 889.755n 1.1v 894.745n 1.1v 894.755n 1.1v 899.745n 1.1v 899.755n 1.1v 904.745n 1.1v 904.755n 1.1v 909.745n 1.1v 909.755n 1.1v 914.745n 1.1v 914.755n 1.1v 919.745n 1.1v 919.755n 1.1v 924.745n 1.1v 924.755n 1.1v 929.745n 1.1v 929.755n 0.0v 934.745n 0.0v 934.755n 0.0v 939.745n 0.0v 939.755n 0.0v 944.745n 0.0v 944.755n 0.0v 949.745n 0.0v 949.755n 0.0v 954.745n 0.0v 954.755n 1.1v 959.745n 1.1v 959.755n 1.1v 964.745n 1.1v 964.755n 1.1v 969.745n 1.1v 969.755n 1.1v 974.745n 1.1v 974.755n 1.1v 979.745n 1.1v 979.755n 0.0v 984.745n 0.0v 984.755n 1.1v 989.745n 1.1v 989.755n 1.1v 994.745n 1.1v 994.755n 0.0v 999.745n 0.0v 999.755n 1.1v 1004.745n 1.1v 1004.755n 1.1v 1009.745n 1.1v 1009.755n 1.1v 1014.745n 1.1v 1014.755n 1.1v 1019.745n 1.1v 1019.755n 0.0v 1024.745n 0.0v 1024.755n 0.0v )
* (time, data): [(0, 0), (5, 1), (10, 0), (15, 0), (20, 0), (25, 0), (30, 0), (35, 0), (40, 0), (45, 0), (50, 0), (55, 0), (60, 1), (65, 1), (70, 1), (75, 1), (80, 1), (85, 1), (90, 0), (95, 0), (100, 0), (105, 0), (110, 0), (115, 0), (120, 0), (125, 0), (130, 0), (135, 1), (140, 1), (145, 1), (150, 1), (155, 1), (160, 1), (165, 1), (170, 0), (175, 0), (180, 0), (185, 0), (190, 0), (195, 0), (200, 0), (205, 0), (210, 0), (215, 0), (220, 1), (225, 1), (230, 1), (235, 1), (240, 1), (245, 1), (250, 1), (255, 0), (260, 0), (265, 1), (270, 1), (275, 1), (280, 1), (285, 1), (290, 1), (295, 1), (300, 0), (305, 0), (310, 0), (315, 1), (320, 1), (325, 1), (330, 0), (335, 1), (340, 1), (345, 1), (350, 1), (355, 1), (360, 1), (365, 1), (370, 1), (375, 1), (380, 1), (385, 1), (390, 1), (395, 1), (400, 0), (405, 0), (410, 0), (415, 0), (420, 1), (425, 0), (430, 1), (435, 1), (440, 1), (445, 1), (450, 1), (455, 1), (460, 0), (465, 1), (470, 0), (475, 0), (480, 1), (485, 1), (490, 1), (495, 1), (500, 0), (505, 1), (510, 0), (515, 0), (520, 0), (525, 0), (530, 0), (535, 0), (540, 1), (545, 1), (550, 1), (555, 1), (560, 1), (565, 1), (570, 1), (575, 0), (580, 0), (585, 0), (590, 0), (595, 0), (600, 0), (605, 0), (610, 0), (615, 0), (620, 0), (625, 0), (630, 0), (635, 0), (640, 0), (645, 0), (650, 0), (655, 1), (660, 1), (665, 1), (670, 0), (675, 0), (680, 0), (685, 0), (690, 0), (695, 0), (700, 0), (705, 0), (710, 0), (715, 1), (720, 1), (725, 1), (730, 1), (735, 0), (740, 1), (745, 1), (750, 1), (755, 0), (760, 0), (765, 0), (770, 1), (775, 1), (780, 1), (785, 1), (790, 0), (795, 0), (800, 0), (805, 0), (810, 0), (815, 0), (820, 0), (825, 0), (830, 1), (835, 0), (840, 0), (845, 0), (850, 0), (855, 1), (860, 1), (865, 1), (870, 0), (875, 1), (880, 0), (885, 0), (890, 0), (895, 0), (900, 0), (905, 0), (910, 0), (915, 0), (920, 0), (925, 0), (930, 0), (935, 0), (940, 1), (945, 1), (950, 1), (955, 0), (960, 0), (965, 1), (970, 1), (975, 1), (980, 1), (985, 1), (990, 1), (995, 0), (1000, 1), (1005, 1), (1010, 1), (1015, 1), (1020, 0), (1025, 0)]
Vdin0_8  din0_8  0 PWL (0n 0.0v 4.745n 0.0v 4.755n 1.1v 9.745n 1.1v 9.755n 0.0v 14.745n 0.0v 14.755n 0.0v 19.745n 0.0v 19.755n 0.0v 24.745n 0.0v 24.755n 0.0v 29.745n 0.0v 29.755n 0.0v 34.745n 0.0v 34.755n 0.0v 39.745n 0.0v 39.755n 0.0v 44.745n 0.0v 44.755n 0.0v 49.745n 0.0v 49.755n 0.0v 54.745n 0.0v 54.755n 0.0v 59.745n 0.0v 59.755n 1.1v 64.745n 1.1v 64.755n 1.1v 69.745n 1.1v 69.755n 1.1v 74.745n 1.1v 74.755n 1.1v 79.745n 1.1v 79.755n 1.1v 84.745n 1.1v 84.755n 1.1v 89.745n 1.1v 89.755n 0.0v 94.745n 0.0v 94.755n 0.0v 99.745n 0.0v 99.755n 0.0v 104.745n 0.0v 104.755n 0.0v 109.745n 0.0v 109.755n 0.0v 114.745n 0.0v 114.755n 0.0v 119.745n 0.0v 119.755n 0.0v 124.745n 0.0v 124.755n 0.0v 129.745n 0.0v 129.755n 0.0v 134.745n 0.0v 134.755n 1.1v 139.745n 1.1v 139.755n 1.1v 144.745n 1.1v 144.755n 1.1v 149.745n 1.1v 149.755n 1.1v 154.745n 1.1v 154.755n 1.1v 159.745n 1.1v 159.755n 1.1v 164.745n 1.1v 164.755n 1.1v 169.745n 1.1v 169.755n 0.0v 174.745n 0.0v 174.755n 0.0v 179.745n 0.0v 179.755n 0.0v 184.745n 0.0v 184.755n 0.0v 189.745n 0.0v 189.755n 0.0v 194.745n 0.0v 194.755n 0.0v 199.745n 0.0v 199.755n 0.0v 204.745n 0.0v 204.755n 0.0v 209.745n 0.0v 209.755n 0.0v 214.745n 0.0v 214.755n 0.0v 219.745n 0.0v 219.755n 1.1v 224.745n 1.1v 224.755n 1.1v 229.745n 1.1v 229.755n 1.1v 234.745n 1.1v 234.755n 1.1v 239.745n 1.1v 239.755n 1.1v 244.745n 1.1v 244.755n 1.1v 249.745n 1.1v 249.755n 1.1v 254.745n 1.1v 254.755n 0.0v 259.745n 0.0v 259.755n 0.0v 264.745n 0.0v 264.755n 1.1v 269.745n 1.1v 269.755n 1.1v 274.745n 1.1v 274.755n 1.1v 279.745n 1.1v 279.755n 1.1v 284.745n 1.1v 284.755n 1.1v 289.745n 1.1v 289.755n 1.1v 294.745n 1.1v 294.755n 1.1v 299.745n 1.1v 299.755n 0.0v 304.745n 0.0v 304.755n 0.0v 309.745n 0.0v 309.755n 0.0v 314.745n 0.0v 314.755n 1.1v 319.745n 1.1v 319.755n 1.1v 324.745n 1.1v 324.755n 1.1v 329.745n 1.1v 329.755n 0.0v 334.745n 0.0v 334.755n 1.1v 339.745n 1.1v 339.755n 1.1v 344.745n 1.1v 344.755n 1.1v 349.745n 1.1v 349.755n 1.1v 354.745n 1.1v 354.755n 1.1v 359.745n 1.1v 359.755n 1.1v 364.745n 1.1v 364.755n 1.1v 369.745n 1.1v 369.755n 1.1v 374.745n 1.1v 374.755n 1.1v 379.745n 1.1v 379.755n 1.1v 384.745n 1.1v 384.755n 1.1v 389.745n 1.1v 389.755n 1.1v 394.745n 1.1v 394.755n 1.1v 399.745n 1.1v 399.755n 0.0v 404.745n 0.0v 404.755n 0.0v 409.745n 0.0v 409.755n 0.0v 414.745n 0.0v 414.755n 0.0v 419.745n 0.0v 419.755n 1.1v 424.745n 1.1v 424.755n 0.0v 429.745n 0.0v 429.755n 1.1v 434.745n 1.1v 434.755n 1.1v 439.745n 1.1v 439.755n 1.1v 444.745n 1.1v 444.755n 1.1v 449.745n 1.1v 449.755n 1.1v 454.745n 1.1v 454.755n 1.1v 459.745n 1.1v 459.755n 0.0v 464.745n 0.0v 464.755n 1.1v 469.745n 1.1v 469.755n 0.0v 474.745n 0.0v 474.755n 0.0v 479.745n 0.0v 479.755n 1.1v 484.745n 1.1v 484.755n 1.1v 489.745n 1.1v 489.755n 1.1v 494.745n 1.1v 494.755n 1.1v 499.745n 1.1v 499.755n 0.0v 504.745n 0.0v 504.755n 1.1v 509.745n 1.1v 509.755n 0.0v 514.745n 0.0v 514.755n 0.0v 519.745n 0.0v 519.755n 0.0v 524.745n 0.0v 524.755n 0.0v 529.745n 0.0v 529.755n 0.0v 534.745n 0.0v 534.755n 0.0v 539.745n 0.0v 539.755n 1.1v 544.745n 1.1v 544.755n 1.1v 549.745n 1.1v 549.755n 1.1v 554.745n 1.1v 554.755n 1.1v 559.745n 1.1v 559.755n 1.1v 564.745n 1.1v 564.755n 1.1v 569.745n 1.1v 569.755n 1.1v 574.745n 1.1v 574.755n 0.0v 579.745n 0.0v 579.755n 0.0v 584.745n 0.0v 584.755n 0.0v 589.745n 0.0v 589.755n 0.0v 594.745n 0.0v 594.755n 0.0v 599.745n 0.0v 599.755n 0.0v 604.745n 0.0v 604.755n 0.0v 609.745n 0.0v 609.755n 0.0v 614.745n 0.0v 614.755n 0.0v 619.745n 0.0v 619.755n 0.0v 624.745n 0.0v 624.755n 0.0v 629.745n 0.0v 629.755n 0.0v 634.745n 0.0v 634.755n 0.0v 639.745n 0.0v 639.755n 0.0v 644.745n 0.0v 644.755n 0.0v 649.745n 0.0v 649.755n 0.0v 654.745n 0.0v 654.755n 1.1v 659.745n 1.1v 659.755n 1.1v 664.745n 1.1v 664.755n 1.1v 669.745n 1.1v 669.755n 0.0v 674.745n 0.0v 674.755n 0.0v 679.745n 0.0v 679.755n 0.0v 684.745n 0.0v 684.755n 0.0v 689.745n 0.0v 689.755n 0.0v 694.745n 0.0v 694.755n 0.0v 699.745n 0.0v 699.755n 0.0v 704.745n 0.0v 704.755n 0.0v 709.745n 0.0v 709.755n 0.0v 714.745n 0.0v 714.755n 1.1v 719.745n 1.1v 719.755n 1.1v 724.745n 1.1v 724.755n 1.1v 729.745n 1.1v 729.755n 1.1v 734.745n 1.1v 734.755n 0.0v 739.745n 0.0v 739.755n 1.1v 744.745n 1.1v 744.755n 1.1v 749.745n 1.1v 749.755n 1.1v 754.745n 1.1v 754.755n 0.0v 759.745n 0.0v 759.755n 0.0v 764.745n 0.0v 764.755n 0.0v 769.745n 0.0v 769.755n 1.1v 774.745n 1.1v 774.755n 1.1v 779.745n 1.1v 779.755n 1.1v 784.745n 1.1v 784.755n 1.1v 789.745n 1.1v 789.755n 0.0v 794.745n 0.0v 794.755n 0.0v 799.745n 0.0v 799.755n 0.0v 804.745n 0.0v 804.755n 0.0v 809.745n 0.0v 809.755n 0.0v 814.745n 0.0v 814.755n 0.0v 819.745n 0.0v 819.755n 0.0v 824.745n 0.0v 824.755n 0.0v 829.745n 0.0v 829.755n 1.1v 834.745n 1.1v 834.755n 0.0v 839.745n 0.0v 839.755n 0.0v 844.745n 0.0v 844.755n 0.0v 849.745n 0.0v 849.755n 0.0v 854.745n 0.0v 854.755n 1.1v 859.745n 1.1v 859.755n 1.1v 864.745n 1.1v 864.755n 1.1v 869.745n 1.1v 869.755n 0.0v 874.745n 0.0v 874.755n 1.1v 879.745n 1.1v 879.755n 0.0v 884.745n 0.0v 884.755n 0.0v 889.745n 0.0v 889.755n 0.0v 894.745n 0.0v 894.755n 0.0v 899.745n 0.0v 899.755n 0.0v 904.745n 0.0v 904.755n 0.0v 909.745n 0.0v 909.755n 0.0v 914.745n 0.0v 914.755n 0.0v 919.745n 0.0v 919.755n 0.0v 924.745n 0.0v 924.755n 0.0v 929.745n 0.0v 929.755n 0.0v 934.745n 0.0v 934.755n 0.0v 939.745n 0.0v 939.755n 1.1v 944.745n 1.1v 944.755n 1.1v 949.745n 1.1v 949.755n 1.1v 954.745n 1.1v 954.755n 0.0v 959.745n 0.0v 959.755n 0.0v 964.745n 0.0v 964.755n 1.1v 969.745n 1.1v 969.755n 1.1v 974.745n 1.1v 974.755n 1.1v 979.745n 1.1v 979.755n 1.1v 984.745n 1.1v 984.755n 1.1v 989.745n 1.1v 989.755n 1.1v 994.745n 1.1v 994.755n 0.0v 999.745n 0.0v 999.755n 1.1v 1004.745n 1.1v 1004.755n 1.1v 1009.745n 1.1v 1009.755n 1.1v 1014.745n 1.1v 1014.755n 1.1v 1019.745n 1.1v 1019.755n 0.0v 1024.745n 0.0v 1024.755n 0.0v )
* (time, data): [(0, 0), (5, 0), (10, 0), (15, 0), (20, 0), (25, 0), (30, 1), (35, 1), (40, 1), (45, 1), (50, 1), (55, 1), (60, 0), (65, 1), (70, 1), (75, 1), (80, 1), (85, 1), (90, 1), (95, 1), (100, 0), (105, 0), (110, 0), (115, 0), (120, 0), (125, 0), (130, 0), (135, 1), (140, 1), (145, 1), (150, 1), (155, 1), (160, 1), (165, 1), (170, 1), (175, 1), (180, 1), (185, 1), (190, 1), (195, 1), (200, 1), (205, 1), (210, 1), (215, 1), (220, 1), (225, 1), (230, 1), (235, 1), (240, 1), (245, 1), (250, 1), (255, 1), (260, 1), (265, 0), (270, 0), (275, 0), (280, 0), (285, 0), (290, 0), (295, 0), (300, 1), (305, 1), (310, 1), (315, 1), (320, 1), (325, 1), (330, 1), (335, 1), (340, 1), (345, 1), (350, 1), (355, 1), (360, 1), (365, 1), (370, 1), (375, 1), (380, 1), (385, 1), (390, 1), (395, 0), (400, 1), (405, 1), (410, 0), (415, 0), (420, 0), (425, 1), (430, 1), (435, 1), (440, 1), (445, 1), (450, 1), (455, 1), (460, 0), (465, 1), (470, 0), (475, 0), (480, 0), (485, 0), (490, 0), (495, 1), (500, 0), (505, 1), (510, 1), (515, 0), (520, 0), (525, 0), (530, 0), (535, 1), (540, 1), (545, 1), (550, 1), (555, 0), (560, 0), (565, 0), (570, 0), (575, 0), (580, 0), (585, 0), (590, 0), (595, 0), (600, 0), (605, 0), (610, 0), (615, 0), (620, 0), (625, 0), (630, 1), (635, 0), (640, 0), (645, 0), (650, 0), (655, 0), (660, 1), (665, 1), (670, 1), (675, 1), (680, 1), (685, 1), (690, 1), (695, 1), (700, 1), (705, 0), (710, 0), (715, 1), (720, 1), (725, 1), (730, 1), (735, 1), (740, 1), (745, 1), (750, 1), (755, 0), (760, 0), (765, 0), (770, 0), (775, 0), (780, 0), (785, 1), (790, 0), (795, 0), (800, 0), (805, 0), (810, 0), (815, 0), (820, 0), (825, 0), (830, 0), (835, 1), (840, 1), (845, 1), (850, 1), (855, 0), (860, 0), (865, 1), (870, 0), (875, 1), (880, 0), (885, 0), (890, 0), (895, 0), (900, 0), (905, 0), (910, 1), (915, 1), (920, 1), (925, 1), (930, 1), (935, 0), (940, 0), (945, 0), (950, 0), (955, 1), (960, 1), (965, 0), (970, 0), (975, 0), (980, 1), (985, 1), (990, 1), (995, 1), (1000, 0), (1005, 0), (1010, 0), (1015, 0), (1020, 1), (1025, 1)]
Vdin0_9  din0_9  0 PWL (0n 0.0v 4.745n 0.0v 4.755n 0.0v 9.745n 0.0v 9.755n 0.0v 14.745n 0.0v 14.755n 0.0v 19.745n 0.0v 19.755n 0.0v 24.745n 0.0v 24.755n 0.0v 29.745n 0.0v 29.755n 1.1v 34.745n 1.1v 34.755n 1.1v 39.745n 1.1v 39.755n 1.1v 44.745n 1.1v 44.755n 1.1v 49.745n 1.1v 49.755n 1.1v 54.745n 1.1v 54.755n 1.1v 59.745n 1.1v 59.755n 0.0v 64.745n 0.0v 64.755n 1.1v 69.745n 1.1v 69.755n 1.1v 74.745n 1.1v 74.755n 1.1v 79.745n 1.1v 79.755n 1.1v 84.745n 1.1v 84.755n 1.1v 89.745n 1.1v 89.755n 1.1v 94.745n 1.1v 94.755n 1.1v 99.745n 1.1v 99.755n 0.0v 104.745n 0.0v 104.755n 0.0v 109.745n 0.0v 109.755n 0.0v 114.745n 0.0v 114.755n 0.0v 119.745n 0.0v 119.755n 0.0v 124.745n 0.0v 124.755n 0.0v 129.745n 0.0v 129.755n 0.0v 134.745n 0.0v 134.755n 1.1v 139.745n 1.1v 139.755n 1.1v 144.745n 1.1v 144.755n 1.1v 149.745n 1.1v 149.755n 1.1v 154.745n 1.1v 154.755n 1.1v 159.745n 1.1v 159.755n 1.1v 164.745n 1.1v 164.755n 1.1v 169.745n 1.1v 169.755n 1.1v 174.745n 1.1v 174.755n 1.1v 179.745n 1.1v 179.755n 1.1v 184.745n 1.1v 184.755n 1.1v 189.745n 1.1v 189.755n 1.1v 194.745n 1.1v 194.755n 1.1v 199.745n 1.1v 199.755n 1.1v 204.745n 1.1v 204.755n 1.1v 209.745n 1.1v 209.755n 1.1v 214.745n 1.1v 214.755n 1.1v 219.745n 1.1v 219.755n 1.1v 224.745n 1.1v 224.755n 1.1v 229.745n 1.1v 229.755n 1.1v 234.745n 1.1v 234.755n 1.1v 239.745n 1.1v 239.755n 1.1v 244.745n 1.1v 244.755n 1.1v 249.745n 1.1v 249.755n 1.1v 254.745n 1.1v 254.755n 1.1v 259.745n 1.1v 259.755n 1.1v 264.745n 1.1v 264.755n 0.0v 269.745n 0.0v 269.755n 0.0v 274.745n 0.0v 274.755n 0.0v 279.745n 0.0v 279.755n 0.0v 284.745n 0.0v 284.755n 0.0v 289.745n 0.0v 289.755n 0.0v 294.745n 0.0v 294.755n 0.0v 299.745n 0.0v 299.755n 1.1v 304.745n 1.1v 304.755n 1.1v 309.745n 1.1v 309.755n 1.1v 314.745n 1.1v 314.755n 1.1v 319.745n 1.1v 319.755n 1.1v 324.745n 1.1v 324.755n 1.1v 329.745n 1.1v 329.755n 1.1v 334.745n 1.1v 334.755n 1.1v 339.745n 1.1v 339.755n 1.1v 344.745n 1.1v 344.755n 1.1v 349.745n 1.1v 349.755n 1.1v 354.745n 1.1v 354.755n 1.1v 359.745n 1.1v 359.755n 1.1v 364.745n 1.1v 364.755n 1.1v 369.745n 1.1v 369.755n 1.1v 374.745n 1.1v 374.755n 1.1v 379.745n 1.1v 379.755n 1.1v 384.745n 1.1v 384.755n 1.1v 389.745n 1.1v 389.755n 1.1v 394.745n 1.1v 394.755n 0.0v 399.745n 0.0v 399.755n 1.1v 404.745n 1.1v 404.755n 1.1v 409.745n 1.1v 409.755n 0.0v 414.745n 0.0v 414.755n 0.0v 419.745n 0.0v 419.755n 0.0v 424.745n 0.0v 424.755n 1.1v 429.745n 1.1v 429.755n 1.1v 434.745n 1.1v 434.755n 1.1v 439.745n 1.1v 439.755n 1.1v 444.745n 1.1v 444.755n 1.1v 449.745n 1.1v 449.755n 1.1v 454.745n 1.1v 454.755n 1.1v 459.745n 1.1v 459.755n 0.0v 464.745n 0.0v 464.755n 1.1v 469.745n 1.1v 469.755n 0.0v 474.745n 0.0v 474.755n 0.0v 479.745n 0.0v 479.755n 0.0v 484.745n 0.0v 484.755n 0.0v 489.745n 0.0v 489.755n 0.0v 494.745n 0.0v 494.755n 1.1v 499.745n 1.1v 499.755n 0.0v 504.745n 0.0v 504.755n 1.1v 509.745n 1.1v 509.755n 1.1v 514.745n 1.1v 514.755n 0.0v 519.745n 0.0v 519.755n 0.0v 524.745n 0.0v 524.755n 0.0v 529.745n 0.0v 529.755n 0.0v 534.745n 0.0v 534.755n 1.1v 539.745n 1.1v 539.755n 1.1v 544.745n 1.1v 544.755n 1.1v 549.745n 1.1v 549.755n 1.1v 554.745n 1.1v 554.755n 0.0v 559.745n 0.0v 559.755n 0.0v 564.745n 0.0v 564.755n 0.0v 569.745n 0.0v 569.755n 0.0v 574.745n 0.0v 574.755n 0.0v 579.745n 0.0v 579.755n 0.0v 584.745n 0.0v 584.755n 0.0v 589.745n 0.0v 589.755n 0.0v 594.745n 0.0v 594.755n 0.0v 599.745n 0.0v 599.755n 0.0v 604.745n 0.0v 604.755n 0.0v 609.745n 0.0v 609.755n 0.0v 614.745n 0.0v 614.755n 0.0v 619.745n 0.0v 619.755n 0.0v 624.745n 0.0v 624.755n 0.0v 629.745n 0.0v 629.755n 1.1v 634.745n 1.1v 634.755n 0.0v 639.745n 0.0v 639.755n 0.0v 644.745n 0.0v 644.755n 0.0v 649.745n 0.0v 649.755n 0.0v 654.745n 0.0v 654.755n 0.0v 659.745n 0.0v 659.755n 1.1v 664.745n 1.1v 664.755n 1.1v 669.745n 1.1v 669.755n 1.1v 674.745n 1.1v 674.755n 1.1v 679.745n 1.1v 679.755n 1.1v 684.745n 1.1v 684.755n 1.1v 689.745n 1.1v 689.755n 1.1v 694.745n 1.1v 694.755n 1.1v 699.745n 1.1v 699.755n 1.1v 704.745n 1.1v 704.755n 0.0v 709.745n 0.0v 709.755n 0.0v 714.745n 0.0v 714.755n 1.1v 719.745n 1.1v 719.755n 1.1v 724.745n 1.1v 724.755n 1.1v 729.745n 1.1v 729.755n 1.1v 734.745n 1.1v 734.755n 1.1v 739.745n 1.1v 739.755n 1.1v 744.745n 1.1v 744.755n 1.1v 749.745n 1.1v 749.755n 1.1v 754.745n 1.1v 754.755n 0.0v 759.745n 0.0v 759.755n 0.0v 764.745n 0.0v 764.755n 0.0v 769.745n 0.0v 769.755n 0.0v 774.745n 0.0v 774.755n 0.0v 779.745n 0.0v 779.755n 0.0v 784.745n 0.0v 784.755n 1.1v 789.745n 1.1v 789.755n 0.0v 794.745n 0.0v 794.755n 0.0v 799.745n 0.0v 799.755n 0.0v 804.745n 0.0v 804.755n 0.0v 809.745n 0.0v 809.755n 0.0v 814.745n 0.0v 814.755n 0.0v 819.745n 0.0v 819.755n 0.0v 824.745n 0.0v 824.755n 0.0v 829.745n 0.0v 829.755n 0.0v 834.745n 0.0v 834.755n 1.1v 839.745n 1.1v 839.755n 1.1v 844.745n 1.1v 844.755n 1.1v 849.745n 1.1v 849.755n 1.1v 854.745n 1.1v 854.755n 0.0v 859.745n 0.0v 859.755n 0.0v 864.745n 0.0v 864.755n 1.1v 869.745n 1.1v 869.755n 0.0v 874.745n 0.0v 874.755n 1.1v 879.745n 1.1v 879.755n 0.0v 884.745n 0.0v 884.755n 0.0v 889.745n 0.0v 889.755n 0.0v 894.745n 0.0v 894.755n 0.0v 899.745n 0.0v 899.755n 0.0v 904.745n 0.0v 904.755n 0.0v 909.745n 0.0v 909.755n 1.1v 914.745n 1.1v 914.755n 1.1v 919.745n 1.1v 919.755n 1.1v 924.745n 1.1v 924.755n 1.1v 929.745n 1.1v 929.755n 1.1v 934.745n 1.1v 934.755n 0.0v 939.745n 0.0v 939.755n 0.0v 944.745n 0.0v 944.755n 0.0v 949.745n 0.0v 949.755n 0.0v 954.745n 0.0v 954.755n 1.1v 959.745n 1.1v 959.755n 1.1v 964.745n 1.1v 964.755n 0.0v 969.745n 0.0v 969.755n 0.0v 974.745n 0.0v 974.755n 0.0v 979.745n 0.0v 979.755n 1.1v 984.745n 1.1v 984.755n 1.1v 989.745n 1.1v 989.755n 1.1v 994.745n 1.1v 994.755n 1.1v 999.745n 1.1v 999.755n 0.0v 1004.745n 0.0v 1004.755n 0.0v 1009.745n 0.0v 1009.755n 0.0v 1014.745n 0.0v 1014.755n 0.0v 1019.745n 0.0v 1019.755n 1.1v 1024.745n 1.1v 1024.755n 1.1v )
* (time, data): [(0, 0), (5, 1), (10, 0), (15, 1), (20, 1), (25, 1), (30, 1), (35, 1), (40, 0), (45, 1), (50, 1), (55, 1), (60, 0), (65, 0), (70, 0), (75, 0), (80, 0), (85, 0), (90, 0), (95, 0), (100, 0), (105, 0), (110, 0), (115, 0), (120, 0), (125, 0), (130, 0), (135, 0), (140, 1), (145, 1), (150, 1), (155, 1), (160, 1), (165, 1), (170, 1), (175, 1), (180, 1), (185, 1), (190, 1), (195, 1), (200, 1), (205, 1), (210, 1), (215, 1), (220, 0), (225, 0), (230, 0), (235, 0), (240, 1), (245, 1), (250, 1), (255, 1), (260, 1), (265, 0), (270, 0), (275, 0), (280, 0), (285, 0), (290, 0), (295, 0), (300, 0), (305, 0), (310, 0), (315, 0), (320, 0), (325, 0), (330, 0), (335, 1), (340, 0), (345, 0), (350, 0), (355, 0), (360, 0), (365, 0), (370, 0), (375, 0), (380, 0), (385, 0), (390, 0), (395, 1), (400, 1), (405, 1), (410, 1), (415, 0), (420, 0), (425, 0), (430, 1), (435, 1), (440, 1), (445, 1), (450, 1), (455, 1), (460, 1), (465, 1), (470, 0), (475, 0), (480, 0), (485, 0), (490, 0), (495, 1), (500, 1), (505, 1), (510, 0), (515, 0), (520, 0), (525, 0), (530, 0), (535, 0), (540, 1), (545, 1), (550, 1), (555, 0), (560, 0), (565, 0), (570, 0), (575, 1), (580, 1), (585, 1), (590, 1), (595, 1), (600, 1), (605, 1), (610, 1), (615, 1), (620, 1), (625, 1), (630, 1), (635, 1), (640, 1), (645, 1), (650, 1), (655, 0), (660, 0), (665, 0), (670, 0), (675, 0), (680, 0), (685, 0), (690, 0), (695, 0), (700, 0), (705, 1), (710, 0), (715, 1), (720, 1), (725, 1), (730, 1), (735, 1), (740, 0), (745, 0), (750, 0), (755, 1), (760, 1), (765, 1), (770, 0), (775, 0), (780, 0), (785, 1), (790, 1), (795, 1), (800, 1), (805, 1), (810, 1), (815, 1), (820, 0), (825, 0), (830, 1), (835, 0), (840, 0), (845, 0), (850, 0), (855, 0), (860, 0), (865, 0), (870, 1), (875, 0), (880, 1), (885, 1), (890, 1), (895, 1), (900, 1), (905, 1), (910, 0), (915, 0), (920, 0), (925, 0), (930, 0), (935, 0), (940, 0), (945, 0), (950, 0), (955, 0), (960, 0), (965, 1), (970, 1), (975, 1), (980, 0), (985, 0), (990, 0), (995, 0), (1000, 0), (1005, 0), (1010, 0), (1015, 0), (1020, 0), (1025, 0)]
Vdin0_10  din0_10  0 PWL (0n 0.0v 4.745n 0.0v 4.755n 1.1v 9.745n 1.1v 9.755n 0.0v 14.745n 0.0v 14.755n 1.1v 19.745n 1.1v 19.755n 1.1v 24.745n 1.1v 24.755n 1.1v 29.745n 1.1v 29.755n 1.1v 34.745n 1.1v 34.755n 1.1v 39.745n 1.1v 39.755n 0.0v 44.745n 0.0v 44.755n 1.1v 49.745n 1.1v 49.755n 1.1v 54.745n 1.1v 54.755n 1.1v 59.745n 1.1v 59.755n 0.0v 64.745n 0.0v 64.755n 0.0v 69.745n 0.0v 69.755n 0.0v 74.745n 0.0v 74.755n 0.0v 79.745n 0.0v 79.755n 0.0v 84.745n 0.0v 84.755n 0.0v 89.745n 0.0v 89.755n 0.0v 94.745n 0.0v 94.755n 0.0v 99.745n 0.0v 99.755n 0.0v 104.745n 0.0v 104.755n 0.0v 109.745n 0.0v 109.755n 0.0v 114.745n 0.0v 114.755n 0.0v 119.745n 0.0v 119.755n 0.0v 124.745n 0.0v 124.755n 0.0v 129.745n 0.0v 129.755n 0.0v 134.745n 0.0v 134.755n 0.0v 139.745n 0.0v 139.755n 1.1v 144.745n 1.1v 144.755n 1.1v 149.745n 1.1v 149.755n 1.1v 154.745n 1.1v 154.755n 1.1v 159.745n 1.1v 159.755n 1.1v 164.745n 1.1v 164.755n 1.1v 169.745n 1.1v 169.755n 1.1v 174.745n 1.1v 174.755n 1.1v 179.745n 1.1v 179.755n 1.1v 184.745n 1.1v 184.755n 1.1v 189.745n 1.1v 189.755n 1.1v 194.745n 1.1v 194.755n 1.1v 199.745n 1.1v 199.755n 1.1v 204.745n 1.1v 204.755n 1.1v 209.745n 1.1v 209.755n 1.1v 214.745n 1.1v 214.755n 1.1v 219.745n 1.1v 219.755n 0.0v 224.745n 0.0v 224.755n 0.0v 229.745n 0.0v 229.755n 0.0v 234.745n 0.0v 234.755n 0.0v 239.745n 0.0v 239.755n 1.1v 244.745n 1.1v 244.755n 1.1v 249.745n 1.1v 249.755n 1.1v 254.745n 1.1v 254.755n 1.1v 259.745n 1.1v 259.755n 1.1v 264.745n 1.1v 264.755n 0.0v 269.745n 0.0v 269.755n 0.0v 274.745n 0.0v 274.755n 0.0v 279.745n 0.0v 279.755n 0.0v 284.745n 0.0v 284.755n 0.0v 289.745n 0.0v 289.755n 0.0v 294.745n 0.0v 294.755n 0.0v 299.745n 0.0v 299.755n 0.0v 304.745n 0.0v 304.755n 0.0v 309.745n 0.0v 309.755n 0.0v 314.745n 0.0v 314.755n 0.0v 319.745n 0.0v 319.755n 0.0v 324.745n 0.0v 324.755n 0.0v 329.745n 0.0v 329.755n 0.0v 334.745n 0.0v 334.755n 1.1v 339.745n 1.1v 339.755n 0.0v 344.745n 0.0v 344.755n 0.0v 349.745n 0.0v 349.755n 0.0v 354.745n 0.0v 354.755n 0.0v 359.745n 0.0v 359.755n 0.0v 364.745n 0.0v 364.755n 0.0v 369.745n 0.0v 369.755n 0.0v 374.745n 0.0v 374.755n 0.0v 379.745n 0.0v 379.755n 0.0v 384.745n 0.0v 384.755n 0.0v 389.745n 0.0v 389.755n 0.0v 394.745n 0.0v 394.755n 1.1v 399.745n 1.1v 399.755n 1.1v 404.745n 1.1v 404.755n 1.1v 409.745n 1.1v 409.755n 1.1v 414.745n 1.1v 414.755n 0.0v 419.745n 0.0v 419.755n 0.0v 424.745n 0.0v 424.755n 0.0v 429.745n 0.0v 429.755n 1.1v 434.745n 1.1v 434.755n 1.1v 439.745n 1.1v 439.755n 1.1v 444.745n 1.1v 444.755n 1.1v 449.745n 1.1v 449.755n 1.1v 454.745n 1.1v 454.755n 1.1v 459.745n 1.1v 459.755n 1.1v 464.745n 1.1v 464.755n 1.1v 469.745n 1.1v 469.755n 0.0v 474.745n 0.0v 474.755n 0.0v 479.745n 0.0v 479.755n 0.0v 484.745n 0.0v 484.755n 0.0v 489.745n 0.0v 489.755n 0.0v 494.745n 0.0v 494.755n 1.1v 499.745n 1.1v 499.755n 1.1v 504.745n 1.1v 504.755n 1.1v 509.745n 1.1v 509.755n 0.0v 514.745n 0.0v 514.755n 0.0v 519.745n 0.0v 519.755n 0.0v 524.745n 0.0v 524.755n 0.0v 529.745n 0.0v 529.755n 0.0v 534.745n 0.0v 534.755n 0.0v 539.745n 0.0v 539.755n 1.1v 544.745n 1.1v 544.755n 1.1v 549.745n 1.1v 549.755n 1.1v 554.745n 1.1v 554.755n 0.0v 559.745n 0.0v 559.755n 0.0v 564.745n 0.0v 564.755n 0.0v 569.745n 0.0v 569.755n 0.0v 574.745n 0.0v 574.755n 1.1v 579.745n 1.1v 579.755n 1.1v 584.745n 1.1v 584.755n 1.1v 589.745n 1.1v 589.755n 1.1v 594.745n 1.1v 594.755n 1.1v 599.745n 1.1v 599.755n 1.1v 604.745n 1.1v 604.755n 1.1v 609.745n 1.1v 609.755n 1.1v 614.745n 1.1v 614.755n 1.1v 619.745n 1.1v 619.755n 1.1v 624.745n 1.1v 624.755n 1.1v 629.745n 1.1v 629.755n 1.1v 634.745n 1.1v 634.755n 1.1v 639.745n 1.1v 639.755n 1.1v 644.745n 1.1v 644.755n 1.1v 649.745n 1.1v 649.755n 1.1v 654.745n 1.1v 654.755n 0.0v 659.745n 0.0v 659.755n 0.0v 664.745n 0.0v 664.755n 0.0v 669.745n 0.0v 669.755n 0.0v 674.745n 0.0v 674.755n 0.0v 679.745n 0.0v 679.755n 0.0v 684.745n 0.0v 684.755n 0.0v 689.745n 0.0v 689.755n 0.0v 694.745n 0.0v 694.755n 0.0v 699.745n 0.0v 699.755n 0.0v 704.745n 0.0v 704.755n 1.1v 709.745n 1.1v 709.755n 0.0v 714.745n 0.0v 714.755n 1.1v 719.745n 1.1v 719.755n 1.1v 724.745n 1.1v 724.755n 1.1v 729.745n 1.1v 729.755n 1.1v 734.745n 1.1v 734.755n 1.1v 739.745n 1.1v 739.755n 0.0v 744.745n 0.0v 744.755n 0.0v 749.745n 0.0v 749.755n 0.0v 754.745n 0.0v 754.755n 1.1v 759.745n 1.1v 759.755n 1.1v 764.745n 1.1v 764.755n 1.1v 769.745n 1.1v 769.755n 0.0v 774.745n 0.0v 774.755n 0.0v 779.745n 0.0v 779.755n 0.0v 784.745n 0.0v 784.755n 1.1v 789.745n 1.1v 789.755n 1.1v 794.745n 1.1v 794.755n 1.1v 799.745n 1.1v 799.755n 1.1v 804.745n 1.1v 804.755n 1.1v 809.745n 1.1v 809.755n 1.1v 814.745n 1.1v 814.755n 1.1v 819.745n 1.1v 819.755n 0.0v 824.745n 0.0v 824.755n 0.0v 829.745n 0.0v 829.755n 1.1v 834.745n 1.1v 834.755n 0.0v 839.745n 0.0v 839.755n 0.0v 844.745n 0.0v 844.755n 0.0v 849.745n 0.0v 849.755n 0.0v 854.745n 0.0v 854.755n 0.0v 859.745n 0.0v 859.755n 0.0v 864.745n 0.0v 864.755n 0.0v 869.745n 0.0v 869.755n 1.1v 874.745n 1.1v 874.755n 0.0v 879.745n 0.0v 879.755n 1.1v 884.745n 1.1v 884.755n 1.1v 889.745n 1.1v 889.755n 1.1v 894.745n 1.1v 894.755n 1.1v 899.745n 1.1v 899.755n 1.1v 904.745n 1.1v 904.755n 1.1v 909.745n 1.1v 909.755n 0.0v 914.745n 0.0v 914.755n 0.0v 919.745n 0.0v 919.755n 0.0v 924.745n 0.0v 924.755n 0.0v 929.745n 0.0v 929.755n 0.0v 934.745n 0.0v 934.755n 0.0v 939.745n 0.0v 939.755n 0.0v 944.745n 0.0v 944.755n 0.0v 949.745n 0.0v 949.755n 0.0v 954.745n 0.0v 954.755n 0.0v 959.745n 0.0v 959.755n 0.0v 964.745n 0.0v 964.755n 1.1v 969.745n 1.1v 969.755n 1.1v 974.745n 1.1v 974.755n 1.1v 979.745n 1.1v 979.755n 0.0v 984.745n 0.0v 984.755n 0.0v 989.745n 0.0v 989.755n 0.0v 994.745n 0.0v 994.755n 0.0v 999.745n 0.0v 999.755n 0.0v 1004.745n 0.0v 1004.755n 0.0v 1009.745n 0.0v 1009.755n 0.0v 1014.745n 0.0v 1014.755n 0.0v 1019.745n 0.0v 1019.755n 0.0v 1024.745n 0.0v 1024.755n 0.0v )
* (time, data): [(0, 0), (5, 0), (10, 1), (15, 0), (20, 0), (25, 0), (30, 1), (35, 1), (40, 0), (45, 1), (50, 1), (55, 1), (60, 0), (65, 0), (70, 0), (75, 0), (80, 0), (85, 0), (90, 0), (95, 0), (100, 0), (105, 0), (110, 0), (115, 0), (120, 0), (125, 0), (130, 0), (135, 1), (140, 1), (145, 1), (150, 1), (155, 1), (160, 1), (165, 1), (170, 1), (175, 1), (180, 1), (185, 0), (190, 0), (195, 0), (200, 1), (205, 1), (210, 0), (215, 0), (220, 1), (225, 1), (230, 1), (235, 1), (240, 1), (245, 1), (250, 1), (255, 0), (260, 0), (265, 1), (270, 1), (275, 1), (280, 0), (285, 0), (290, 0), (295, 0), (300, 0), (305, 0), (310, 0), (315, 0), (320, 0), (325, 0), (330, 0), (335, 0), (340, 0), (345, 0), (350, 0), (355, 0), (360, 1), (365, 1), (370, 1), (375, 1), (380, 1), (385, 1), (390, 1), (395, 1), (400, 0), (405, 0), (410, 1), (415, 0), (420, 0), (425, 0), (430, 0), (435, 0), (440, 0), (445, 0), (450, 0), (455, 0), (460, 1), (465, 1), (470, 0), (475, 0), (480, 0), (485, 0), (490, 0), (495, 1), (500, 1), (505, 1), (510, 1), (515, 1), (520, 1), (525, 1), (530, 1), (535, 0), (540, 1), (545, 1), (550, 1), (555, 0), (560, 0), (565, 0), (570, 0), (575, 0), (580, 0), (585, 0), (590, 0), (595, 0), (600, 0), (605, 0), (610, 0), (615, 0), (620, 0), (625, 0), (630, 0), (635, 1), (640, 0), (645, 0), (650, 0), (655, 0), (660, 0), (665, 0), (670, 0), (675, 0), (680, 0), (685, 0), (690, 0), (695, 0), (700, 0), (705, 1), (710, 0), (715, 1), (720, 1), (725, 1), (730, 1), (735, 0), (740, 1), (745, 1), (750, 1), (755, 0), (760, 0), (765, 0), (770, 0), (775, 1), (780, 1), (785, 0), (790, 0), (795, 0), (800, 0), (805, 0), (810, 0), (815, 0), (820, 1), (825, 1), (830, 0), (835, 0), (840, 0), (845, 0), (850, 0), (855, 1), (860, 0), (865, 1), (870, 0), (875, 0), (880, 1), (885, 0), (890, 0), (895, 0), (900, 0), (905, 0), (910, 0), (915, 0), (920, 0), (925, 0), (930, 0), (935, 0), (940, 0), (945, 0), (950, 0), (955, 0), (960, 0), (965, 1), (970, 1), (975, 1), (980, 1), (985, 0), (990, 0), (995, 1), (1000, 1), (1005, 1), (1010, 1), (1015, 1), (1020, 0), (1025, 0)]
Vdin0_11  din0_11  0 PWL (0n 0.0v 4.745n 0.0v 4.755n 0.0v 9.745n 0.0v 9.755n 1.1v 14.745n 1.1v 14.755n 0.0v 19.745n 0.0v 19.755n 0.0v 24.745n 0.0v 24.755n 0.0v 29.745n 0.0v 29.755n 1.1v 34.745n 1.1v 34.755n 1.1v 39.745n 1.1v 39.755n 0.0v 44.745n 0.0v 44.755n 1.1v 49.745n 1.1v 49.755n 1.1v 54.745n 1.1v 54.755n 1.1v 59.745n 1.1v 59.755n 0.0v 64.745n 0.0v 64.755n 0.0v 69.745n 0.0v 69.755n 0.0v 74.745n 0.0v 74.755n 0.0v 79.745n 0.0v 79.755n 0.0v 84.745n 0.0v 84.755n 0.0v 89.745n 0.0v 89.755n 0.0v 94.745n 0.0v 94.755n 0.0v 99.745n 0.0v 99.755n 0.0v 104.745n 0.0v 104.755n 0.0v 109.745n 0.0v 109.755n 0.0v 114.745n 0.0v 114.755n 0.0v 119.745n 0.0v 119.755n 0.0v 124.745n 0.0v 124.755n 0.0v 129.745n 0.0v 129.755n 0.0v 134.745n 0.0v 134.755n 1.1v 139.745n 1.1v 139.755n 1.1v 144.745n 1.1v 144.755n 1.1v 149.745n 1.1v 149.755n 1.1v 154.745n 1.1v 154.755n 1.1v 159.745n 1.1v 159.755n 1.1v 164.745n 1.1v 164.755n 1.1v 169.745n 1.1v 169.755n 1.1v 174.745n 1.1v 174.755n 1.1v 179.745n 1.1v 179.755n 1.1v 184.745n 1.1v 184.755n 0.0v 189.745n 0.0v 189.755n 0.0v 194.745n 0.0v 194.755n 0.0v 199.745n 0.0v 199.755n 1.1v 204.745n 1.1v 204.755n 1.1v 209.745n 1.1v 209.755n 0.0v 214.745n 0.0v 214.755n 0.0v 219.745n 0.0v 219.755n 1.1v 224.745n 1.1v 224.755n 1.1v 229.745n 1.1v 229.755n 1.1v 234.745n 1.1v 234.755n 1.1v 239.745n 1.1v 239.755n 1.1v 244.745n 1.1v 244.755n 1.1v 249.745n 1.1v 249.755n 1.1v 254.745n 1.1v 254.755n 0.0v 259.745n 0.0v 259.755n 0.0v 264.745n 0.0v 264.755n 1.1v 269.745n 1.1v 269.755n 1.1v 274.745n 1.1v 274.755n 1.1v 279.745n 1.1v 279.755n 0.0v 284.745n 0.0v 284.755n 0.0v 289.745n 0.0v 289.755n 0.0v 294.745n 0.0v 294.755n 0.0v 299.745n 0.0v 299.755n 0.0v 304.745n 0.0v 304.755n 0.0v 309.745n 0.0v 309.755n 0.0v 314.745n 0.0v 314.755n 0.0v 319.745n 0.0v 319.755n 0.0v 324.745n 0.0v 324.755n 0.0v 329.745n 0.0v 329.755n 0.0v 334.745n 0.0v 334.755n 0.0v 339.745n 0.0v 339.755n 0.0v 344.745n 0.0v 344.755n 0.0v 349.745n 0.0v 349.755n 0.0v 354.745n 0.0v 354.755n 0.0v 359.745n 0.0v 359.755n 1.1v 364.745n 1.1v 364.755n 1.1v 369.745n 1.1v 369.755n 1.1v 374.745n 1.1v 374.755n 1.1v 379.745n 1.1v 379.755n 1.1v 384.745n 1.1v 384.755n 1.1v 389.745n 1.1v 389.755n 1.1v 394.745n 1.1v 394.755n 1.1v 399.745n 1.1v 399.755n 0.0v 404.745n 0.0v 404.755n 0.0v 409.745n 0.0v 409.755n 1.1v 414.745n 1.1v 414.755n 0.0v 419.745n 0.0v 419.755n 0.0v 424.745n 0.0v 424.755n 0.0v 429.745n 0.0v 429.755n 0.0v 434.745n 0.0v 434.755n 0.0v 439.745n 0.0v 439.755n 0.0v 444.745n 0.0v 444.755n 0.0v 449.745n 0.0v 449.755n 0.0v 454.745n 0.0v 454.755n 0.0v 459.745n 0.0v 459.755n 1.1v 464.745n 1.1v 464.755n 1.1v 469.745n 1.1v 469.755n 0.0v 474.745n 0.0v 474.755n 0.0v 479.745n 0.0v 479.755n 0.0v 484.745n 0.0v 484.755n 0.0v 489.745n 0.0v 489.755n 0.0v 494.745n 0.0v 494.755n 1.1v 499.745n 1.1v 499.755n 1.1v 504.745n 1.1v 504.755n 1.1v 509.745n 1.1v 509.755n 1.1v 514.745n 1.1v 514.755n 1.1v 519.745n 1.1v 519.755n 1.1v 524.745n 1.1v 524.755n 1.1v 529.745n 1.1v 529.755n 1.1v 534.745n 1.1v 534.755n 0.0v 539.745n 0.0v 539.755n 1.1v 544.745n 1.1v 544.755n 1.1v 549.745n 1.1v 549.755n 1.1v 554.745n 1.1v 554.755n 0.0v 559.745n 0.0v 559.755n 0.0v 564.745n 0.0v 564.755n 0.0v 569.745n 0.0v 569.755n 0.0v 574.745n 0.0v 574.755n 0.0v 579.745n 0.0v 579.755n 0.0v 584.745n 0.0v 584.755n 0.0v 589.745n 0.0v 589.755n 0.0v 594.745n 0.0v 594.755n 0.0v 599.745n 0.0v 599.755n 0.0v 604.745n 0.0v 604.755n 0.0v 609.745n 0.0v 609.755n 0.0v 614.745n 0.0v 614.755n 0.0v 619.745n 0.0v 619.755n 0.0v 624.745n 0.0v 624.755n 0.0v 629.745n 0.0v 629.755n 0.0v 634.745n 0.0v 634.755n 1.1v 639.745n 1.1v 639.755n 0.0v 644.745n 0.0v 644.755n 0.0v 649.745n 0.0v 649.755n 0.0v 654.745n 0.0v 654.755n 0.0v 659.745n 0.0v 659.755n 0.0v 664.745n 0.0v 664.755n 0.0v 669.745n 0.0v 669.755n 0.0v 674.745n 0.0v 674.755n 0.0v 679.745n 0.0v 679.755n 0.0v 684.745n 0.0v 684.755n 0.0v 689.745n 0.0v 689.755n 0.0v 694.745n 0.0v 694.755n 0.0v 699.745n 0.0v 699.755n 0.0v 704.745n 0.0v 704.755n 1.1v 709.745n 1.1v 709.755n 0.0v 714.745n 0.0v 714.755n 1.1v 719.745n 1.1v 719.755n 1.1v 724.745n 1.1v 724.755n 1.1v 729.745n 1.1v 729.755n 1.1v 734.745n 1.1v 734.755n 0.0v 739.745n 0.0v 739.755n 1.1v 744.745n 1.1v 744.755n 1.1v 749.745n 1.1v 749.755n 1.1v 754.745n 1.1v 754.755n 0.0v 759.745n 0.0v 759.755n 0.0v 764.745n 0.0v 764.755n 0.0v 769.745n 0.0v 769.755n 0.0v 774.745n 0.0v 774.755n 1.1v 779.745n 1.1v 779.755n 1.1v 784.745n 1.1v 784.755n 0.0v 789.745n 0.0v 789.755n 0.0v 794.745n 0.0v 794.755n 0.0v 799.745n 0.0v 799.755n 0.0v 804.745n 0.0v 804.755n 0.0v 809.745n 0.0v 809.755n 0.0v 814.745n 0.0v 814.755n 0.0v 819.745n 0.0v 819.755n 1.1v 824.745n 1.1v 824.755n 1.1v 829.745n 1.1v 829.755n 0.0v 834.745n 0.0v 834.755n 0.0v 839.745n 0.0v 839.755n 0.0v 844.745n 0.0v 844.755n 0.0v 849.745n 0.0v 849.755n 0.0v 854.745n 0.0v 854.755n 1.1v 859.745n 1.1v 859.755n 0.0v 864.745n 0.0v 864.755n 1.1v 869.745n 1.1v 869.755n 0.0v 874.745n 0.0v 874.755n 0.0v 879.745n 0.0v 879.755n 1.1v 884.745n 1.1v 884.755n 0.0v 889.745n 0.0v 889.755n 0.0v 894.745n 0.0v 894.755n 0.0v 899.745n 0.0v 899.755n 0.0v 904.745n 0.0v 904.755n 0.0v 909.745n 0.0v 909.755n 0.0v 914.745n 0.0v 914.755n 0.0v 919.745n 0.0v 919.755n 0.0v 924.745n 0.0v 924.755n 0.0v 929.745n 0.0v 929.755n 0.0v 934.745n 0.0v 934.755n 0.0v 939.745n 0.0v 939.755n 0.0v 944.745n 0.0v 944.755n 0.0v 949.745n 0.0v 949.755n 0.0v 954.745n 0.0v 954.755n 0.0v 959.745n 0.0v 959.755n 0.0v 964.745n 0.0v 964.755n 1.1v 969.745n 1.1v 969.755n 1.1v 974.745n 1.1v 974.755n 1.1v 979.745n 1.1v 979.755n 1.1v 984.745n 1.1v 984.755n 0.0v 989.745n 0.0v 989.755n 0.0v 994.745n 0.0v 994.755n 1.1v 999.745n 1.1v 999.755n 1.1v 1004.745n 1.1v 1004.755n 1.1v 1009.745n 1.1v 1009.755n 1.1v 1014.745n 1.1v 1014.755n 1.1v 1019.745n 1.1v 1019.755n 0.0v 1024.745n 0.0v 1024.755n 0.0v )
* (time, data): [(0, 0), (5, 1), (10, 0), (15, 0), (20, 0), (25, 0), (30, 0), (35, 0), (40, 0), (45, 1), (50, 1), (55, 1), (60, 0), (65, 0), (70, 0), (75, 0), (80, 0), (85, 0), (90, 1), (95, 1), (100, 1), (105, 1), (110, 1), (115, 1), (120, 1), (125, 1), (130, 1), (135, 0), (140, 0), (145, 0), (150, 0), (155, 0), (160, 0), (165, 0), (170, 0), (175, 0), (180, 0), (185, 0), (190, 0), (195, 0), (200, 0), (205, 0), (210, 1), (215, 1), (220, 1), (225, 1), (230, 0), (235, 0), (240, 0), (245, 0), (250, 0), (255, 1), (260, 1), (265, 1), (270, 1), (275, 1), (280, 1), (285, 1), (290, 1), (295, 1), (300, 0), (305, 0), (310, 0), (315, 0), (320, 0), (325, 0), (330, 1), (335, 1), (340, 1), (345, 1), (350, 1), (355, 1), (360, 0), (365, 0), (370, 0), (375, 0), (380, 0), (385, 0), (390, 0), (395, 0), (400, 0), (405, 0), (410, 1), (415, 0), (420, 0), (425, 1), (430, 1), (435, 1), (440, 1), (445, 1), (450, 0), (455, 0), (460, 0), (465, 0), (470, 0), (475, 0), (480, 1), (485, 1), (490, 1), (495, 0), (500, 1), (505, 1), (510, 0), (515, 1), (520, 1), (525, 1), (530, 1), (535, 1), (540, 0), (545, 0), (550, 0), (555, 1), (560, 1), (565, 1), (570, 1), (575, 1), (580, 1), (585, 1), (590, 1), (595, 1), (600, 1), (605, 1), (610, 1), (615, 1), (620, 1), (625, 1), (630, 1), (635, 1), (640, 0), (645, 0), (650, 0), (655, 1), (660, 0), (665, 0), (670, 1), (675, 1), (680, 1), (685, 1), (690, 1), (695, 1), (700, 1), (705, 0), (710, 0), (715, 1), (720, 1), (725, 1), (730, 1), (735, 0), (740, 1), (745, 1), (750, 1), (755, 1), (760, 1), (765, 1), (770, 0), (775, 1), (780, 1), (785, 0), (790, 1), (795, 1), (800, 1), (805, 1), (810, 1), (815, 1), (820, 0), (825, 0), (830, 0), (835, 0), (840, 0), (845, 0), (850, 0), (855, 0), (860, 1), (865, 0), (870, 1), (875, 0), (880, 0), (885, 1), (890, 1), (895, 1), (900, 1), (905, 1), (910, 1), (915, 1), (920, 1), (925, 1), (930, 1), (935, 1), (940, 1), (945, 1), (950, 1), (955, 1), (960, 1), (965, 0), (970, 0), (975, 0), (980, 0), (985, 1), (990, 1), (995, 1), (1000, 1), (1005, 1), (1010, 1), (1015, 1), (1020, 1), (1025, 1)]
Vdin0_12  din0_12  0 PWL (0n 0.0v 4.745n 0.0v 4.755n 1.1v 9.745n 1.1v 9.755n 0.0v 14.745n 0.0v 14.755n 0.0v 19.745n 0.0v 19.755n 0.0v 24.745n 0.0v 24.755n 0.0v 29.745n 0.0v 29.755n 0.0v 34.745n 0.0v 34.755n 0.0v 39.745n 0.0v 39.755n 0.0v 44.745n 0.0v 44.755n 1.1v 49.745n 1.1v 49.755n 1.1v 54.745n 1.1v 54.755n 1.1v 59.745n 1.1v 59.755n 0.0v 64.745n 0.0v 64.755n 0.0v 69.745n 0.0v 69.755n 0.0v 74.745n 0.0v 74.755n 0.0v 79.745n 0.0v 79.755n 0.0v 84.745n 0.0v 84.755n 0.0v 89.745n 0.0v 89.755n 1.1v 94.745n 1.1v 94.755n 1.1v 99.745n 1.1v 99.755n 1.1v 104.745n 1.1v 104.755n 1.1v 109.745n 1.1v 109.755n 1.1v 114.745n 1.1v 114.755n 1.1v 119.745n 1.1v 119.755n 1.1v 124.745n 1.1v 124.755n 1.1v 129.745n 1.1v 129.755n 1.1v 134.745n 1.1v 134.755n 0.0v 139.745n 0.0v 139.755n 0.0v 144.745n 0.0v 144.755n 0.0v 149.745n 0.0v 149.755n 0.0v 154.745n 0.0v 154.755n 0.0v 159.745n 0.0v 159.755n 0.0v 164.745n 0.0v 164.755n 0.0v 169.745n 0.0v 169.755n 0.0v 174.745n 0.0v 174.755n 0.0v 179.745n 0.0v 179.755n 0.0v 184.745n 0.0v 184.755n 0.0v 189.745n 0.0v 189.755n 0.0v 194.745n 0.0v 194.755n 0.0v 199.745n 0.0v 199.755n 0.0v 204.745n 0.0v 204.755n 0.0v 209.745n 0.0v 209.755n 1.1v 214.745n 1.1v 214.755n 1.1v 219.745n 1.1v 219.755n 1.1v 224.745n 1.1v 224.755n 1.1v 229.745n 1.1v 229.755n 0.0v 234.745n 0.0v 234.755n 0.0v 239.745n 0.0v 239.755n 0.0v 244.745n 0.0v 244.755n 0.0v 249.745n 0.0v 249.755n 0.0v 254.745n 0.0v 254.755n 1.1v 259.745n 1.1v 259.755n 1.1v 264.745n 1.1v 264.755n 1.1v 269.745n 1.1v 269.755n 1.1v 274.745n 1.1v 274.755n 1.1v 279.745n 1.1v 279.755n 1.1v 284.745n 1.1v 284.755n 1.1v 289.745n 1.1v 289.755n 1.1v 294.745n 1.1v 294.755n 1.1v 299.745n 1.1v 299.755n 0.0v 304.745n 0.0v 304.755n 0.0v 309.745n 0.0v 309.755n 0.0v 314.745n 0.0v 314.755n 0.0v 319.745n 0.0v 319.755n 0.0v 324.745n 0.0v 324.755n 0.0v 329.745n 0.0v 329.755n 1.1v 334.745n 1.1v 334.755n 1.1v 339.745n 1.1v 339.755n 1.1v 344.745n 1.1v 344.755n 1.1v 349.745n 1.1v 349.755n 1.1v 354.745n 1.1v 354.755n 1.1v 359.745n 1.1v 359.755n 0.0v 364.745n 0.0v 364.755n 0.0v 369.745n 0.0v 369.755n 0.0v 374.745n 0.0v 374.755n 0.0v 379.745n 0.0v 379.755n 0.0v 384.745n 0.0v 384.755n 0.0v 389.745n 0.0v 389.755n 0.0v 394.745n 0.0v 394.755n 0.0v 399.745n 0.0v 399.755n 0.0v 404.745n 0.0v 404.755n 0.0v 409.745n 0.0v 409.755n 1.1v 414.745n 1.1v 414.755n 0.0v 419.745n 0.0v 419.755n 0.0v 424.745n 0.0v 424.755n 1.1v 429.745n 1.1v 429.755n 1.1v 434.745n 1.1v 434.755n 1.1v 439.745n 1.1v 439.755n 1.1v 444.745n 1.1v 444.755n 1.1v 449.745n 1.1v 449.755n 0.0v 454.745n 0.0v 454.755n 0.0v 459.745n 0.0v 459.755n 0.0v 464.745n 0.0v 464.755n 0.0v 469.745n 0.0v 469.755n 0.0v 474.745n 0.0v 474.755n 0.0v 479.745n 0.0v 479.755n 1.1v 484.745n 1.1v 484.755n 1.1v 489.745n 1.1v 489.755n 1.1v 494.745n 1.1v 494.755n 0.0v 499.745n 0.0v 499.755n 1.1v 504.745n 1.1v 504.755n 1.1v 509.745n 1.1v 509.755n 0.0v 514.745n 0.0v 514.755n 1.1v 519.745n 1.1v 519.755n 1.1v 524.745n 1.1v 524.755n 1.1v 529.745n 1.1v 529.755n 1.1v 534.745n 1.1v 534.755n 1.1v 539.745n 1.1v 539.755n 0.0v 544.745n 0.0v 544.755n 0.0v 549.745n 0.0v 549.755n 0.0v 554.745n 0.0v 554.755n 1.1v 559.745n 1.1v 559.755n 1.1v 564.745n 1.1v 564.755n 1.1v 569.745n 1.1v 569.755n 1.1v 574.745n 1.1v 574.755n 1.1v 579.745n 1.1v 579.755n 1.1v 584.745n 1.1v 584.755n 1.1v 589.745n 1.1v 589.755n 1.1v 594.745n 1.1v 594.755n 1.1v 599.745n 1.1v 599.755n 1.1v 604.745n 1.1v 604.755n 1.1v 609.745n 1.1v 609.755n 1.1v 614.745n 1.1v 614.755n 1.1v 619.745n 1.1v 619.755n 1.1v 624.745n 1.1v 624.755n 1.1v 629.745n 1.1v 629.755n 1.1v 634.745n 1.1v 634.755n 1.1v 639.745n 1.1v 639.755n 0.0v 644.745n 0.0v 644.755n 0.0v 649.745n 0.0v 649.755n 0.0v 654.745n 0.0v 654.755n 1.1v 659.745n 1.1v 659.755n 0.0v 664.745n 0.0v 664.755n 0.0v 669.745n 0.0v 669.755n 1.1v 674.745n 1.1v 674.755n 1.1v 679.745n 1.1v 679.755n 1.1v 684.745n 1.1v 684.755n 1.1v 689.745n 1.1v 689.755n 1.1v 694.745n 1.1v 694.755n 1.1v 699.745n 1.1v 699.755n 1.1v 704.745n 1.1v 704.755n 0.0v 709.745n 0.0v 709.755n 0.0v 714.745n 0.0v 714.755n 1.1v 719.745n 1.1v 719.755n 1.1v 724.745n 1.1v 724.755n 1.1v 729.745n 1.1v 729.755n 1.1v 734.745n 1.1v 734.755n 0.0v 739.745n 0.0v 739.755n 1.1v 744.745n 1.1v 744.755n 1.1v 749.745n 1.1v 749.755n 1.1v 754.745n 1.1v 754.755n 1.1v 759.745n 1.1v 759.755n 1.1v 764.745n 1.1v 764.755n 1.1v 769.745n 1.1v 769.755n 0.0v 774.745n 0.0v 774.755n 1.1v 779.745n 1.1v 779.755n 1.1v 784.745n 1.1v 784.755n 0.0v 789.745n 0.0v 789.755n 1.1v 794.745n 1.1v 794.755n 1.1v 799.745n 1.1v 799.755n 1.1v 804.745n 1.1v 804.755n 1.1v 809.745n 1.1v 809.755n 1.1v 814.745n 1.1v 814.755n 1.1v 819.745n 1.1v 819.755n 0.0v 824.745n 0.0v 824.755n 0.0v 829.745n 0.0v 829.755n 0.0v 834.745n 0.0v 834.755n 0.0v 839.745n 0.0v 839.755n 0.0v 844.745n 0.0v 844.755n 0.0v 849.745n 0.0v 849.755n 0.0v 854.745n 0.0v 854.755n 0.0v 859.745n 0.0v 859.755n 1.1v 864.745n 1.1v 864.755n 0.0v 869.745n 0.0v 869.755n 1.1v 874.745n 1.1v 874.755n 0.0v 879.745n 0.0v 879.755n 0.0v 884.745n 0.0v 884.755n 1.1v 889.745n 1.1v 889.755n 1.1v 894.745n 1.1v 894.755n 1.1v 899.745n 1.1v 899.755n 1.1v 904.745n 1.1v 904.755n 1.1v 909.745n 1.1v 909.755n 1.1v 914.745n 1.1v 914.755n 1.1v 919.745n 1.1v 919.755n 1.1v 924.745n 1.1v 924.755n 1.1v 929.745n 1.1v 929.755n 1.1v 934.745n 1.1v 934.755n 1.1v 939.745n 1.1v 939.755n 1.1v 944.745n 1.1v 944.755n 1.1v 949.745n 1.1v 949.755n 1.1v 954.745n 1.1v 954.755n 1.1v 959.745n 1.1v 959.755n 1.1v 964.745n 1.1v 964.755n 0.0v 969.745n 0.0v 969.755n 0.0v 974.745n 0.0v 974.755n 0.0v 979.745n 0.0v 979.755n 0.0v 984.745n 0.0v 984.755n 1.1v 989.745n 1.1v 989.755n 1.1v 994.745n 1.1v 994.755n 1.1v 999.745n 1.1v 999.755n 1.1v 1004.745n 1.1v 1004.755n 1.1v 1009.745n 1.1v 1009.755n 1.1v 1014.745n 1.1v 1014.755n 1.1v 1019.745n 1.1v 1019.755n 1.1v 1024.745n 1.1v 1024.755n 1.1v )
* (time, data): [(0, 0), (5, 1), (10, 1), (15, 0), (20, 0), (25, 0), (30, 1), (35, 1), (40, 0), (45, 1), (50, 1), (55, 1), (60, 1), (65, 1), (70, 1), (75, 1), (80, 1), (85, 1), (90, 1), (95, 1), (100, 0), (105, 0), (110, 0), (115, 0), (120, 0), (125, 0), (130, 0), (135, 1), (140, 1), (145, 1), (150, 1), (155, 1), (160, 1), (165, 1), (170, 1), (175, 1), (180, 1), (185, 1), (190, 1), (195, 1), (200, 0), (205, 0), (210, 0), (215, 0), (220, 0), (225, 0), (230, 1), (235, 1), (240, 1), (245, 1), (250, 1), (255, 0), (260, 0), (265, 0), (270, 0), (275, 0), (280, 1), (285, 1), (290, 1), (295, 1), (300, 1), (305, 1), (310, 1), (315, 0), (320, 0), (325, 0), (330, 0), (335, 1), (340, 0), (345, 0), (350, 0), (355, 0), (360, 1), (365, 1), (370, 1), (375, 1), (380, 1), (385, 1), (390, 1), (395, 0), (400, 1), (405, 1), (410, 1), (415, 1), (420, 0), (425, 1), (430, 0), (435, 0), (440, 0), (445, 0), (450, 1), (455, 1), (460, 1), (465, 1), (470, 1), (475, 1), (480, 0), (485, 0), (490, 0), (495, 0), (500, 1), (505, 1), (510, 0), (515, 1), (520, 1), (525, 1), (530, 1), (535, 0), (540, 1), (545, 1), (550, 1), (555, 0), (560, 0), (565, 0), (570, 0), (575, 0), (580, 0), (585, 0), (590, 0), (595, 0), (600, 0), (605, 0), (610, 0), (615, 0), (620, 0), (625, 0), (630, 0), (635, 0), (640, 1), (645, 1), (650, 1), (655, 1), (660, 0), (665, 0), (670, 0), (675, 0), (680, 0), (685, 0), (690, 0), (695, 0), (700, 0), (705, 1), (710, 0), (715, 0), (720, 0), (725, 0), (730, 0), (735, 1), (740, 1), (745, 1), (750, 1), (755, 0), (760, 0), (765, 0), (770, 1), (775, 0), (780, 0), (785, 1), (790, 0), (795, 0), (800, 0), (805, 0), (810, 0), (815, 0), (820, 0), (825, 0), (830, 1), (835, 0), (840, 0), (845, 0), (850, 0), (855, 1), (860, 1), (865, 0), (870, 0), (875, 0), (880, 1), (885, 1), (890, 1), (895, 1), (900, 1), (905, 1), (910, 1), (915, 1), (920, 1), (925, 1), (930, 0), (935, 0), (940, 0), (945, 0), (950, 0), (955, 1), (960, 1), (965, 0), (970, 0), (975, 0), (980, 1), (985, 1), (990, 1), (995, 0), (1000, 1), (1005, 1), (1010, 1), (1015, 1), (1020, 0), (1025, 0)]
Vdin0_13  din0_13  0 PWL (0n 0.0v 4.745n 0.0v 4.755n 1.1v 9.745n 1.1v 9.755n 1.1v 14.745n 1.1v 14.755n 0.0v 19.745n 0.0v 19.755n 0.0v 24.745n 0.0v 24.755n 0.0v 29.745n 0.0v 29.755n 1.1v 34.745n 1.1v 34.755n 1.1v 39.745n 1.1v 39.755n 0.0v 44.745n 0.0v 44.755n 1.1v 49.745n 1.1v 49.755n 1.1v 54.745n 1.1v 54.755n 1.1v 59.745n 1.1v 59.755n 1.1v 64.745n 1.1v 64.755n 1.1v 69.745n 1.1v 69.755n 1.1v 74.745n 1.1v 74.755n 1.1v 79.745n 1.1v 79.755n 1.1v 84.745n 1.1v 84.755n 1.1v 89.745n 1.1v 89.755n 1.1v 94.745n 1.1v 94.755n 1.1v 99.745n 1.1v 99.755n 0.0v 104.745n 0.0v 104.755n 0.0v 109.745n 0.0v 109.755n 0.0v 114.745n 0.0v 114.755n 0.0v 119.745n 0.0v 119.755n 0.0v 124.745n 0.0v 124.755n 0.0v 129.745n 0.0v 129.755n 0.0v 134.745n 0.0v 134.755n 1.1v 139.745n 1.1v 139.755n 1.1v 144.745n 1.1v 144.755n 1.1v 149.745n 1.1v 149.755n 1.1v 154.745n 1.1v 154.755n 1.1v 159.745n 1.1v 159.755n 1.1v 164.745n 1.1v 164.755n 1.1v 169.745n 1.1v 169.755n 1.1v 174.745n 1.1v 174.755n 1.1v 179.745n 1.1v 179.755n 1.1v 184.745n 1.1v 184.755n 1.1v 189.745n 1.1v 189.755n 1.1v 194.745n 1.1v 194.755n 1.1v 199.745n 1.1v 199.755n 0.0v 204.745n 0.0v 204.755n 0.0v 209.745n 0.0v 209.755n 0.0v 214.745n 0.0v 214.755n 0.0v 219.745n 0.0v 219.755n 0.0v 224.745n 0.0v 224.755n 0.0v 229.745n 0.0v 229.755n 1.1v 234.745n 1.1v 234.755n 1.1v 239.745n 1.1v 239.755n 1.1v 244.745n 1.1v 244.755n 1.1v 249.745n 1.1v 249.755n 1.1v 254.745n 1.1v 254.755n 0.0v 259.745n 0.0v 259.755n 0.0v 264.745n 0.0v 264.755n 0.0v 269.745n 0.0v 269.755n 0.0v 274.745n 0.0v 274.755n 0.0v 279.745n 0.0v 279.755n 1.1v 284.745n 1.1v 284.755n 1.1v 289.745n 1.1v 289.755n 1.1v 294.745n 1.1v 294.755n 1.1v 299.745n 1.1v 299.755n 1.1v 304.745n 1.1v 304.755n 1.1v 309.745n 1.1v 309.755n 1.1v 314.745n 1.1v 314.755n 0.0v 319.745n 0.0v 319.755n 0.0v 324.745n 0.0v 324.755n 0.0v 329.745n 0.0v 329.755n 0.0v 334.745n 0.0v 334.755n 1.1v 339.745n 1.1v 339.755n 0.0v 344.745n 0.0v 344.755n 0.0v 349.745n 0.0v 349.755n 0.0v 354.745n 0.0v 354.755n 0.0v 359.745n 0.0v 359.755n 1.1v 364.745n 1.1v 364.755n 1.1v 369.745n 1.1v 369.755n 1.1v 374.745n 1.1v 374.755n 1.1v 379.745n 1.1v 379.755n 1.1v 384.745n 1.1v 384.755n 1.1v 389.745n 1.1v 389.755n 1.1v 394.745n 1.1v 394.755n 0.0v 399.745n 0.0v 399.755n 1.1v 404.745n 1.1v 404.755n 1.1v 409.745n 1.1v 409.755n 1.1v 414.745n 1.1v 414.755n 1.1v 419.745n 1.1v 419.755n 0.0v 424.745n 0.0v 424.755n 1.1v 429.745n 1.1v 429.755n 0.0v 434.745n 0.0v 434.755n 0.0v 439.745n 0.0v 439.755n 0.0v 444.745n 0.0v 444.755n 0.0v 449.745n 0.0v 449.755n 1.1v 454.745n 1.1v 454.755n 1.1v 459.745n 1.1v 459.755n 1.1v 464.745n 1.1v 464.755n 1.1v 469.745n 1.1v 469.755n 1.1v 474.745n 1.1v 474.755n 1.1v 479.745n 1.1v 479.755n 0.0v 484.745n 0.0v 484.755n 0.0v 489.745n 0.0v 489.755n 0.0v 494.745n 0.0v 494.755n 0.0v 499.745n 0.0v 499.755n 1.1v 504.745n 1.1v 504.755n 1.1v 509.745n 1.1v 509.755n 0.0v 514.745n 0.0v 514.755n 1.1v 519.745n 1.1v 519.755n 1.1v 524.745n 1.1v 524.755n 1.1v 529.745n 1.1v 529.755n 1.1v 534.745n 1.1v 534.755n 0.0v 539.745n 0.0v 539.755n 1.1v 544.745n 1.1v 544.755n 1.1v 549.745n 1.1v 549.755n 1.1v 554.745n 1.1v 554.755n 0.0v 559.745n 0.0v 559.755n 0.0v 564.745n 0.0v 564.755n 0.0v 569.745n 0.0v 569.755n 0.0v 574.745n 0.0v 574.755n 0.0v 579.745n 0.0v 579.755n 0.0v 584.745n 0.0v 584.755n 0.0v 589.745n 0.0v 589.755n 0.0v 594.745n 0.0v 594.755n 0.0v 599.745n 0.0v 599.755n 0.0v 604.745n 0.0v 604.755n 0.0v 609.745n 0.0v 609.755n 0.0v 614.745n 0.0v 614.755n 0.0v 619.745n 0.0v 619.755n 0.0v 624.745n 0.0v 624.755n 0.0v 629.745n 0.0v 629.755n 0.0v 634.745n 0.0v 634.755n 0.0v 639.745n 0.0v 639.755n 1.1v 644.745n 1.1v 644.755n 1.1v 649.745n 1.1v 649.755n 1.1v 654.745n 1.1v 654.755n 1.1v 659.745n 1.1v 659.755n 0.0v 664.745n 0.0v 664.755n 0.0v 669.745n 0.0v 669.755n 0.0v 674.745n 0.0v 674.755n 0.0v 679.745n 0.0v 679.755n 0.0v 684.745n 0.0v 684.755n 0.0v 689.745n 0.0v 689.755n 0.0v 694.745n 0.0v 694.755n 0.0v 699.745n 0.0v 699.755n 0.0v 704.745n 0.0v 704.755n 1.1v 709.745n 1.1v 709.755n 0.0v 714.745n 0.0v 714.755n 0.0v 719.745n 0.0v 719.755n 0.0v 724.745n 0.0v 724.755n 0.0v 729.745n 0.0v 729.755n 0.0v 734.745n 0.0v 734.755n 1.1v 739.745n 1.1v 739.755n 1.1v 744.745n 1.1v 744.755n 1.1v 749.745n 1.1v 749.755n 1.1v 754.745n 1.1v 754.755n 0.0v 759.745n 0.0v 759.755n 0.0v 764.745n 0.0v 764.755n 0.0v 769.745n 0.0v 769.755n 1.1v 774.745n 1.1v 774.755n 0.0v 779.745n 0.0v 779.755n 0.0v 784.745n 0.0v 784.755n 1.1v 789.745n 1.1v 789.755n 0.0v 794.745n 0.0v 794.755n 0.0v 799.745n 0.0v 799.755n 0.0v 804.745n 0.0v 804.755n 0.0v 809.745n 0.0v 809.755n 0.0v 814.745n 0.0v 814.755n 0.0v 819.745n 0.0v 819.755n 0.0v 824.745n 0.0v 824.755n 0.0v 829.745n 0.0v 829.755n 1.1v 834.745n 1.1v 834.755n 0.0v 839.745n 0.0v 839.755n 0.0v 844.745n 0.0v 844.755n 0.0v 849.745n 0.0v 849.755n 0.0v 854.745n 0.0v 854.755n 1.1v 859.745n 1.1v 859.755n 1.1v 864.745n 1.1v 864.755n 0.0v 869.745n 0.0v 869.755n 0.0v 874.745n 0.0v 874.755n 0.0v 879.745n 0.0v 879.755n 1.1v 884.745n 1.1v 884.755n 1.1v 889.745n 1.1v 889.755n 1.1v 894.745n 1.1v 894.755n 1.1v 899.745n 1.1v 899.755n 1.1v 904.745n 1.1v 904.755n 1.1v 909.745n 1.1v 909.755n 1.1v 914.745n 1.1v 914.755n 1.1v 919.745n 1.1v 919.755n 1.1v 924.745n 1.1v 924.755n 1.1v 929.745n 1.1v 929.755n 0.0v 934.745n 0.0v 934.755n 0.0v 939.745n 0.0v 939.755n 0.0v 944.745n 0.0v 944.755n 0.0v 949.745n 0.0v 949.755n 0.0v 954.745n 0.0v 954.755n 1.1v 959.745n 1.1v 959.755n 1.1v 964.745n 1.1v 964.755n 0.0v 969.745n 0.0v 969.755n 0.0v 974.745n 0.0v 974.755n 0.0v 979.745n 0.0v 979.755n 1.1v 984.745n 1.1v 984.755n 1.1v 989.745n 1.1v 989.755n 1.1v 994.745n 1.1v 994.755n 0.0v 999.745n 0.0v 999.755n 1.1v 1004.745n 1.1v 1004.755n 1.1v 1009.745n 1.1v 1009.755n 1.1v 1014.745n 1.1v 1014.755n 1.1v 1019.745n 1.1v 1019.755n 0.0v 1024.745n 0.0v 1024.755n 0.0v )
* (time, data): [(0, 0), (5, 1), (10, 0), (15, 0), (20, 0), (25, 0), (30, 1), (35, 1), (40, 0), (45, 0), (50, 0), (55, 0), (60, 1), (65, 1), (70, 1), (75, 1), (80, 1), (85, 1), (90, 0), (95, 0), (100, 0), (105, 0), (110, 0), (115, 0), (120, 0), (125, 0), (130, 0), (135, 0), (140, 0), (145, 0), (150, 0), (155, 0), (160, 0), (165, 0), (170, 0), (175, 0), (180, 0), (185, 1), (190, 1), (195, 1), (200, 1), (205, 1), (210, 1), (215, 1), (220, 0), (225, 0), (230, 0), (235, 0), (240, 0), (245, 0), (250, 0), (255, 1), (260, 1), (265, 0), (270, 0), (275, 0), (280, 1), (285, 1), (290, 1), (295, 1), (300, 0), (305, 0), (310, 0), (315, 1), (320, 1), (325, 1), (330, 1), (335, 1), (340, 0), (345, 0), (350, 0), (355, 0), (360, 0), (365, 0), (370, 0), (375, 0), (380, 0), (385, 0), (390, 0), (395, 0), (400, 1), (405, 1), (410, 0), (415, 1), (420, 0), (425, 1), (430, 0), (435, 0), (440, 0), (445, 0), (450, 0), (455, 0), (460, 1), (465, 1), (470, 0), (475, 0), (480, 0), (485, 0), (490, 0), (495, 1), (500, 0), (505, 0), (510, 1), (515, 0), (520, 0), (525, 0), (530, 0), (535, 0), (540, 1), (545, 1), (550, 1), (555, 1), (560, 1), (565, 1), (570, 1), (575, 1), (580, 1), (585, 1), (590, 1), (595, 1), (600, 1), (605, 1), (610, 1), (615, 1), (620, 1), (625, 1), (630, 0), (635, 1), (640, 0), (645, 0), (650, 0), (655, 0), (660, 0), (665, 0), (670, 0), (675, 0), (680, 0), (685, 0), (690, 0), (695, 0), (700, 0), (705, 0), (710, 1), (715, 1), (720, 1), (725, 1), (730, 1), (735, 0), (740, 0), (745, 0), (750, 0), (755, 1), (760, 1), (765, 1), (770, 0), (775, 0), (780, 0), (785, 0), (790, 0), (795, 0), (800, 0), (805, 0), (810, 0), (815, 0), (820, 1), (825, 1), (830, 0), (835, 0), (840, 0), (845, 0), (850, 0), (855, 1), (860, 0), (865, 0), (870, 0), (875, 0), (880, 0), (885, 1), (890, 1), (895, 1), (900, 1), (905, 1), (910, 1), (915, 1), (920, 1), (925, 1), (930, 1), (935, 0), (940, 1), (945, 1), (950, 1), (955, 1), (960, 1), (965, 0), (970, 0), (975, 0), (980, 1), (985, 0), (990, 0), (995, 1), (1000, 1), (1005, 1), (1010, 1), (1015, 1), (1020, 1), (1025, 1)]
Vdin0_14  din0_14  0 PWL (0n 0.0v 4.745n 0.0v 4.755n 1.1v 9.745n 1.1v 9.755n 0.0v 14.745n 0.0v 14.755n 0.0v 19.745n 0.0v 19.755n 0.0v 24.745n 0.0v 24.755n 0.0v 29.745n 0.0v 29.755n 1.1v 34.745n 1.1v 34.755n 1.1v 39.745n 1.1v 39.755n 0.0v 44.745n 0.0v 44.755n 0.0v 49.745n 0.0v 49.755n 0.0v 54.745n 0.0v 54.755n 0.0v 59.745n 0.0v 59.755n 1.1v 64.745n 1.1v 64.755n 1.1v 69.745n 1.1v 69.755n 1.1v 74.745n 1.1v 74.755n 1.1v 79.745n 1.1v 79.755n 1.1v 84.745n 1.1v 84.755n 1.1v 89.745n 1.1v 89.755n 0.0v 94.745n 0.0v 94.755n 0.0v 99.745n 0.0v 99.755n 0.0v 104.745n 0.0v 104.755n 0.0v 109.745n 0.0v 109.755n 0.0v 114.745n 0.0v 114.755n 0.0v 119.745n 0.0v 119.755n 0.0v 124.745n 0.0v 124.755n 0.0v 129.745n 0.0v 129.755n 0.0v 134.745n 0.0v 134.755n 0.0v 139.745n 0.0v 139.755n 0.0v 144.745n 0.0v 144.755n 0.0v 149.745n 0.0v 149.755n 0.0v 154.745n 0.0v 154.755n 0.0v 159.745n 0.0v 159.755n 0.0v 164.745n 0.0v 164.755n 0.0v 169.745n 0.0v 169.755n 0.0v 174.745n 0.0v 174.755n 0.0v 179.745n 0.0v 179.755n 0.0v 184.745n 0.0v 184.755n 1.1v 189.745n 1.1v 189.755n 1.1v 194.745n 1.1v 194.755n 1.1v 199.745n 1.1v 199.755n 1.1v 204.745n 1.1v 204.755n 1.1v 209.745n 1.1v 209.755n 1.1v 214.745n 1.1v 214.755n 1.1v 219.745n 1.1v 219.755n 0.0v 224.745n 0.0v 224.755n 0.0v 229.745n 0.0v 229.755n 0.0v 234.745n 0.0v 234.755n 0.0v 239.745n 0.0v 239.755n 0.0v 244.745n 0.0v 244.755n 0.0v 249.745n 0.0v 249.755n 0.0v 254.745n 0.0v 254.755n 1.1v 259.745n 1.1v 259.755n 1.1v 264.745n 1.1v 264.755n 0.0v 269.745n 0.0v 269.755n 0.0v 274.745n 0.0v 274.755n 0.0v 279.745n 0.0v 279.755n 1.1v 284.745n 1.1v 284.755n 1.1v 289.745n 1.1v 289.755n 1.1v 294.745n 1.1v 294.755n 1.1v 299.745n 1.1v 299.755n 0.0v 304.745n 0.0v 304.755n 0.0v 309.745n 0.0v 309.755n 0.0v 314.745n 0.0v 314.755n 1.1v 319.745n 1.1v 319.755n 1.1v 324.745n 1.1v 324.755n 1.1v 329.745n 1.1v 329.755n 1.1v 334.745n 1.1v 334.755n 1.1v 339.745n 1.1v 339.755n 0.0v 344.745n 0.0v 344.755n 0.0v 349.745n 0.0v 349.755n 0.0v 354.745n 0.0v 354.755n 0.0v 359.745n 0.0v 359.755n 0.0v 364.745n 0.0v 364.755n 0.0v 369.745n 0.0v 369.755n 0.0v 374.745n 0.0v 374.755n 0.0v 379.745n 0.0v 379.755n 0.0v 384.745n 0.0v 384.755n 0.0v 389.745n 0.0v 389.755n 0.0v 394.745n 0.0v 394.755n 0.0v 399.745n 0.0v 399.755n 1.1v 404.745n 1.1v 404.755n 1.1v 409.745n 1.1v 409.755n 0.0v 414.745n 0.0v 414.755n 1.1v 419.745n 1.1v 419.755n 0.0v 424.745n 0.0v 424.755n 1.1v 429.745n 1.1v 429.755n 0.0v 434.745n 0.0v 434.755n 0.0v 439.745n 0.0v 439.755n 0.0v 444.745n 0.0v 444.755n 0.0v 449.745n 0.0v 449.755n 0.0v 454.745n 0.0v 454.755n 0.0v 459.745n 0.0v 459.755n 1.1v 464.745n 1.1v 464.755n 1.1v 469.745n 1.1v 469.755n 0.0v 474.745n 0.0v 474.755n 0.0v 479.745n 0.0v 479.755n 0.0v 484.745n 0.0v 484.755n 0.0v 489.745n 0.0v 489.755n 0.0v 494.745n 0.0v 494.755n 1.1v 499.745n 1.1v 499.755n 0.0v 504.745n 0.0v 504.755n 0.0v 509.745n 0.0v 509.755n 1.1v 514.745n 1.1v 514.755n 0.0v 519.745n 0.0v 519.755n 0.0v 524.745n 0.0v 524.755n 0.0v 529.745n 0.0v 529.755n 0.0v 534.745n 0.0v 534.755n 0.0v 539.745n 0.0v 539.755n 1.1v 544.745n 1.1v 544.755n 1.1v 549.745n 1.1v 549.755n 1.1v 554.745n 1.1v 554.755n 1.1v 559.745n 1.1v 559.755n 1.1v 564.745n 1.1v 564.755n 1.1v 569.745n 1.1v 569.755n 1.1v 574.745n 1.1v 574.755n 1.1v 579.745n 1.1v 579.755n 1.1v 584.745n 1.1v 584.755n 1.1v 589.745n 1.1v 589.755n 1.1v 594.745n 1.1v 594.755n 1.1v 599.745n 1.1v 599.755n 1.1v 604.745n 1.1v 604.755n 1.1v 609.745n 1.1v 609.755n 1.1v 614.745n 1.1v 614.755n 1.1v 619.745n 1.1v 619.755n 1.1v 624.745n 1.1v 624.755n 1.1v 629.745n 1.1v 629.755n 0.0v 634.745n 0.0v 634.755n 1.1v 639.745n 1.1v 639.755n 0.0v 644.745n 0.0v 644.755n 0.0v 649.745n 0.0v 649.755n 0.0v 654.745n 0.0v 654.755n 0.0v 659.745n 0.0v 659.755n 0.0v 664.745n 0.0v 664.755n 0.0v 669.745n 0.0v 669.755n 0.0v 674.745n 0.0v 674.755n 0.0v 679.745n 0.0v 679.755n 0.0v 684.745n 0.0v 684.755n 0.0v 689.745n 0.0v 689.755n 0.0v 694.745n 0.0v 694.755n 0.0v 699.745n 0.0v 699.755n 0.0v 704.745n 0.0v 704.755n 0.0v 709.745n 0.0v 709.755n 1.1v 714.745n 1.1v 714.755n 1.1v 719.745n 1.1v 719.755n 1.1v 724.745n 1.1v 724.755n 1.1v 729.745n 1.1v 729.755n 1.1v 734.745n 1.1v 734.755n 0.0v 739.745n 0.0v 739.755n 0.0v 744.745n 0.0v 744.755n 0.0v 749.745n 0.0v 749.755n 0.0v 754.745n 0.0v 754.755n 1.1v 759.745n 1.1v 759.755n 1.1v 764.745n 1.1v 764.755n 1.1v 769.745n 1.1v 769.755n 0.0v 774.745n 0.0v 774.755n 0.0v 779.745n 0.0v 779.755n 0.0v 784.745n 0.0v 784.755n 0.0v 789.745n 0.0v 789.755n 0.0v 794.745n 0.0v 794.755n 0.0v 799.745n 0.0v 799.755n 0.0v 804.745n 0.0v 804.755n 0.0v 809.745n 0.0v 809.755n 0.0v 814.745n 0.0v 814.755n 0.0v 819.745n 0.0v 819.755n 1.1v 824.745n 1.1v 824.755n 1.1v 829.745n 1.1v 829.755n 0.0v 834.745n 0.0v 834.755n 0.0v 839.745n 0.0v 839.755n 0.0v 844.745n 0.0v 844.755n 0.0v 849.745n 0.0v 849.755n 0.0v 854.745n 0.0v 854.755n 1.1v 859.745n 1.1v 859.755n 0.0v 864.745n 0.0v 864.755n 0.0v 869.745n 0.0v 869.755n 0.0v 874.745n 0.0v 874.755n 0.0v 879.745n 0.0v 879.755n 0.0v 884.745n 0.0v 884.755n 1.1v 889.745n 1.1v 889.755n 1.1v 894.745n 1.1v 894.755n 1.1v 899.745n 1.1v 899.755n 1.1v 904.745n 1.1v 904.755n 1.1v 909.745n 1.1v 909.755n 1.1v 914.745n 1.1v 914.755n 1.1v 919.745n 1.1v 919.755n 1.1v 924.745n 1.1v 924.755n 1.1v 929.745n 1.1v 929.755n 1.1v 934.745n 1.1v 934.755n 0.0v 939.745n 0.0v 939.755n 1.1v 944.745n 1.1v 944.755n 1.1v 949.745n 1.1v 949.755n 1.1v 954.745n 1.1v 954.755n 1.1v 959.745n 1.1v 959.755n 1.1v 964.745n 1.1v 964.755n 0.0v 969.745n 0.0v 969.755n 0.0v 974.745n 0.0v 974.755n 0.0v 979.745n 0.0v 979.755n 1.1v 984.745n 1.1v 984.755n 0.0v 989.745n 0.0v 989.755n 0.0v 994.745n 0.0v 994.755n 1.1v 999.745n 1.1v 999.755n 1.1v 1004.745n 1.1v 1004.755n 1.1v 1009.745n 1.1v 1009.755n 1.1v 1014.745n 1.1v 1014.755n 1.1v 1019.745n 1.1v 1019.755n 1.1v 1024.745n 1.1v 1024.755n 1.1v )
* (time, data): [(0, 0), (5, 1), (10, 1), (15, 1), (20, 1), (25, 1), (30, 0), (35, 0), (40, 0), (45, 0), (50, 0), (55, 0), (60, 0), (65, 1), (70, 1), (75, 1), (80, 1), (85, 1), (90, 0), (95, 0), (100, 1), (105, 1), (110, 1), (115, 1), (120, 1), (125, 1), (130, 1), (135, 1), (140, 0), (145, 0), (150, 0), (155, 0), (160, 0), (165, 0), (170, 0), (175, 0), (180, 0), (185, 0), (190, 0), (195, 0), (200, 1), (205, 1), (210, 1), (215, 1), (220, 1), (225, 1), (230, 0), (235, 0), (240, 1), (245, 1), (250, 1), (255, 1), (260, 1), (265, 1), (270, 1), (275, 1), (280, 1), (285, 1), (290, 1), (295, 1), (300, 1), (305, 1), (310, 1), (315, 0), (320, 0), (325, 0), (330, 1), (335, 1), (340, 1), (345, 1), (350, 1), (355, 1), (360, 1), (365, 1), (370, 1), (375, 1), (380, 1), (385, 1), (390, 1), (395, 0), (400, 1), (405, 1), (410, 1), (415, 0), (420, 0), (425, 1), (430, 0), (435, 0), (440, 0), (445, 0), (450, 0), (455, 0), (460, 0), (465, 1), (470, 0), (475, 0), (480, 1), (485, 1), (490, 1), (495, 0), (500, 1), (505, 0), (510, 1), (515, 1), (520, 1), (525, 1), (530, 1), (535, 0), (540, 0), (545, 0), (550, 0), (555, 0), (560, 0), (565, 0), (570, 0), (575, 0), (580, 0), (585, 0), (590, 0), (595, 0), (600, 0), (605, 0), (610, 0), (615, 0), (620, 0), (625, 0), (630, 1), (635, 0), (640, 1), (645, 1), (650, 1), (655, 0), (660, 0), (665, 0), (670, 0), (675, 0), (680, 0), (685, 0), (690, 0), (695, 0), (700, 0), (705, 1), (710, 1), (715, 0), (720, 0), (725, 0), (730, 0), (735, 1), (740, 0), (745, 0), (750, 0), (755, 1), (760, 1), (765, 1), (770, 1), (775, 1), (780, 1), (785, 0), (790, 0), (795, 0), (800, 0), (805, 0), (810, 0), (815, 0), (820, 0), (825, 0), (830, 0), (835, 0), (840, 0), (845, 0), (850, 0), (855, 0), (860, 1), (865, 1), (870, 1), (875, 0), (880, 0), (885, 1), (890, 1), (895, 1), (900, 1), (905, 1), (910, 0), (915, 0), (920, 0), (925, 0), (930, 1), (935, 0), (940, 1), (945, 1), (950, 1), (955, 1), (960, 1), (965, 1), (970, 1), (975, 1), (980, 0), (985, 0), (990, 0), (995, 1), (1000, 1), (1005, 1), (1010, 1), (1015, 1), (1020, 0), (1025, 0)]
Vdin0_15  din0_15  0 PWL (0n 0.0v 4.745n 0.0v 4.755n 1.1v 9.745n 1.1v 9.755n 1.1v 14.745n 1.1v 14.755n 1.1v 19.745n 1.1v 19.755n 1.1v 24.745n 1.1v 24.755n 1.1v 29.745n 1.1v 29.755n 0.0v 34.745n 0.0v 34.755n 0.0v 39.745n 0.0v 39.755n 0.0v 44.745n 0.0v 44.755n 0.0v 49.745n 0.0v 49.755n 0.0v 54.745n 0.0v 54.755n 0.0v 59.745n 0.0v 59.755n 0.0v 64.745n 0.0v 64.755n 1.1v 69.745n 1.1v 69.755n 1.1v 74.745n 1.1v 74.755n 1.1v 79.745n 1.1v 79.755n 1.1v 84.745n 1.1v 84.755n 1.1v 89.745n 1.1v 89.755n 0.0v 94.745n 0.0v 94.755n 0.0v 99.745n 0.0v 99.755n 1.1v 104.745n 1.1v 104.755n 1.1v 109.745n 1.1v 109.755n 1.1v 114.745n 1.1v 114.755n 1.1v 119.745n 1.1v 119.755n 1.1v 124.745n 1.1v 124.755n 1.1v 129.745n 1.1v 129.755n 1.1v 134.745n 1.1v 134.755n 1.1v 139.745n 1.1v 139.755n 0.0v 144.745n 0.0v 144.755n 0.0v 149.745n 0.0v 149.755n 0.0v 154.745n 0.0v 154.755n 0.0v 159.745n 0.0v 159.755n 0.0v 164.745n 0.0v 164.755n 0.0v 169.745n 0.0v 169.755n 0.0v 174.745n 0.0v 174.755n 0.0v 179.745n 0.0v 179.755n 0.0v 184.745n 0.0v 184.755n 0.0v 189.745n 0.0v 189.755n 0.0v 194.745n 0.0v 194.755n 0.0v 199.745n 0.0v 199.755n 1.1v 204.745n 1.1v 204.755n 1.1v 209.745n 1.1v 209.755n 1.1v 214.745n 1.1v 214.755n 1.1v 219.745n 1.1v 219.755n 1.1v 224.745n 1.1v 224.755n 1.1v 229.745n 1.1v 229.755n 0.0v 234.745n 0.0v 234.755n 0.0v 239.745n 0.0v 239.755n 1.1v 244.745n 1.1v 244.755n 1.1v 249.745n 1.1v 249.755n 1.1v 254.745n 1.1v 254.755n 1.1v 259.745n 1.1v 259.755n 1.1v 264.745n 1.1v 264.755n 1.1v 269.745n 1.1v 269.755n 1.1v 274.745n 1.1v 274.755n 1.1v 279.745n 1.1v 279.755n 1.1v 284.745n 1.1v 284.755n 1.1v 289.745n 1.1v 289.755n 1.1v 294.745n 1.1v 294.755n 1.1v 299.745n 1.1v 299.755n 1.1v 304.745n 1.1v 304.755n 1.1v 309.745n 1.1v 309.755n 1.1v 314.745n 1.1v 314.755n 0.0v 319.745n 0.0v 319.755n 0.0v 324.745n 0.0v 324.755n 0.0v 329.745n 0.0v 329.755n 1.1v 334.745n 1.1v 334.755n 1.1v 339.745n 1.1v 339.755n 1.1v 344.745n 1.1v 344.755n 1.1v 349.745n 1.1v 349.755n 1.1v 354.745n 1.1v 354.755n 1.1v 359.745n 1.1v 359.755n 1.1v 364.745n 1.1v 364.755n 1.1v 369.745n 1.1v 369.755n 1.1v 374.745n 1.1v 374.755n 1.1v 379.745n 1.1v 379.755n 1.1v 384.745n 1.1v 384.755n 1.1v 389.745n 1.1v 389.755n 1.1v 394.745n 1.1v 394.755n 0.0v 399.745n 0.0v 399.755n 1.1v 404.745n 1.1v 404.755n 1.1v 409.745n 1.1v 409.755n 1.1v 414.745n 1.1v 414.755n 0.0v 419.745n 0.0v 419.755n 0.0v 424.745n 0.0v 424.755n 1.1v 429.745n 1.1v 429.755n 0.0v 434.745n 0.0v 434.755n 0.0v 439.745n 0.0v 439.755n 0.0v 444.745n 0.0v 444.755n 0.0v 449.745n 0.0v 449.755n 0.0v 454.745n 0.0v 454.755n 0.0v 459.745n 0.0v 459.755n 0.0v 464.745n 0.0v 464.755n 1.1v 469.745n 1.1v 469.755n 0.0v 474.745n 0.0v 474.755n 0.0v 479.745n 0.0v 479.755n 1.1v 484.745n 1.1v 484.755n 1.1v 489.745n 1.1v 489.755n 1.1v 494.745n 1.1v 494.755n 0.0v 499.745n 0.0v 499.755n 1.1v 504.745n 1.1v 504.755n 0.0v 509.745n 0.0v 509.755n 1.1v 514.745n 1.1v 514.755n 1.1v 519.745n 1.1v 519.755n 1.1v 524.745n 1.1v 524.755n 1.1v 529.745n 1.1v 529.755n 1.1v 534.745n 1.1v 534.755n 0.0v 539.745n 0.0v 539.755n 0.0v 544.745n 0.0v 544.755n 0.0v 549.745n 0.0v 549.755n 0.0v 554.745n 0.0v 554.755n 0.0v 559.745n 0.0v 559.755n 0.0v 564.745n 0.0v 564.755n 0.0v 569.745n 0.0v 569.755n 0.0v 574.745n 0.0v 574.755n 0.0v 579.745n 0.0v 579.755n 0.0v 584.745n 0.0v 584.755n 0.0v 589.745n 0.0v 589.755n 0.0v 594.745n 0.0v 594.755n 0.0v 599.745n 0.0v 599.755n 0.0v 604.745n 0.0v 604.755n 0.0v 609.745n 0.0v 609.755n 0.0v 614.745n 0.0v 614.755n 0.0v 619.745n 0.0v 619.755n 0.0v 624.745n 0.0v 624.755n 0.0v 629.745n 0.0v 629.755n 1.1v 634.745n 1.1v 634.755n 0.0v 639.745n 0.0v 639.755n 1.1v 644.745n 1.1v 644.755n 1.1v 649.745n 1.1v 649.755n 1.1v 654.745n 1.1v 654.755n 0.0v 659.745n 0.0v 659.755n 0.0v 664.745n 0.0v 664.755n 0.0v 669.745n 0.0v 669.755n 0.0v 674.745n 0.0v 674.755n 0.0v 679.745n 0.0v 679.755n 0.0v 684.745n 0.0v 684.755n 0.0v 689.745n 0.0v 689.755n 0.0v 694.745n 0.0v 694.755n 0.0v 699.745n 0.0v 699.755n 0.0v 704.745n 0.0v 704.755n 1.1v 709.745n 1.1v 709.755n 1.1v 714.745n 1.1v 714.755n 0.0v 719.745n 0.0v 719.755n 0.0v 724.745n 0.0v 724.755n 0.0v 729.745n 0.0v 729.755n 0.0v 734.745n 0.0v 734.755n 1.1v 739.745n 1.1v 739.755n 0.0v 744.745n 0.0v 744.755n 0.0v 749.745n 0.0v 749.755n 0.0v 754.745n 0.0v 754.755n 1.1v 759.745n 1.1v 759.755n 1.1v 764.745n 1.1v 764.755n 1.1v 769.745n 1.1v 769.755n 1.1v 774.745n 1.1v 774.755n 1.1v 779.745n 1.1v 779.755n 1.1v 784.745n 1.1v 784.755n 0.0v 789.745n 0.0v 789.755n 0.0v 794.745n 0.0v 794.755n 0.0v 799.745n 0.0v 799.755n 0.0v 804.745n 0.0v 804.755n 0.0v 809.745n 0.0v 809.755n 0.0v 814.745n 0.0v 814.755n 0.0v 819.745n 0.0v 819.755n 0.0v 824.745n 0.0v 824.755n 0.0v 829.745n 0.0v 829.755n 0.0v 834.745n 0.0v 834.755n 0.0v 839.745n 0.0v 839.755n 0.0v 844.745n 0.0v 844.755n 0.0v 849.745n 0.0v 849.755n 0.0v 854.745n 0.0v 854.755n 0.0v 859.745n 0.0v 859.755n 1.1v 864.745n 1.1v 864.755n 1.1v 869.745n 1.1v 869.755n 1.1v 874.745n 1.1v 874.755n 0.0v 879.745n 0.0v 879.755n 0.0v 884.745n 0.0v 884.755n 1.1v 889.745n 1.1v 889.755n 1.1v 894.745n 1.1v 894.755n 1.1v 899.745n 1.1v 899.755n 1.1v 904.745n 1.1v 904.755n 1.1v 909.745n 1.1v 909.755n 0.0v 914.745n 0.0v 914.755n 0.0v 919.745n 0.0v 919.755n 0.0v 924.745n 0.0v 924.755n 0.0v 929.745n 0.0v 929.755n 1.1v 934.745n 1.1v 934.755n 0.0v 939.745n 0.0v 939.755n 1.1v 944.745n 1.1v 944.755n 1.1v 949.745n 1.1v 949.755n 1.1v 954.745n 1.1v 954.755n 1.1v 959.745n 1.1v 959.755n 1.1v 964.745n 1.1v 964.755n 1.1v 969.745n 1.1v 969.755n 1.1v 974.745n 1.1v 974.755n 1.1v 979.745n 1.1v 979.755n 0.0v 984.745n 0.0v 984.755n 0.0v 989.745n 0.0v 989.755n 0.0v 994.745n 0.0v 994.755n 1.1v 999.745n 1.1v 999.755n 1.1v 1004.745n 1.1v 1004.755n 1.1v 1009.745n 1.1v 1009.755n 1.1v 1014.745n 1.1v 1014.755n 1.1v 1019.745n 1.1v 1019.755n 0.0v 1024.745n 0.0v 1024.755n 0.0v )
* (time, data): [(0, 0), (5, 1), (10, 0), (15, 0), (20, 0), (25, 0), (30, 1), (35, 1), (40, 1), (45, 1), (50, 1), (55, 1), (60, 1), (65, 1), (70, 1), (75, 1), (80, 1), (85, 1), (90, 0), (95, 0), (100, 0), (105, 0), (110, 0), (115, 0), (120, 0), (125, 0), (130, 0), (135, 0), (140, 0), (145, 0), (150, 0), (155, 0), (160, 0), (165, 0), (170, 0), (175, 0), (180, 0), (185, 0), (190, 0), (195, 0), (200, 0), (205, 0), (210, 1), (215, 1), (220, 1), (225, 1), (230, 1), (235, 1), (240, 1), (245, 1), (250, 1), (255, 1), (260, 1), (265, 0), (270, 0), (275, 0), (280, 1), (285, 1), (290, 1), (295, 1), (300, 1), (305, 1), (310, 1), (315, 0), (320, 0), (325, 0), (330, 1), (335, 0), (340, 1), (345, 1), (350, 1), (355, 1), (360, 1), (365, 1), (370, 1), (375, 1), (380, 1), (385, 1), (390, 1), (395, 0), (400, 1), (405, 1), (410, 0), (415, 0), (420, 1), (425, 1), (430, 0), (435, 0), (440, 0), (445, 0), (450, 0), (455, 0), (460, 0), (465, 1), (470, 0), (475, 0), (480, 1), (485, 1), (490, 1), (495, 1), (500, 1), (505, 0), (510, 0), (515, 0), (520, 0), (525, 0), (530, 0), (535, 0), (540, 1), (545, 1), (550, 1), (555, 0), (560, 0), (565, 0), (570, 0), (575, 0), (580, 0), (585, 0), (590, 0), (595, 0), (600, 0), (605, 0), (610, 0), (615, 0), (620, 0), (625, 0), (630, 1), (635, 1), (640, 1), (645, 1), (650, 1), (655, 1), (660, 1), (665, 1), (670, 1), (675, 1), (680, 1), (685, 1), (690, 1), (695, 1), (700, 1), (705, 1), (710, 0), (715, 1), (720, 1), (725, 1), (730, 1), (735, 1), (740, 0), (745, 0), (750, 0), (755, 0), (760, 0), (765, 0), (770, 1), (775, 1), (780, 1), (785, 1), (790, 1), (795, 1), (800, 1), (805, 1), (810, 1), (815, 1), (820, 1), (825, 1), (830, 1), (835, 0), (840, 0), (845, 0), (850, 0), (855, 1), (860, 0), (865, 0), (870, 0), (875, 0), (880, 0), (885, 1), (890, 1), (895, 1), (900, 1), (905, 1), (910, 0), (915, 0), (920, 0), (925, 0), (930, 0), (935, 0), (940, 1), (945, 1), (950, 1), (955, 0), (960, 0), (965, 0), (970, 0), (975, 0), (980, 1), (985, 1), (990, 1), (995, 0), (1000, 1), (1005, 1), (1010, 1), (1015, 1), (1020, 0), (1025, 0)]
Vdin0_16  din0_16  0 PWL (0n 0.0v 4.745n 0.0v 4.755n 1.1v 9.745n 1.1v 9.755n 0.0v 14.745n 0.0v 14.755n 0.0v 19.745n 0.0v 19.755n 0.0v 24.745n 0.0v 24.755n 0.0v 29.745n 0.0v 29.755n 1.1v 34.745n 1.1v 34.755n 1.1v 39.745n 1.1v 39.755n 1.1v 44.745n 1.1v 44.755n 1.1v 49.745n 1.1v 49.755n 1.1v 54.745n 1.1v 54.755n 1.1v 59.745n 1.1v 59.755n 1.1v 64.745n 1.1v 64.755n 1.1v 69.745n 1.1v 69.755n 1.1v 74.745n 1.1v 74.755n 1.1v 79.745n 1.1v 79.755n 1.1v 84.745n 1.1v 84.755n 1.1v 89.745n 1.1v 89.755n 0.0v 94.745n 0.0v 94.755n 0.0v 99.745n 0.0v 99.755n 0.0v 104.745n 0.0v 104.755n 0.0v 109.745n 0.0v 109.755n 0.0v 114.745n 0.0v 114.755n 0.0v 119.745n 0.0v 119.755n 0.0v 124.745n 0.0v 124.755n 0.0v 129.745n 0.0v 129.755n 0.0v 134.745n 0.0v 134.755n 0.0v 139.745n 0.0v 139.755n 0.0v 144.745n 0.0v 144.755n 0.0v 149.745n 0.0v 149.755n 0.0v 154.745n 0.0v 154.755n 0.0v 159.745n 0.0v 159.755n 0.0v 164.745n 0.0v 164.755n 0.0v 169.745n 0.0v 169.755n 0.0v 174.745n 0.0v 174.755n 0.0v 179.745n 0.0v 179.755n 0.0v 184.745n 0.0v 184.755n 0.0v 189.745n 0.0v 189.755n 0.0v 194.745n 0.0v 194.755n 0.0v 199.745n 0.0v 199.755n 0.0v 204.745n 0.0v 204.755n 0.0v 209.745n 0.0v 209.755n 1.1v 214.745n 1.1v 214.755n 1.1v 219.745n 1.1v 219.755n 1.1v 224.745n 1.1v 224.755n 1.1v 229.745n 1.1v 229.755n 1.1v 234.745n 1.1v 234.755n 1.1v 239.745n 1.1v 239.755n 1.1v 244.745n 1.1v 244.755n 1.1v 249.745n 1.1v 249.755n 1.1v 254.745n 1.1v 254.755n 1.1v 259.745n 1.1v 259.755n 1.1v 264.745n 1.1v 264.755n 0.0v 269.745n 0.0v 269.755n 0.0v 274.745n 0.0v 274.755n 0.0v 279.745n 0.0v 279.755n 1.1v 284.745n 1.1v 284.755n 1.1v 289.745n 1.1v 289.755n 1.1v 294.745n 1.1v 294.755n 1.1v 299.745n 1.1v 299.755n 1.1v 304.745n 1.1v 304.755n 1.1v 309.745n 1.1v 309.755n 1.1v 314.745n 1.1v 314.755n 0.0v 319.745n 0.0v 319.755n 0.0v 324.745n 0.0v 324.755n 0.0v 329.745n 0.0v 329.755n 1.1v 334.745n 1.1v 334.755n 0.0v 339.745n 0.0v 339.755n 1.1v 344.745n 1.1v 344.755n 1.1v 349.745n 1.1v 349.755n 1.1v 354.745n 1.1v 354.755n 1.1v 359.745n 1.1v 359.755n 1.1v 364.745n 1.1v 364.755n 1.1v 369.745n 1.1v 369.755n 1.1v 374.745n 1.1v 374.755n 1.1v 379.745n 1.1v 379.755n 1.1v 384.745n 1.1v 384.755n 1.1v 389.745n 1.1v 389.755n 1.1v 394.745n 1.1v 394.755n 0.0v 399.745n 0.0v 399.755n 1.1v 404.745n 1.1v 404.755n 1.1v 409.745n 1.1v 409.755n 0.0v 414.745n 0.0v 414.755n 0.0v 419.745n 0.0v 419.755n 1.1v 424.745n 1.1v 424.755n 1.1v 429.745n 1.1v 429.755n 0.0v 434.745n 0.0v 434.755n 0.0v 439.745n 0.0v 439.755n 0.0v 444.745n 0.0v 444.755n 0.0v 449.745n 0.0v 449.755n 0.0v 454.745n 0.0v 454.755n 0.0v 459.745n 0.0v 459.755n 0.0v 464.745n 0.0v 464.755n 1.1v 469.745n 1.1v 469.755n 0.0v 474.745n 0.0v 474.755n 0.0v 479.745n 0.0v 479.755n 1.1v 484.745n 1.1v 484.755n 1.1v 489.745n 1.1v 489.755n 1.1v 494.745n 1.1v 494.755n 1.1v 499.745n 1.1v 499.755n 1.1v 504.745n 1.1v 504.755n 0.0v 509.745n 0.0v 509.755n 0.0v 514.745n 0.0v 514.755n 0.0v 519.745n 0.0v 519.755n 0.0v 524.745n 0.0v 524.755n 0.0v 529.745n 0.0v 529.755n 0.0v 534.745n 0.0v 534.755n 0.0v 539.745n 0.0v 539.755n 1.1v 544.745n 1.1v 544.755n 1.1v 549.745n 1.1v 549.755n 1.1v 554.745n 1.1v 554.755n 0.0v 559.745n 0.0v 559.755n 0.0v 564.745n 0.0v 564.755n 0.0v 569.745n 0.0v 569.755n 0.0v 574.745n 0.0v 574.755n 0.0v 579.745n 0.0v 579.755n 0.0v 584.745n 0.0v 584.755n 0.0v 589.745n 0.0v 589.755n 0.0v 594.745n 0.0v 594.755n 0.0v 599.745n 0.0v 599.755n 0.0v 604.745n 0.0v 604.755n 0.0v 609.745n 0.0v 609.755n 0.0v 614.745n 0.0v 614.755n 0.0v 619.745n 0.0v 619.755n 0.0v 624.745n 0.0v 624.755n 0.0v 629.745n 0.0v 629.755n 1.1v 634.745n 1.1v 634.755n 1.1v 639.745n 1.1v 639.755n 1.1v 644.745n 1.1v 644.755n 1.1v 649.745n 1.1v 649.755n 1.1v 654.745n 1.1v 654.755n 1.1v 659.745n 1.1v 659.755n 1.1v 664.745n 1.1v 664.755n 1.1v 669.745n 1.1v 669.755n 1.1v 674.745n 1.1v 674.755n 1.1v 679.745n 1.1v 679.755n 1.1v 684.745n 1.1v 684.755n 1.1v 689.745n 1.1v 689.755n 1.1v 694.745n 1.1v 694.755n 1.1v 699.745n 1.1v 699.755n 1.1v 704.745n 1.1v 704.755n 1.1v 709.745n 1.1v 709.755n 0.0v 714.745n 0.0v 714.755n 1.1v 719.745n 1.1v 719.755n 1.1v 724.745n 1.1v 724.755n 1.1v 729.745n 1.1v 729.755n 1.1v 734.745n 1.1v 734.755n 1.1v 739.745n 1.1v 739.755n 0.0v 744.745n 0.0v 744.755n 0.0v 749.745n 0.0v 749.755n 0.0v 754.745n 0.0v 754.755n 0.0v 759.745n 0.0v 759.755n 0.0v 764.745n 0.0v 764.755n 0.0v 769.745n 0.0v 769.755n 1.1v 774.745n 1.1v 774.755n 1.1v 779.745n 1.1v 779.755n 1.1v 784.745n 1.1v 784.755n 1.1v 789.745n 1.1v 789.755n 1.1v 794.745n 1.1v 794.755n 1.1v 799.745n 1.1v 799.755n 1.1v 804.745n 1.1v 804.755n 1.1v 809.745n 1.1v 809.755n 1.1v 814.745n 1.1v 814.755n 1.1v 819.745n 1.1v 819.755n 1.1v 824.745n 1.1v 824.755n 1.1v 829.745n 1.1v 829.755n 1.1v 834.745n 1.1v 834.755n 0.0v 839.745n 0.0v 839.755n 0.0v 844.745n 0.0v 844.755n 0.0v 849.745n 0.0v 849.755n 0.0v 854.745n 0.0v 854.755n 1.1v 859.745n 1.1v 859.755n 0.0v 864.745n 0.0v 864.755n 0.0v 869.745n 0.0v 869.755n 0.0v 874.745n 0.0v 874.755n 0.0v 879.745n 0.0v 879.755n 0.0v 884.745n 0.0v 884.755n 1.1v 889.745n 1.1v 889.755n 1.1v 894.745n 1.1v 894.755n 1.1v 899.745n 1.1v 899.755n 1.1v 904.745n 1.1v 904.755n 1.1v 909.745n 1.1v 909.755n 0.0v 914.745n 0.0v 914.755n 0.0v 919.745n 0.0v 919.755n 0.0v 924.745n 0.0v 924.755n 0.0v 929.745n 0.0v 929.755n 0.0v 934.745n 0.0v 934.755n 0.0v 939.745n 0.0v 939.755n 1.1v 944.745n 1.1v 944.755n 1.1v 949.745n 1.1v 949.755n 1.1v 954.745n 1.1v 954.755n 0.0v 959.745n 0.0v 959.755n 0.0v 964.745n 0.0v 964.755n 0.0v 969.745n 0.0v 969.755n 0.0v 974.745n 0.0v 974.755n 0.0v 979.745n 0.0v 979.755n 1.1v 984.745n 1.1v 984.755n 1.1v 989.745n 1.1v 989.755n 1.1v 994.745n 1.1v 994.755n 0.0v 999.745n 0.0v 999.755n 1.1v 1004.745n 1.1v 1004.755n 1.1v 1009.745n 1.1v 1009.755n 1.1v 1014.745n 1.1v 1014.755n 1.1v 1019.745n 1.1v 1019.755n 0.0v 1024.745n 0.0v 1024.755n 0.0v )
* (time, data): [(0, 0), (5, 0), (10, 1), (15, 1), (20, 1), (25, 1), (30, 0), (35, 0), (40, 1), (45, 0), (50, 0), (55, 0), (60, 1), (65, 1), (70, 1), (75, 1), (80, 1), (85, 1), (90, 0), (95, 0), (100, 0), (105, 0), (110, 0), (115, 0), (120, 0), (125, 0), (130, 0), (135, 0), (140, 1), (145, 1), (150, 1), (155, 1), (160, 1), (165, 1), (170, 1), (175, 1), (180, 1), (185, 0), (190, 0), (195, 0), (200, 1), (205, 1), (210, 1), (215, 1), (220, 0), (225, 0), (230, 1), (235, 1), (240, 0), (245, 0), (250, 0), (255, 0), (260, 0), (265, 0), (270, 0), (275, 0), (280, 1), (285, 1), (290, 1), (295, 1), (300, 1), (305, 1), (310, 1), (315, 1), (320, 1), (325, 1), (330, 1), (335, 0), (340, 1), (345, 1), (350, 1), (355, 1), (360, 0), (365, 0), (370, 0), (375, 0), (380, 0), (385, 0), (390, 0), (395, 0), (400, 0), (405, 0), (410, 0), (415, 0), (420, 0), (425, 0), (430, 0), (435, 0), (440, 0), (445, 0), (450, 0), (455, 0), (460, 0), (465, 1), (470, 0), (475, 0), (480, 0), (485, 0), (490, 0), (495, 0), (500, 1), (505, 1), (510, 1), (515, 1), (520, 1), (525, 1), (530, 1), (535, 1), (540, 0), (545, 0), (550, 0), (555, 1), (560, 1), (565, 1), (570, 1), (575, 1), (580, 1), (585, 1), (590, 1), (595, 1), (600, 1), (605, 1), (610, 1), (615, 1), (620, 1), (625, 1), (630, 1), (635, 1), (640, 1), (645, 1), (650, 1), (655, 1), (660, 1), (665, 1), (670, 1), (675, 1), (680, 1), (685, 1), (690, 1), (695, 1), (700, 1), (705, 0), (710, 1), (715, 1), (720, 1), (725, 1), (730, 1), (735, 1), (740, 0), (745, 0), (750, 0), (755, 0), (760, 0), (765, 0), (770, 0), (775, 0), (780, 0), (785, 1), (790, 0), (795, 0), (800, 0), (805, 0), (810, 0), (815, 0), (820, 0), (825, 0), (830, 0), (835, 0), (840, 0), (845, 0), (850, 0), (855, 0), (860, 0), (865, 1), (870, 0), (875, 0), (880, 1), (885, 1), (890, 1), (895, 1), (900, 1), (905, 1), (910, 0), (915, 0), (920, 0), (925, 0), (930, 0), (935, 1), (940, 0), (945, 0), (950, 0), (955, 0), (960, 0), (965, 0), (970, 0), (975, 0), (980, 0), (985, 0), (990, 0), (995, 0), (1000, 1), (1005, 1), (1010, 1), (1015, 1), (1020, 1), (1025, 1)]
Vdin0_17  din0_17  0 PWL (0n 0.0v 4.745n 0.0v 4.755n 0.0v 9.745n 0.0v 9.755n 1.1v 14.745n 1.1v 14.755n 1.1v 19.745n 1.1v 19.755n 1.1v 24.745n 1.1v 24.755n 1.1v 29.745n 1.1v 29.755n 0.0v 34.745n 0.0v 34.755n 0.0v 39.745n 0.0v 39.755n 1.1v 44.745n 1.1v 44.755n 0.0v 49.745n 0.0v 49.755n 0.0v 54.745n 0.0v 54.755n 0.0v 59.745n 0.0v 59.755n 1.1v 64.745n 1.1v 64.755n 1.1v 69.745n 1.1v 69.755n 1.1v 74.745n 1.1v 74.755n 1.1v 79.745n 1.1v 79.755n 1.1v 84.745n 1.1v 84.755n 1.1v 89.745n 1.1v 89.755n 0.0v 94.745n 0.0v 94.755n 0.0v 99.745n 0.0v 99.755n 0.0v 104.745n 0.0v 104.755n 0.0v 109.745n 0.0v 109.755n 0.0v 114.745n 0.0v 114.755n 0.0v 119.745n 0.0v 119.755n 0.0v 124.745n 0.0v 124.755n 0.0v 129.745n 0.0v 129.755n 0.0v 134.745n 0.0v 134.755n 0.0v 139.745n 0.0v 139.755n 1.1v 144.745n 1.1v 144.755n 1.1v 149.745n 1.1v 149.755n 1.1v 154.745n 1.1v 154.755n 1.1v 159.745n 1.1v 159.755n 1.1v 164.745n 1.1v 164.755n 1.1v 169.745n 1.1v 169.755n 1.1v 174.745n 1.1v 174.755n 1.1v 179.745n 1.1v 179.755n 1.1v 184.745n 1.1v 184.755n 0.0v 189.745n 0.0v 189.755n 0.0v 194.745n 0.0v 194.755n 0.0v 199.745n 0.0v 199.755n 1.1v 204.745n 1.1v 204.755n 1.1v 209.745n 1.1v 209.755n 1.1v 214.745n 1.1v 214.755n 1.1v 219.745n 1.1v 219.755n 0.0v 224.745n 0.0v 224.755n 0.0v 229.745n 0.0v 229.755n 1.1v 234.745n 1.1v 234.755n 1.1v 239.745n 1.1v 239.755n 0.0v 244.745n 0.0v 244.755n 0.0v 249.745n 0.0v 249.755n 0.0v 254.745n 0.0v 254.755n 0.0v 259.745n 0.0v 259.755n 0.0v 264.745n 0.0v 264.755n 0.0v 269.745n 0.0v 269.755n 0.0v 274.745n 0.0v 274.755n 0.0v 279.745n 0.0v 279.755n 1.1v 284.745n 1.1v 284.755n 1.1v 289.745n 1.1v 289.755n 1.1v 294.745n 1.1v 294.755n 1.1v 299.745n 1.1v 299.755n 1.1v 304.745n 1.1v 304.755n 1.1v 309.745n 1.1v 309.755n 1.1v 314.745n 1.1v 314.755n 1.1v 319.745n 1.1v 319.755n 1.1v 324.745n 1.1v 324.755n 1.1v 329.745n 1.1v 329.755n 1.1v 334.745n 1.1v 334.755n 0.0v 339.745n 0.0v 339.755n 1.1v 344.745n 1.1v 344.755n 1.1v 349.745n 1.1v 349.755n 1.1v 354.745n 1.1v 354.755n 1.1v 359.745n 1.1v 359.755n 0.0v 364.745n 0.0v 364.755n 0.0v 369.745n 0.0v 369.755n 0.0v 374.745n 0.0v 374.755n 0.0v 379.745n 0.0v 379.755n 0.0v 384.745n 0.0v 384.755n 0.0v 389.745n 0.0v 389.755n 0.0v 394.745n 0.0v 394.755n 0.0v 399.745n 0.0v 399.755n 0.0v 404.745n 0.0v 404.755n 0.0v 409.745n 0.0v 409.755n 0.0v 414.745n 0.0v 414.755n 0.0v 419.745n 0.0v 419.755n 0.0v 424.745n 0.0v 424.755n 0.0v 429.745n 0.0v 429.755n 0.0v 434.745n 0.0v 434.755n 0.0v 439.745n 0.0v 439.755n 0.0v 444.745n 0.0v 444.755n 0.0v 449.745n 0.0v 449.755n 0.0v 454.745n 0.0v 454.755n 0.0v 459.745n 0.0v 459.755n 0.0v 464.745n 0.0v 464.755n 1.1v 469.745n 1.1v 469.755n 0.0v 474.745n 0.0v 474.755n 0.0v 479.745n 0.0v 479.755n 0.0v 484.745n 0.0v 484.755n 0.0v 489.745n 0.0v 489.755n 0.0v 494.745n 0.0v 494.755n 0.0v 499.745n 0.0v 499.755n 1.1v 504.745n 1.1v 504.755n 1.1v 509.745n 1.1v 509.755n 1.1v 514.745n 1.1v 514.755n 1.1v 519.745n 1.1v 519.755n 1.1v 524.745n 1.1v 524.755n 1.1v 529.745n 1.1v 529.755n 1.1v 534.745n 1.1v 534.755n 1.1v 539.745n 1.1v 539.755n 0.0v 544.745n 0.0v 544.755n 0.0v 549.745n 0.0v 549.755n 0.0v 554.745n 0.0v 554.755n 1.1v 559.745n 1.1v 559.755n 1.1v 564.745n 1.1v 564.755n 1.1v 569.745n 1.1v 569.755n 1.1v 574.745n 1.1v 574.755n 1.1v 579.745n 1.1v 579.755n 1.1v 584.745n 1.1v 584.755n 1.1v 589.745n 1.1v 589.755n 1.1v 594.745n 1.1v 594.755n 1.1v 599.745n 1.1v 599.755n 1.1v 604.745n 1.1v 604.755n 1.1v 609.745n 1.1v 609.755n 1.1v 614.745n 1.1v 614.755n 1.1v 619.745n 1.1v 619.755n 1.1v 624.745n 1.1v 624.755n 1.1v 629.745n 1.1v 629.755n 1.1v 634.745n 1.1v 634.755n 1.1v 639.745n 1.1v 639.755n 1.1v 644.745n 1.1v 644.755n 1.1v 649.745n 1.1v 649.755n 1.1v 654.745n 1.1v 654.755n 1.1v 659.745n 1.1v 659.755n 1.1v 664.745n 1.1v 664.755n 1.1v 669.745n 1.1v 669.755n 1.1v 674.745n 1.1v 674.755n 1.1v 679.745n 1.1v 679.755n 1.1v 684.745n 1.1v 684.755n 1.1v 689.745n 1.1v 689.755n 1.1v 694.745n 1.1v 694.755n 1.1v 699.745n 1.1v 699.755n 1.1v 704.745n 1.1v 704.755n 0.0v 709.745n 0.0v 709.755n 1.1v 714.745n 1.1v 714.755n 1.1v 719.745n 1.1v 719.755n 1.1v 724.745n 1.1v 724.755n 1.1v 729.745n 1.1v 729.755n 1.1v 734.745n 1.1v 734.755n 1.1v 739.745n 1.1v 739.755n 0.0v 744.745n 0.0v 744.755n 0.0v 749.745n 0.0v 749.755n 0.0v 754.745n 0.0v 754.755n 0.0v 759.745n 0.0v 759.755n 0.0v 764.745n 0.0v 764.755n 0.0v 769.745n 0.0v 769.755n 0.0v 774.745n 0.0v 774.755n 0.0v 779.745n 0.0v 779.755n 0.0v 784.745n 0.0v 784.755n 1.1v 789.745n 1.1v 789.755n 0.0v 794.745n 0.0v 794.755n 0.0v 799.745n 0.0v 799.755n 0.0v 804.745n 0.0v 804.755n 0.0v 809.745n 0.0v 809.755n 0.0v 814.745n 0.0v 814.755n 0.0v 819.745n 0.0v 819.755n 0.0v 824.745n 0.0v 824.755n 0.0v 829.745n 0.0v 829.755n 0.0v 834.745n 0.0v 834.755n 0.0v 839.745n 0.0v 839.755n 0.0v 844.745n 0.0v 844.755n 0.0v 849.745n 0.0v 849.755n 0.0v 854.745n 0.0v 854.755n 0.0v 859.745n 0.0v 859.755n 0.0v 864.745n 0.0v 864.755n 1.1v 869.745n 1.1v 869.755n 0.0v 874.745n 0.0v 874.755n 0.0v 879.745n 0.0v 879.755n 1.1v 884.745n 1.1v 884.755n 1.1v 889.745n 1.1v 889.755n 1.1v 894.745n 1.1v 894.755n 1.1v 899.745n 1.1v 899.755n 1.1v 904.745n 1.1v 904.755n 1.1v 909.745n 1.1v 909.755n 0.0v 914.745n 0.0v 914.755n 0.0v 919.745n 0.0v 919.755n 0.0v 924.745n 0.0v 924.755n 0.0v 929.745n 0.0v 929.755n 0.0v 934.745n 0.0v 934.755n 1.1v 939.745n 1.1v 939.755n 0.0v 944.745n 0.0v 944.755n 0.0v 949.745n 0.0v 949.755n 0.0v 954.745n 0.0v 954.755n 0.0v 959.745n 0.0v 959.755n 0.0v 964.745n 0.0v 964.755n 0.0v 969.745n 0.0v 969.755n 0.0v 974.745n 0.0v 974.755n 0.0v 979.745n 0.0v 979.755n 0.0v 984.745n 0.0v 984.755n 0.0v 989.745n 0.0v 989.755n 0.0v 994.745n 0.0v 994.755n 0.0v 999.745n 0.0v 999.755n 1.1v 1004.745n 1.1v 1004.755n 1.1v 1009.745n 1.1v 1009.755n 1.1v 1014.745n 1.1v 1014.755n 1.1v 1019.745n 1.1v 1019.755n 1.1v 1024.745n 1.1v 1024.755n 1.1v )
* (time, data): [(0, 0), (5, 1), (10, 1), (15, 1), (20, 1), (25, 1), (30, 0), (35, 0), (40, 0), (45, 0), (50, 0), (55, 0), (60, 0), (65, 0), (70, 0), (75, 0), (80, 0), (85, 0), (90, 1), (95, 1), (100, 0), (105, 0), (110, 0), (115, 0), (120, 0), (125, 0), (130, 0), (135, 0), (140, 0), (145, 0), (150, 0), (155, 0), (160, 0), (165, 0), (170, 1), (175, 1), (180, 1), (185, 1), (190, 1), (195, 1), (200, 0), (205, 0), (210, 1), (215, 1), (220, 1), (225, 1), (230, 1), (235, 1), (240, 0), (245, 0), (250, 0), (255, 0), (260, 0), (265, 0), (270, 0), (275, 0), (280, 0), (285, 0), (290, 0), (295, 0), (300, 1), (305, 1), (310, 1), (315, 0), (320, 0), (325, 0), (330, 1), (335, 1), (340, 0), (345, 0), (350, 0), (355, 0), (360, 0), (365, 0), (370, 0), (375, 0), (380, 0), (385, 0), (390, 0), (395, 0), (400, 1), (405, 1), (410, 0), (415, 0), (420, 0), (425, 1), (430, 0), (435, 0), (440, 0), (445, 0), (450, 0), (455, 0), (460, 1), (465, 0), (470, 1), (475, 1), (480, 0), (485, 0), (490, 0), (495, 1), (500, 1), (505, 0), (510, 1), (515, 0), (520, 0), (525, 0), (530, 0), (535, 0), (540, 0), (545, 0), (550, 0), (555, 1), (560, 1), (565, 1), (570, 1), (575, 1), (580, 1), (585, 1), (590, 1), (595, 1), (600, 1), (605, 1), (610, 1), (615, 1), (620, 1), (625, 1), (630, 1), (635, 0), (640, 0), (645, 0), (650, 0), (655, 1), (660, 1), (665, 1), (670, 1), (675, 1), (680, 1), (685, 1), (690, 1), (695, 1), (700, 1), (705, 0), (710, 1), (715, 1), (720, 1), (725, 1), (730, 1), (735, 1), (740, 0), (745, 0), (750, 0), (755, 0), (760, 0), (765, 0), (770, 1), (775, 0), (780, 0), (785, 1), (790, 0), (795, 0), (800, 0), (805, 0), (810, 0), (815, 0), (820, 1), (825, 1), (830, 1), (835, 0), (840, 0), (845, 0), (850, 0), (855, 1), (860, 0), (865, 0), (870, 0), (875, 0), (880, 0), (885, 1), (890, 1), (895, 1), (900, 1), (905, 1), (910, 1), (915, 1), (920, 1), (925, 1), (930, 0), (935, 1), (940, 0), (945, 0), (950, 0), (955, 1), (960, 1), (965, 1), (970, 1), (975, 1), (980, 1), (985, 1), (990, 1), (995, 0), (1000, 1), (1005, 1), (1010, 1), (1015, 1), (1020, 0), (1025, 0)]
Vdin0_18  din0_18  0 PWL (0n 0.0v 4.745n 0.0v 4.755n 1.1v 9.745n 1.1v 9.755n 1.1v 14.745n 1.1v 14.755n 1.1v 19.745n 1.1v 19.755n 1.1v 24.745n 1.1v 24.755n 1.1v 29.745n 1.1v 29.755n 0.0v 34.745n 0.0v 34.755n 0.0v 39.745n 0.0v 39.755n 0.0v 44.745n 0.0v 44.755n 0.0v 49.745n 0.0v 49.755n 0.0v 54.745n 0.0v 54.755n 0.0v 59.745n 0.0v 59.755n 0.0v 64.745n 0.0v 64.755n 0.0v 69.745n 0.0v 69.755n 0.0v 74.745n 0.0v 74.755n 0.0v 79.745n 0.0v 79.755n 0.0v 84.745n 0.0v 84.755n 0.0v 89.745n 0.0v 89.755n 1.1v 94.745n 1.1v 94.755n 1.1v 99.745n 1.1v 99.755n 0.0v 104.745n 0.0v 104.755n 0.0v 109.745n 0.0v 109.755n 0.0v 114.745n 0.0v 114.755n 0.0v 119.745n 0.0v 119.755n 0.0v 124.745n 0.0v 124.755n 0.0v 129.745n 0.0v 129.755n 0.0v 134.745n 0.0v 134.755n 0.0v 139.745n 0.0v 139.755n 0.0v 144.745n 0.0v 144.755n 0.0v 149.745n 0.0v 149.755n 0.0v 154.745n 0.0v 154.755n 0.0v 159.745n 0.0v 159.755n 0.0v 164.745n 0.0v 164.755n 0.0v 169.745n 0.0v 169.755n 1.1v 174.745n 1.1v 174.755n 1.1v 179.745n 1.1v 179.755n 1.1v 184.745n 1.1v 184.755n 1.1v 189.745n 1.1v 189.755n 1.1v 194.745n 1.1v 194.755n 1.1v 199.745n 1.1v 199.755n 0.0v 204.745n 0.0v 204.755n 0.0v 209.745n 0.0v 209.755n 1.1v 214.745n 1.1v 214.755n 1.1v 219.745n 1.1v 219.755n 1.1v 224.745n 1.1v 224.755n 1.1v 229.745n 1.1v 229.755n 1.1v 234.745n 1.1v 234.755n 1.1v 239.745n 1.1v 239.755n 0.0v 244.745n 0.0v 244.755n 0.0v 249.745n 0.0v 249.755n 0.0v 254.745n 0.0v 254.755n 0.0v 259.745n 0.0v 259.755n 0.0v 264.745n 0.0v 264.755n 0.0v 269.745n 0.0v 269.755n 0.0v 274.745n 0.0v 274.755n 0.0v 279.745n 0.0v 279.755n 0.0v 284.745n 0.0v 284.755n 0.0v 289.745n 0.0v 289.755n 0.0v 294.745n 0.0v 294.755n 0.0v 299.745n 0.0v 299.755n 1.1v 304.745n 1.1v 304.755n 1.1v 309.745n 1.1v 309.755n 1.1v 314.745n 1.1v 314.755n 0.0v 319.745n 0.0v 319.755n 0.0v 324.745n 0.0v 324.755n 0.0v 329.745n 0.0v 329.755n 1.1v 334.745n 1.1v 334.755n 1.1v 339.745n 1.1v 339.755n 0.0v 344.745n 0.0v 344.755n 0.0v 349.745n 0.0v 349.755n 0.0v 354.745n 0.0v 354.755n 0.0v 359.745n 0.0v 359.755n 0.0v 364.745n 0.0v 364.755n 0.0v 369.745n 0.0v 369.755n 0.0v 374.745n 0.0v 374.755n 0.0v 379.745n 0.0v 379.755n 0.0v 384.745n 0.0v 384.755n 0.0v 389.745n 0.0v 389.755n 0.0v 394.745n 0.0v 394.755n 0.0v 399.745n 0.0v 399.755n 1.1v 404.745n 1.1v 404.755n 1.1v 409.745n 1.1v 409.755n 0.0v 414.745n 0.0v 414.755n 0.0v 419.745n 0.0v 419.755n 0.0v 424.745n 0.0v 424.755n 1.1v 429.745n 1.1v 429.755n 0.0v 434.745n 0.0v 434.755n 0.0v 439.745n 0.0v 439.755n 0.0v 444.745n 0.0v 444.755n 0.0v 449.745n 0.0v 449.755n 0.0v 454.745n 0.0v 454.755n 0.0v 459.745n 0.0v 459.755n 1.1v 464.745n 1.1v 464.755n 0.0v 469.745n 0.0v 469.755n 1.1v 474.745n 1.1v 474.755n 1.1v 479.745n 1.1v 479.755n 0.0v 484.745n 0.0v 484.755n 0.0v 489.745n 0.0v 489.755n 0.0v 494.745n 0.0v 494.755n 1.1v 499.745n 1.1v 499.755n 1.1v 504.745n 1.1v 504.755n 0.0v 509.745n 0.0v 509.755n 1.1v 514.745n 1.1v 514.755n 0.0v 519.745n 0.0v 519.755n 0.0v 524.745n 0.0v 524.755n 0.0v 529.745n 0.0v 529.755n 0.0v 534.745n 0.0v 534.755n 0.0v 539.745n 0.0v 539.755n 0.0v 544.745n 0.0v 544.755n 0.0v 549.745n 0.0v 549.755n 0.0v 554.745n 0.0v 554.755n 1.1v 559.745n 1.1v 559.755n 1.1v 564.745n 1.1v 564.755n 1.1v 569.745n 1.1v 569.755n 1.1v 574.745n 1.1v 574.755n 1.1v 579.745n 1.1v 579.755n 1.1v 584.745n 1.1v 584.755n 1.1v 589.745n 1.1v 589.755n 1.1v 594.745n 1.1v 594.755n 1.1v 599.745n 1.1v 599.755n 1.1v 604.745n 1.1v 604.755n 1.1v 609.745n 1.1v 609.755n 1.1v 614.745n 1.1v 614.755n 1.1v 619.745n 1.1v 619.755n 1.1v 624.745n 1.1v 624.755n 1.1v 629.745n 1.1v 629.755n 1.1v 634.745n 1.1v 634.755n 0.0v 639.745n 0.0v 639.755n 0.0v 644.745n 0.0v 644.755n 0.0v 649.745n 0.0v 649.755n 0.0v 654.745n 0.0v 654.755n 1.1v 659.745n 1.1v 659.755n 1.1v 664.745n 1.1v 664.755n 1.1v 669.745n 1.1v 669.755n 1.1v 674.745n 1.1v 674.755n 1.1v 679.745n 1.1v 679.755n 1.1v 684.745n 1.1v 684.755n 1.1v 689.745n 1.1v 689.755n 1.1v 694.745n 1.1v 694.755n 1.1v 699.745n 1.1v 699.755n 1.1v 704.745n 1.1v 704.755n 0.0v 709.745n 0.0v 709.755n 1.1v 714.745n 1.1v 714.755n 1.1v 719.745n 1.1v 719.755n 1.1v 724.745n 1.1v 724.755n 1.1v 729.745n 1.1v 729.755n 1.1v 734.745n 1.1v 734.755n 1.1v 739.745n 1.1v 739.755n 0.0v 744.745n 0.0v 744.755n 0.0v 749.745n 0.0v 749.755n 0.0v 754.745n 0.0v 754.755n 0.0v 759.745n 0.0v 759.755n 0.0v 764.745n 0.0v 764.755n 0.0v 769.745n 0.0v 769.755n 1.1v 774.745n 1.1v 774.755n 0.0v 779.745n 0.0v 779.755n 0.0v 784.745n 0.0v 784.755n 1.1v 789.745n 1.1v 789.755n 0.0v 794.745n 0.0v 794.755n 0.0v 799.745n 0.0v 799.755n 0.0v 804.745n 0.0v 804.755n 0.0v 809.745n 0.0v 809.755n 0.0v 814.745n 0.0v 814.755n 0.0v 819.745n 0.0v 819.755n 1.1v 824.745n 1.1v 824.755n 1.1v 829.745n 1.1v 829.755n 1.1v 834.745n 1.1v 834.755n 0.0v 839.745n 0.0v 839.755n 0.0v 844.745n 0.0v 844.755n 0.0v 849.745n 0.0v 849.755n 0.0v 854.745n 0.0v 854.755n 1.1v 859.745n 1.1v 859.755n 0.0v 864.745n 0.0v 864.755n 0.0v 869.745n 0.0v 869.755n 0.0v 874.745n 0.0v 874.755n 0.0v 879.745n 0.0v 879.755n 0.0v 884.745n 0.0v 884.755n 1.1v 889.745n 1.1v 889.755n 1.1v 894.745n 1.1v 894.755n 1.1v 899.745n 1.1v 899.755n 1.1v 904.745n 1.1v 904.755n 1.1v 909.745n 1.1v 909.755n 1.1v 914.745n 1.1v 914.755n 1.1v 919.745n 1.1v 919.755n 1.1v 924.745n 1.1v 924.755n 1.1v 929.745n 1.1v 929.755n 0.0v 934.745n 0.0v 934.755n 1.1v 939.745n 1.1v 939.755n 0.0v 944.745n 0.0v 944.755n 0.0v 949.745n 0.0v 949.755n 0.0v 954.745n 0.0v 954.755n 1.1v 959.745n 1.1v 959.755n 1.1v 964.745n 1.1v 964.755n 1.1v 969.745n 1.1v 969.755n 1.1v 974.745n 1.1v 974.755n 1.1v 979.745n 1.1v 979.755n 1.1v 984.745n 1.1v 984.755n 1.1v 989.745n 1.1v 989.755n 1.1v 994.745n 1.1v 994.755n 0.0v 999.745n 0.0v 999.755n 1.1v 1004.745n 1.1v 1004.755n 1.1v 1009.745n 1.1v 1009.755n 1.1v 1014.745n 1.1v 1014.755n 1.1v 1019.745n 1.1v 1019.755n 0.0v 1024.745n 0.0v 1024.755n 0.0v )
* (time, data): [(0, 0), (5, 0), (10, 0), (15, 1), (20, 1), (25, 1), (30, 0), (35, 0), (40, 1), (45, 1), (50, 1), (55, 1), (60, 1), (65, 1), (70, 1), (75, 1), (80, 1), (85, 1), (90, 0), (95, 0), (100, 0), (105, 0), (110, 0), (115, 0), (120, 0), (125, 0), (130, 0), (135, 0), (140, 0), (145, 0), (150, 0), (155, 0), (160, 0), (165, 0), (170, 1), (175, 1), (180, 1), (185, 0), (190, 0), (195, 0), (200, 0), (205, 0), (210, 1), (215, 1), (220, 1), (225, 1), (230, 0), (235, 0), (240, 0), (245, 0), (250, 0), (255, 1), (260, 1), (265, 1), (270, 1), (275, 1), (280, 0), (285, 0), (290, 0), (295, 0), (300, 1), (305, 1), (310, 1), (315, 1), (320, 1), (325, 1), (330, 1), (335, 0), (340, 1), (345, 1), (350, 1), (355, 1), (360, 1), (365, 1), (370, 1), (375, 1), (380, 1), (385, 1), (390, 1), (395, 0), (400, 1), (405, 1), (410, 0), (415, 0), (420, 1), (425, 0), (430, 1), (435, 1), (440, 1), (445, 1), (450, 1), (455, 1), (460, 0), (465, 0), (470, 0), (475, 0), (480, 1), (485, 1), (490, 1), (495, 0), (500, 0), (505, 0), (510, 1), (515, 0), (520, 0), (525, 0), (530, 0), (535, 1), (540, 1), (545, 1), (550, 1), (555, 0), (560, 0), (565, 0), (570, 0), (575, 1), (580, 1), (585, 1), (590, 1), (595, 1), (600, 1), (605, 1), (610, 1), (615, 1), (620, 1), (625, 1), (630, 0), (635, 0), (640, 0), (645, 0), (650, 0), (655, 1), (660, 1), (665, 1), (670, 1), (675, 1), (680, 1), (685, 1), (690, 1), (695, 1), (700, 1), (705, 0), (710, 0), (715, 1), (720, 1), (725, 1), (730, 1), (735, 0), (740, 1), (745, 1), (750, 1), (755, 1), (760, 1), (765, 1), (770, 0), (775, 1), (780, 1), (785, 1), (790, 0), (795, 0), (800, 0), (805, 0), (810, 0), (815, 0), (820, 0), (825, 0), (830, 1), (835, 1), (840, 1), (845, 1), (850, 1), (855, 1), (860, 0), (865, 0), (870, 0), (875, 1), (880, 1), (885, 0), (890, 0), (895, 0), (900, 0), (905, 0), (910, 1), (915, 1), (920, 1), (925, 1), (930, 1), (935, 0), (940, 1), (945, 1), (950, 1), (955, 0), (960, 0), (965, 0), (970, 0), (975, 0), (980, 0), (985, 0), (990, 0), (995, 0), (1000, 1), (1005, 1), (1010, 1), (1015, 1), (1020, 1), (1025, 1)]
Vdin0_19  din0_19  0 PWL (0n 0.0v 4.745n 0.0v 4.755n 0.0v 9.745n 0.0v 9.755n 0.0v 14.745n 0.0v 14.755n 1.1v 19.745n 1.1v 19.755n 1.1v 24.745n 1.1v 24.755n 1.1v 29.745n 1.1v 29.755n 0.0v 34.745n 0.0v 34.755n 0.0v 39.745n 0.0v 39.755n 1.1v 44.745n 1.1v 44.755n 1.1v 49.745n 1.1v 49.755n 1.1v 54.745n 1.1v 54.755n 1.1v 59.745n 1.1v 59.755n 1.1v 64.745n 1.1v 64.755n 1.1v 69.745n 1.1v 69.755n 1.1v 74.745n 1.1v 74.755n 1.1v 79.745n 1.1v 79.755n 1.1v 84.745n 1.1v 84.755n 1.1v 89.745n 1.1v 89.755n 0.0v 94.745n 0.0v 94.755n 0.0v 99.745n 0.0v 99.755n 0.0v 104.745n 0.0v 104.755n 0.0v 109.745n 0.0v 109.755n 0.0v 114.745n 0.0v 114.755n 0.0v 119.745n 0.0v 119.755n 0.0v 124.745n 0.0v 124.755n 0.0v 129.745n 0.0v 129.755n 0.0v 134.745n 0.0v 134.755n 0.0v 139.745n 0.0v 139.755n 0.0v 144.745n 0.0v 144.755n 0.0v 149.745n 0.0v 149.755n 0.0v 154.745n 0.0v 154.755n 0.0v 159.745n 0.0v 159.755n 0.0v 164.745n 0.0v 164.755n 0.0v 169.745n 0.0v 169.755n 1.1v 174.745n 1.1v 174.755n 1.1v 179.745n 1.1v 179.755n 1.1v 184.745n 1.1v 184.755n 0.0v 189.745n 0.0v 189.755n 0.0v 194.745n 0.0v 194.755n 0.0v 199.745n 0.0v 199.755n 0.0v 204.745n 0.0v 204.755n 0.0v 209.745n 0.0v 209.755n 1.1v 214.745n 1.1v 214.755n 1.1v 219.745n 1.1v 219.755n 1.1v 224.745n 1.1v 224.755n 1.1v 229.745n 1.1v 229.755n 0.0v 234.745n 0.0v 234.755n 0.0v 239.745n 0.0v 239.755n 0.0v 244.745n 0.0v 244.755n 0.0v 249.745n 0.0v 249.755n 0.0v 254.745n 0.0v 254.755n 1.1v 259.745n 1.1v 259.755n 1.1v 264.745n 1.1v 264.755n 1.1v 269.745n 1.1v 269.755n 1.1v 274.745n 1.1v 274.755n 1.1v 279.745n 1.1v 279.755n 0.0v 284.745n 0.0v 284.755n 0.0v 289.745n 0.0v 289.755n 0.0v 294.745n 0.0v 294.755n 0.0v 299.745n 0.0v 299.755n 1.1v 304.745n 1.1v 304.755n 1.1v 309.745n 1.1v 309.755n 1.1v 314.745n 1.1v 314.755n 1.1v 319.745n 1.1v 319.755n 1.1v 324.745n 1.1v 324.755n 1.1v 329.745n 1.1v 329.755n 1.1v 334.745n 1.1v 334.755n 0.0v 339.745n 0.0v 339.755n 1.1v 344.745n 1.1v 344.755n 1.1v 349.745n 1.1v 349.755n 1.1v 354.745n 1.1v 354.755n 1.1v 359.745n 1.1v 359.755n 1.1v 364.745n 1.1v 364.755n 1.1v 369.745n 1.1v 369.755n 1.1v 374.745n 1.1v 374.755n 1.1v 379.745n 1.1v 379.755n 1.1v 384.745n 1.1v 384.755n 1.1v 389.745n 1.1v 389.755n 1.1v 394.745n 1.1v 394.755n 0.0v 399.745n 0.0v 399.755n 1.1v 404.745n 1.1v 404.755n 1.1v 409.745n 1.1v 409.755n 0.0v 414.745n 0.0v 414.755n 0.0v 419.745n 0.0v 419.755n 1.1v 424.745n 1.1v 424.755n 0.0v 429.745n 0.0v 429.755n 1.1v 434.745n 1.1v 434.755n 1.1v 439.745n 1.1v 439.755n 1.1v 444.745n 1.1v 444.755n 1.1v 449.745n 1.1v 449.755n 1.1v 454.745n 1.1v 454.755n 1.1v 459.745n 1.1v 459.755n 0.0v 464.745n 0.0v 464.755n 0.0v 469.745n 0.0v 469.755n 0.0v 474.745n 0.0v 474.755n 0.0v 479.745n 0.0v 479.755n 1.1v 484.745n 1.1v 484.755n 1.1v 489.745n 1.1v 489.755n 1.1v 494.745n 1.1v 494.755n 0.0v 499.745n 0.0v 499.755n 0.0v 504.745n 0.0v 504.755n 0.0v 509.745n 0.0v 509.755n 1.1v 514.745n 1.1v 514.755n 0.0v 519.745n 0.0v 519.755n 0.0v 524.745n 0.0v 524.755n 0.0v 529.745n 0.0v 529.755n 0.0v 534.745n 0.0v 534.755n 1.1v 539.745n 1.1v 539.755n 1.1v 544.745n 1.1v 544.755n 1.1v 549.745n 1.1v 549.755n 1.1v 554.745n 1.1v 554.755n 0.0v 559.745n 0.0v 559.755n 0.0v 564.745n 0.0v 564.755n 0.0v 569.745n 0.0v 569.755n 0.0v 574.745n 0.0v 574.755n 1.1v 579.745n 1.1v 579.755n 1.1v 584.745n 1.1v 584.755n 1.1v 589.745n 1.1v 589.755n 1.1v 594.745n 1.1v 594.755n 1.1v 599.745n 1.1v 599.755n 1.1v 604.745n 1.1v 604.755n 1.1v 609.745n 1.1v 609.755n 1.1v 614.745n 1.1v 614.755n 1.1v 619.745n 1.1v 619.755n 1.1v 624.745n 1.1v 624.755n 1.1v 629.745n 1.1v 629.755n 0.0v 634.745n 0.0v 634.755n 0.0v 639.745n 0.0v 639.755n 0.0v 644.745n 0.0v 644.755n 0.0v 649.745n 0.0v 649.755n 0.0v 654.745n 0.0v 654.755n 1.1v 659.745n 1.1v 659.755n 1.1v 664.745n 1.1v 664.755n 1.1v 669.745n 1.1v 669.755n 1.1v 674.745n 1.1v 674.755n 1.1v 679.745n 1.1v 679.755n 1.1v 684.745n 1.1v 684.755n 1.1v 689.745n 1.1v 689.755n 1.1v 694.745n 1.1v 694.755n 1.1v 699.745n 1.1v 699.755n 1.1v 704.745n 1.1v 704.755n 0.0v 709.745n 0.0v 709.755n 0.0v 714.745n 0.0v 714.755n 1.1v 719.745n 1.1v 719.755n 1.1v 724.745n 1.1v 724.755n 1.1v 729.745n 1.1v 729.755n 1.1v 734.745n 1.1v 734.755n 0.0v 739.745n 0.0v 739.755n 1.1v 744.745n 1.1v 744.755n 1.1v 749.745n 1.1v 749.755n 1.1v 754.745n 1.1v 754.755n 1.1v 759.745n 1.1v 759.755n 1.1v 764.745n 1.1v 764.755n 1.1v 769.745n 1.1v 769.755n 0.0v 774.745n 0.0v 774.755n 1.1v 779.745n 1.1v 779.755n 1.1v 784.745n 1.1v 784.755n 1.1v 789.745n 1.1v 789.755n 0.0v 794.745n 0.0v 794.755n 0.0v 799.745n 0.0v 799.755n 0.0v 804.745n 0.0v 804.755n 0.0v 809.745n 0.0v 809.755n 0.0v 814.745n 0.0v 814.755n 0.0v 819.745n 0.0v 819.755n 0.0v 824.745n 0.0v 824.755n 0.0v 829.745n 0.0v 829.755n 1.1v 834.745n 1.1v 834.755n 1.1v 839.745n 1.1v 839.755n 1.1v 844.745n 1.1v 844.755n 1.1v 849.745n 1.1v 849.755n 1.1v 854.745n 1.1v 854.755n 1.1v 859.745n 1.1v 859.755n 0.0v 864.745n 0.0v 864.755n 0.0v 869.745n 0.0v 869.755n 0.0v 874.745n 0.0v 874.755n 1.1v 879.745n 1.1v 879.755n 1.1v 884.745n 1.1v 884.755n 0.0v 889.745n 0.0v 889.755n 0.0v 894.745n 0.0v 894.755n 0.0v 899.745n 0.0v 899.755n 0.0v 904.745n 0.0v 904.755n 0.0v 909.745n 0.0v 909.755n 1.1v 914.745n 1.1v 914.755n 1.1v 919.745n 1.1v 919.755n 1.1v 924.745n 1.1v 924.755n 1.1v 929.745n 1.1v 929.755n 1.1v 934.745n 1.1v 934.755n 0.0v 939.745n 0.0v 939.755n 1.1v 944.745n 1.1v 944.755n 1.1v 949.745n 1.1v 949.755n 1.1v 954.745n 1.1v 954.755n 0.0v 959.745n 0.0v 959.755n 0.0v 964.745n 0.0v 964.755n 0.0v 969.745n 0.0v 969.755n 0.0v 974.745n 0.0v 974.755n 0.0v 979.745n 0.0v 979.755n 0.0v 984.745n 0.0v 984.755n 0.0v 989.745n 0.0v 989.755n 0.0v 994.745n 0.0v 994.755n 0.0v 999.745n 0.0v 999.755n 1.1v 1004.745n 1.1v 1004.755n 1.1v 1009.745n 1.1v 1009.755n 1.1v 1014.745n 1.1v 1014.755n 1.1v 1019.745n 1.1v 1019.755n 1.1v 1024.745n 1.1v 1024.755n 1.1v )
* (time, data): [(0, 0), (5, 0), (10, 1), (15, 1), (20, 1), (25, 1), (30, 1), (35, 1), (40, 1), (45, 1), (50, 1), (55, 1), (60, 1), (65, 0), (70, 0), (75, 0), (80, 0), (85, 0), (90, 0), (95, 0), (100, 1), (105, 1), (110, 1), (115, 1), (120, 1), (125, 1), (130, 1), (135, 0), (140, 1), (145, 1), (150, 1), (155, 1), (160, 1), (165, 1), (170, 0), (175, 0), (180, 0), (185, 1), (190, 1), (195, 1), (200, 1), (205, 1), (210, 1), (215, 1), (220, 1), (225, 1), (230, 0), (235, 0), (240, 0), (245, 0), (250, 0), (255, 0), (260, 0), (265, 0), (270, 0), (275, 0), (280, 0), (285, 0), (290, 0), (295, 0), (300, 1), (305, 1), (310, 1), (315, 1), (320, 1), (325, 1), (330, 1), (335, 0), (340, 1), (345, 1), (350, 1), (355, 1), (360, 0), (365, 0), (370, 0), (375, 0), (380, 0), (385, 0), (390, 0), (395, 1), (400, 1), (405, 1), (410, 0), (415, 0), (420, 1), (425, 1), (430, 0), (435, 0), (440, 0), (445, 0), (450, 0), (455, 0), (460, 0), (465, 1), (470, 1), (475, 1), (480, 1), (485, 1), (490, 1), (495, 0), (500, 1), (505, 1), (510, 1), (515, 1), (520, 1), (525, 1), (530, 1), (535, 1), (540, 1), (545, 1), (550, 1), (555, 0), (560, 0), (565, 0), (570, 0), (575, 0), (580, 0), (585, 0), (590, 0), (595, 0), (600, 0), (605, 0), (610, 0), (615, 0), (620, 0), (625, 0), (630, 1), (635, 1), (640, 1), (645, 1), (650, 1), (655, 1), (660, 0), (665, 0), (670, 1), (675, 1), (680, 1), (685, 1), (690, 1), (695, 1), (700, 1), (705, 0), (710, 1), (715, 1), (720, 1), (725, 1), (730, 1), (735, 1), (740, 1), (745, 1), (750, 1), (755, 0), (760, 0), (765, 0), (770, 0), (775, 0), (780, 0), (785, 0), (790, 0), (795, 0), (800, 0), (805, 0), (810, 0), (815, 0), (820, 0), (825, 0), (830, 1), (835, 0), (840, 0), (845, 0), (850, 0), (855, 0), (860, 1), (865, 1), (870, 1), (875, 1), (880, 0), (885, 1), (890, 1), (895, 1), (900, 1), (905, 1), (910, 1), (915, 1), (920, 1), (925, 1), (930, 0), (935, 1), (940, 1), (945, 1), (950, 1), (955, 0), (960, 0), (965, 1), (970, 1), (975, 1), (980, 1), (985, 1), (990, 1), (995, 1), (1000, 0), (1005, 0), (1010, 0), (1015, 0), (1020, 0), (1025, 0)]
Vdin0_20  din0_20  0 PWL (0n 0.0v 4.745n 0.0v 4.755n 0.0v 9.745n 0.0v 9.755n 1.1v 14.745n 1.1v 14.755n 1.1v 19.745n 1.1v 19.755n 1.1v 24.745n 1.1v 24.755n 1.1v 29.745n 1.1v 29.755n 1.1v 34.745n 1.1v 34.755n 1.1v 39.745n 1.1v 39.755n 1.1v 44.745n 1.1v 44.755n 1.1v 49.745n 1.1v 49.755n 1.1v 54.745n 1.1v 54.755n 1.1v 59.745n 1.1v 59.755n 1.1v 64.745n 1.1v 64.755n 0.0v 69.745n 0.0v 69.755n 0.0v 74.745n 0.0v 74.755n 0.0v 79.745n 0.0v 79.755n 0.0v 84.745n 0.0v 84.755n 0.0v 89.745n 0.0v 89.755n 0.0v 94.745n 0.0v 94.755n 0.0v 99.745n 0.0v 99.755n 1.1v 104.745n 1.1v 104.755n 1.1v 109.745n 1.1v 109.755n 1.1v 114.745n 1.1v 114.755n 1.1v 119.745n 1.1v 119.755n 1.1v 124.745n 1.1v 124.755n 1.1v 129.745n 1.1v 129.755n 1.1v 134.745n 1.1v 134.755n 0.0v 139.745n 0.0v 139.755n 1.1v 144.745n 1.1v 144.755n 1.1v 149.745n 1.1v 149.755n 1.1v 154.745n 1.1v 154.755n 1.1v 159.745n 1.1v 159.755n 1.1v 164.745n 1.1v 164.755n 1.1v 169.745n 1.1v 169.755n 0.0v 174.745n 0.0v 174.755n 0.0v 179.745n 0.0v 179.755n 0.0v 184.745n 0.0v 184.755n 1.1v 189.745n 1.1v 189.755n 1.1v 194.745n 1.1v 194.755n 1.1v 199.745n 1.1v 199.755n 1.1v 204.745n 1.1v 204.755n 1.1v 209.745n 1.1v 209.755n 1.1v 214.745n 1.1v 214.755n 1.1v 219.745n 1.1v 219.755n 1.1v 224.745n 1.1v 224.755n 1.1v 229.745n 1.1v 229.755n 0.0v 234.745n 0.0v 234.755n 0.0v 239.745n 0.0v 239.755n 0.0v 244.745n 0.0v 244.755n 0.0v 249.745n 0.0v 249.755n 0.0v 254.745n 0.0v 254.755n 0.0v 259.745n 0.0v 259.755n 0.0v 264.745n 0.0v 264.755n 0.0v 269.745n 0.0v 269.755n 0.0v 274.745n 0.0v 274.755n 0.0v 279.745n 0.0v 279.755n 0.0v 284.745n 0.0v 284.755n 0.0v 289.745n 0.0v 289.755n 0.0v 294.745n 0.0v 294.755n 0.0v 299.745n 0.0v 299.755n 1.1v 304.745n 1.1v 304.755n 1.1v 309.745n 1.1v 309.755n 1.1v 314.745n 1.1v 314.755n 1.1v 319.745n 1.1v 319.755n 1.1v 324.745n 1.1v 324.755n 1.1v 329.745n 1.1v 329.755n 1.1v 334.745n 1.1v 334.755n 0.0v 339.745n 0.0v 339.755n 1.1v 344.745n 1.1v 344.755n 1.1v 349.745n 1.1v 349.755n 1.1v 354.745n 1.1v 354.755n 1.1v 359.745n 1.1v 359.755n 0.0v 364.745n 0.0v 364.755n 0.0v 369.745n 0.0v 369.755n 0.0v 374.745n 0.0v 374.755n 0.0v 379.745n 0.0v 379.755n 0.0v 384.745n 0.0v 384.755n 0.0v 389.745n 0.0v 389.755n 0.0v 394.745n 0.0v 394.755n 1.1v 399.745n 1.1v 399.755n 1.1v 404.745n 1.1v 404.755n 1.1v 409.745n 1.1v 409.755n 0.0v 414.745n 0.0v 414.755n 0.0v 419.745n 0.0v 419.755n 1.1v 424.745n 1.1v 424.755n 1.1v 429.745n 1.1v 429.755n 0.0v 434.745n 0.0v 434.755n 0.0v 439.745n 0.0v 439.755n 0.0v 444.745n 0.0v 444.755n 0.0v 449.745n 0.0v 449.755n 0.0v 454.745n 0.0v 454.755n 0.0v 459.745n 0.0v 459.755n 0.0v 464.745n 0.0v 464.755n 1.1v 469.745n 1.1v 469.755n 1.1v 474.745n 1.1v 474.755n 1.1v 479.745n 1.1v 479.755n 1.1v 484.745n 1.1v 484.755n 1.1v 489.745n 1.1v 489.755n 1.1v 494.745n 1.1v 494.755n 0.0v 499.745n 0.0v 499.755n 1.1v 504.745n 1.1v 504.755n 1.1v 509.745n 1.1v 509.755n 1.1v 514.745n 1.1v 514.755n 1.1v 519.745n 1.1v 519.755n 1.1v 524.745n 1.1v 524.755n 1.1v 529.745n 1.1v 529.755n 1.1v 534.745n 1.1v 534.755n 1.1v 539.745n 1.1v 539.755n 1.1v 544.745n 1.1v 544.755n 1.1v 549.745n 1.1v 549.755n 1.1v 554.745n 1.1v 554.755n 0.0v 559.745n 0.0v 559.755n 0.0v 564.745n 0.0v 564.755n 0.0v 569.745n 0.0v 569.755n 0.0v 574.745n 0.0v 574.755n 0.0v 579.745n 0.0v 579.755n 0.0v 584.745n 0.0v 584.755n 0.0v 589.745n 0.0v 589.755n 0.0v 594.745n 0.0v 594.755n 0.0v 599.745n 0.0v 599.755n 0.0v 604.745n 0.0v 604.755n 0.0v 609.745n 0.0v 609.755n 0.0v 614.745n 0.0v 614.755n 0.0v 619.745n 0.0v 619.755n 0.0v 624.745n 0.0v 624.755n 0.0v 629.745n 0.0v 629.755n 1.1v 634.745n 1.1v 634.755n 1.1v 639.745n 1.1v 639.755n 1.1v 644.745n 1.1v 644.755n 1.1v 649.745n 1.1v 649.755n 1.1v 654.745n 1.1v 654.755n 1.1v 659.745n 1.1v 659.755n 0.0v 664.745n 0.0v 664.755n 0.0v 669.745n 0.0v 669.755n 1.1v 674.745n 1.1v 674.755n 1.1v 679.745n 1.1v 679.755n 1.1v 684.745n 1.1v 684.755n 1.1v 689.745n 1.1v 689.755n 1.1v 694.745n 1.1v 694.755n 1.1v 699.745n 1.1v 699.755n 1.1v 704.745n 1.1v 704.755n 0.0v 709.745n 0.0v 709.755n 1.1v 714.745n 1.1v 714.755n 1.1v 719.745n 1.1v 719.755n 1.1v 724.745n 1.1v 724.755n 1.1v 729.745n 1.1v 729.755n 1.1v 734.745n 1.1v 734.755n 1.1v 739.745n 1.1v 739.755n 1.1v 744.745n 1.1v 744.755n 1.1v 749.745n 1.1v 749.755n 1.1v 754.745n 1.1v 754.755n 0.0v 759.745n 0.0v 759.755n 0.0v 764.745n 0.0v 764.755n 0.0v 769.745n 0.0v 769.755n 0.0v 774.745n 0.0v 774.755n 0.0v 779.745n 0.0v 779.755n 0.0v 784.745n 0.0v 784.755n 0.0v 789.745n 0.0v 789.755n 0.0v 794.745n 0.0v 794.755n 0.0v 799.745n 0.0v 799.755n 0.0v 804.745n 0.0v 804.755n 0.0v 809.745n 0.0v 809.755n 0.0v 814.745n 0.0v 814.755n 0.0v 819.745n 0.0v 819.755n 0.0v 824.745n 0.0v 824.755n 0.0v 829.745n 0.0v 829.755n 1.1v 834.745n 1.1v 834.755n 0.0v 839.745n 0.0v 839.755n 0.0v 844.745n 0.0v 844.755n 0.0v 849.745n 0.0v 849.755n 0.0v 854.745n 0.0v 854.755n 0.0v 859.745n 0.0v 859.755n 1.1v 864.745n 1.1v 864.755n 1.1v 869.745n 1.1v 869.755n 1.1v 874.745n 1.1v 874.755n 1.1v 879.745n 1.1v 879.755n 0.0v 884.745n 0.0v 884.755n 1.1v 889.745n 1.1v 889.755n 1.1v 894.745n 1.1v 894.755n 1.1v 899.745n 1.1v 899.755n 1.1v 904.745n 1.1v 904.755n 1.1v 909.745n 1.1v 909.755n 1.1v 914.745n 1.1v 914.755n 1.1v 919.745n 1.1v 919.755n 1.1v 924.745n 1.1v 924.755n 1.1v 929.745n 1.1v 929.755n 0.0v 934.745n 0.0v 934.755n 1.1v 939.745n 1.1v 939.755n 1.1v 944.745n 1.1v 944.755n 1.1v 949.745n 1.1v 949.755n 1.1v 954.745n 1.1v 954.755n 0.0v 959.745n 0.0v 959.755n 0.0v 964.745n 0.0v 964.755n 1.1v 969.745n 1.1v 969.755n 1.1v 974.745n 1.1v 974.755n 1.1v 979.745n 1.1v 979.755n 1.1v 984.745n 1.1v 984.755n 1.1v 989.745n 1.1v 989.755n 1.1v 994.745n 1.1v 994.755n 1.1v 999.745n 1.1v 999.755n 0.0v 1004.745n 0.0v 1004.755n 0.0v 1009.745n 0.0v 1009.755n 0.0v 1014.745n 0.0v 1014.755n 0.0v 1019.745n 0.0v 1019.755n 0.0v 1024.745n 0.0v 1024.755n 0.0v )
* (time, data): [(0, 0), (5, 1), (10, 0), (15, 0), (20, 0), (25, 0), (30, 0), (35, 0), (40, 0), (45, 1), (50, 1), (55, 1), (60, 1), (65, 1), (70, 1), (75, 1), (80, 1), (85, 1), (90, 0), (95, 0), (100, 1), (105, 1), (110, 1), (115, 1), (120, 1), (125, 1), (130, 1), (135, 1), (140, 1), (145, 1), (150, 1), (155, 1), (160, 1), (165, 1), (170, 1), (175, 1), (180, 1), (185, 0), (190, 0), (195, 0), (200, 1), (205, 1), (210, 1), (215, 1), (220, 1), (225, 1), (230, 1), (235, 1), (240, 0), (245, 0), (250, 0), (255, 0), (260, 0), (265, 0), (270, 0), (275, 0), (280, 0), (285, 0), (290, 0), (295, 0), (300, 1), (305, 1), (310, 1), (315, 1), (320, 1), (325, 1), (330, 1), (335, 1), (340, 0), (345, 0), (350, 0), (355, 0), (360, 0), (365, 0), (370, 0), (375, 0), (380, 0), (385, 0), (390, 0), (395, 1), (400, 1), (405, 1), (410, 0), (415, 1), (420, 1), (425, 0), (430, 0), (435, 0), (440, 0), (445, 0), (450, 1), (455, 1), (460, 1), (465, 0), (470, 1), (475, 1), (480, 1), (485, 1), (490, 1), (495, 1), (500, 0), (505, 1), (510, 0), (515, 0), (520, 0), (525, 0), (530, 0), (535, 1), (540, 1), (545, 1), (550, 1), (555, 1), (560, 1), (565, 1), (570, 1), (575, 0), (580, 0), (585, 0), (590, 0), (595, 0), (600, 0), (605, 0), (610, 0), (615, 0), (620, 0), (625, 0), (630, 0), (635, 1), (640, 0), (645, 0), (650, 0), (655, 1), (660, 0), (665, 0), (670, 1), (675, 1), (680, 1), (685, 1), (690, 1), (695, 1), (700, 1), (705, 0), (710, 1), (715, 1), (720, 1), (725, 1), (730, 1), (735, 0), (740, 1), (745, 1), (750, 1), (755, 0), (760, 0), (765, 0), (770, 0), (775, 1), (780, 1), (785, 1), (790, 0), (795, 0), (800, 0), (805, 0), (810, 0), (815, 0), (820, 0), (825, 0), (830, 1), (835, 1), (840, 1), (845, 1), (850, 1), (855, 0), (860, 0), (865, 1), (870, 1), (875, 0), (880, 0), (885, 1), (890, 1), (895, 1), (900, 1), (905, 1), (910, 0), (915, 0), (920, 0), (925, 0), (930, 1), (935, 0), (940, 1), (945, 1), (950, 1), (955, 1), (960, 1), (965, 0), (970, 0), (975, 0), (980, 0), (985, 0), (990, 0), (995, 0), (1000, 1), (1005, 1), (1010, 1), (1015, 1), (1020, 1), (1025, 1)]
Vdin0_21  din0_21  0 PWL (0n 0.0v 4.745n 0.0v 4.755n 1.1v 9.745n 1.1v 9.755n 0.0v 14.745n 0.0v 14.755n 0.0v 19.745n 0.0v 19.755n 0.0v 24.745n 0.0v 24.755n 0.0v 29.745n 0.0v 29.755n 0.0v 34.745n 0.0v 34.755n 0.0v 39.745n 0.0v 39.755n 0.0v 44.745n 0.0v 44.755n 1.1v 49.745n 1.1v 49.755n 1.1v 54.745n 1.1v 54.755n 1.1v 59.745n 1.1v 59.755n 1.1v 64.745n 1.1v 64.755n 1.1v 69.745n 1.1v 69.755n 1.1v 74.745n 1.1v 74.755n 1.1v 79.745n 1.1v 79.755n 1.1v 84.745n 1.1v 84.755n 1.1v 89.745n 1.1v 89.755n 0.0v 94.745n 0.0v 94.755n 0.0v 99.745n 0.0v 99.755n 1.1v 104.745n 1.1v 104.755n 1.1v 109.745n 1.1v 109.755n 1.1v 114.745n 1.1v 114.755n 1.1v 119.745n 1.1v 119.755n 1.1v 124.745n 1.1v 124.755n 1.1v 129.745n 1.1v 129.755n 1.1v 134.745n 1.1v 134.755n 1.1v 139.745n 1.1v 139.755n 1.1v 144.745n 1.1v 144.755n 1.1v 149.745n 1.1v 149.755n 1.1v 154.745n 1.1v 154.755n 1.1v 159.745n 1.1v 159.755n 1.1v 164.745n 1.1v 164.755n 1.1v 169.745n 1.1v 169.755n 1.1v 174.745n 1.1v 174.755n 1.1v 179.745n 1.1v 179.755n 1.1v 184.745n 1.1v 184.755n 0.0v 189.745n 0.0v 189.755n 0.0v 194.745n 0.0v 194.755n 0.0v 199.745n 0.0v 199.755n 1.1v 204.745n 1.1v 204.755n 1.1v 209.745n 1.1v 209.755n 1.1v 214.745n 1.1v 214.755n 1.1v 219.745n 1.1v 219.755n 1.1v 224.745n 1.1v 224.755n 1.1v 229.745n 1.1v 229.755n 1.1v 234.745n 1.1v 234.755n 1.1v 239.745n 1.1v 239.755n 0.0v 244.745n 0.0v 244.755n 0.0v 249.745n 0.0v 249.755n 0.0v 254.745n 0.0v 254.755n 0.0v 259.745n 0.0v 259.755n 0.0v 264.745n 0.0v 264.755n 0.0v 269.745n 0.0v 269.755n 0.0v 274.745n 0.0v 274.755n 0.0v 279.745n 0.0v 279.755n 0.0v 284.745n 0.0v 284.755n 0.0v 289.745n 0.0v 289.755n 0.0v 294.745n 0.0v 294.755n 0.0v 299.745n 0.0v 299.755n 1.1v 304.745n 1.1v 304.755n 1.1v 309.745n 1.1v 309.755n 1.1v 314.745n 1.1v 314.755n 1.1v 319.745n 1.1v 319.755n 1.1v 324.745n 1.1v 324.755n 1.1v 329.745n 1.1v 329.755n 1.1v 334.745n 1.1v 334.755n 1.1v 339.745n 1.1v 339.755n 0.0v 344.745n 0.0v 344.755n 0.0v 349.745n 0.0v 349.755n 0.0v 354.745n 0.0v 354.755n 0.0v 359.745n 0.0v 359.755n 0.0v 364.745n 0.0v 364.755n 0.0v 369.745n 0.0v 369.755n 0.0v 374.745n 0.0v 374.755n 0.0v 379.745n 0.0v 379.755n 0.0v 384.745n 0.0v 384.755n 0.0v 389.745n 0.0v 389.755n 0.0v 394.745n 0.0v 394.755n 1.1v 399.745n 1.1v 399.755n 1.1v 404.745n 1.1v 404.755n 1.1v 409.745n 1.1v 409.755n 0.0v 414.745n 0.0v 414.755n 1.1v 419.745n 1.1v 419.755n 1.1v 424.745n 1.1v 424.755n 0.0v 429.745n 0.0v 429.755n 0.0v 434.745n 0.0v 434.755n 0.0v 439.745n 0.0v 439.755n 0.0v 444.745n 0.0v 444.755n 0.0v 449.745n 0.0v 449.755n 1.1v 454.745n 1.1v 454.755n 1.1v 459.745n 1.1v 459.755n 1.1v 464.745n 1.1v 464.755n 0.0v 469.745n 0.0v 469.755n 1.1v 474.745n 1.1v 474.755n 1.1v 479.745n 1.1v 479.755n 1.1v 484.745n 1.1v 484.755n 1.1v 489.745n 1.1v 489.755n 1.1v 494.745n 1.1v 494.755n 1.1v 499.745n 1.1v 499.755n 0.0v 504.745n 0.0v 504.755n 1.1v 509.745n 1.1v 509.755n 0.0v 514.745n 0.0v 514.755n 0.0v 519.745n 0.0v 519.755n 0.0v 524.745n 0.0v 524.755n 0.0v 529.745n 0.0v 529.755n 0.0v 534.745n 0.0v 534.755n 1.1v 539.745n 1.1v 539.755n 1.1v 544.745n 1.1v 544.755n 1.1v 549.745n 1.1v 549.755n 1.1v 554.745n 1.1v 554.755n 1.1v 559.745n 1.1v 559.755n 1.1v 564.745n 1.1v 564.755n 1.1v 569.745n 1.1v 569.755n 1.1v 574.745n 1.1v 574.755n 0.0v 579.745n 0.0v 579.755n 0.0v 584.745n 0.0v 584.755n 0.0v 589.745n 0.0v 589.755n 0.0v 594.745n 0.0v 594.755n 0.0v 599.745n 0.0v 599.755n 0.0v 604.745n 0.0v 604.755n 0.0v 609.745n 0.0v 609.755n 0.0v 614.745n 0.0v 614.755n 0.0v 619.745n 0.0v 619.755n 0.0v 624.745n 0.0v 624.755n 0.0v 629.745n 0.0v 629.755n 0.0v 634.745n 0.0v 634.755n 1.1v 639.745n 1.1v 639.755n 0.0v 644.745n 0.0v 644.755n 0.0v 649.745n 0.0v 649.755n 0.0v 654.745n 0.0v 654.755n 1.1v 659.745n 1.1v 659.755n 0.0v 664.745n 0.0v 664.755n 0.0v 669.745n 0.0v 669.755n 1.1v 674.745n 1.1v 674.755n 1.1v 679.745n 1.1v 679.755n 1.1v 684.745n 1.1v 684.755n 1.1v 689.745n 1.1v 689.755n 1.1v 694.745n 1.1v 694.755n 1.1v 699.745n 1.1v 699.755n 1.1v 704.745n 1.1v 704.755n 0.0v 709.745n 0.0v 709.755n 1.1v 714.745n 1.1v 714.755n 1.1v 719.745n 1.1v 719.755n 1.1v 724.745n 1.1v 724.755n 1.1v 729.745n 1.1v 729.755n 1.1v 734.745n 1.1v 734.755n 0.0v 739.745n 0.0v 739.755n 1.1v 744.745n 1.1v 744.755n 1.1v 749.745n 1.1v 749.755n 1.1v 754.745n 1.1v 754.755n 0.0v 759.745n 0.0v 759.755n 0.0v 764.745n 0.0v 764.755n 0.0v 769.745n 0.0v 769.755n 0.0v 774.745n 0.0v 774.755n 1.1v 779.745n 1.1v 779.755n 1.1v 784.745n 1.1v 784.755n 1.1v 789.745n 1.1v 789.755n 0.0v 794.745n 0.0v 794.755n 0.0v 799.745n 0.0v 799.755n 0.0v 804.745n 0.0v 804.755n 0.0v 809.745n 0.0v 809.755n 0.0v 814.745n 0.0v 814.755n 0.0v 819.745n 0.0v 819.755n 0.0v 824.745n 0.0v 824.755n 0.0v 829.745n 0.0v 829.755n 1.1v 834.745n 1.1v 834.755n 1.1v 839.745n 1.1v 839.755n 1.1v 844.745n 1.1v 844.755n 1.1v 849.745n 1.1v 849.755n 1.1v 854.745n 1.1v 854.755n 0.0v 859.745n 0.0v 859.755n 0.0v 864.745n 0.0v 864.755n 1.1v 869.745n 1.1v 869.755n 1.1v 874.745n 1.1v 874.755n 0.0v 879.745n 0.0v 879.755n 0.0v 884.745n 0.0v 884.755n 1.1v 889.745n 1.1v 889.755n 1.1v 894.745n 1.1v 894.755n 1.1v 899.745n 1.1v 899.755n 1.1v 904.745n 1.1v 904.755n 1.1v 909.745n 1.1v 909.755n 0.0v 914.745n 0.0v 914.755n 0.0v 919.745n 0.0v 919.755n 0.0v 924.745n 0.0v 924.755n 0.0v 929.745n 0.0v 929.755n 1.1v 934.745n 1.1v 934.755n 0.0v 939.745n 0.0v 939.755n 1.1v 944.745n 1.1v 944.755n 1.1v 949.745n 1.1v 949.755n 1.1v 954.745n 1.1v 954.755n 1.1v 959.745n 1.1v 959.755n 1.1v 964.745n 1.1v 964.755n 0.0v 969.745n 0.0v 969.755n 0.0v 974.745n 0.0v 974.755n 0.0v 979.745n 0.0v 979.755n 0.0v 984.745n 0.0v 984.755n 0.0v 989.745n 0.0v 989.755n 0.0v 994.745n 0.0v 994.755n 0.0v 999.745n 0.0v 999.755n 1.1v 1004.745n 1.1v 1004.755n 1.1v 1009.745n 1.1v 1009.755n 1.1v 1014.745n 1.1v 1014.755n 1.1v 1019.745n 1.1v 1019.755n 1.1v 1024.745n 1.1v 1024.755n 1.1v )
* (time, data): [(0, 0), (5, 1), (10, 0), (15, 1), (20, 1), (25, 1), (30, 1), (35, 1), (40, 0), (45, 1), (50, 1), (55, 1), (60, 0), (65, 1), (70, 1), (75, 1), (80, 1), (85, 1), (90, 0), (95, 0), (100, 0), (105, 0), (110, 0), (115, 0), (120, 0), (125, 0), (130, 0), (135, 1), (140, 0), (145, 0), (150, 0), (155, 0), (160, 0), (165, 0), (170, 0), (175, 0), (180, 0), (185, 0), (190, 0), (195, 0), (200, 0), (205, 0), (210, 0), (215, 0), (220, 1), (225, 1), (230, 1), (235, 1), (240, 1), (245, 1), (250, 1), (255, 0), (260, 0), (265, 0), (270, 0), (275, 0), (280, 1), (285, 1), (290, 1), (295, 1), (300, 1), (305, 1), (310, 1), (315, 1), (320, 1), (325, 1), (330, 1), (335, 0), (340, 0), (345, 0), (350, 0), (355, 0), (360, 0), (365, 0), (370, 0), (375, 0), (380, 0), (385, 0), (390, 0), (395, 0), (400, 1), (405, 1), (410, 1), (415, 0), (420, 1), (425, 1), (430, 0), (435, 0), (440, 0), (445, 0), (450, 0), (455, 0), (460, 1), (465, 0), (470, 1), (475, 1), (480, 1), (485, 1), (490, 1), (495, 1), (500, 1), (505, 0), (510, 1), (515, 0), (520, 0), (525, 0), (530, 0), (535, 0), (540, 0), (545, 0), (550, 0), (555, 1), (560, 1), (565, 1), (570, 1), (575, 0), (580, 0), (585, 0), (590, 0), (595, 0), (600, 0), (605, 0), (610, 0), (615, 0), (620, 0), (625, 0), (630, 1), (635, 1), (640, 0), (645, 0), (650, 0), (655, 1), (660, 0), (665, 0), (670, 1), (675, 1), (680, 1), (685, 1), (690, 1), (695, 1), (700, 1), (705, 1), (710, 1), (715, 0), (720, 0), (725, 0), (730, 0), (735, 1), (740, 1), (745, 1), (750, 1), (755, 1), (760, 1), (765, 1), (770, 1), (775, 0), (780, 0), (785, 0), (790, 0), (795, 0), (800, 0), (805, 0), (810, 0), (815, 0), (820, 1), (825, 1), (830, 0), (835, 1), (840, 1), (845, 1), (850, 1), (855, 0), (860, 1), (865, 0), (870, 1), (875, 1), (880, 0), (885, 0), (890, 0), (895, 0), (900, 0), (905, 0), (910, 1), (915, 1), (920, 1), (925, 1), (930, 1), (935, 0), (940, 1), (945, 1), (950, 1), (955, 0), (960, 0), (965, 1), (970, 1), (975, 1), (980, 0), (985, 1), (990, 1), (995, 0), (1000, 1), (1005, 1), (1010, 1), (1015, 1), (1020, 1), (1025, 1)]
Vdin0_22  din0_22  0 PWL (0n 0.0v 4.745n 0.0v 4.755n 1.1v 9.745n 1.1v 9.755n 0.0v 14.745n 0.0v 14.755n 1.1v 19.745n 1.1v 19.755n 1.1v 24.745n 1.1v 24.755n 1.1v 29.745n 1.1v 29.755n 1.1v 34.745n 1.1v 34.755n 1.1v 39.745n 1.1v 39.755n 0.0v 44.745n 0.0v 44.755n 1.1v 49.745n 1.1v 49.755n 1.1v 54.745n 1.1v 54.755n 1.1v 59.745n 1.1v 59.755n 0.0v 64.745n 0.0v 64.755n 1.1v 69.745n 1.1v 69.755n 1.1v 74.745n 1.1v 74.755n 1.1v 79.745n 1.1v 79.755n 1.1v 84.745n 1.1v 84.755n 1.1v 89.745n 1.1v 89.755n 0.0v 94.745n 0.0v 94.755n 0.0v 99.745n 0.0v 99.755n 0.0v 104.745n 0.0v 104.755n 0.0v 109.745n 0.0v 109.755n 0.0v 114.745n 0.0v 114.755n 0.0v 119.745n 0.0v 119.755n 0.0v 124.745n 0.0v 124.755n 0.0v 129.745n 0.0v 129.755n 0.0v 134.745n 0.0v 134.755n 1.1v 139.745n 1.1v 139.755n 0.0v 144.745n 0.0v 144.755n 0.0v 149.745n 0.0v 149.755n 0.0v 154.745n 0.0v 154.755n 0.0v 159.745n 0.0v 159.755n 0.0v 164.745n 0.0v 164.755n 0.0v 169.745n 0.0v 169.755n 0.0v 174.745n 0.0v 174.755n 0.0v 179.745n 0.0v 179.755n 0.0v 184.745n 0.0v 184.755n 0.0v 189.745n 0.0v 189.755n 0.0v 194.745n 0.0v 194.755n 0.0v 199.745n 0.0v 199.755n 0.0v 204.745n 0.0v 204.755n 0.0v 209.745n 0.0v 209.755n 0.0v 214.745n 0.0v 214.755n 0.0v 219.745n 0.0v 219.755n 1.1v 224.745n 1.1v 224.755n 1.1v 229.745n 1.1v 229.755n 1.1v 234.745n 1.1v 234.755n 1.1v 239.745n 1.1v 239.755n 1.1v 244.745n 1.1v 244.755n 1.1v 249.745n 1.1v 249.755n 1.1v 254.745n 1.1v 254.755n 0.0v 259.745n 0.0v 259.755n 0.0v 264.745n 0.0v 264.755n 0.0v 269.745n 0.0v 269.755n 0.0v 274.745n 0.0v 274.755n 0.0v 279.745n 0.0v 279.755n 1.1v 284.745n 1.1v 284.755n 1.1v 289.745n 1.1v 289.755n 1.1v 294.745n 1.1v 294.755n 1.1v 299.745n 1.1v 299.755n 1.1v 304.745n 1.1v 304.755n 1.1v 309.745n 1.1v 309.755n 1.1v 314.745n 1.1v 314.755n 1.1v 319.745n 1.1v 319.755n 1.1v 324.745n 1.1v 324.755n 1.1v 329.745n 1.1v 329.755n 1.1v 334.745n 1.1v 334.755n 0.0v 339.745n 0.0v 339.755n 0.0v 344.745n 0.0v 344.755n 0.0v 349.745n 0.0v 349.755n 0.0v 354.745n 0.0v 354.755n 0.0v 359.745n 0.0v 359.755n 0.0v 364.745n 0.0v 364.755n 0.0v 369.745n 0.0v 369.755n 0.0v 374.745n 0.0v 374.755n 0.0v 379.745n 0.0v 379.755n 0.0v 384.745n 0.0v 384.755n 0.0v 389.745n 0.0v 389.755n 0.0v 394.745n 0.0v 394.755n 0.0v 399.745n 0.0v 399.755n 1.1v 404.745n 1.1v 404.755n 1.1v 409.745n 1.1v 409.755n 1.1v 414.745n 1.1v 414.755n 0.0v 419.745n 0.0v 419.755n 1.1v 424.745n 1.1v 424.755n 1.1v 429.745n 1.1v 429.755n 0.0v 434.745n 0.0v 434.755n 0.0v 439.745n 0.0v 439.755n 0.0v 444.745n 0.0v 444.755n 0.0v 449.745n 0.0v 449.755n 0.0v 454.745n 0.0v 454.755n 0.0v 459.745n 0.0v 459.755n 1.1v 464.745n 1.1v 464.755n 0.0v 469.745n 0.0v 469.755n 1.1v 474.745n 1.1v 474.755n 1.1v 479.745n 1.1v 479.755n 1.1v 484.745n 1.1v 484.755n 1.1v 489.745n 1.1v 489.755n 1.1v 494.745n 1.1v 494.755n 1.1v 499.745n 1.1v 499.755n 1.1v 504.745n 1.1v 504.755n 0.0v 509.745n 0.0v 509.755n 1.1v 514.745n 1.1v 514.755n 0.0v 519.745n 0.0v 519.755n 0.0v 524.745n 0.0v 524.755n 0.0v 529.745n 0.0v 529.755n 0.0v 534.745n 0.0v 534.755n 0.0v 539.745n 0.0v 539.755n 0.0v 544.745n 0.0v 544.755n 0.0v 549.745n 0.0v 549.755n 0.0v 554.745n 0.0v 554.755n 1.1v 559.745n 1.1v 559.755n 1.1v 564.745n 1.1v 564.755n 1.1v 569.745n 1.1v 569.755n 1.1v 574.745n 1.1v 574.755n 0.0v 579.745n 0.0v 579.755n 0.0v 584.745n 0.0v 584.755n 0.0v 589.745n 0.0v 589.755n 0.0v 594.745n 0.0v 594.755n 0.0v 599.745n 0.0v 599.755n 0.0v 604.745n 0.0v 604.755n 0.0v 609.745n 0.0v 609.755n 0.0v 614.745n 0.0v 614.755n 0.0v 619.745n 0.0v 619.755n 0.0v 624.745n 0.0v 624.755n 0.0v 629.745n 0.0v 629.755n 1.1v 634.745n 1.1v 634.755n 1.1v 639.745n 1.1v 639.755n 0.0v 644.745n 0.0v 644.755n 0.0v 649.745n 0.0v 649.755n 0.0v 654.745n 0.0v 654.755n 1.1v 659.745n 1.1v 659.755n 0.0v 664.745n 0.0v 664.755n 0.0v 669.745n 0.0v 669.755n 1.1v 674.745n 1.1v 674.755n 1.1v 679.745n 1.1v 679.755n 1.1v 684.745n 1.1v 684.755n 1.1v 689.745n 1.1v 689.755n 1.1v 694.745n 1.1v 694.755n 1.1v 699.745n 1.1v 699.755n 1.1v 704.745n 1.1v 704.755n 1.1v 709.745n 1.1v 709.755n 1.1v 714.745n 1.1v 714.755n 0.0v 719.745n 0.0v 719.755n 0.0v 724.745n 0.0v 724.755n 0.0v 729.745n 0.0v 729.755n 0.0v 734.745n 0.0v 734.755n 1.1v 739.745n 1.1v 739.755n 1.1v 744.745n 1.1v 744.755n 1.1v 749.745n 1.1v 749.755n 1.1v 754.745n 1.1v 754.755n 1.1v 759.745n 1.1v 759.755n 1.1v 764.745n 1.1v 764.755n 1.1v 769.745n 1.1v 769.755n 1.1v 774.745n 1.1v 774.755n 0.0v 779.745n 0.0v 779.755n 0.0v 784.745n 0.0v 784.755n 0.0v 789.745n 0.0v 789.755n 0.0v 794.745n 0.0v 794.755n 0.0v 799.745n 0.0v 799.755n 0.0v 804.745n 0.0v 804.755n 0.0v 809.745n 0.0v 809.755n 0.0v 814.745n 0.0v 814.755n 0.0v 819.745n 0.0v 819.755n 1.1v 824.745n 1.1v 824.755n 1.1v 829.745n 1.1v 829.755n 0.0v 834.745n 0.0v 834.755n 1.1v 839.745n 1.1v 839.755n 1.1v 844.745n 1.1v 844.755n 1.1v 849.745n 1.1v 849.755n 1.1v 854.745n 1.1v 854.755n 0.0v 859.745n 0.0v 859.755n 1.1v 864.745n 1.1v 864.755n 0.0v 869.745n 0.0v 869.755n 1.1v 874.745n 1.1v 874.755n 1.1v 879.745n 1.1v 879.755n 0.0v 884.745n 0.0v 884.755n 0.0v 889.745n 0.0v 889.755n 0.0v 894.745n 0.0v 894.755n 0.0v 899.745n 0.0v 899.755n 0.0v 904.745n 0.0v 904.755n 0.0v 909.745n 0.0v 909.755n 1.1v 914.745n 1.1v 914.755n 1.1v 919.745n 1.1v 919.755n 1.1v 924.745n 1.1v 924.755n 1.1v 929.745n 1.1v 929.755n 1.1v 934.745n 1.1v 934.755n 0.0v 939.745n 0.0v 939.755n 1.1v 944.745n 1.1v 944.755n 1.1v 949.745n 1.1v 949.755n 1.1v 954.745n 1.1v 954.755n 0.0v 959.745n 0.0v 959.755n 0.0v 964.745n 0.0v 964.755n 1.1v 969.745n 1.1v 969.755n 1.1v 974.745n 1.1v 974.755n 1.1v 979.745n 1.1v 979.755n 0.0v 984.745n 0.0v 984.755n 1.1v 989.745n 1.1v 989.755n 1.1v 994.745n 1.1v 994.755n 0.0v 999.745n 0.0v 999.755n 1.1v 1004.745n 1.1v 1004.755n 1.1v 1009.745n 1.1v 1009.755n 1.1v 1014.745n 1.1v 1014.755n 1.1v 1019.745n 1.1v 1019.755n 1.1v 1024.745n 1.1v 1024.755n 1.1v )
* (time, data): [(0, 0), (5, 0), (10, 0), (15, 1), (20, 1), (25, 1), (30, 1), (35, 1), (40, 1), (45, 1), (50, 1), (55, 1), (60, 1), (65, 1), (70, 1), (75, 1), (80, 1), (85, 1), (90, 0), (95, 0), (100, 1), (105, 1), (110, 1), (115, 1), (120, 1), (125, 1), (130, 1), (135, 0), (140, 1), (145, 1), (150, 1), (155, 1), (160, 1), (165, 1), (170, 1), (175, 1), (180, 1), (185, 1), (190, 1), (195, 1), (200, 1), (205, 1), (210, 0), (215, 0), (220, 0), (225, 0), (230, 0), (235, 0), (240, 1), (245, 1), (250, 1), (255, 1), (260, 1), (265, 0), (270, 0), (275, 0), (280, 1), (285, 1), (290, 1), (295, 1), (300, 0), (305, 0), (310, 0), (315, 0), (320, 0), (325, 0), (330, 1), (335, 1), (340, 0), (345, 0), (350, 0), (355, 0), (360, 0), (365, 0), (370, 0), (375, 0), (380, 0), (385, 0), (390, 0), (395, 0), (400, 0), (405, 0), (410, 0), (415, 0), (420, 1), (425, 1), (430, 1), (435, 1), (440, 1), (445, 1), (450, 1), (455, 1), (460, 1), (465, 1), (470, 0), (475, 0), (480, 0), (485, 0), (490, 0), (495, 0), (500, 1), (505, 1), (510, 0), (515, 0), (520, 0), (525, 0), (530, 0), (535, 0), (540, 0), (545, 0), (550, 0), (555, 0), (560, 0), (565, 0), (570, 0), (575, 1), (580, 1), (585, 1), (590, 1), (595, 1), (600, 1), (605, 1), (610, 1), (615, 1), (620, 1), (625, 1), (630, 0), (635, 1), (640, 1), (645, 1), (650, 1), (655, 0), (660, 0), (665, 0), (670, 1), (675, 1), (680, 1), (685, 1), (690, 1), (695, 1), (700, 1), (705, 1), (710, 1), (715, 1), (720, 1), (725, 1), (730, 1), (735, 1), (740, 0), (745, 0), (750, 0), (755, 1), (760, 1), (765, 1), (770, 0), (775, 0), (780, 0), (785, 0), (790, 0), (795, 0), (800, 0), (805, 0), (810, 0), (815, 0), (820, 0), (825, 0), (830, 1), (835, 1), (840, 1), (845, 1), (850, 1), (855, 1), (860, 0), (865, 0), (870, 1), (875, 1), (880, 0), (885, 1), (890, 1), (895, 1), (900, 1), (905, 1), (910, 1), (915, 1), (920, 1), (925, 1), (930, 1), (935, 1), (940, 1), (945, 1), (950, 1), (955, 1), (960, 1), (965, 0), (970, 0), (975, 0), (980, 1), (985, 1), (990, 1), (995, 0), (1000, 0), (1005, 0), (1010, 0), (1015, 0), (1020, 0), (1025, 0)]
Vdin0_23  din0_23  0 PWL (0n 0.0v 4.745n 0.0v 4.755n 0.0v 9.745n 0.0v 9.755n 0.0v 14.745n 0.0v 14.755n 1.1v 19.745n 1.1v 19.755n 1.1v 24.745n 1.1v 24.755n 1.1v 29.745n 1.1v 29.755n 1.1v 34.745n 1.1v 34.755n 1.1v 39.745n 1.1v 39.755n 1.1v 44.745n 1.1v 44.755n 1.1v 49.745n 1.1v 49.755n 1.1v 54.745n 1.1v 54.755n 1.1v 59.745n 1.1v 59.755n 1.1v 64.745n 1.1v 64.755n 1.1v 69.745n 1.1v 69.755n 1.1v 74.745n 1.1v 74.755n 1.1v 79.745n 1.1v 79.755n 1.1v 84.745n 1.1v 84.755n 1.1v 89.745n 1.1v 89.755n 0.0v 94.745n 0.0v 94.755n 0.0v 99.745n 0.0v 99.755n 1.1v 104.745n 1.1v 104.755n 1.1v 109.745n 1.1v 109.755n 1.1v 114.745n 1.1v 114.755n 1.1v 119.745n 1.1v 119.755n 1.1v 124.745n 1.1v 124.755n 1.1v 129.745n 1.1v 129.755n 1.1v 134.745n 1.1v 134.755n 0.0v 139.745n 0.0v 139.755n 1.1v 144.745n 1.1v 144.755n 1.1v 149.745n 1.1v 149.755n 1.1v 154.745n 1.1v 154.755n 1.1v 159.745n 1.1v 159.755n 1.1v 164.745n 1.1v 164.755n 1.1v 169.745n 1.1v 169.755n 1.1v 174.745n 1.1v 174.755n 1.1v 179.745n 1.1v 179.755n 1.1v 184.745n 1.1v 184.755n 1.1v 189.745n 1.1v 189.755n 1.1v 194.745n 1.1v 194.755n 1.1v 199.745n 1.1v 199.755n 1.1v 204.745n 1.1v 204.755n 1.1v 209.745n 1.1v 209.755n 0.0v 214.745n 0.0v 214.755n 0.0v 219.745n 0.0v 219.755n 0.0v 224.745n 0.0v 224.755n 0.0v 229.745n 0.0v 229.755n 0.0v 234.745n 0.0v 234.755n 0.0v 239.745n 0.0v 239.755n 1.1v 244.745n 1.1v 244.755n 1.1v 249.745n 1.1v 249.755n 1.1v 254.745n 1.1v 254.755n 1.1v 259.745n 1.1v 259.755n 1.1v 264.745n 1.1v 264.755n 0.0v 269.745n 0.0v 269.755n 0.0v 274.745n 0.0v 274.755n 0.0v 279.745n 0.0v 279.755n 1.1v 284.745n 1.1v 284.755n 1.1v 289.745n 1.1v 289.755n 1.1v 294.745n 1.1v 294.755n 1.1v 299.745n 1.1v 299.755n 0.0v 304.745n 0.0v 304.755n 0.0v 309.745n 0.0v 309.755n 0.0v 314.745n 0.0v 314.755n 0.0v 319.745n 0.0v 319.755n 0.0v 324.745n 0.0v 324.755n 0.0v 329.745n 0.0v 329.755n 1.1v 334.745n 1.1v 334.755n 1.1v 339.745n 1.1v 339.755n 0.0v 344.745n 0.0v 344.755n 0.0v 349.745n 0.0v 349.755n 0.0v 354.745n 0.0v 354.755n 0.0v 359.745n 0.0v 359.755n 0.0v 364.745n 0.0v 364.755n 0.0v 369.745n 0.0v 369.755n 0.0v 374.745n 0.0v 374.755n 0.0v 379.745n 0.0v 379.755n 0.0v 384.745n 0.0v 384.755n 0.0v 389.745n 0.0v 389.755n 0.0v 394.745n 0.0v 394.755n 0.0v 399.745n 0.0v 399.755n 0.0v 404.745n 0.0v 404.755n 0.0v 409.745n 0.0v 409.755n 0.0v 414.745n 0.0v 414.755n 0.0v 419.745n 0.0v 419.755n 1.1v 424.745n 1.1v 424.755n 1.1v 429.745n 1.1v 429.755n 1.1v 434.745n 1.1v 434.755n 1.1v 439.745n 1.1v 439.755n 1.1v 444.745n 1.1v 444.755n 1.1v 449.745n 1.1v 449.755n 1.1v 454.745n 1.1v 454.755n 1.1v 459.745n 1.1v 459.755n 1.1v 464.745n 1.1v 464.755n 1.1v 469.745n 1.1v 469.755n 0.0v 474.745n 0.0v 474.755n 0.0v 479.745n 0.0v 479.755n 0.0v 484.745n 0.0v 484.755n 0.0v 489.745n 0.0v 489.755n 0.0v 494.745n 0.0v 494.755n 0.0v 499.745n 0.0v 499.755n 1.1v 504.745n 1.1v 504.755n 1.1v 509.745n 1.1v 509.755n 0.0v 514.745n 0.0v 514.755n 0.0v 519.745n 0.0v 519.755n 0.0v 524.745n 0.0v 524.755n 0.0v 529.745n 0.0v 529.755n 0.0v 534.745n 0.0v 534.755n 0.0v 539.745n 0.0v 539.755n 0.0v 544.745n 0.0v 544.755n 0.0v 549.745n 0.0v 549.755n 0.0v 554.745n 0.0v 554.755n 0.0v 559.745n 0.0v 559.755n 0.0v 564.745n 0.0v 564.755n 0.0v 569.745n 0.0v 569.755n 0.0v 574.745n 0.0v 574.755n 1.1v 579.745n 1.1v 579.755n 1.1v 584.745n 1.1v 584.755n 1.1v 589.745n 1.1v 589.755n 1.1v 594.745n 1.1v 594.755n 1.1v 599.745n 1.1v 599.755n 1.1v 604.745n 1.1v 604.755n 1.1v 609.745n 1.1v 609.755n 1.1v 614.745n 1.1v 614.755n 1.1v 619.745n 1.1v 619.755n 1.1v 624.745n 1.1v 624.755n 1.1v 629.745n 1.1v 629.755n 0.0v 634.745n 0.0v 634.755n 1.1v 639.745n 1.1v 639.755n 1.1v 644.745n 1.1v 644.755n 1.1v 649.745n 1.1v 649.755n 1.1v 654.745n 1.1v 654.755n 0.0v 659.745n 0.0v 659.755n 0.0v 664.745n 0.0v 664.755n 0.0v 669.745n 0.0v 669.755n 1.1v 674.745n 1.1v 674.755n 1.1v 679.745n 1.1v 679.755n 1.1v 684.745n 1.1v 684.755n 1.1v 689.745n 1.1v 689.755n 1.1v 694.745n 1.1v 694.755n 1.1v 699.745n 1.1v 699.755n 1.1v 704.745n 1.1v 704.755n 1.1v 709.745n 1.1v 709.755n 1.1v 714.745n 1.1v 714.755n 1.1v 719.745n 1.1v 719.755n 1.1v 724.745n 1.1v 724.755n 1.1v 729.745n 1.1v 729.755n 1.1v 734.745n 1.1v 734.755n 1.1v 739.745n 1.1v 739.755n 0.0v 744.745n 0.0v 744.755n 0.0v 749.745n 0.0v 749.755n 0.0v 754.745n 0.0v 754.755n 1.1v 759.745n 1.1v 759.755n 1.1v 764.745n 1.1v 764.755n 1.1v 769.745n 1.1v 769.755n 0.0v 774.745n 0.0v 774.755n 0.0v 779.745n 0.0v 779.755n 0.0v 784.745n 0.0v 784.755n 0.0v 789.745n 0.0v 789.755n 0.0v 794.745n 0.0v 794.755n 0.0v 799.745n 0.0v 799.755n 0.0v 804.745n 0.0v 804.755n 0.0v 809.745n 0.0v 809.755n 0.0v 814.745n 0.0v 814.755n 0.0v 819.745n 0.0v 819.755n 0.0v 824.745n 0.0v 824.755n 0.0v 829.745n 0.0v 829.755n 1.1v 834.745n 1.1v 834.755n 1.1v 839.745n 1.1v 839.755n 1.1v 844.745n 1.1v 844.755n 1.1v 849.745n 1.1v 849.755n 1.1v 854.745n 1.1v 854.755n 1.1v 859.745n 1.1v 859.755n 0.0v 864.745n 0.0v 864.755n 0.0v 869.745n 0.0v 869.755n 1.1v 874.745n 1.1v 874.755n 1.1v 879.745n 1.1v 879.755n 0.0v 884.745n 0.0v 884.755n 1.1v 889.745n 1.1v 889.755n 1.1v 894.745n 1.1v 894.755n 1.1v 899.745n 1.1v 899.755n 1.1v 904.745n 1.1v 904.755n 1.1v 909.745n 1.1v 909.755n 1.1v 914.745n 1.1v 914.755n 1.1v 919.745n 1.1v 919.755n 1.1v 924.745n 1.1v 924.755n 1.1v 929.745n 1.1v 929.755n 1.1v 934.745n 1.1v 934.755n 1.1v 939.745n 1.1v 939.755n 1.1v 944.745n 1.1v 944.755n 1.1v 949.745n 1.1v 949.755n 1.1v 954.745n 1.1v 954.755n 1.1v 959.745n 1.1v 959.755n 1.1v 964.745n 1.1v 964.755n 0.0v 969.745n 0.0v 969.755n 0.0v 974.745n 0.0v 974.755n 0.0v 979.745n 0.0v 979.755n 1.1v 984.745n 1.1v 984.755n 1.1v 989.745n 1.1v 989.755n 1.1v 994.745n 1.1v 994.755n 0.0v 999.745n 0.0v 999.755n 0.0v 1004.745n 0.0v 1004.755n 0.0v 1009.745n 0.0v 1009.755n 0.0v 1014.745n 0.0v 1014.755n 0.0v 1019.745n 0.0v 1019.755n 0.0v 1024.745n 0.0v 1024.755n 0.0v )
* (time, data): [(0, 0), (5, 0), (10, 1), (15, 0), (20, 0), (25, 0), (30, 0), (35, 0), (40, 0), (45, 1), (50, 1), (55, 1), (60, 1), (65, 0), (70, 0), (75, 0), (80, 0), (85, 0), (90, 1), (95, 1), (100, 1), (105, 1), (110, 1), (115, 1), (120, 1), (125, 1), (130, 1), (135, 1), (140, 0), (145, 0), (150, 0), (155, 0), (160, 0), (165, 0), (170, 0), (175, 0), (180, 0), (185, 1), (190, 1), (195, 1), (200, 0), (205, 0), (210, 0), (215, 0), (220, 1), (225, 1), (230, 0), (235, 0), (240, 1), (245, 1), (250, 1), (255, 1), (260, 1), (265, 1), (270, 1), (275, 1), (280, 1), (285, 1), (290, 1), (295, 1), (300, 0), (305, 0), (310, 0), (315, 1), (320, 1), (325, 1), (330, 0), (335, 0), (340, 1), (345, 1), (350, 1), (355, 1), (360, 0), (365, 0), (370, 0), (375, 0), (380, 0), (385, 0), (390, 0), (395, 0), (400, 0), (405, 0), (410, 0), (415, 1), (420, 0), (425, 1), (430, 1), (435, 1), (440, 1), (445, 1), (450, 1), (455, 1), (460, 1), (465, 0), (470, 1), (475, 1), (480, 1), (485, 1), (490, 1), (495, 1), (500, 0), (505, 1), (510, 0), (515, 1), (520, 1), (525, 1), (530, 1), (535, 0), (540, 1), (545, 1), (550, 1), (555, 1), (560, 1), (565, 1), (570, 1), (575, 0), (580, 0), (585, 0), (590, 0), (595, 0), (600, 0), (605, 0), (610, 0), (615, 0), (620, 0), (625, 0), (630, 1), (635, 0), (640, 1), (645, 1), (650, 1), (655, 1), (660, 0), (665, 0), (670, 0), (675, 0), (680, 0), (685, 0), (690, 0), (695, 0), (700, 0), (705, 0), (710, 0), (715, 0), (720, 0), (725, 0), (730, 0), (735, 0), (740, 0), (745, 0), (750, 0), (755, 1), (760, 1), (765, 1), (770, 0), (775, 0), (780, 0), (785, 0), (790, 0), (795, 0), (800, 0), (805, 0), (810, 0), (815, 0), (820, 0), (825, 0), (830, 1), (835, 1), (840, 1), (845, 1), (850, 1), (855, 1), (860, 1), (865, 0), (870, 1), (875, 1), (880, 0), (885, 1), (890, 1), (895, 1), (900, 1), (905, 1), (910, 1), (915, 1), (920, 1), (925, 1), (930, 1), (935, 1), (940, 1), (945, 1), (950, 1), (955, 1), (960, 1), (965, 0), (970, 0), (975, 0), (980, 1), (985, 1), (990, 1), (995, 1), (1000, 1), (1005, 1), (1010, 1), (1015, 1), (1020, 1), (1025, 1)]
Vdin0_24  din0_24  0 PWL (0n 0.0v 4.745n 0.0v 4.755n 0.0v 9.745n 0.0v 9.755n 1.1v 14.745n 1.1v 14.755n 0.0v 19.745n 0.0v 19.755n 0.0v 24.745n 0.0v 24.755n 0.0v 29.745n 0.0v 29.755n 0.0v 34.745n 0.0v 34.755n 0.0v 39.745n 0.0v 39.755n 0.0v 44.745n 0.0v 44.755n 1.1v 49.745n 1.1v 49.755n 1.1v 54.745n 1.1v 54.755n 1.1v 59.745n 1.1v 59.755n 1.1v 64.745n 1.1v 64.755n 0.0v 69.745n 0.0v 69.755n 0.0v 74.745n 0.0v 74.755n 0.0v 79.745n 0.0v 79.755n 0.0v 84.745n 0.0v 84.755n 0.0v 89.745n 0.0v 89.755n 1.1v 94.745n 1.1v 94.755n 1.1v 99.745n 1.1v 99.755n 1.1v 104.745n 1.1v 104.755n 1.1v 109.745n 1.1v 109.755n 1.1v 114.745n 1.1v 114.755n 1.1v 119.745n 1.1v 119.755n 1.1v 124.745n 1.1v 124.755n 1.1v 129.745n 1.1v 129.755n 1.1v 134.745n 1.1v 134.755n 1.1v 139.745n 1.1v 139.755n 0.0v 144.745n 0.0v 144.755n 0.0v 149.745n 0.0v 149.755n 0.0v 154.745n 0.0v 154.755n 0.0v 159.745n 0.0v 159.755n 0.0v 164.745n 0.0v 164.755n 0.0v 169.745n 0.0v 169.755n 0.0v 174.745n 0.0v 174.755n 0.0v 179.745n 0.0v 179.755n 0.0v 184.745n 0.0v 184.755n 1.1v 189.745n 1.1v 189.755n 1.1v 194.745n 1.1v 194.755n 1.1v 199.745n 1.1v 199.755n 0.0v 204.745n 0.0v 204.755n 0.0v 209.745n 0.0v 209.755n 0.0v 214.745n 0.0v 214.755n 0.0v 219.745n 0.0v 219.755n 1.1v 224.745n 1.1v 224.755n 1.1v 229.745n 1.1v 229.755n 0.0v 234.745n 0.0v 234.755n 0.0v 239.745n 0.0v 239.755n 1.1v 244.745n 1.1v 244.755n 1.1v 249.745n 1.1v 249.755n 1.1v 254.745n 1.1v 254.755n 1.1v 259.745n 1.1v 259.755n 1.1v 264.745n 1.1v 264.755n 1.1v 269.745n 1.1v 269.755n 1.1v 274.745n 1.1v 274.755n 1.1v 279.745n 1.1v 279.755n 1.1v 284.745n 1.1v 284.755n 1.1v 289.745n 1.1v 289.755n 1.1v 294.745n 1.1v 294.755n 1.1v 299.745n 1.1v 299.755n 0.0v 304.745n 0.0v 304.755n 0.0v 309.745n 0.0v 309.755n 0.0v 314.745n 0.0v 314.755n 1.1v 319.745n 1.1v 319.755n 1.1v 324.745n 1.1v 324.755n 1.1v 329.745n 1.1v 329.755n 0.0v 334.745n 0.0v 334.755n 0.0v 339.745n 0.0v 339.755n 1.1v 344.745n 1.1v 344.755n 1.1v 349.745n 1.1v 349.755n 1.1v 354.745n 1.1v 354.755n 1.1v 359.745n 1.1v 359.755n 0.0v 364.745n 0.0v 364.755n 0.0v 369.745n 0.0v 369.755n 0.0v 374.745n 0.0v 374.755n 0.0v 379.745n 0.0v 379.755n 0.0v 384.745n 0.0v 384.755n 0.0v 389.745n 0.0v 389.755n 0.0v 394.745n 0.0v 394.755n 0.0v 399.745n 0.0v 399.755n 0.0v 404.745n 0.0v 404.755n 0.0v 409.745n 0.0v 409.755n 0.0v 414.745n 0.0v 414.755n 1.1v 419.745n 1.1v 419.755n 0.0v 424.745n 0.0v 424.755n 1.1v 429.745n 1.1v 429.755n 1.1v 434.745n 1.1v 434.755n 1.1v 439.745n 1.1v 439.755n 1.1v 444.745n 1.1v 444.755n 1.1v 449.745n 1.1v 449.755n 1.1v 454.745n 1.1v 454.755n 1.1v 459.745n 1.1v 459.755n 1.1v 464.745n 1.1v 464.755n 0.0v 469.745n 0.0v 469.755n 1.1v 474.745n 1.1v 474.755n 1.1v 479.745n 1.1v 479.755n 1.1v 484.745n 1.1v 484.755n 1.1v 489.745n 1.1v 489.755n 1.1v 494.745n 1.1v 494.755n 1.1v 499.745n 1.1v 499.755n 0.0v 504.745n 0.0v 504.755n 1.1v 509.745n 1.1v 509.755n 0.0v 514.745n 0.0v 514.755n 1.1v 519.745n 1.1v 519.755n 1.1v 524.745n 1.1v 524.755n 1.1v 529.745n 1.1v 529.755n 1.1v 534.745n 1.1v 534.755n 0.0v 539.745n 0.0v 539.755n 1.1v 544.745n 1.1v 544.755n 1.1v 549.745n 1.1v 549.755n 1.1v 554.745n 1.1v 554.755n 1.1v 559.745n 1.1v 559.755n 1.1v 564.745n 1.1v 564.755n 1.1v 569.745n 1.1v 569.755n 1.1v 574.745n 1.1v 574.755n 0.0v 579.745n 0.0v 579.755n 0.0v 584.745n 0.0v 584.755n 0.0v 589.745n 0.0v 589.755n 0.0v 594.745n 0.0v 594.755n 0.0v 599.745n 0.0v 599.755n 0.0v 604.745n 0.0v 604.755n 0.0v 609.745n 0.0v 609.755n 0.0v 614.745n 0.0v 614.755n 0.0v 619.745n 0.0v 619.755n 0.0v 624.745n 0.0v 624.755n 0.0v 629.745n 0.0v 629.755n 1.1v 634.745n 1.1v 634.755n 0.0v 639.745n 0.0v 639.755n 1.1v 644.745n 1.1v 644.755n 1.1v 649.745n 1.1v 649.755n 1.1v 654.745n 1.1v 654.755n 1.1v 659.745n 1.1v 659.755n 0.0v 664.745n 0.0v 664.755n 0.0v 669.745n 0.0v 669.755n 0.0v 674.745n 0.0v 674.755n 0.0v 679.745n 0.0v 679.755n 0.0v 684.745n 0.0v 684.755n 0.0v 689.745n 0.0v 689.755n 0.0v 694.745n 0.0v 694.755n 0.0v 699.745n 0.0v 699.755n 0.0v 704.745n 0.0v 704.755n 0.0v 709.745n 0.0v 709.755n 0.0v 714.745n 0.0v 714.755n 0.0v 719.745n 0.0v 719.755n 0.0v 724.745n 0.0v 724.755n 0.0v 729.745n 0.0v 729.755n 0.0v 734.745n 0.0v 734.755n 0.0v 739.745n 0.0v 739.755n 0.0v 744.745n 0.0v 744.755n 0.0v 749.745n 0.0v 749.755n 0.0v 754.745n 0.0v 754.755n 1.1v 759.745n 1.1v 759.755n 1.1v 764.745n 1.1v 764.755n 1.1v 769.745n 1.1v 769.755n 0.0v 774.745n 0.0v 774.755n 0.0v 779.745n 0.0v 779.755n 0.0v 784.745n 0.0v 784.755n 0.0v 789.745n 0.0v 789.755n 0.0v 794.745n 0.0v 794.755n 0.0v 799.745n 0.0v 799.755n 0.0v 804.745n 0.0v 804.755n 0.0v 809.745n 0.0v 809.755n 0.0v 814.745n 0.0v 814.755n 0.0v 819.745n 0.0v 819.755n 0.0v 824.745n 0.0v 824.755n 0.0v 829.745n 0.0v 829.755n 1.1v 834.745n 1.1v 834.755n 1.1v 839.745n 1.1v 839.755n 1.1v 844.745n 1.1v 844.755n 1.1v 849.745n 1.1v 849.755n 1.1v 854.745n 1.1v 854.755n 1.1v 859.745n 1.1v 859.755n 1.1v 864.745n 1.1v 864.755n 0.0v 869.745n 0.0v 869.755n 1.1v 874.745n 1.1v 874.755n 1.1v 879.745n 1.1v 879.755n 0.0v 884.745n 0.0v 884.755n 1.1v 889.745n 1.1v 889.755n 1.1v 894.745n 1.1v 894.755n 1.1v 899.745n 1.1v 899.755n 1.1v 904.745n 1.1v 904.755n 1.1v 909.745n 1.1v 909.755n 1.1v 914.745n 1.1v 914.755n 1.1v 919.745n 1.1v 919.755n 1.1v 924.745n 1.1v 924.755n 1.1v 929.745n 1.1v 929.755n 1.1v 934.745n 1.1v 934.755n 1.1v 939.745n 1.1v 939.755n 1.1v 944.745n 1.1v 944.755n 1.1v 949.745n 1.1v 949.755n 1.1v 954.745n 1.1v 954.755n 1.1v 959.745n 1.1v 959.755n 1.1v 964.745n 1.1v 964.755n 0.0v 969.745n 0.0v 969.755n 0.0v 974.745n 0.0v 974.755n 0.0v 979.745n 0.0v 979.755n 1.1v 984.745n 1.1v 984.755n 1.1v 989.745n 1.1v 989.755n 1.1v 994.745n 1.1v 994.755n 1.1v 999.745n 1.1v 999.755n 1.1v 1004.745n 1.1v 1004.755n 1.1v 1009.745n 1.1v 1009.755n 1.1v 1014.745n 1.1v 1014.755n 1.1v 1019.745n 1.1v 1019.755n 1.1v 1024.745n 1.1v 1024.755n 1.1v )
* (time, data): [(0, 0), (5, 1), (10, 1), (15, 1), (20, 1), (25, 1), (30, 0), (35, 0), (40, 0), (45, 0), (50, 0), (55, 0), (60, 1), (65, 0), (70, 0), (75, 0), (80, 0), (85, 0), (90, 0), (95, 0), (100, 1), (105, 1), (110, 1), (115, 1), (120, 1), (125, 1), (130, 1), (135, 0), (140, 0), (145, 0), (150, 0), (155, 0), (160, 0), (165, 0), (170, 0), (175, 0), (180, 0), (185, 0), (190, 0), (195, 0), (200, 1), (205, 1), (210, 0), (215, 0), (220, 1), (225, 1), (230, 1), (235, 1), (240, 1), (245, 1), (250, 1), (255, 1), (260, 1), (265, 0), (270, 0), (275, 0), (280, 1), (285, 1), (290, 1), (295, 1), (300, 1), (305, 1), (310, 1), (315, 0), (320, 0), (325, 0), (330, 0), (335, 0), (340, 1), (345, 1), (350, 1), (355, 1), (360, 1), (365, 1), (370, 1), (375, 1), (380, 1), (385, 1), (390, 1), (395, 0), (400, 0), (405, 0), (410, 0), (415, 0), (420, 1), (425, 1), (430, 1), (435, 1), (440, 1), (445, 1), (450, 1), (455, 1), (460, 1), (465, 1), (470, 1), (475, 1), (480, 1), (485, 1), (490, 1), (495, 1), (500, 1), (505, 1), (510, 0), (515, 1), (520, 1), (525, 1), (530, 1), (535, 1), (540, 0), (545, 0), (550, 0), (555, 0), (560, 0), (565, 0), (570, 0), (575, 0), (580, 0), (585, 0), (590, 0), (595, 0), (600, 0), (605, 0), (610, 0), (615, 0), (620, 0), (625, 0), (630, 0), (635, 0), (640, 1), (645, 1), (650, 1), (655, 1), (660, 1), (665, 1), (670, 1), (675, 1), (680, 1), (685, 1), (690, 1), (695, 1), (700, 1), (705, 0), (710, 0), (715, 1), (720, 1), (725, 1), (730, 1), (735, 0), (740, 0), (745, 0), (750, 0), (755, 1), (760, 1), (765, 1), (770, 1), (775, 0), (780, 0), (785, 0), (790, 0), (795, 0), (800, 0), (805, 0), (810, 0), (815, 0), (820, 1), (825, 1), (830, 0), (835, 1), (840, 1), (845, 1), (850, 1), (855, 0), (860, 1), (865, 1), (870, 1), (875, 1), (880, 1), (885, 0), (890, 0), (895, 0), (900, 0), (905, 0), (910, 1), (915, 1), (920, 1), (925, 1), (930, 0), (935, 0), (940, 0), (945, 0), (950, 0), (955, 0), (960, 0), (965, 1), (970, 1), (975, 1), (980, 0), (985, 1), (990, 1), (995, 0), (1000, 0), (1005, 0), (1010, 0), (1015, 0), (1020, 0), (1025, 0)]
Vdin0_25  din0_25  0 PWL (0n 0.0v 4.745n 0.0v 4.755n 1.1v 9.745n 1.1v 9.755n 1.1v 14.745n 1.1v 14.755n 1.1v 19.745n 1.1v 19.755n 1.1v 24.745n 1.1v 24.755n 1.1v 29.745n 1.1v 29.755n 0.0v 34.745n 0.0v 34.755n 0.0v 39.745n 0.0v 39.755n 0.0v 44.745n 0.0v 44.755n 0.0v 49.745n 0.0v 49.755n 0.0v 54.745n 0.0v 54.755n 0.0v 59.745n 0.0v 59.755n 1.1v 64.745n 1.1v 64.755n 0.0v 69.745n 0.0v 69.755n 0.0v 74.745n 0.0v 74.755n 0.0v 79.745n 0.0v 79.755n 0.0v 84.745n 0.0v 84.755n 0.0v 89.745n 0.0v 89.755n 0.0v 94.745n 0.0v 94.755n 0.0v 99.745n 0.0v 99.755n 1.1v 104.745n 1.1v 104.755n 1.1v 109.745n 1.1v 109.755n 1.1v 114.745n 1.1v 114.755n 1.1v 119.745n 1.1v 119.755n 1.1v 124.745n 1.1v 124.755n 1.1v 129.745n 1.1v 129.755n 1.1v 134.745n 1.1v 134.755n 0.0v 139.745n 0.0v 139.755n 0.0v 144.745n 0.0v 144.755n 0.0v 149.745n 0.0v 149.755n 0.0v 154.745n 0.0v 154.755n 0.0v 159.745n 0.0v 159.755n 0.0v 164.745n 0.0v 164.755n 0.0v 169.745n 0.0v 169.755n 0.0v 174.745n 0.0v 174.755n 0.0v 179.745n 0.0v 179.755n 0.0v 184.745n 0.0v 184.755n 0.0v 189.745n 0.0v 189.755n 0.0v 194.745n 0.0v 194.755n 0.0v 199.745n 0.0v 199.755n 1.1v 204.745n 1.1v 204.755n 1.1v 209.745n 1.1v 209.755n 0.0v 214.745n 0.0v 214.755n 0.0v 219.745n 0.0v 219.755n 1.1v 224.745n 1.1v 224.755n 1.1v 229.745n 1.1v 229.755n 1.1v 234.745n 1.1v 234.755n 1.1v 239.745n 1.1v 239.755n 1.1v 244.745n 1.1v 244.755n 1.1v 249.745n 1.1v 249.755n 1.1v 254.745n 1.1v 254.755n 1.1v 259.745n 1.1v 259.755n 1.1v 264.745n 1.1v 264.755n 0.0v 269.745n 0.0v 269.755n 0.0v 274.745n 0.0v 274.755n 0.0v 279.745n 0.0v 279.755n 1.1v 284.745n 1.1v 284.755n 1.1v 289.745n 1.1v 289.755n 1.1v 294.745n 1.1v 294.755n 1.1v 299.745n 1.1v 299.755n 1.1v 304.745n 1.1v 304.755n 1.1v 309.745n 1.1v 309.755n 1.1v 314.745n 1.1v 314.755n 0.0v 319.745n 0.0v 319.755n 0.0v 324.745n 0.0v 324.755n 0.0v 329.745n 0.0v 329.755n 0.0v 334.745n 0.0v 334.755n 0.0v 339.745n 0.0v 339.755n 1.1v 344.745n 1.1v 344.755n 1.1v 349.745n 1.1v 349.755n 1.1v 354.745n 1.1v 354.755n 1.1v 359.745n 1.1v 359.755n 1.1v 364.745n 1.1v 364.755n 1.1v 369.745n 1.1v 369.755n 1.1v 374.745n 1.1v 374.755n 1.1v 379.745n 1.1v 379.755n 1.1v 384.745n 1.1v 384.755n 1.1v 389.745n 1.1v 389.755n 1.1v 394.745n 1.1v 394.755n 0.0v 399.745n 0.0v 399.755n 0.0v 404.745n 0.0v 404.755n 0.0v 409.745n 0.0v 409.755n 0.0v 414.745n 0.0v 414.755n 0.0v 419.745n 0.0v 419.755n 1.1v 424.745n 1.1v 424.755n 1.1v 429.745n 1.1v 429.755n 1.1v 434.745n 1.1v 434.755n 1.1v 439.745n 1.1v 439.755n 1.1v 444.745n 1.1v 444.755n 1.1v 449.745n 1.1v 449.755n 1.1v 454.745n 1.1v 454.755n 1.1v 459.745n 1.1v 459.755n 1.1v 464.745n 1.1v 464.755n 1.1v 469.745n 1.1v 469.755n 1.1v 474.745n 1.1v 474.755n 1.1v 479.745n 1.1v 479.755n 1.1v 484.745n 1.1v 484.755n 1.1v 489.745n 1.1v 489.755n 1.1v 494.745n 1.1v 494.755n 1.1v 499.745n 1.1v 499.755n 1.1v 504.745n 1.1v 504.755n 1.1v 509.745n 1.1v 509.755n 0.0v 514.745n 0.0v 514.755n 1.1v 519.745n 1.1v 519.755n 1.1v 524.745n 1.1v 524.755n 1.1v 529.745n 1.1v 529.755n 1.1v 534.745n 1.1v 534.755n 1.1v 539.745n 1.1v 539.755n 0.0v 544.745n 0.0v 544.755n 0.0v 549.745n 0.0v 549.755n 0.0v 554.745n 0.0v 554.755n 0.0v 559.745n 0.0v 559.755n 0.0v 564.745n 0.0v 564.755n 0.0v 569.745n 0.0v 569.755n 0.0v 574.745n 0.0v 574.755n 0.0v 579.745n 0.0v 579.755n 0.0v 584.745n 0.0v 584.755n 0.0v 589.745n 0.0v 589.755n 0.0v 594.745n 0.0v 594.755n 0.0v 599.745n 0.0v 599.755n 0.0v 604.745n 0.0v 604.755n 0.0v 609.745n 0.0v 609.755n 0.0v 614.745n 0.0v 614.755n 0.0v 619.745n 0.0v 619.755n 0.0v 624.745n 0.0v 624.755n 0.0v 629.745n 0.0v 629.755n 0.0v 634.745n 0.0v 634.755n 0.0v 639.745n 0.0v 639.755n 1.1v 644.745n 1.1v 644.755n 1.1v 649.745n 1.1v 649.755n 1.1v 654.745n 1.1v 654.755n 1.1v 659.745n 1.1v 659.755n 1.1v 664.745n 1.1v 664.755n 1.1v 669.745n 1.1v 669.755n 1.1v 674.745n 1.1v 674.755n 1.1v 679.745n 1.1v 679.755n 1.1v 684.745n 1.1v 684.755n 1.1v 689.745n 1.1v 689.755n 1.1v 694.745n 1.1v 694.755n 1.1v 699.745n 1.1v 699.755n 1.1v 704.745n 1.1v 704.755n 0.0v 709.745n 0.0v 709.755n 0.0v 714.745n 0.0v 714.755n 1.1v 719.745n 1.1v 719.755n 1.1v 724.745n 1.1v 724.755n 1.1v 729.745n 1.1v 729.755n 1.1v 734.745n 1.1v 734.755n 0.0v 739.745n 0.0v 739.755n 0.0v 744.745n 0.0v 744.755n 0.0v 749.745n 0.0v 749.755n 0.0v 754.745n 0.0v 754.755n 1.1v 759.745n 1.1v 759.755n 1.1v 764.745n 1.1v 764.755n 1.1v 769.745n 1.1v 769.755n 1.1v 774.745n 1.1v 774.755n 0.0v 779.745n 0.0v 779.755n 0.0v 784.745n 0.0v 784.755n 0.0v 789.745n 0.0v 789.755n 0.0v 794.745n 0.0v 794.755n 0.0v 799.745n 0.0v 799.755n 0.0v 804.745n 0.0v 804.755n 0.0v 809.745n 0.0v 809.755n 0.0v 814.745n 0.0v 814.755n 0.0v 819.745n 0.0v 819.755n 1.1v 824.745n 1.1v 824.755n 1.1v 829.745n 1.1v 829.755n 0.0v 834.745n 0.0v 834.755n 1.1v 839.745n 1.1v 839.755n 1.1v 844.745n 1.1v 844.755n 1.1v 849.745n 1.1v 849.755n 1.1v 854.745n 1.1v 854.755n 0.0v 859.745n 0.0v 859.755n 1.1v 864.745n 1.1v 864.755n 1.1v 869.745n 1.1v 869.755n 1.1v 874.745n 1.1v 874.755n 1.1v 879.745n 1.1v 879.755n 1.1v 884.745n 1.1v 884.755n 0.0v 889.745n 0.0v 889.755n 0.0v 894.745n 0.0v 894.755n 0.0v 899.745n 0.0v 899.755n 0.0v 904.745n 0.0v 904.755n 0.0v 909.745n 0.0v 909.755n 1.1v 914.745n 1.1v 914.755n 1.1v 919.745n 1.1v 919.755n 1.1v 924.745n 1.1v 924.755n 1.1v 929.745n 1.1v 929.755n 0.0v 934.745n 0.0v 934.755n 0.0v 939.745n 0.0v 939.755n 0.0v 944.745n 0.0v 944.755n 0.0v 949.745n 0.0v 949.755n 0.0v 954.745n 0.0v 954.755n 0.0v 959.745n 0.0v 959.755n 0.0v 964.745n 0.0v 964.755n 1.1v 969.745n 1.1v 969.755n 1.1v 974.745n 1.1v 974.755n 1.1v 979.745n 1.1v 979.755n 0.0v 984.745n 0.0v 984.755n 1.1v 989.745n 1.1v 989.755n 1.1v 994.745n 1.1v 994.755n 0.0v 999.745n 0.0v 999.755n 0.0v 1004.745n 0.0v 1004.755n 0.0v 1009.745n 0.0v 1009.755n 0.0v 1014.745n 0.0v 1014.755n 0.0v 1019.745n 0.0v 1019.755n 0.0v 1024.745n 0.0v 1024.755n 0.0v )
* (time, data): [(0, 0), (5, 1), (10, 0), (15, 0), (20, 0), (25, 0), (30, 1), (35, 1), (40, 1), (45, 1), (50, 1), (55, 1), (60, 0), (65, 1), (70, 1), (75, 1), (80, 1), (85, 1), (90, 0), (95, 0), (100, 0), (105, 0), (110, 0), (115, 0), (120, 0), (125, 0), (130, 0), (135, 0), (140, 1), (145, 1), (150, 1), (155, 1), (160, 1), (165, 1), (170, 0), (175, 0), (180, 0), (185, 1), (190, 1), (195, 1), (200, 1), (205, 1), (210, 1), (215, 1), (220, 0), (225, 0), (230, 1), (235, 1), (240, 1), (245, 1), (250, 1), (255, 0), (260, 0), (265, 0), (270, 0), (275, 0), (280, 0), (285, 0), (290, 0), (295, 0), (300, 0), (305, 0), (310, 0), (315, 1), (320, 1), (325, 1), (330, 1), (335, 1), (340, 1), (345, 1), (350, 1), (355, 1), (360, 0), (365, 0), (370, 0), (375, 0), (380, 0), (385, 0), (390, 0), (395, 1), (400, 0), (405, 0), (410, 1), (415, 0), (420, 1), (425, 1), (430, 0), (435, 0), (440, 0), (445, 0), (450, 1), (455, 1), (460, 0), (465, 1), (470, 1), (475, 1), (480, 0), (485, 0), (490, 0), (495, 1), (500, 0), (505, 1), (510, 0), (515, 1), (520, 1), (525, 1), (530, 1), (535, 1), (540, 0), (545, 0), (550, 0), (555, 1), (560, 1), (565, 1), (570, 1), (575, 1), (580, 1), (585, 1), (590, 1), (595, 1), (600, 1), (605, 1), (610, 1), (615, 1), (620, 1), (625, 1), (630, 0), (635, 1), (640, 1), (645, 1), (650, 1), (655, 0), (660, 1), (665, 1), (670, 1), (675, 1), (680, 1), (685, 1), (690, 1), (695, 1), (700, 1), (705, 1), (710, 0), (715, 1), (720, 1), (725, 1), (730, 1), (735, 0), (740, 0), (745, 0), (750, 0), (755, 0), (760, 0), (765, 0), (770, 1), (775, 0), (780, 0), (785, 1), (790, 1), (795, 1), (800, 1), (805, 1), (810, 1), (815, 1), (820, 0), (825, 0), (830, 0), (835, 1), (840, 1), (845, 1), (850, 1), (855, 1), (860, 1), (865, 0), (870, 0), (875, 1), (880, 0), (885, 0), (890, 0), (895, 0), (900, 0), (905, 0), (910, 0), (915, 0), (920, 0), (925, 0), (930, 1), (935, 0), (940, 1), (945, 1), (950, 1), (955, 1), (960, 1), (965, 1), (970, 1), (975, 1), (980, 0), (985, 0), (990, 0), (995, 0), (1000, 0), (1005, 0), (1010, 0), (1015, 0), (1020, 0), (1025, 0)]
Vdin0_26  din0_26  0 PWL (0n 0.0v 4.745n 0.0v 4.755n 1.1v 9.745n 1.1v 9.755n 0.0v 14.745n 0.0v 14.755n 0.0v 19.745n 0.0v 19.755n 0.0v 24.745n 0.0v 24.755n 0.0v 29.745n 0.0v 29.755n 1.1v 34.745n 1.1v 34.755n 1.1v 39.745n 1.1v 39.755n 1.1v 44.745n 1.1v 44.755n 1.1v 49.745n 1.1v 49.755n 1.1v 54.745n 1.1v 54.755n 1.1v 59.745n 1.1v 59.755n 0.0v 64.745n 0.0v 64.755n 1.1v 69.745n 1.1v 69.755n 1.1v 74.745n 1.1v 74.755n 1.1v 79.745n 1.1v 79.755n 1.1v 84.745n 1.1v 84.755n 1.1v 89.745n 1.1v 89.755n 0.0v 94.745n 0.0v 94.755n 0.0v 99.745n 0.0v 99.755n 0.0v 104.745n 0.0v 104.755n 0.0v 109.745n 0.0v 109.755n 0.0v 114.745n 0.0v 114.755n 0.0v 119.745n 0.0v 119.755n 0.0v 124.745n 0.0v 124.755n 0.0v 129.745n 0.0v 129.755n 0.0v 134.745n 0.0v 134.755n 0.0v 139.745n 0.0v 139.755n 1.1v 144.745n 1.1v 144.755n 1.1v 149.745n 1.1v 149.755n 1.1v 154.745n 1.1v 154.755n 1.1v 159.745n 1.1v 159.755n 1.1v 164.745n 1.1v 164.755n 1.1v 169.745n 1.1v 169.755n 0.0v 174.745n 0.0v 174.755n 0.0v 179.745n 0.0v 179.755n 0.0v 184.745n 0.0v 184.755n 1.1v 189.745n 1.1v 189.755n 1.1v 194.745n 1.1v 194.755n 1.1v 199.745n 1.1v 199.755n 1.1v 204.745n 1.1v 204.755n 1.1v 209.745n 1.1v 209.755n 1.1v 214.745n 1.1v 214.755n 1.1v 219.745n 1.1v 219.755n 0.0v 224.745n 0.0v 224.755n 0.0v 229.745n 0.0v 229.755n 1.1v 234.745n 1.1v 234.755n 1.1v 239.745n 1.1v 239.755n 1.1v 244.745n 1.1v 244.755n 1.1v 249.745n 1.1v 249.755n 1.1v 254.745n 1.1v 254.755n 0.0v 259.745n 0.0v 259.755n 0.0v 264.745n 0.0v 264.755n 0.0v 269.745n 0.0v 269.755n 0.0v 274.745n 0.0v 274.755n 0.0v 279.745n 0.0v 279.755n 0.0v 284.745n 0.0v 284.755n 0.0v 289.745n 0.0v 289.755n 0.0v 294.745n 0.0v 294.755n 0.0v 299.745n 0.0v 299.755n 0.0v 304.745n 0.0v 304.755n 0.0v 309.745n 0.0v 309.755n 0.0v 314.745n 0.0v 314.755n 1.1v 319.745n 1.1v 319.755n 1.1v 324.745n 1.1v 324.755n 1.1v 329.745n 1.1v 329.755n 1.1v 334.745n 1.1v 334.755n 1.1v 339.745n 1.1v 339.755n 1.1v 344.745n 1.1v 344.755n 1.1v 349.745n 1.1v 349.755n 1.1v 354.745n 1.1v 354.755n 1.1v 359.745n 1.1v 359.755n 0.0v 364.745n 0.0v 364.755n 0.0v 369.745n 0.0v 369.755n 0.0v 374.745n 0.0v 374.755n 0.0v 379.745n 0.0v 379.755n 0.0v 384.745n 0.0v 384.755n 0.0v 389.745n 0.0v 389.755n 0.0v 394.745n 0.0v 394.755n 1.1v 399.745n 1.1v 399.755n 0.0v 404.745n 0.0v 404.755n 0.0v 409.745n 0.0v 409.755n 1.1v 414.745n 1.1v 414.755n 0.0v 419.745n 0.0v 419.755n 1.1v 424.745n 1.1v 424.755n 1.1v 429.745n 1.1v 429.755n 0.0v 434.745n 0.0v 434.755n 0.0v 439.745n 0.0v 439.755n 0.0v 444.745n 0.0v 444.755n 0.0v 449.745n 0.0v 449.755n 1.1v 454.745n 1.1v 454.755n 1.1v 459.745n 1.1v 459.755n 0.0v 464.745n 0.0v 464.755n 1.1v 469.745n 1.1v 469.755n 1.1v 474.745n 1.1v 474.755n 1.1v 479.745n 1.1v 479.755n 0.0v 484.745n 0.0v 484.755n 0.0v 489.745n 0.0v 489.755n 0.0v 494.745n 0.0v 494.755n 1.1v 499.745n 1.1v 499.755n 0.0v 504.745n 0.0v 504.755n 1.1v 509.745n 1.1v 509.755n 0.0v 514.745n 0.0v 514.755n 1.1v 519.745n 1.1v 519.755n 1.1v 524.745n 1.1v 524.755n 1.1v 529.745n 1.1v 529.755n 1.1v 534.745n 1.1v 534.755n 1.1v 539.745n 1.1v 539.755n 0.0v 544.745n 0.0v 544.755n 0.0v 549.745n 0.0v 549.755n 0.0v 554.745n 0.0v 554.755n 1.1v 559.745n 1.1v 559.755n 1.1v 564.745n 1.1v 564.755n 1.1v 569.745n 1.1v 569.755n 1.1v 574.745n 1.1v 574.755n 1.1v 579.745n 1.1v 579.755n 1.1v 584.745n 1.1v 584.755n 1.1v 589.745n 1.1v 589.755n 1.1v 594.745n 1.1v 594.755n 1.1v 599.745n 1.1v 599.755n 1.1v 604.745n 1.1v 604.755n 1.1v 609.745n 1.1v 609.755n 1.1v 614.745n 1.1v 614.755n 1.1v 619.745n 1.1v 619.755n 1.1v 624.745n 1.1v 624.755n 1.1v 629.745n 1.1v 629.755n 0.0v 634.745n 0.0v 634.755n 1.1v 639.745n 1.1v 639.755n 1.1v 644.745n 1.1v 644.755n 1.1v 649.745n 1.1v 649.755n 1.1v 654.745n 1.1v 654.755n 0.0v 659.745n 0.0v 659.755n 1.1v 664.745n 1.1v 664.755n 1.1v 669.745n 1.1v 669.755n 1.1v 674.745n 1.1v 674.755n 1.1v 679.745n 1.1v 679.755n 1.1v 684.745n 1.1v 684.755n 1.1v 689.745n 1.1v 689.755n 1.1v 694.745n 1.1v 694.755n 1.1v 699.745n 1.1v 699.755n 1.1v 704.745n 1.1v 704.755n 1.1v 709.745n 1.1v 709.755n 0.0v 714.745n 0.0v 714.755n 1.1v 719.745n 1.1v 719.755n 1.1v 724.745n 1.1v 724.755n 1.1v 729.745n 1.1v 729.755n 1.1v 734.745n 1.1v 734.755n 0.0v 739.745n 0.0v 739.755n 0.0v 744.745n 0.0v 744.755n 0.0v 749.745n 0.0v 749.755n 0.0v 754.745n 0.0v 754.755n 0.0v 759.745n 0.0v 759.755n 0.0v 764.745n 0.0v 764.755n 0.0v 769.745n 0.0v 769.755n 1.1v 774.745n 1.1v 774.755n 0.0v 779.745n 0.0v 779.755n 0.0v 784.745n 0.0v 784.755n 1.1v 789.745n 1.1v 789.755n 1.1v 794.745n 1.1v 794.755n 1.1v 799.745n 1.1v 799.755n 1.1v 804.745n 1.1v 804.755n 1.1v 809.745n 1.1v 809.755n 1.1v 814.745n 1.1v 814.755n 1.1v 819.745n 1.1v 819.755n 0.0v 824.745n 0.0v 824.755n 0.0v 829.745n 0.0v 829.755n 0.0v 834.745n 0.0v 834.755n 1.1v 839.745n 1.1v 839.755n 1.1v 844.745n 1.1v 844.755n 1.1v 849.745n 1.1v 849.755n 1.1v 854.745n 1.1v 854.755n 1.1v 859.745n 1.1v 859.755n 1.1v 864.745n 1.1v 864.755n 0.0v 869.745n 0.0v 869.755n 0.0v 874.745n 0.0v 874.755n 1.1v 879.745n 1.1v 879.755n 0.0v 884.745n 0.0v 884.755n 0.0v 889.745n 0.0v 889.755n 0.0v 894.745n 0.0v 894.755n 0.0v 899.745n 0.0v 899.755n 0.0v 904.745n 0.0v 904.755n 0.0v 909.745n 0.0v 909.755n 0.0v 914.745n 0.0v 914.755n 0.0v 919.745n 0.0v 919.755n 0.0v 924.745n 0.0v 924.755n 0.0v 929.745n 0.0v 929.755n 1.1v 934.745n 1.1v 934.755n 0.0v 939.745n 0.0v 939.755n 1.1v 944.745n 1.1v 944.755n 1.1v 949.745n 1.1v 949.755n 1.1v 954.745n 1.1v 954.755n 1.1v 959.745n 1.1v 959.755n 1.1v 964.745n 1.1v 964.755n 1.1v 969.745n 1.1v 969.755n 1.1v 974.745n 1.1v 974.755n 1.1v 979.745n 1.1v 979.755n 0.0v 984.745n 0.0v 984.755n 0.0v 989.745n 0.0v 989.755n 0.0v 994.745n 0.0v 994.755n 0.0v 999.745n 0.0v 999.755n 0.0v 1004.745n 0.0v 1004.755n 0.0v 1009.745n 0.0v 1009.755n 0.0v 1014.745n 0.0v 1014.755n 0.0v 1019.745n 0.0v 1019.755n 0.0v 1024.745n 0.0v 1024.755n 0.0v )
* (time, data): [(0, 0), (5, 1), (10, 1), (15, 1), (20, 1), (25, 1), (30, 0), (35, 0), (40, 1), (45, 0), (50, 0), (55, 0), (60, 0), (65, 1), (70, 1), (75, 1), (80, 1), (85, 1), (90, 0), (95, 0), (100, 1), (105, 1), (110, 1), (115, 1), (120, 1), (125, 1), (130, 1), (135, 1), (140, 0), (145, 0), (150, 0), (155, 0), (160, 0), (165, 0), (170, 0), (175, 0), (180, 0), (185, 0), (190, 0), (195, 0), (200, 1), (205, 1), (210, 1), (215, 1), (220, 0), (225, 0), (230, 0), (235, 0), (240, 1), (245, 1), (250, 1), (255, 0), (260, 0), (265, 1), (270, 1), (275, 1), (280, 1), (285, 1), (290, 1), (295, 1), (300, 0), (305, 0), (310, 0), (315, 0), (320, 0), (325, 0), (330, 1), (335, 1), (340, 0), (345, 0), (350, 0), (355, 0), (360, 0), (365, 0), (370, 0), (375, 0), (380, 0), (385, 0), (390, 0), (395, 0), (400, 0), (405, 0), (410, 0), (415, 1), (420, 0), (425, 1), (430, 0), (435, 0), (440, 0), (445, 0), (450, 0), (455, 0), (460, 0), (465, 1), (470, 0), (475, 0), (480, 1), (485, 1), (490, 1), (495, 1), (500, 0), (505, 1), (510, 0), (515, 0), (520, 0), (525, 0), (530, 0), (535, 1), (540, 1), (545, 1), (550, 1), (555, 0), (560, 0), (565, 0), (570, 0), (575, 1), (580, 1), (585, 1), (590, 1), (595, 1), (600, 1), (605, 1), (610, 1), (615, 1), (620, 1), (625, 1), (630, 0), (635, 1), (640, 1), (645, 1), (650, 1), (655, 1), (660, 1), (665, 1), (670, 0), (675, 0), (680, 0), (685, 0), (690, 0), (695, 0), (700, 0), (705, 1), (710, 0), (715, 0), (720, 0), (725, 0), (730, 0), (735, 0), (740, 0), (745, 0), (750, 0), (755, 0), (760, 0), (765, 0), (770, 0), (775, 0), (780, 0), (785, 1), (790, 1), (795, 1), (800, 1), (805, 1), (810, 1), (815, 1), (820, 0), (825, 0), (830, 0), (835, 0), (840, 0), (845, 0), (850, 0), (855, 0), (860, 0), (865, 0), (870, 0), (875, 1), (880, 0), (885, 0), (890, 0), (895, 0), (900, 0), (905, 0), (910, 1), (915, 1), (920, 1), (925, 1), (930, 0), (935, 1), (940, 1), (945, 1), (950, 1), (955, 1), (960, 1), (965, 1), (970, 1), (975, 1), (980, 0), (985, 1), (990, 1), (995, 0), (1000, 1), (1005, 1), (1010, 1), (1015, 1), (1020, 1), (1025, 1)]
Vdin0_27  din0_27  0 PWL (0n 0.0v 4.745n 0.0v 4.755n 1.1v 9.745n 1.1v 9.755n 1.1v 14.745n 1.1v 14.755n 1.1v 19.745n 1.1v 19.755n 1.1v 24.745n 1.1v 24.755n 1.1v 29.745n 1.1v 29.755n 0.0v 34.745n 0.0v 34.755n 0.0v 39.745n 0.0v 39.755n 1.1v 44.745n 1.1v 44.755n 0.0v 49.745n 0.0v 49.755n 0.0v 54.745n 0.0v 54.755n 0.0v 59.745n 0.0v 59.755n 0.0v 64.745n 0.0v 64.755n 1.1v 69.745n 1.1v 69.755n 1.1v 74.745n 1.1v 74.755n 1.1v 79.745n 1.1v 79.755n 1.1v 84.745n 1.1v 84.755n 1.1v 89.745n 1.1v 89.755n 0.0v 94.745n 0.0v 94.755n 0.0v 99.745n 0.0v 99.755n 1.1v 104.745n 1.1v 104.755n 1.1v 109.745n 1.1v 109.755n 1.1v 114.745n 1.1v 114.755n 1.1v 119.745n 1.1v 119.755n 1.1v 124.745n 1.1v 124.755n 1.1v 129.745n 1.1v 129.755n 1.1v 134.745n 1.1v 134.755n 1.1v 139.745n 1.1v 139.755n 0.0v 144.745n 0.0v 144.755n 0.0v 149.745n 0.0v 149.755n 0.0v 154.745n 0.0v 154.755n 0.0v 159.745n 0.0v 159.755n 0.0v 164.745n 0.0v 164.755n 0.0v 169.745n 0.0v 169.755n 0.0v 174.745n 0.0v 174.755n 0.0v 179.745n 0.0v 179.755n 0.0v 184.745n 0.0v 184.755n 0.0v 189.745n 0.0v 189.755n 0.0v 194.745n 0.0v 194.755n 0.0v 199.745n 0.0v 199.755n 1.1v 204.745n 1.1v 204.755n 1.1v 209.745n 1.1v 209.755n 1.1v 214.745n 1.1v 214.755n 1.1v 219.745n 1.1v 219.755n 0.0v 224.745n 0.0v 224.755n 0.0v 229.745n 0.0v 229.755n 0.0v 234.745n 0.0v 234.755n 0.0v 239.745n 0.0v 239.755n 1.1v 244.745n 1.1v 244.755n 1.1v 249.745n 1.1v 249.755n 1.1v 254.745n 1.1v 254.755n 0.0v 259.745n 0.0v 259.755n 0.0v 264.745n 0.0v 264.755n 1.1v 269.745n 1.1v 269.755n 1.1v 274.745n 1.1v 274.755n 1.1v 279.745n 1.1v 279.755n 1.1v 284.745n 1.1v 284.755n 1.1v 289.745n 1.1v 289.755n 1.1v 294.745n 1.1v 294.755n 1.1v 299.745n 1.1v 299.755n 0.0v 304.745n 0.0v 304.755n 0.0v 309.745n 0.0v 309.755n 0.0v 314.745n 0.0v 314.755n 0.0v 319.745n 0.0v 319.755n 0.0v 324.745n 0.0v 324.755n 0.0v 329.745n 0.0v 329.755n 1.1v 334.745n 1.1v 334.755n 1.1v 339.745n 1.1v 339.755n 0.0v 344.745n 0.0v 344.755n 0.0v 349.745n 0.0v 349.755n 0.0v 354.745n 0.0v 354.755n 0.0v 359.745n 0.0v 359.755n 0.0v 364.745n 0.0v 364.755n 0.0v 369.745n 0.0v 369.755n 0.0v 374.745n 0.0v 374.755n 0.0v 379.745n 0.0v 379.755n 0.0v 384.745n 0.0v 384.755n 0.0v 389.745n 0.0v 389.755n 0.0v 394.745n 0.0v 394.755n 0.0v 399.745n 0.0v 399.755n 0.0v 404.745n 0.0v 404.755n 0.0v 409.745n 0.0v 409.755n 0.0v 414.745n 0.0v 414.755n 1.1v 419.745n 1.1v 419.755n 0.0v 424.745n 0.0v 424.755n 1.1v 429.745n 1.1v 429.755n 0.0v 434.745n 0.0v 434.755n 0.0v 439.745n 0.0v 439.755n 0.0v 444.745n 0.0v 444.755n 0.0v 449.745n 0.0v 449.755n 0.0v 454.745n 0.0v 454.755n 0.0v 459.745n 0.0v 459.755n 0.0v 464.745n 0.0v 464.755n 1.1v 469.745n 1.1v 469.755n 0.0v 474.745n 0.0v 474.755n 0.0v 479.745n 0.0v 479.755n 1.1v 484.745n 1.1v 484.755n 1.1v 489.745n 1.1v 489.755n 1.1v 494.745n 1.1v 494.755n 1.1v 499.745n 1.1v 499.755n 0.0v 504.745n 0.0v 504.755n 1.1v 509.745n 1.1v 509.755n 0.0v 514.745n 0.0v 514.755n 0.0v 519.745n 0.0v 519.755n 0.0v 524.745n 0.0v 524.755n 0.0v 529.745n 0.0v 529.755n 0.0v 534.745n 0.0v 534.755n 1.1v 539.745n 1.1v 539.755n 1.1v 544.745n 1.1v 544.755n 1.1v 549.745n 1.1v 549.755n 1.1v 554.745n 1.1v 554.755n 0.0v 559.745n 0.0v 559.755n 0.0v 564.745n 0.0v 564.755n 0.0v 569.745n 0.0v 569.755n 0.0v 574.745n 0.0v 574.755n 1.1v 579.745n 1.1v 579.755n 1.1v 584.745n 1.1v 584.755n 1.1v 589.745n 1.1v 589.755n 1.1v 594.745n 1.1v 594.755n 1.1v 599.745n 1.1v 599.755n 1.1v 604.745n 1.1v 604.755n 1.1v 609.745n 1.1v 609.755n 1.1v 614.745n 1.1v 614.755n 1.1v 619.745n 1.1v 619.755n 1.1v 624.745n 1.1v 624.755n 1.1v 629.745n 1.1v 629.755n 0.0v 634.745n 0.0v 634.755n 1.1v 639.745n 1.1v 639.755n 1.1v 644.745n 1.1v 644.755n 1.1v 649.745n 1.1v 649.755n 1.1v 654.745n 1.1v 654.755n 1.1v 659.745n 1.1v 659.755n 1.1v 664.745n 1.1v 664.755n 1.1v 669.745n 1.1v 669.755n 0.0v 674.745n 0.0v 674.755n 0.0v 679.745n 0.0v 679.755n 0.0v 684.745n 0.0v 684.755n 0.0v 689.745n 0.0v 689.755n 0.0v 694.745n 0.0v 694.755n 0.0v 699.745n 0.0v 699.755n 0.0v 704.745n 0.0v 704.755n 1.1v 709.745n 1.1v 709.755n 0.0v 714.745n 0.0v 714.755n 0.0v 719.745n 0.0v 719.755n 0.0v 724.745n 0.0v 724.755n 0.0v 729.745n 0.0v 729.755n 0.0v 734.745n 0.0v 734.755n 0.0v 739.745n 0.0v 739.755n 0.0v 744.745n 0.0v 744.755n 0.0v 749.745n 0.0v 749.755n 0.0v 754.745n 0.0v 754.755n 0.0v 759.745n 0.0v 759.755n 0.0v 764.745n 0.0v 764.755n 0.0v 769.745n 0.0v 769.755n 0.0v 774.745n 0.0v 774.755n 0.0v 779.745n 0.0v 779.755n 0.0v 784.745n 0.0v 784.755n 1.1v 789.745n 1.1v 789.755n 1.1v 794.745n 1.1v 794.755n 1.1v 799.745n 1.1v 799.755n 1.1v 804.745n 1.1v 804.755n 1.1v 809.745n 1.1v 809.755n 1.1v 814.745n 1.1v 814.755n 1.1v 819.745n 1.1v 819.755n 0.0v 824.745n 0.0v 824.755n 0.0v 829.745n 0.0v 829.755n 0.0v 834.745n 0.0v 834.755n 0.0v 839.745n 0.0v 839.755n 0.0v 844.745n 0.0v 844.755n 0.0v 849.745n 0.0v 849.755n 0.0v 854.745n 0.0v 854.755n 0.0v 859.745n 0.0v 859.755n 0.0v 864.745n 0.0v 864.755n 0.0v 869.745n 0.0v 869.755n 0.0v 874.745n 0.0v 874.755n 1.1v 879.745n 1.1v 879.755n 0.0v 884.745n 0.0v 884.755n 0.0v 889.745n 0.0v 889.755n 0.0v 894.745n 0.0v 894.755n 0.0v 899.745n 0.0v 899.755n 0.0v 904.745n 0.0v 904.755n 0.0v 909.745n 0.0v 909.755n 1.1v 914.745n 1.1v 914.755n 1.1v 919.745n 1.1v 919.755n 1.1v 924.745n 1.1v 924.755n 1.1v 929.745n 1.1v 929.755n 0.0v 934.745n 0.0v 934.755n 1.1v 939.745n 1.1v 939.755n 1.1v 944.745n 1.1v 944.755n 1.1v 949.745n 1.1v 949.755n 1.1v 954.745n 1.1v 954.755n 1.1v 959.745n 1.1v 959.755n 1.1v 964.745n 1.1v 964.755n 1.1v 969.745n 1.1v 969.755n 1.1v 974.745n 1.1v 974.755n 1.1v 979.745n 1.1v 979.755n 0.0v 984.745n 0.0v 984.755n 1.1v 989.745n 1.1v 989.755n 1.1v 994.745n 1.1v 994.755n 0.0v 999.745n 0.0v 999.755n 1.1v 1004.745n 1.1v 1004.755n 1.1v 1009.745n 1.1v 1009.755n 1.1v 1014.745n 1.1v 1014.755n 1.1v 1019.745n 1.1v 1019.755n 1.1v 1024.745n 1.1v 1024.755n 1.1v )
* (time, data): [(0, 0), (5, 0), (10, 0), (15, 1), (20, 1), (25, 1), (30, 1), (35, 1), (40, 0), (45, 1), (50, 1), (55, 1), (60, 1), (65, 1), (70, 1), (75, 1), (80, 1), (85, 1), (90, 1), (95, 1), (100, 1), (105, 1), (110, 1), (115, 1), (120, 1), (125, 1), (130, 1), (135, 0), (140, 0), (145, 0), (150, 0), (155, 0), (160, 0), (165, 0), (170, 0), (175, 0), (180, 0), (185, 0), (190, 0), (195, 0), (200, 1), (205, 1), (210, 1), (215, 1), (220, 0), (225, 0), (230, 1), (235, 1), (240, 0), (245, 0), (250, 0), (255, 1), (260, 1), (265, 0), (270, 0), (275, 0), (280, 0), (285, 0), (290, 0), (295, 0), (300, 0), (305, 0), (310, 0), (315, 0), (320, 0), (325, 0), (330, 1), (335, 0), (340, 0), (345, 0), (350, 0), (355, 0), (360, 0), (365, 0), (370, 0), (375, 0), (380, 0), (385, 0), (390, 0), (395, 1), (400, 0), (405, 0), (410, 1), (415, 1), (420, 0), (425, 0), (430, 1), (435, 1), (440, 1), (445, 1), (450, 1), (455, 1), (460, 1), (465, 0), (470, 0), (475, 0), (480, 1), (485, 1), (490, 1), (495, 0), (500, 0), (505, 0), (510, 0), (515, 1), (520, 1), (525, 1), (530, 1), (535, 0), (540, 0), (545, 0), (550, 0), (555, 1), (560, 1), (565, 1), (570, 1), (575, 1), (580, 1), (585, 1), (590, 1), (595, 1), (600, 1), (605, 1), (610, 1), (615, 1), (620, 1), (625, 1), (630, 0), (635, 1), (640, 1), (645, 1), (650, 1), (655, 1), (660, 0), (665, 0), (670, 0), (675, 0), (680, 0), (685, 0), (690, 0), (695, 0), (700, 0), (705, 1), (710, 1), (715, 0), (720, 0), (725, 0), (730, 0), (735, 0), (740, 1), (745, 1), (750, 1), (755, 1), (760, 1), (765, 1), (770, 0), (775, 0), (780, 0), (785, 1), (790, 0), (795, 0), (800, 0), (805, 0), (810, 0), (815, 0), (820, 0), (825, 0), (830, 1), (835, 0), (840, 0), (845, 0), (850, 0), (855, 0), (860, 0), (865, 1), (870, 0), (875, 0), (880, 0), (885, 0), (890, 0), (895, 0), (900, 0), (905, 0), (910, 0), (915, 0), (920, 0), (925, 0), (930, 1), (935, 1), (940, 1), (945, 1), (950, 1), (955, 1), (960, 1), (965, 1), (970, 1), (975, 1), (980, 0), (985, 0), (990, 0), (995, 0), (1000, 0), (1005, 0), (1010, 0), (1015, 0), (1020, 0), (1025, 0)]
Vdin0_28  din0_28  0 PWL (0n 0.0v 4.745n 0.0v 4.755n 0.0v 9.745n 0.0v 9.755n 0.0v 14.745n 0.0v 14.755n 1.1v 19.745n 1.1v 19.755n 1.1v 24.745n 1.1v 24.755n 1.1v 29.745n 1.1v 29.755n 1.1v 34.745n 1.1v 34.755n 1.1v 39.745n 1.1v 39.755n 0.0v 44.745n 0.0v 44.755n 1.1v 49.745n 1.1v 49.755n 1.1v 54.745n 1.1v 54.755n 1.1v 59.745n 1.1v 59.755n 1.1v 64.745n 1.1v 64.755n 1.1v 69.745n 1.1v 69.755n 1.1v 74.745n 1.1v 74.755n 1.1v 79.745n 1.1v 79.755n 1.1v 84.745n 1.1v 84.755n 1.1v 89.745n 1.1v 89.755n 1.1v 94.745n 1.1v 94.755n 1.1v 99.745n 1.1v 99.755n 1.1v 104.745n 1.1v 104.755n 1.1v 109.745n 1.1v 109.755n 1.1v 114.745n 1.1v 114.755n 1.1v 119.745n 1.1v 119.755n 1.1v 124.745n 1.1v 124.755n 1.1v 129.745n 1.1v 129.755n 1.1v 134.745n 1.1v 134.755n 0.0v 139.745n 0.0v 139.755n 0.0v 144.745n 0.0v 144.755n 0.0v 149.745n 0.0v 149.755n 0.0v 154.745n 0.0v 154.755n 0.0v 159.745n 0.0v 159.755n 0.0v 164.745n 0.0v 164.755n 0.0v 169.745n 0.0v 169.755n 0.0v 174.745n 0.0v 174.755n 0.0v 179.745n 0.0v 179.755n 0.0v 184.745n 0.0v 184.755n 0.0v 189.745n 0.0v 189.755n 0.0v 194.745n 0.0v 194.755n 0.0v 199.745n 0.0v 199.755n 1.1v 204.745n 1.1v 204.755n 1.1v 209.745n 1.1v 209.755n 1.1v 214.745n 1.1v 214.755n 1.1v 219.745n 1.1v 219.755n 0.0v 224.745n 0.0v 224.755n 0.0v 229.745n 0.0v 229.755n 1.1v 234.745n 1.1v 234.755n 1.1v 239.745n 1.1v 239.755n 0.0v 244.745n 0.0v 244.755n 0.0v 249.745n 0.0v 249.755n 0.0v 254.745n 0.0v 254.755n 1.1v 259.745n 1.1v 259.755n 1.1v 264.745n 1.1v 264.755n 0.0v 269.745n 0.0v 269.755n 0.0v 274.745n 0.0v 274.755n 0.0v 279.745n 0.0v 279.755n 0.0v 284.745n 0.0v 284.755n 0.0v 289.745n 0.0v 289.755n 0.0v 294.745n 0.0v 294.755n 0.0v 299.745n 0.0v 299.755n 0.0v 304.745n 0.0v 304.755n 0.0v 309.745n 0.0v 309.755n 0.0v 314.745n 0.0v 314.755n 0.0v 319.745n 0.0v 319.755n 0.0v 324.745n 0.0v 324.755n 0.0v 329.745n 0.0v 329.755n 1.1v 334.745n 1.1v 334.755n 0.0v 339.745n 0.0v 339.755n 0.0v 344.745n 0.0v 344.755n 0.0v 349.745n 0.0v 349.755n 0.0v 354.745n 0.0v 354.755n 0.0v 359.745n 0.0v 359.755n 0.0v 364.745n 0.0v 364.755n 0.0v 369.745n 0.0v 369.755n 0.0v 374.745n 0.0v 374.755n 0.0v 379.745n 0.0v 379.755n 0.0v 384.745n 0.0v 384.755n 0.0v 389.745n 0.0v 389.755n 0.0v 394.745n 0.0v 394.755n 1.1v 399.745n 1.1v 399.755n 0.0v 404.745n 0.0v 404.755n 0.0v 409.745n 0.0v 409.755n 1.1v 414.745n 1.1v 414.755n 1.1v 419.745n 1.1v 419.755n 0.0v 424.745n 0.0v 424.755n 0.0v 429.745n 0.0v 429.755n 1.1v 434.745n 1.1v 434.755n 1.1v 439.745n 1.1v 439.755n 1.1v 444.745n 1.1v 444.755n 1.1v 449.745n 1.1v 449.755n 1.1v 454.745n 1.1v 454.755n 1.1v 459.745n 1.1v 459.755n 1.1v 464.745n 1.1v 464.755n 0.0v 469.745n 0.0v 469.755n 0.0v 474.745n 0.0v 474.755n 0.0v 479.745n 0.0v 479.755n 1.1v 484.745n 1.1v 484.755n 1.1v 489.745n 1.1v 489.755n 1.1v 494.745n 1.1v 494.755n 0.0v 499.745n 0.0v 499.755n 0.0v 504.745n 0.0v 504.755n 0.0v 509.745n 0.0v 509.755n 0.0v 514.745n 0.0v 514.755n 1.1v 519.745n 1.1v 519.755n 1.1v 524.745n 1.1v 524.755n 1.1v 529.745n 1.1v 529.755n 1.1v 534.745n 1.1v 534.755n 0.0v 539.745n 0.0v 539.755n 0.0v 544.745n 0.0v 544.755n 0.0v 549.745n 0.0v 549.755n 0.0v 554.745n 0.0v 554.755n 1.1v 559.745n 1.1v 559.755n 1.1v 564.745n 1.1v 564.755n 1.1v 569.745n 1.1v 569.755n 1.1v 574.745n 1.1v 574.755n 1.1v 579.745n 1.1v 579.755n 1.1v 584.745n 1.1v 584.755n 1.1v 589.745n 1.1v 589.755n 1.1v 594.745n 1.1v 594.755n 1.1v 599.745n 1.1v 599.755n 1.1v 604.745n 1.1v 604.755n 1.1v 609.745n 1.1v 609.755n 1.1v 614.745n 1.1v 614.755n 1.1v 619.745n 1.1v 619.755n 1.1v 624.745n 1.1v 624.755n 1.1v 629.745n 1.1v 629.755n 0.0v 634.745n 0.0v 634.755n 1.1v 639.745n 1.1v 639.755n 1.1v 644.745n 1.1v 644.755n 1.1v 649.745n 1.1v 649.755n 1.1v 654.745n 1.1v 654.755n 1.1v 659.745n 1.1v 659.755n 0.0v 664.745n 0.0v 664.755n 0.0v 669.745n 0.0v 669.755n 0.0v 674.745n 0.0v 674.755n 0.0v 679.745n 0.0v 679.755n 0.0v 684.745n 0.0v 684.755n 0.0v 689.745n 0.0v 689.755n 0.0v 694.745n 0.0v 694.755n 0.0v 699.745n 0.0v 699.755n 0.0v 704.745n 0.0v 704.755n 1.1v 709.745n 1.1v 709.755n 1.1v 714.745n 1.1v 714.755n 0.0v 719.745n 0.0v 719.755n 0.0v 724.745n 0.0v 724.755n 0.0v 729.745n 0.0v 729.755n 0.0v 734.745n 0.0v 734.755n 0.0v 739.745n 0.0v 739.755n 1.1v 744.745n 1.1v 744.755n 1.1v 749.745n 1.1v 749.755n 1.1v 754.745n 1.1v 754.755n 1.1v 759.745n 1.1v 759.755n 1.1v 764.745n 1.1v 764.755n 1.1v 769.745n 1.1v 769.755n 0.0v 774.745n 0.0v 774.755n 0.0v 779.745n 0.0v 779.755n 0.0v 784.745n 0.0v 784.755n 1.1v 789.745n 1.1v 789.755n 0.0v 794.745n 0.0v 794.755n 0.0v 799.745n 0.0v 799.755n 0.0v 804.745n 0.0v 804.755n 0.0v 809.745n 0.0v 809.755n 0.0v 814.745n 0.0v 814.755n 0.0v 819.745n 0.0v 819.755n 0.0v 824.745n 0.0v 824.755n 0.0v 829.745n 0.0v 829.755n 1.1v 834.745n 1.1v 834.755n 0.0v 839.745n 0.0v 839.755n 0.0v 844.745n 0.0v 844.755n 0.0v 849.745n 0.0v 849.755n 0.0v 854.745n 0.0v 854.755n 0.0v 859.745n 0.0v 859.755n 0.0v 864.745n 0.0v 864.755n 1.1v 869.745n 1.1v 869.755n 0.0v 874.745n 0.0v 874.755n 0.0v 879.745n 0.0v 879.755n 0.0v 884.745n 0.0v 884.755n 0.0v 889.745n 0.0v 889.755n 0.0v 894.745n 0.0v 894.755n 0.0v 899.745n 0.0v 899.755n 0.0v 904.745n 0.0v 904.755n 0.0v 909.745n 0.0v 909.755n 0.0v 914.745n 0.0v 914.755n 0.0v 919.745n 0.0v 919.755n 0.0v 924.745n 0.0v 924.755n 0.0v 929.745n 0.0v 929.755n 1.1v 934.745n 1.1v 934.755n 1.1v 939.745n 1.1v 939.755n 1.1v 944.745n 1.1v 944.755n 1.1v 949.745n 1.1v 949.755n 1.1v 954.745n 1.1v 954.755n 1.1v 959.745n 1.1v 959.755n 1.1v 964.745n 1.1v 964.755n 1.1v 969.745n 1.1v 969.755n 1.1v 974.745n 1.1v 974.755n 1.1v 979.745n 1.1v 979.755n 0.0v 984.745n 0.0v 984.755n 0.0v 989.745n 0.0v 989.755n 0.0v 994.745n 0.0v 994.755n 0.0v 999.745n 0.0v 999.755n 0.0v 1004.745n 0.0v 1004.755n 0.0v 1009.745n 0.0v 1009.755n 0.0v 1014.745n 0.0v 1014.755n 0.0v 1019.745n 0.0v 1019.755n 0.0v 1024.745n 0.0v 1024.755n 0.0v )
* (time, data): [(0, 0), (5, 1), (10, 1), (15, 1), (20, 1), (25, 1), (30, 1), (35, 1), (40, 0), (45, 1), (50, 1), (55, 1), (60, 0), (65, 0), (70, 0), (75, 0), (80, 0), (85, 0), (90, 0), (95, 0), (100, 0), (105, 0), (110, 0), (115, 0), (120, 0), (125, 0), (130, 0), (135, 1), (140, 1), (145, 1), (150, 1), (155, 1), (160, 1), (165, 1), (170, 0), (175, 0), (180, 0), (185, 0), (190, 0), (195, 0), (200, 1), (205, 1), (210, 1), (215, 1), (220, 0), (225, 0), (230, 0), (235, 0), (240, 1), (245, 1), (250, 1), (255, 0), (260, 0), (265, 0), (270, 0), (275, 0), (280, 1), (285, 1), (290, 1), (295, 1), (300, 0), (305, 0), (310, 0), (315, 0), (320, 0), (325, 0), (330, 1), (335, 0), (340, 0), (345, 0), (350, 0), (355, 0), (360, 1), (365, 1), (370, 1), (375, 1), (380, 1), (385, 1), (390, 1), (395, 0), (400, 1), (405, 1), (410, 0), (415, 0), (420, 1), (425, 1), (430, 0), (435, 0), (440, 0), (445, 0), (450, 1), (455, 1), (460, 0), (465, 1), (470, 1), (475, 1), (480, 1), (485, 1), (490, 1), (495, 1), (500, 1), (505, 1), (510, 0), (515, 0), (520, 0), (525, 0), (530, 0), (535, 1), (540, 0), (545, 0), (550, 0), (555, 1), (560, 1), (565, 1), (570, 1), (575, 1), (580, 1), (585, 1), (590, 1), (595, 1), (600, 1), (605, 1), (610, 1), (615, 1), (620, 1), (625, 1), (630, 1), (635, 0), (640, 1), (645, 1), (650, 1), (655, 0), (660, 1), (665, 1), (670, 1), (675, 1), (680, 1), (685, 1), (690, 1), (695, 1), (700, 1), (705, 1), (710, 1), (715, 0), (720, 0), (725, 0), (730, 0), (735, 1), (740, 0), (745, 0), (750, 0), (755, 1), (760, 1), (765, 1), (770, 0), (775, 1), (780, 1), (785, 1), (790, 0), (795, 0), (800, 0), (805, 0), (810, 0), (815, 0), (820, 0), (825, 0), (830, 1), (835, 0), (840, 0), (845, 0), (850, 0), (855, 0), (860, 1), (865, 1), (870, 1), (875, 1), (880, 1), (885, 0), (890, 0), (895, 0), (900, 0), (905, 0), (910, 1), (915, 1), (920, 1), (925, 1), (930, 1), (935, 0), (940, 0), (945, 0), (950, 0), (955, 1), (960, 1), (965, 0), (970, 0), (975, 0), (980, 0), (985, 0), (990, 0), (995, 0), (1000, 1), (1005, 1), (1010, 1), (1015, 1), (1020, 1), (1025, 1)]
Vdin0_29  din0_29  0 PWL (0n 0.0v 4.745n 0.0v 4.755n 1.1v 9.745n 1.1v 9.755n 1.1v 14.745n 1.1v 14.755n 1.1v 19.745n 1.1v 19.755n 1.1v 24.745n 1.1v 24.755n 1.1v 29.745n 1.1v 29.755n 1.1v 34.745n 1.1v 34.755n 1.1v 39.745n 1.1v 39.755n 0.0v 44.745n 0.0v 44.755n 1.1v 49.745n 1.1v 49.755n 1.1v 54.745n 1.1v 54.755n 1.1v 59.745n 1.1v 59.755n 0.0v 64.745n 0.0v 64.755n 0.0v 69.745n 0.0v 69.755n 0.0v 74.745n 0.0v 74.755n 0.0v 79.745n 0.0v 79.755n 0.0v 84.745n 0.0v 84.755n 0.0v 89.745n 0.0v 89.755n 0.0v 94.745n 0.0v 94.755n 0.0v 99.745n 0.0v 99.755n 0.0v 104.745n 0.0v 104.755n 0.0v 109.745n 0.0v 109.755n 0.0v 114.745n 0.0v 114.755n 0.0v 119.745n 0.0v 119.755n 0.0v 124.745n 0.0v 124.755n 0.0v 129.745n 0.0v 129.755n 0.0v 134.745n 0.0v 134.755n 1.1v 139.745n 1.1v 139.755n 1.1v 144.745n 1.1v 144.755n 1.1v 149.745n 1.1v 149.755n 1.1v 154.745n 1.1v 154.755n 1.1v 159.745n 1.1v 159.755n 1.1v 164.745n 1.1v 164.755n 1.1v 169.745n 1.1v 169.755n 0.0v 174.745n 0.0v 174.755n 0.0v 179.745n 0.0v 179.755n 0.0v 184.745n 0.0v 184.755n 0.0v 189.745n 0.0v 189.755n 0.0v 194.745n 0.0v 194.755n 0.0v 199.745n 0.0v 199.755n 1.1v 204.745n 1.1v 204.755n 1.1v 209.745n 1.1v 209.755n 1.1v 214.745n 1.1v 214.755n 1.1v 219.745n 1.1v 219.755n 0.0v 224.745n 0.0v 224.755n 0.0v 229.745n 0.0v 229.755n 0.0v 234.745n 0.0v 234.755n 0.0v 239.745n 0.0v 239.755n 1.1v 244.745n 1.1v 244.755n 1.1v 249.745n 1.1v 249.755n 1.1v 254.745n 1.1v 254.755n 0.0v 259.745n 0.0v 259.755n 0.0v 264.745n 0.0v 264.755n 0.0v 269.745n 0.0v 269.755n 0.0v 274.745n 0.0v 274.755n 0.0v 279.745n 0.0v 279.755n 1.1v 284.745n 1.1v 284.755n 1.1v 289.745n 1.1v 289.755n 1.1v 294.745n 1.1v 294.755n 1.1v 299.745n 1.1v 299.755n 0.0v 304.745n 0.0v 304.755n 0.0v 309.745n 0.0v 309.755n 0.0v 314.745n 0.0v 314.755n 0.0v 319.745n 0.0v 319.755n 0.0v 324.745n 0.0v 324.755n 0.0v 329.745n 0.0v 329.755n 1.1v 334.745n 1.1v 334.755n 0.0v 339.745n 0.0v 339.755n 0.0v 344.745n 0.0v 344.755n 0.0v 349.745n 0.0v 349.755n 0.0v 354.745n 0.0v 354.755n 0.0v 359.745n 0.0v 359.755n 1.1v 364.745n 1.1v 364.755n 1.1v 369.745n 1.1v 369.755n 1.1v 374.745n 1.1v 374.755n 1.1v 379.745n 1.1v 379.755n 1.1v 384.745n 1.1v 384.755n 1.1v 389.745n 1.1v 389.755n 1.1v 394.745n 1.1v 394.755n 0.0v 399.745n 0.0v 399.755n 1.1v 404.745n 1.1v 404.755n 1.1v 409.745n 1.1v 409.755n 0.0v 414.745n 0.0v 414.755n 0.0v 419.745n 0.0v 419.755n 1.1v 424.745n 1.1v 424.755n 1.1v 429.745n 1.1v 429.755n 0.0v 434.745n 0.0v 434.755n 0.0v 439.745n 0.0v 439.755n 0.0v 444.745n 0.0v 444.755n 0.0v 449.745n 0.0v 449.755n 1.1v 454.745n 1.1v 454.755n 1.1v 459.745n 1.1v 459.755n 0.0v 464.745n 0.0v 464.755n 1.1v 469.745n 1.1v 469.755n 1.1v 474.745n 1.1v 474.755n 1.1v 479.745n 1.1v 479.755n 1.1v 484.745n 1.1v 484.755n 1.1v 489.745n 1.1v 489.755n 1.1v 494.745n 1.1v 494.755n 1.1v 499.745n 1.1v 499.755n 1.1v 504.745n 1.1v 504.755n 1.1v 509.745n 1.1v 509.755n 0.0v 514.745n 0.0v 514.755n 0.0v 519.745n 0.0v 519.755n 0.0v 524.745n 0.0v 524.755n 0.0v 529.745n 0.0v 529.755n 0.0v 534.745n 0.0v 534.755n 1.1v 539.745n 1.1v 539.755n 0.0v 544.745n 0.0v 544.755n 0.0v 549.745n 0.0v 549.755n 0.0v 554.745n 0.0v 554.755n 1.1v 559.745n 1.1v 559.755n 1.1v 564.745n 1.1v 564.755n 1.1v 569.745n 1.1v 569.755n 1.1v 574.745n 1.1v 574.755n 1.1v 579.745n 1.1v 579.755n 1.1v 584.745n 1.1v 584.755n 1.1v 589.745n 1.1v 589.755n 1.1v 594.745n 1.1v 594.755n 1.1v 599.745n 1.1v 599.755n 1.1v 604.745n 1.1v 604.755n 1.1v 609.745n 1.1v 609.755n 1.1v 614.745n 1.1v 614.755n 1.1v 619.745n 1.1v 619.755n 1.1v 624.745n 1.1v 624.755n 1.1v 629.745n 1.1v 629.755n 1.1v 634.745n 1.1v 634.755n 0.0v 639.745n 0.0v 639.755n 1.1v 644.745n 1.1v 644.755n 1.1v 649.745n 1.1v 649.755n 1.1v 654.745n 1.1v 654.755n 0.0v 659.745n 0.0v 659.755n 1.1v 664.745n 1.1v 664.755n 1.1v 669.745n 1.1v 669.755n 1.1v 674.745n 1.1v 674.755n 1.1v 679.745n 1.1v 679.755n 1.1v 684.745n 1.1v 684.755n 1.1v 689.745n 1.1v 689.755n 1.1v 694.745n 1.1v 694.755n 1.1v 699.745n 1.1v 699.755n 1.1v 704.745n 1.1v 704.755n 1.1v 709.745n 1.1v 709.755n 1.1v 714.745n 1.1v 714.755n 0.0v 719.745n 0.0v 719.755n 0.0v 724.745n 0.0v 724.755n 0.0v 729.745n 0.0v 729.755n 0.0v 734.745n 0.0v 734.755n 1.1v 739.745n 1.1v 739.755n 0.0v 744.745n 0.0v 744.755n 0.0v 749.745n 0.0v 749.755n 0.0v 754.745n 0.0v 754.755n 1.1v 759.745n 1.1v 759.755n 1.1v 764.745n 1.1v 764.755n 1.1v 769.745n 1.1v 769.755n 0.0v 774.745n 0.0v 774.755n 1.1v 779.745n 1.1v 779.755n 1.1v 784.745n 1.1v 784.755n 1.1v 789.745n 1.1v 789.755n 0.0v 794.745n 0.0v 794.755n 0.0v 799.745n 0.0v 799.755n 0.0v 804.745n 0.0v 804.755n 0.0v 809.745n 0.0v 809.755n 0.0v 814.745n 0.0v 814.755n 0.0v 819.745n 0.0v 819.755n 0.0v 824.745n 0.0v 824.755n 0.0v 829.745n 0.0v 829.755n 1.1v 834.745n 1.1v 834.755n 0.0v 839.745n 0.0v 839.755n 0.0v 844.745n 0.0v 844.755n 0.0v 849.745n 0.0v 849.755n 0.0v 854.745n 0.0v 854.755n 0.0v 859.745n 0.0v 859.755n 1.1v 864.745n 1.1v 864.755n 1.1v 869.745n 1.1v 869.755n 1.1v 874.745n 1.1v 874.755n 1.1v 879.745n 1.1v 879.755n 1.1v 884.745n 1.1v 884.755n 0.0v 889.745n 0.0v 889.755n 0.0v 894.745n 0.0v 894.755n 0.0v 899.745n 0.0v 899.755n 0.0v 904.745n 0.0v 904.755n 0.0v 909.745n 0.0v 909.755n 1.1v 914.745n 1.1v 914.755n 1.1v 919.745n 1.1v 919.755n 1.1v 924.745n 1.1v 924.755n 1.1v 929.745n 1.1v 929.755n 1.1v 934.745n 1.1v 934.755n 0.0v 939.745n 0.0v 939.755n 0.0v 944.745n 0.0v 944.755n 0.0v 949.745n 0.0v 949.755n 0.0v 954.745n 0.0v 954.755n 1.1v 959.745n 1.1v 959.755n 1.1v 964.745n 1.1v 964.755n 0.0v 969.745n 0.0v 969.755n 0.0v 974.745n 0.0v 974.755n 0.0v 979.745n 0.0v 979.755n 0.0v 984.745n 0.0v 984.755n 0.0v 989.745n 0.0v 989.755n 0.0v 994.745n 0.0v 994.755n 0.0v 999.745n 0.0v 999.755n 1.1v 1004.745n 1.1v 1004.755n 1.1v 1009.745n 1.1v 1009.755n 1.1v 1014.745n 1.1v 1014.755n 1.1v 1019.745n 1.1v 1019.755n 1.1v 1024.745n 1.1v 1024.755n 1.1v )
* (time, data): [(0, 0), (5, 1), (10, 1), (15, 0), (20, 0), (25, 0), (30, 0), (35, 0), (40, 1), (45, 0), (50, 0), (55, 0), (60, 1), (65, 1), (70, 1), (75, 1), (80, 1), (85, 1), (90, 0), (95, 0), (100, 1), (105, 1), (110, 1), (115, 1), (120, 1), (125, 1), (130, 1), (135, 0), (140, 1), (145, 1), (150, 1), (155, 1), (160, 1), (165, 1), (170, 1), (175, 1), (180, 1), (185, 0), (190, 0), (195, 0), (200, 1), (205, 1), (210, 0), (215, 0), (220, 1), (225, 1), (230, 1), (235, 1), (240, 1), (245, 1), (250, 1), (255, 1), (260, 1), (265, 0), (270, 0), (275, 0), (280, 0), (285, 0), (290, 0), (295, 0), (300, 1), (305, 1), (310, 1), (315, 1), (320, 1), (325, 1), (330, 1), (335, 0), (340, 0), (345, 0), (350, 0), (355, 0), (360, 1), (365, 1), (370, 1), (375, 1), (380, 1), (385, 1), (390, 1), (395, 0), (400, 1), (405, 1), (410, 1), (415, 0), (420, 1), (425, 1), (430, 0), (435, 0), (440, 0), (445, 0), (450, 0), (455, 0), (460, 0), (465, 1), (470, 0), (475, 0), (480, 1), (485, 1), (490, 1), (495, 1), (500, 0), (505, 0), (510, 0), (515, 1), (520, 1), (525, 1), (530, 1), (535, 0), (540, 0), (545, 0), (550, 0), (555, 1), (560, 1), (565, 1), (570, 1), (575, 0), (580, 0), (585, 0), (590, 0), (595, 0), (600, 0), (605, 0), (610, 0), (615, 0), (620, 0), (625, 0), (630, 0), (635, 0), (640, 0), (645, 0), (650, 0), (655, 0), (660, 0), (665, 0), (670, 0), (675, 0), (680, 0), (685, 0), (690, 0), (695, 0), (700, 0), (705, 1), (710, 0), (715, 0), (720, 0), (725, 0), (730, 0), (735, 1), (740, 0), (745, 0), (750, 0), (755, 0), (760, 0), (765, 0), (770, 1), (775, 0), (780, 0), (785, 0), (790, 1), (795, 1), (800, 1), (805, 1), (810, 1), (815, 1), (820, 0), (825, 0), (830, 1), (835, 1), (840, 1), (845, 1), (850, 1), (855, 1), (860, 1), (865, 1), (870, 0), (875, 1), (880, 0), (885, 1), (890, 1), (895, 1), (900, 1), (905, 1), (910, 1), (915, 1), (920, 1), (925, 1), (930, 0), (935, 0), (940, 0), (945, 0), (950, 0), (955, 0), (960, 0), (965, 1), (970, 1), (975, 1), (980, 1), (985, 0), (990, 0), (995, 1), (1000, 0), (1005, 0), (1010, 0), (1015, 0), (1020, 0), (1025, 0)]
Vdin0_30  din0_30  0 PWL (0n 0.0v 4.745n 0.0v 4.755n 1.1v 9.745n 1.1v 9.755n 1.1v 14.745n 1.1v 14.755n 0.0v 19.745n 0.0v 19.755n 0.0v 24.745n 0.0v 24.755n 0.0v 29.745n 0.0v 29.755n 0.0v 34.745n 0.0v 34.755n 0.0v 39.745n 0.0v 39.755n 1.1v 44.745n 1.1v 44.755n 0.0v 49.745n 0.0v 49.755n 0.0v 54.745n 0.0v 54.755n 0.0v 59.745n 0.0v 59.755n 1.1v 64.745n 1.1v 64.755n 1.1v 69.745n 1.1v 69.755n 1.1v 74.745n 1.1v 74.755n 1.1v 79.745n 1.1v 79.755n 1.1v 84.745n 1.1v 84.755n 1.1v 89.745n 1.1v 89.755n 0.0v 94.745n 0.0v 94.755n 0.0v 99.745n 0.0v 99.755n 1.1v 104.745n 1.1v 104.755n 1.1v 109.745n 1.1v 109.755n 1.1v 114.745n 1.1v 114.755n 1.1v 119.745n 1.1v 119.755n 1.1v 124.745n 1.1v 124.755n 1.1v 129.745n 1.1v 129.755n 1.1v 134.745n 1.1v 134.755n 0.0v 139.745n 0.0v 139.755n 1.1v 144.745n 1.1v 144.755n 1.1v 149.745n 1.1v 149.755n 1.1v 154.745n 1.1v 154.755n 1.1v 159.745n 1.1v 159.755n 1.1v 164.745n 1.1v 164.755n 1.1v 169.745n 1.1v 169.755n 1.1v 174.745n 1.1v 174.755n 1.1v 179.745n 1.1v 179.755n 1.1v 184.745n 1.1v 184.755n 0.0v 189.745n 0.0v 189.755n 0.0v 194.745n 0.0v 194.755n 0.0v 199.745n 0.0v 199.755n 1.1v 204.745n 1.1v 204.755n 1.1v 209.745n 1.1v 209.755n 0.0v 214.745n 0.0v 214.755n 0.0v 219.745n 0.0v 219.755n 1.1v 224.745n 1.1v 224.755n 1.1v 229.745n 1.1v 229.755n 1.1v 234.745n 1.1v 234.755n 1.1v 239.745n 1.1v 239.755n 1.1v 244.745n 1.1v 244.755n 1.1v 249.745n 1.1v 249.755n 1.1v 254.745n 1.1v 254.755n 1.1v 259.745n 1.1v 259.755n 1.1v 264.745n 1.1v 264.755n 0.0v 269.745n 0.0v 269.755n 0.0v 274.745n 0.0v 274.755n 0.0v 279.745n 0.0v 279.755n 0.0v 284.745n 0.0v 284.755n 0.0v 289.745n 0.0v 289.755n 0.0v 294.745n 0.0v 294.755n 0.0v 299.745n 0.0v 299.755n 1.1v 304.745n 1.1v 304.755n 1.1v 309.745n 1.1v 309.755n 1.1v 314.745n 1.1v 314.755n 1.1v 319.745n 1.1v 319.755n 1.1v 324.745n 1.1v 324.755n 1.1v 329.745n 1.1v 329.755n 1.1v 334.745n 1.1v 334.755n 0.0v 339.745n 0.0v 339.755n 0.0v 344.745n 0.0v 344.755n 0.0v 349.745n 0.0v 349.755n 0.0v 354.745n 0.0v 354.755n 0.0v 359.745n 0.0v 359.755n 1.1v 364.745n 1.1v 364.755n 1.1v 369.745n 1.1v 369.755n 1.1v 374.745n 1.1v 374.755n 1.1v 379.745n 1.1v 379.755n 1.1v 384.745n 1.1v 384.755n 1.1v 389.745n 1.1v 389.755n 1.1v 394.745n 1.1v 394.755n 0.0v 399.745n 0.0v 399.755n 1.1v 404.745n 1.1v 404.755n 1.1v 409.745n 1.1v 409.755n 1.1v 414.745n 1.1v 414.755n 0.0v 419.745n 0.0v 419.755n 1.1v 424.745n 1.1v 424.755n 1.1v 429.745n 1.1v 429.755n 0.0v 434.745n 0.0v 434.755n 0.0v 439.745n 0.0v 439.755n 0.0v 444.745n 0.0v 444.755n 0.0v 449.745n 0.0v 449.755n 0.0v 454.745n 0.0v 454.755n 0.0v 459.745n 0.0v 459.755n 0.0v 464.745n 0.0v 464.755n 1.1v 469.745n 1.1v 469.755n 0.0v 474.745n 0.0v 474.755n 0.0v 479.745n 0.0v 479.755n 1.1v 484.745n 1.1v 484.755n 1.1v 489.745n 1.1v 489.755n 1.1v 494.745n 1.1v 494.755n 1.1v 499.745n 1.1v 499.755n 0.0v 504.745n 0.0v 504.755n 0.0v 509.745n 0.0v 509.755n 0.0v 514.745n 0.0v 514.755n 1.1v 519.745n 1.1v 519.755n 1.1v 524.745n 1.1v 524.755n 1.1v 529.745n 1.1v 529.755n 1.1v 534.745n 1.1v 534.755n 0.0v 539.745n 0.0v 539.755n 0.0v 544.745n 0.0v 544.755n 0.0v 549.745n 0.0v 549.755n 0.0v 554.745n 0.0v 554.755n 1.1v 559.745n 1.1v 559.755n 1.1v 564.745n 1.1v 564.755n 1.1v 569.745n 1.1v 569.755n 1.1v 574.745n 1.1v 574.755n 0.0v 579.745n 0.0v 579.755n 0.0v 584.745n 0.0v 584.755n 0.0v 589.745n 0.0v 589.755n 0.0v 594.745n 0.0v 594.755n 0.0v 599.745n 0.0v 599.755n 0.0v 604.745n 0.0v 604.755n 0.0v 609.745n 0.0v 609.755n 0.0v 614.745n 0.0v 614.755n 0.0v 619.745n 0.0v 619.755n 0.0v 624.745n 0.0v 624.755n 0.0v 629.745n 0.0v 629.755n 0.0v 634.745n 0.0v 634.755n 0.0v 639.745n 0.0v 639.755n 0.0v 644.745n 0.0v 644.755n 0.0v 649.745n 0.0v 649.755n 0.0v 654.745n 0.0v 654.755n 0.0v 659.745n 0.0v 659.755n 0.0v 664.745n 0.0v 664.755n 0.0v 669.745n 0.0v 669.755n 0.0v 674.745n 0.0v 674.755n 0.0v 679.745n 0.0v 679.755n 0.0v 684.745n 0.0v 684.755n 0.0v 689.745n 0.0v 689.755n 0.0v 694.745n 0.0v 694.755n 0.0v 699.745n 0.0v 699.755n 0.0v 704.745n 0.0v 704.755n 1.1v 709.745n 1.1v 709.755n 0.0v 714.745n 0.0v 714.755n 0.0v 719.745n 0.0v 719.755n 0.0v 724.745n 0.0v 724.755n 0.0v 729.745n 0.0v 729.755n 0.0v 734.745n 0.0v 734.755n 1.1v 739.745n 1.1v 739.755n 0.0v 744.745n 0.0v 744.755n 0.0v 749.745n 0.0v 749.755n 0.0v 754.745n 0.0v 754.755n 0.0v 759.745n 0.0v 759.755n 0.0v 764.745n 0.0v 764.755n 0.0v 769.745n 0.0v 769.755n 1.1v 774.745n 1.1v 774.755n 0.0v 779.745n 0.0v 779.755n 0.0v 784.745n 0.0v 784.755n 0.0v 789.745n 0.0v 789.755n 1.1v 794.745n 1.1v 794.755n 1.1v 799.745n 1.1v 799.755n 1.1v 804.745n 1.1v 804.755n 1.1v 809.745n 1.1v 809.755n 1.1v 814.745n 1.1v 814.755n 1.1v 819.745n 1.1v 819.755n 0.0v 824.745n 0.0v 824.755n 0.0v 829.745n 0.0v 829.755n 1.1v 834.745n 1.1v 834.755n 1.1v 839.745n 1.1v 839.755n 1.1v 844.745n 1.1v 844.755n 1.1v 849.745n 1.1v 849.755n 1.1v 854.745n 1.1v 854.755n 1.1v 859.745n 1.1v 859.755n 1.1v 864.745n 1.1v 864.755n 1.1v 869.745n 1.1v 869.755n 0.0v 874.745n 0.0v 874.755n 1.1v 879.745n 1.1v 879.755n 0.0v 884.745n 0.0v 884.755n 1.1v 889.745n 1.1v 889.755n 1.1v 894.745n 1.1v 894.755n 1.1v 899.745n 1.1v 899.755n 1.1v 904.745n 1.1v 904.755n 1.1v 909.745n 1.1v 909.755n 1.1v 914.745n 1.1v 914.755n 1.1v 919.745n 1.1v 919.755n 1.1v 924.745n 1.1v 924.755n 1.1v 929.745n 1.1v 929.755n 0.0v 934.745n 0.0v 934.755n 0.0v 939.745n 0.0v 939.755n 0.0v 944.745n 0.0v 944.755n 0.0v 949.745n 0.0v 949.755n 0.0v 954.745n 0.0v 954.755n 0.0v 959.745n 0.0v 959.755n 0.0v 964.745n 0.0v 964.755n 1.1v 969.745n 1.1v 969.755n 1.1v 974.745n 1.1v 974.755n 1.1v 979.745n 1.1v 979.755n 1.1v 984.745n 1.1v 984.755n 0.0v 989.745n 0.0v 989.755n 0.0v 994.745n 0.0v 994.755n 1.1v 999.745n 1.1v 999.755n 0.0v 1004.745n 0.0v 1004.755n 0.0v 1009.745n 0.0v 1009.755n 0.0v 1014.745n 0.0v 1014.755n 0.0v 1019.745n 0.0v 1019.755n 0.0v 1024.745n 0.0v 1024.755n 0.0v )
* (time, data): [(0, 0), (5, 1), (10, 1), (15, 0), (20, 0), (25, 0), (30, 0), (35, 0), (40, 1), (45, 0), (50, 0), (55, 0), (60, 1), (65, 0), (70, 0), (75, 0), (80, 0), (85, 0), (90, 0), (95, 0), (100, 1), (105, 1), (110, 1), (115, 1), (120, 1), (125, 1), (130, 1), (135, 0), (140, 0), (145, 0), (150, 0), (155, 0), (160, 0), (165, 0), (170, 0), (175, 0), (180, 0), (185, 1), (190, 1), (195, 1), (200, 1), (205, 1), (210, 0), (215, 0), (220, 1), (225, 1), (230, 0), (235, 0), (240, 0), (245, 0), (250, 0), (255, 1), (260, 1), (265, 0), (270, 0), (275, 0), (280, 0), (285, 0), (290, 0), (295, 0), (300, 1), (305, 1), (310, 1), (315, 0), (320, 0), (325, 0), (330, 0), (335, 1), (340, 1), (345, 1), (350, 1), (355, 1), (360, 0), (365, 0), (370, 0), (375, 0), (380, 0), (385, 0), (390, 0), (395, 1), (400, 1), (405, 1), (410, 0), (415, 1), (420, 1), (425, 0), (430, 1), (435, 1), (440, 1), (445, 1), (450, 0), (455, 0), (460, 0), (465, 1), (470, 1), (475, 1), (480, 1), (485, 1), (490, 1), (495, 0), (500, 1), (505, 1), (510, 1), (515, 1), (520, 1), (525, 1), (530, 1), (535, 1), (540, 1), (545, 1), (550, 1), (555, 1), (560, 1), (565, 1), (570, 1), (575, 1), (580, 1), (585, 1), (590, 1), (595, 1), (600, 1), (605, 1), (610, 1), (615, 1), (620, 1), (625, 1), (630, 0), (635, 0), (640, 1), (645, 1), (650, 1), (655, 1), (660, 0), (665, 0), (670, 1), (675, 1), (680, 1), (685, 1), (690, 1), (695, 1), (700, 1), (705, 0), (710, 0), (715, 1), (720, 1), (725, 1), (730, 1), (735, 1), (740, 0), (745, 0), (750, 0), (755, 1), (760, 1), (765, 1), (770, 1), (775, 1), (780, 1), (785, 1), (790, 1), (795, 1), (800, 1), (805, 1), (810, 1), (815, 1), (820, 0), (825, 0), (830, 0), (835, 0), (840, 0), (845, 0), (850, 0), (855, 1), (860, 1), (865, 0), (870, 0), (875, 1), (880, 0), (885, 0), (890, 0), (895, 0), (900, 0), (905, 0), (910, 1), (915, 1), (920, 1), (925, 1), (930, 0), (935, 1), (940, 1), (945, 1), (950, 1), (955, 0), (960, 0), (965, 1), (970, 1), (975, 1), (980, 1), (985, 1), (990, 1), (995, 1), (1000, 1), (1005, 1), (1010, 1), (1015, 1), (1020, 1), (1025, 1)]
Vdin0_31  din0_31  0 PWL (0n 0.0v 4.745n 0.0v 4.755n 1.1v 9.745n 1.1v 9.755n 1.1v 14.745n 1.1v 14.755n 0.0v 19.745n 0.0v 19.755n 0.0v 24.745n 0.0v 24.755n 0.0v 29.745n 0.0v 29.755n 0.0v 34.745n 0.0v 34.755n 0.0v 39.745n 0.0v 39.755n 1.1v 44.745n 1.1v 44.755n 0.0v 49.745n 0.0v 49.755n 0.0v 54.745n 0.0v 54.755n 0.0v 59.745n 0.0v 59.755n 1.1v 64.745n 1.1v 64.755n 0.0v 69.745n 0.0v 69.755n 0.0v 74.745n 0.0v 74.755n 0.0v 79.745n 0.0v 79.755n 0.0v 84.745n 0.0v 84.755n 0.0v 89.745n 0.0v 89.755n 0.0v 94.745n 0.0v 94.755n 0.0v 99.745n 0.0v 99.755n 1.1v 104.745n 1.1v 104.755n 1.1v 109.745n 1.1v 109.755n 1.1v 114.745n 1.1v 114.755n 1.1v 119.745n 1.1v 119.755n 1.1v 124.745n 1.1v 124.755n 1.1v 129.745n 1.1v 129.755n 1.1v 134.745n 1.1v 134.755n 0.0v 139.745n 0.0v 139.755n 0.0v 144.745n 0.0v 144.755n 0.0v 149.745n 0.0v 149.755n 0.0v 154.745n 0.0v 154.755n 0.0v 159.745n 0.0v 159.755n 0.0v 164.745n 0.0v 164.755n 0.0v 169.745n 0.0v 169.755n 0.0v 174.745n 0.0v 174.755n 0.0v 179.745n 0.0v 179.755n 0.0v 184.745n 0.0v 184.755n 1.1v 189.745n 1.1v 189.755n 1.1v 194.745n 1.1v 194.755n 1.1v 199.745n 1.1v 199.755n 1.1v 204.745n 1.1v 204.755n 1.1v 209.745n 1.1v 209.755n 0.0v 214.745n 0.0v 214.755n 0.0v 219.745n 0.0v 219.755n 1.1v 224.745n 1.1v 224.755n 1.1v 229.745n 1.1v 229.755n 0.0v 234.745n 0.0v 234.755n 0.0v 239.745n 0.0v 239.755n 0.0v 244.745n 0.0v 244.755n 0.0v 249.745n 0.0v 249.755n 0.0v 254.745n 0.0v 254.755n 1.1v 259.745n 1.1v 259.755n 1.1v 264.745n 1.1v 264.755n 0.0v 269.745n 0.0v 269.755n 0.0v 274.745n 0.0v 274.755n 0.0v 279.745n 0.0v 279.755n 0.0v 284.745n 0.0v 284.755n 0.0v 289.745n 0.0v 289.755n 0.0v 294.745n 0.0v 294.755n 0.0v 299.745n 0.0v 299.755n 1.1v 304.745n 1.1v 304.755n 1.1v 309.745n 1.1v 309.755n 1.1v 314.745n 1.1v 314.755n 0.0v 319.745n 0.0v 319.755n 0.0v 324.745n 0.0v 324.755n 0.0v 329.745n 0.0v 329.755n 0.0v 334.745n 0.0v 334.755n 1.1v 339.745n 1.1v 339.755n 1.1v 344.745n 1.1v 344.755n 1.1v 349.745n 1.1v 349.755n 1.1v 354.745n 1.1v 354.755n 1.1v 359.745n 1.1v 359.755n 0.0v 364.745n 0.0v 364.755n 0.0v 369.745n 0.0v 369.755n 0.0v 374.745n 0.0v 374.755n 0.0v 379.745n 0.0v 379.755n 0.0v 384.745n 0.0v 384.755n 0.0v 389.745n 0.0v 389.755n 0.0v 394.745n 0.0v 394.755n 1.1v 399.745n 1.1v 399.755n 1.1v 404.745n 1.1v 404.755n 1.1v 409.745n 1.1v 409.755n 0.0v 414.745n 0.0v 414.755n 1.1v 419.745n 1.1v 419.755n 1.1v 424.745n 1.1v 424.755n 0.0v 429.745n 0.0v 429.755n 1.1v 434.745n 1.1v 434.755n 1.1v 439.745n 1.1v 439.755n 1.1v 444.745n 1.1v 444.755n 1.1v 449.745n 1.1v 449.755n 0.0v 454.745n 0.0v 454.755n 0.0v 459.745n 0.0v 459.755n 0.0v 464.745n 0.0v 464.755n 1.1v 469.745n 1.1v 469.755n 1.1v 474.745n 1.1v 474.755n 1.1v 479.745n 1.1v 479.755n 1.1v 484.745n 1.1v 484.755n 1.1v 489.745n 1.1v 489.755n 1.1v 494.745n 1.1v 494.755n 0.0v 499.745n 0.0v 499.755n 1.1v 504.745n 1.1v 504.755n 1.1v 509.745n 1.1v 509.755n 1.1v 514.745n 1.1v 514.755n 1.1v 519.745n 1.1v 519.755n 1.1v 524.745n 1.1v 524.755n 1.1v 529.745n 1.1v 529.755n 1.1v 534.745n 1.1v 534.755n 1.1v 539.745n 1.1v 539.755n 1.1v 544.745n 1.1v 544.755n 1.1v 549.745n 1.1v 549.755n 1.1v 554.745n 1.1v 554.755n 1.1v 559.745n 1.1v 559.755n 1.1v 564.745n 1.1v 564.755n 1.1v 569.745n 1.1v 569.755n 1.1v 574.745n 1.1v 574.755n 1.1v 579.745n 1.1v 579.755n 1.1v 584.745n 1.1v 584.755n 1.1v 589.745n 1.1v 589.755n 1.1v 594.745n 1.1v 594.755n 1.1v 599.745n 1.1v 599.755n 1.1v 604.745n 1.1v 604.755n 1.1v 609.745n 1.1v 609.755n 1.1v 614.745n 1.1v 614.755n 1.1v 619.745n 1.1v 619.755n 1.1v 624.745n 1.1v 624.755n 1.1v 629.745n 1.1v 629.755n 0.0v 634.745n 0.0v 634.755n 0.0v 639.745n 0.0v 639.755n 1.1v 644.745n 1.1v 644.755n 1.1v 649.745n 1.1v 649.755n 1.1v 654.745n 1.1v 654.755n 1.1v 659.745n 1.1v 659.755n 0.0v 664.745n 0.0v 664.755n 0.0v 669.745n 0.0v 669.755n 1.1v 674.745n 1.1v 674.755n 1.1v 679.745n 1.1v 679.755n 1.1v 684.745n 1.1v 684.755n 1.1v 689.745n 1.1v 689.755n 1.1v 694.745n 1.1v 694.755n 1.1v 699.745n 1.1v 699.755n 1.1v 704.745n 1.1v 704.755n 0.0v 709.745n 0.0v 709.755n 0.0v 714.745n 0.0v 714.755n 1.1v 719.745n 1.1v 719.755n 1.1v 724.745n 1.1v 724.755n 1.1v 729.745n 1.1v 729.755n 1.1v 734.745n 1.1v 734.755n 1.1v 739.745n 1.1v 739.755n 0.0v 744.745n 0.0v 744.755n 0.0v 749.745n 0.0v 749.755n 0.0v 754.745n 0.0v 754.755n 1.1v 759.745n 1.1v 759.755n 1.1v 764.745n 1.1v 764.755n 1.1v 769.745n 1.1v 769.755n 1.1v 774.745n 1.1v 774.755n 1.1v 779.745n 1.1v 779.755n 1.1v 784.745n 1.1v 784.755n 1.1v 789.745n 1.1v 789.755n 1.1v 794.745n 1.1v 794.755n 1.1v 799.745n 1.1v 799.755n 1.1v 804.745n 1.1v 804.755n 1.1v 809.745n 1.1v 809.755n 1.1v 814.745n 1.1v 814.755n 1.1v 819.745n 1.1v 819.755n 0.0v 824.745n 0.0v 824.755n 0.0v 829.745n 0.0v 829.755n 0.0v 834.745n 0.0v 834.755n 0.0v 839.745n 0.0v 839.755n 0.0v 844.745n 0.0v 844.755n 0.0v 849.745n 0.0v 849.755n 0.0v 854.745n 0.0v 854.755n 1.1v 859.745n 1.1v 859.755n 1.1v 864.745n 1.1v 864.755n 0.0v 869.745n 0.0v 869.755n 0.0v 874.745n 0.0v 874.755n 1.1v 879.745n 1.1v 879.755n 0.0v 884.745n 0.0v 884.755n 0.0v 889.745n 0.0v 889.755n 0.0v 894.745n 0.0v 894.755n 0.0v 899.745n 0.0v 899.755n 0.0v 904.745n 0.0v 904.755n 0.0v 909.745n 0.0v 909.755n 1.1v 914.745n 1.1v 914.755n 1.1v 919.745n 1.1v 919.755n 1.1v 924.745n 1.1v 924.755n 1.1v 929.745n 1.1v 929.755n 0.0v 934.745n 0.0v 934.755n 1.1v 939.745n 1.1v 939.755n 1.1v 944.745n 1.1v 944.755n 1.1v 949.745n 1.1v 949.755n 1.1v 954.745n 1.1v 954.755n 0.0v 959.745n 0.0v 959.755n 0.0v 964.745n 0.0v 964.755n 1.1v 969.745n 1.1v 969.755n 1.1v 974.745n 1.1v 974.755n 1.1v 979.745n 1.1v 979.755n 1.1v 984.745n 1.1v 984.755n 1.1v 989.745n 1.1v 989.755n 1.1v 994.745n 1.1v 994.755n 1.1v 999.745n 1.1v 999.755n 1.1v 1004.745n 1.1v 1004.755n 1.1v 1009.745n 1.1v 1009.755n 1.1v 1014.745n 1.1v 1014.755n 1.1v 1019.745n 1.1v 1019.755n 1.1v 1024.745n 1.1v 1024.755n 1.1v )
* (time, data): [(0, 0), (5, 1), (10, 0), (15, 0), (20, 0), (25, 0), (30, 0), (35, 0), (40, 1), (45, 0), (50, 0), (55, 0), (60, 1), (65, 0), (70, 0), (75, 0), (80, 0), (85, 0), (90, 1), (95, 1), (100, 1), (105, 1), (110, 1), (115, 1), (120, 1), (125, 1), (130, 1), (135, 0), (140, 1), (145, 1), (150, 1), (155, 1), (160, 1), (165, 1), (170, 0), (175, 0), (180, 0), (185, 1), (190, 1), (195, 1), (200, 1), (205, 1), (210, 0), (215, 0), (220, 0), (225, 0), (230, 1), (235, 1), (240, 1), (245, 1), (250, 1), (255, 0), (260, 0), (265, 0), (270, 0), (275, 0), (280, 1), (285, 1), (290, 1), (295, 1), (300, 0), (305, 0), (310, 0), (315, 1), (320, 1), (325, 1), (330, 1), (335, 1), (340, 0), (345, 0), (350, 0), (355, 0), (360, 0), (365, 0), (370, 0), (375, 0), (380, 0), (385, 0), (390, 0), (395, 1), (400, 0), (405, 0), (410, 1), (415, 1), (420, 0), (425, 0), (430, 0), (435, 0), (440, 0), (445, 0), (450, 1), (455, 1), (460, 1), (465, 0), (470, 0), (475, 0), (480, 1), (485, 1), (490, 1), (495, 0), (500, 0), (505, 1), (510, 0), (515, 1), (520, 1), (525, 1), (530, 1), (535, 1), (540, 1), (545, 1), (550, 1), (555, 1), (560, 1), (565, 1), (570, 1), (575, 1), (580, 1), (585, 1), (590, 1), (595, 1), (600, 1), (605, 1), (610, 1), (615, 1), (620, 1), (625, 1), (630, 1), (635, 1), (640, 1), (645, 1), (650, 1), (655, 0), (660, 0), (665, 0), (670, 1), (675, 1), (680, 1), (685, 1), (690, 1), (695, 1), (700, 1), (705, 1), (710, 0), (715, 0), (720, 0), (725, 0), (730, 0), (735, 1), (740, 0), (745, 0), (750, 0), (755, 1), (760, 1), (765, 1), (770, 0), (775, 1), (780, 1), (785, 0), (790, 1), (795, 1), (800, 1), (805, 1), (810, 1), (815, 1), (820, 1), (825, 1), (830, 0), (835, 0), (840, 0), (845, 0), (850, 0), (855, 0), (860, 1), (865, 1), (870, 0), (875, 1), (880, 0), (885, 0), (890, 0), (895, 0), (900, 0), (905, 0), (910, 1), (915, 1), (920, 1), (925, 1), (930, 0), (935, 0), (940, 0), (945, 0), (950, 0), (955, 0), (960, 0), (965, 1), (970, 1), (975, 1), (980, 1), (985, 0), (990, 0), (995, 0), (1000, 0), (1005, 0), (1010, 0), (1015, 0), (1020, 0), (1025, 0)]
Vdin0_32  din0_32  0 PWL (0n 0.0v 4.745n 0.0v 4.755n 1.1v 9.745n 1.1v 9.755n 0.0v 14.745n 0.0v 14.755n 0.0v 19.745n 0.0v 19.755n 0.0v 24.745n 0.0v 24.755n 0.0v 29.745n 0.0v 29.755n 0.0v 34.745n 0.0v 34.755n 0.0v 39.745n 0.0v 39.755n 1.1v 44.745n 1.1v 44.755n 0.0v 49.745n 0.0v 49.755n 0.0v 54.745n 0.0v 54.755n 0.0v 59.745n 0.0v 59.755n 1.1v 64.745n 1.1v 64.755n 0.0v 69.745n 0.0v 69.755n 0.0v 74.745n 0.0v 74.755n 0.0v 79.745n 0.0v 79.755n 0.0v 84.745n 0.0v 84.755n 0.0v 89.745n 0.0v 89.755n 1.1v 94.745n 1.1v 94.755n 1.1v 99.745n 1.1v 99.755n 1.1v 104.745n 1.1v 104.755n 1.1v 109.745n 1.1v 109.755n 1.1v 114.745n 1.1v 114.755n 1.1v 119.745n 1.1v 119.755n 1.1v 124.745n 1.1v 124.755n 1.1v 129.745n 1.1v 129.755n 1.1v 134.745n 1.1v 134.755n 0.0v 139.745n 0.0v 139.755n 1.1v 144.745n 1.1v 144.755n 1.1v 149.745n 1.1v 149.755n 1.1v 154.745n 1.1v 154.755n 1.1v 159.745n 1.1v 159.755n 1.1v 164.745n 1.1v 164.755n 1.1v 169.745n 1.1v 169.755n 0.0v 174.745n 0.0v 174.755n 0.0v 179.745n 0.0v 179.755n 0.0v 184.745n 0.0v 184.755n 1.1v 189.745n 1.1v 189.755n 1.1v 194.745n 1.1v 194.755n 1.1v 199.745n 1.1v 199.755n 1.1v 204.745n 1.1v 204.755n 1.1v 209.745n 1.1v 209.755n 0.0v 214.745n 0.0v 214.755n 0.0v 219.745n 0.0v 219.755n 0.0v 224.745n 0.0v 224.755n 0.0v 229.745n 0.0v 229.755n 1.1v 234.745n 1.1v 234.755n 1.1v 239.745n 1.1v 239.755n 1.1v 244.745n 1.1v 244.755n 1.1v 249.745n 1.1v 249.755n 1.1v 254.745n 1.1v 254.755n 0.0v 259.745n 0.0v 259.755n 0.0v 264.745n 0.0v 264.755n 0.0v 269.745n 0.0v 269.755n 0.0v 274.745n 0.0v 274.755n 0.0v 279.745n 0.0v 279.755n 1.1v 284.745n 1.1v 284.755n 1.1v 289.745n 1.1v 289.755n 1.1v 294.745n 1.1v 294.755n 1.1v 299.745n 1.1v 299.755n 0.0v 304.745n 0.0v 304.755n 0.0v 309.745n 0.0v 309.755n 0.0v 314.745n 0.0v 314.755n 1.1v 319.745n 1.1v 319.755n 1.1v 324.745n 1.1v 324.755n 1.1v 329.745n 1.1v 329.755n 1.1v 334.745n 1.1v 334.755n 1.1v 339.745n 1.1v 339.755n 0.0v 344.745n 0.0v 344.755n 0.0v 349.745n 0.0v 349.755n 0.0v 354.745n 0.0v 354.755n 0.0v 359.745n 0.0v 359.755n 0.0v 364.745n 0.0v 364.755n 0.0v 369.745n 0.0v 369.755n 0.0v 374.745n 0.0v 374.755n 0.0v 379.745n 0.0v 379.755n 0.0v 384.745n 0.0v 384.755n 0.0v 389.745n 0.0v 389.755n 0.0v 394.745n 0.0v 394.755n 1.1v 399.745n 1.1v 399.755n 0.0v 404.745n 0.0v 404.755n 0.0v 409.745n 0.0v 409.755n 1.1v 414.745n 1.1v 414.755n 1.1v 419.745n 1.1v 419.755n 0.0v 424.745n 0.0v 424.755n 0.0v 429.745n 0.0v 429.755n 0.0v 434.745n 0.0v 434.755n 0.0v 439.745n 0.0v 439.755n 0.0v 444.745n 0.0v 444.755n 0.0v 449.745n 0.0v 449.755n 1.1v 454.745n 1.1v 454.755n 1.1v 459.745n 1.1v 459.755n 1.1v 464.745n 1.1v 464.755n 0.0v 469.745n 0.0v 469.755n 0.0v 474.745n 0.0v 474.755n 0.0v 479.745n 0.0v 479.755n 1.1v 484.745n 1.1v 484.755n 1.1v 489.745n 1.1v 489.755n 1.1v 494.745n 1.1v 494.755n 0.0v 499.745n 0.0v 499.755n 0.0v 504.745n 0.0v 504.755n 1.1v 509.745n 1.1v 509.755n 0.0v 514.745n 0.0v 514.755n 1.1v 519.745n 1.1v 519.755n 1.1v 524.745n 1.1v 524.755n 1.1v 529.745n 1.1v 529.755n 1.1v 534.745n 1.1v 534.755n 1.1v 539.745n 1.1v 539.755n 1.1v 544.745n 1.1v 544.755n 1.1v 549.745n 1.1v 549.755n 1.1v 554.745n 1.1v 554.755n 1.1v 559.745n 1.1v 559.755n 1.1v 564.745n 1.1v 564.755n 1.1v 569.745n 1.1v 569.755n 1.1v 574.745n 1.1v 574.755n 1.1v 579.745n 1.1v 579.755n 1.1v 584.745n 1.1v 584.755n 1.1v 589.745n 1.1v 589.755n 1.1v 594.745n 1.1v 594.755n 1.1v 599.745n 1.1v 599.755n 1.1v 604.745n 1.1v 604.755n 1.1v 609.745n 1.1v 609.755n 1.1v 614.745n 1.1v 614.755n 1.1v 619.745n 1.1v 619.755n 1.1v 624.745n 1.1v 624.755n 1.1v 629.745n 1.1v 629.755n 1.1v 634.745n 1.1v 634.755n 1.1v 639.745n 1.1v 639.755n 1.1v 644.745n 1.1v 644.755n 1.1v 649.745n 1.1v 649.755n 1.1v 654.745n 1.1v 654.755n 0.0v 659.745n 0.0v 659.755n 0.0v 664.745n 0.0v 664.755n 0.0v 669.745n 0.0v 669.755n 1.1v 674.745n 1.1v 674.755n 1.1v 679.745n 1.1v 679.755n 1.1v 684.745n 1.1v 684.755n 1.1v 689.745n 1.1v 689.755n 1.1v 694.745n 1.1v 694.755n 1.1v 699.745n 1.1v 699.755n 1.1v 704.745n 1.1v 704.755n 1.1v 709.745n 1.1v 709.755n 0.0v 714.745n 0.0v 714.755n 0.0v 719.745n 0.0v 719.755n 0.0v 724.745n 0.0v 724.755n 0.0v 729.745n 0.0v 729.755n 0.0v 734.745n 0.0v 734.755n 1.1v 739.745n 1.1v 739.755n 0.0v 744.745n 0.0v 744.755n 0.0v 749.745n 0.0v 749.755n 0.0v 754.745n 0.0v 754.755n 1.1v 759.745n 1.1v 759.755n 1.1v 764.745n 1.1v 764.755n 1.1v 769.745n 1.1v 769.755n 0.0v 774.745n 0.0v 774.755n 1.1v 779.745n 1.1v 779.755n 1.1v 784.745n 1.1v 784.755n 0.0v 789.745n 0.0v 789.755n 1.1v 794.745n 1.1v 794.755n 1.1v 799.745n 1.1v 799.755n 1.1v 804.745n 1.1v 804.755n 1.1v 809.745n 1.1v 809.755n 1.1v 814.745n 1.1v 814.755n 1.1v 819.745n 1.1v 819.755n 1.1v 824.745n 1.1v 824.755n 1.1v 829.745n 1.1v 829.755n 0.0v 834.745n 0.0v 834.755n 0.0v 839.745n 0.0v 839.755n 0.0v 844.745n 0.0v 844.755n 0.0v 849.745n 0.0v 849.755n 0.0v 854.745n 0.0v 854.755n 0.0v 859.745n 0.0v 859.755n 1.1v 864.745n 1.1v 864.755n 1.1v 869.745n 1.1v 869.755n 0.0v 874.745n 0.0v 874.755n 1.1v 879.745n 1.1v 879.755n 0.0v 884.745n 0.0v 884.755n 0.0v 889.745n 0.0v 889.755n 0.0v 894.745n 0.0v 894.755n 0.0v 899.745n 0.0v 899.755n 0.0v 904.745n 0.0v 904.755n 0.0v 909.745n 0.0v 909.755n 1.1v 914.745n 1.1v 914.755n 1.1v 919.745n 1.1v 919.755n 1.1v 924.745n 1.1v 924.755n 1.1v 929.745n 1.1v 929.755n 0.0v 934.745n 0.0v 934.755n 0.0v 939.745n 0.0v 939.755n 0.0v 944.745n 0.0v 944.755n 0.0v 949.745n 0.0v 949.755n 0.0v 954.745n 0.0v 954.755n 0.0v 959.745n 0.0v 959.755n 0.0v 964.745n 0.0v 964.755n 1.1v 969.745n 1.1v 969.755n 1.1v 974.745n 1.1v 974.755n 1.1v 979.745n 1.1v 979.755n 1.1v 984.745n 1.1v 984.755n 0.0v 989.745n 0.0v 989.755n 0.0v 994.745n 0.0v 994.755n 0.0v 999.745n 0.0v 999.755n 0.0v 1004.745n 0.0v 1004.755n 0.0v 1009.745n 0.0v 1009.755n 0.0v 1014.745n 0.0v 1014.755n 0.0v 1019.745n 0.0v 1019.755n 0.0v 1024.745n 0.0v 1024.755n 0.0v )
* (time, data): [(0, 0), (5, 1), (10, 0), (15, 0), (20, 0), (25, 0), (30, 1), (35, 1), (40, 0), (45, 1), (50, 1), (55, 1), (60, 0), (65, 1), (70, 1), (75, 1), (80, 1), (85, 1), (90, 0), (95, 0), (100, 1), (105, 1), (110, 1), (115, 1), (120, 1), (125, 1), (130, 1), (135, 0), (140, 0), (145, 0), (150, 0), (155, 0), (160, 0), (165, 0), (170, 1), (175, 1), (180, 1), (185, 1), (190, 1), (195, 1), (200, 0), (205, 0), (210, 0), (215, 0), (220, 0), (225, 0), (230, 1), (235, 1), (240, 1), (245, 1), (250, 1), (255, 0), (260, 0), (265, 0), (270, 0), (275, 0), (280, 1), (285, 1), (290, 1), (295, 1), (300, 0), (305, 0), (310, 0), (315, 1), (320, 1), (325, 1), (330, 1), (335, 0), (340, 1), (345, 1), (350, 1), (355, 1), (360, 0), (365, 0), (370, 0), (375, 0), (380, 0), (385, 0), (390, 0), (395, 1), (400, 0), (405, 0), (410, 0), (415, 1), (420, 0), (425, 1), (430, 0), (435, 0), (440, 0), (445, 0), (450, 1), (455, 1), (460, 1), (465, 1), (470, 1), (475, 1), (480, 1), (485, 1), (490, 1), (495, 1), (500, 1), (505, 0), (510, 1), (515, 0), (520, 0), (525, 0), (530, 0), (535, 1), (540, 0), (545, 0), (550, 0), (555, 0), (560, 0), (565, 0), (570, 0), (575, 1), (580, 1), (585, 1), (590, 1), (595, 1), (600, 1), (605, 1), (610, 1), (615, 1), (620, 1), (625, 1), (630, 1), (635, 0), (640, 0), (645, 0), (650, 0), (655, 0), (660, 0), (665, 0), (670, 0), (675, 0), (680, 0), (685, 0), (690, 0), (695, 0), (700, 0), (705, 1), (710, 1), (715, 0), (720, 0), (725, 0), (730, 0), (735, 1), (740, 1), (745, 1), (750, 1), (755, 1), (760, 1), (765, 1), (770, 1), (775, 1), (780, 1), (785, 1), (790, 0), (795, 0), (800, 0), (805, 0), (810, 0), (815, 0), (820, 0), (825, 0), (830, 0), (835, 0), (840, 0), (845, 0), (850, 0), (855, 0), (860, 0), (865, 1), (870, 0), (875, 1), (880, 0), (885, 0), (890, 0), (895, 0), (900, 0), (905, 0), (910, 0), (915, 0), (920, 0), (925, 0), (930, 1), (935, 1), (940, 1), (945, 1), (950, 1), (955, 1), (960, 1), (965, 1), (970, 1), (975, 1), (980, 0), (985, 0), (990, 0), (995, 0), (1000, 1), (1005, 1), (1010, 1), (1015, 1), (1020, 1), (1025, 1)]
Vdin0_33  din0_33  0 PWL (0n 0.0v 4.745n 0.0v 4.755n 1.1v 9.745n 1.1v 9.755n 0.0v 14.745n 0.0v 14.755n 0.0v 19.745n 0.0v 19.755n 0.0v 24.745n 0.0v 24.755n 0.0v 29.745n 0.0v 29.755n 1.1v 34.745n 1.1v 34.755n 1.1v 39.745n 1.1v 39.755n 0.0v 44.745n 0.0v 44.755n 1.1v 49.745n 1.1v 49.755n 1.1v 54.745n 1.1v 54.755n 1.1v 59.745n 1.1v 59.755n 0.0v 64.745n 0.0v 64.755n 1.1v 69.745n 1.1v 69.755n 1.1v 74.745n 1.1v 74.755n 1.1v 79.745n 1.1v 79.755n 1.1v 84.745n 1.1v 84.755n 1.1v 89.745n 1.1v 89.755n 0.0v 94.745n 0.0v 94.755n 0.0v 99.745n 0.0v 99.755n 1.1v 104.745n 1.1v 104.755n 1.1v 109.745n 1.1v 109.755n 1.1v 114.745n 1.1v 114.755n 1.1v 119.745n 1.1v 119.755n 1.1v 124.745n 1.1v 124.755n 1.1v 129.745n 1.1v 129.755n 1.1v 134.745n 1.1v 134.755n 0.0v 139.745n 0.0v 139.755n 0.0v 144.745n 0.0v 144.755n 0.0v 149.745n 0.0v 149.755n 0.0v 154.745n 0.0v 154.755n 0.0v 159.745n 0.0v 159.755n 0.0v 164.745n 0.0v 164.755n 0.0v 169.745n 0.0v 169.755n 1.1v 174.745n 1.1v 174.755n 1.1v 179.745n 1.1v 179.755n 1.1v 184.745n 1.1v 184.755n 1.1v 189.745n 1.1v 189.755n 1.1v 194.745n 1.1v 194.755n 1.1v 199.745n 1.1v 199.755n 0.0v 204.745n 0.0v 204.755n 0.0v 209.745n 0.0v 209.755n 0.0v 214.745n 0.0v 214.755n 0.0v 219.745n 0.0v 219.755n 0.0v 224.745n 0.0v 224.755n 0.0v 229.745n 0.0v 229.755n 1.1v 234.745n 1.1v 234.755n 1.1v 239.745n 1.1v 239.755n 1.1v 244.745n 1.1v 244.755n 1.1v 249.745n 1.1v 249.755n 1.1v 254.745n 1.1v 254.755n 0.0v 259.745n 0.0v 259.755n 0.0v 264.745n 0.0v 264.755n 0.0v 269.745n 0.0v 269.755n 0.0v 274.745n 0.0v 274.755n 0.0v 279.745n 0.0v 279.755n 1.1v 284.745n 1.1v 284.755n 1.1v 289.745n 1.1v 289.755n 1.1v 294.745n 1.1v 294.755n 1.1v 299.745n 1.1v 299.755n 0.0v 304.745n 0.0v 304.755n 0.0v 309.745n 0.0v 309.755n 0.0v 314.745n 0.0v 314.755n 1.1v 319.745n 1.1v 319.755n 1.1v 324.745n 1.1v 324.755n 1.1v 329.745n 1.1v 329.755n 1.1v 334.745n 1.1v 334.755n 0.0v 339.745n 0.0v 339.755n 1.1v 344.745n 1.1v 344.755n 1.1v 349.745n 1.1v 349.755n 1.1v 354.745n 1.1v 354.755n 1.1v 359.745n 1.1v 359.755n 0.0v 364.745n 0.0v 364.755n 0.0v 369.745n 0.0v 369.755n 0.0v 374.745n 0.0v 374.755n 0.0v 379.745n 0.0v 379.755n 0.0v 384.745n 0.0v 384.755n 0.0v 389.745n 0.0v 389.755n 0.0v 394.745n 0.0v 394.755n 1.1v 399.745n 1.1v 399.755n 0.0v 404.745n 0.0v 404.755n 0.0v 409.745n 0.0v 409.755n 0.0v 414.745n 0.0v 414.755n 1.1v 419.745n 1.1v 419.755n 0.0v 424.745n 0.0v 424.755n 1.1v 429.745n 1.1v 429.755n 0.0v 434.745n 0.0v 434.755n 0.0v 439.745n 0.0v 439.755n 0.0v 444.745n 0.0v 444.755n 0.0v 449.745n 0.0v 449.755n 1.1v 454.745n 1.1v 454.755n 1.1v 459.745n 1.1v 459.755n 1.1v 464.745n 1.1v 464.755n 1.1v 469.745n 1.1v 469.755n 1.1v 474.745n 1.1v 474.755n 1.1v 479.745n 1.1v 479.755n 1.1v 484.745n 1.1v 484.755n 1.1v 489.745n 1.1v 489.755n 1.1v 494.745n 1.1v 494.755n 1.1v 499.745n 1.1v 499.755n 1.1v 504.745n 1.1v 504.755n 0.0v 509.745n 0.0v 509.755n 1.1v 514.745n 1.1v 514.755n 0.0v 519.745n 0.0v 519.755n 0.0v 524.745n 0.0v 524.755n 0.0v 529.745n 0.0v 529.755n 0.0v 534.745n 0.0v 534.755n 1.1v 539.745n 1.1v 539.755n 0.0v 544.745n 0.0v 544.755n 0.0v 549.745n 0.0v 549.755n 0.0v 554.745n 0.0v 554.755n 0.0v 559.745n 0.0v 559.755n 0.0v 564.745n 0.0v 564.755n 0.0v 569.745n 0.0v 569.755n 0.0v 574.745n 0.0v 574.755n 1.1v 579.745n 1.1v 579.755n 1.1v 584.745n 1.1v 584.755n 1.1v 589.745n 1.1v 589.755n 1.1v 594.745n 1.1v 594.755n 1.1v 599.745n 1.1v 599.755n 1.1v 604.745n 1.1v 604.755n 1.1v 609.745n 1.1v 609.755n 1.1v 614.745n 1.1v 614.755n 1.1v 619.745n 1.1v 619.755n 1.1v 624.745n 1.1v 624.755n 1.1v 629.745n 1.1v 629.755n 1.1v 634.745n 1.1v 634.755n 0.0v 639.745n 0.0v 639.755n 0.0v 644.745n 0.0v 644.755n 0.0v 649.745n 0.0v 649.755n 0.0v 654.745n 0.0v 654.755n 0.0v 659.745n 0.0v 659.755n 0.0v 664.745n 0.0v 664.755n 0.0v 669.745n 0.0v 669.755n 0.0v 674.745n 0.0v 674.755n 0.0v 679.745n 0.0v 679.755n 0.0v 684.745n 0.0v 684.755n 0.0v 689.745n 0.0v 689.755n 0.0v 694.745n 0.0v 694.755n 0.0v 699.745n 0.0v 699.755n 0.0v 704.745n 0.0v 704.755n 1.1v 709.745n 1.1v 709.755n 1.1v 714.745n 1.1v 714.755n 0.0v 719.745n 0.0v 719.755n 0.0v 724.745n 0.0v 724.755n 0.0v 729.745n 0.0v 729.755n 0.0v 734.745n 0.0v 734.755n 1.1v 739.745n 1.1v 739.755n 1.1v 744.745n 1.1v 744.755n 1.1v 749.745n 1.1v 749.755n 1.1v 754.745n 1.1v 754.755n 1.1v 759.745n 1.1v 759.755n 1.1v 764.745n 1.1v 764.755n 1.1v 769.745n 1.1v 769.755n 1.1v 774.745n 1.1v 774.755n 1.1v 779.745n 1.1v 779.755n 1.1v 784.745n 1.1v 784.755n 1.1v 789.745n 1.1v 789.755n 0.0v 794.745n 0.0v 794.755n 0.0v 799.745n 0.0v 799.755n 0.0v 804.745n 0.0v 804.755n 0.0v 809.745n 0.0v 809.755n 0.0v 814.745n 0.0v 814.755n 0.0v 819.745n 0.0v 819.755n 0.0v 824.745n 0.0v 824.755n 0.0v 829.745n 0.0v 829.755n 0.0v 834.745n 0.0v 834.755n 0.0v 839.745n 0.0v 839.755n 0.0v 844.745n 0.0v 844.755n 0.0v 849.745n 0.0v 849.755n 0.0v 854.745n 0.0v 854.755n 0.0v 859.745n 0.0v 859.755n 0.0v 864.745n 0.0v 864.755n 1.1v 869.745n 1.1v 869.755n 0.0v 874.745n 0.0v 874.755n 1.1v 879.745n 1.1v 879.755n 0.0v 884.745n 0.0v 884.755n 0.0v 889.745n 0.0v 889.755n 0.0v 894.745n 0.0v 894.755n 0.0v 899.745n 0.0v 899.755n 0.0v 904.745n 0.0v 904.755n 0.0v 909.745n 0.0v 909.755n 0.0v 914.745n 0.0v 914.755n 0.0v 919.745n 0.0v 919.755n 0.0v 924.745n 0.0v 924.755n 0.0v 929.745n 0.0v 929.755n 1.1v 934.745n 1.1v 934.755n 1.1v 939.745n 1.1v 939.755n 1.1v 944.745n 1.1v 944.755n 1.1v 949.745n 1.1v 949.755n 1.1v 954.745n 1.1v 954.755n 1.1v 959.745n 1.1v 959.755n 1.1v 964.745n 1.1v 964.755n 1.1v 969.745n 1.1v 969.755n 1.1v 974.745n 1.1v 974.755n 1.1v 979.745n 1.1v 979.755n 0.0v 984.745n 0.0v 984.755n 0.0v 989.745n 0.0v 989.755n 0.0v 994.745n 0.0v 994.755n 0.0v 999.745n 0.0v 999.755n 1.1v 1004.745n 1.1v 1004.755n 1.1v 1009.745n 1.1v 1009.755n 1.1v 1014.745n 1.1v 1014.755n 1.1v 1019.745n 1.1v 1019.755n 1.1v 1024.745n 1.1v 1024.755n 1.1v )
* (time, data): [(0, 0), (5, 1), (10, 1), (15, 1), (20, 1), (25, 1), (30, 1), (35, 1), (40, 0), (45, 1), (50, 1), (55, 1), (60, 1), (65, 0), (70, 0), (75, 0), (80, 0), (85, 0), (90, 0), (95, 0), (100, 1), (105, 1), (110, 1), (115, 1), (120, 1), (125, 1), (130, 1), (135, 0), (140, 1), (145, 1), (150, 1), (155, 1), (160, 1), (165, 1), (170, 0), (175, 0), (180, 0), (185, 1), (190, 1), (195, 1), (200, 1), (205, 1), (210, 0), (215, 0), (220, 1), (225, 1), (230, 0), (235, 0), (240, 0), (245, 0), (250, 0), (255, 1), (260, 1), (265, 0), (270, 0), (275, 0), (280, 0), (285, 0), (290, 0), (295, 0), (300, 0), (305, 0), (310, 0), (315, 1), (320, 1), (325, 1), (330, 0), (335, 0), (340, 1), (345, 1), (350, 1), (355, 1), (360, 0), (365, 0), (370, 0), (375, 0), (380, 0), (385, 0), (390, 0), (395, 1), (400, 0), (405, 0), (410, 1), (415, 1), (420, 0), (425, 1), (430, 1), (435, 1), (440, 1), (445, 1), (450, 1), (455, 1), (460, 1), (465, 0), (470, 0), (475, 0), (480, 0), (485, 0), (490, 0), (495, 0), (500, 1), (505, 0), (510, 0), (515, 0), (520, 0), (525, 0), (530, 0), (535, 1), (540, 1), (545, 1), (550, 1), (555, 0), (560, 0), (565, 0), (570, 0), (575, 1), (580, 1), (585, 1), (590, 1), (595, 1), (600, 1), (605, 1), (610, 1), (615, 1), (620, 1), (625, 1), (630, 1), (635, 0), (640, 1), (645, 1), (650, 1), (655, 0), (660, 1), (665, 1), (670, 0), (675, 0), (680, 0), (685, 0), (690, 0), (695, 0), (700, 0), (705, 0), (710, 1), (715, 1), (720, 1), (725, 1), (730, 1), (735, 1), (740, 0), (745, 0), (750, 0), (755, 0), (760, 0), (765, 0), (770, 0), (775, 0), (780, 0), (785, 0), (790, 1), (795, 1), (800, 1), (805, 1), (810, 1), (815, 1), (820, 1), (825, 1), (830, 0), (835, 1), (840, 1), (845, 1), (850, 1), (855, 1), (860, 1), (865, 0), (870, 0), (875, 1), (880, 0), (885, 1), (890, 1), (895, 1), (900, 1), (905, 1), (910, 1), (915, 1), (920, 1), (925, 1), (930, 1), (935, 1), (940, 0), (945, 0), (950, 0), (955, 0), (960, 0), (965, 1), (970, 1), (975, 1), (980, 0), (985, 0), (990, 0), (995, 0), (1000, 1), (1005, 1), (1010, 1), (1015, 1), (1020, 0), (1025, 0)]
Vdin0_34  din0_34  0 PWL (0n 0.0v 4.745n 0.0v 4.755n 1.1v 9.745n 1.1v 9.755n 1.1v 14.745n 1.1v 14.755n 1.1v 19.745n 1.1v 19.755n 1.1v 24.745n 1.1v 24.755n 1.1v 29.745n 1.1v 29.755n 1.1v 34.745n 1.1v 34.755n 1.1v 39.745n 1.1v 39.755n 0.0v 44.745n 0.0v 44.755n 1.1v 49.745n 1.1v 49.755n 1.1v 54.745n 1.1v 54.755n 1.1v 59.745n 1.1v 59.755n 1.1v 64.745n 1.1v 64.755n 0.0v 69.745n 0.0v 69.755n 0.0v 74.745n 0.0v 74.755n 0.0v 79.745n 0.0v 79.755n 0.0v 84.745n 0.0v 84.755n 0.0v 89.745n 0.0v 89.755n 0.0v 94.745n 0.0v 94.755n 0.0v 99.745n 0.0v 99.755n 1.1v 104.745n 1.1v 104.755n 1.1v 109.745n 1.1v 109.755n 1.1v 114.745n 1.1v 114.755n 1.1v 119.745n 1.1v 119.755n 1.1v 124.745n 1.1v 124.755n 1.1v 129.745n 1.1v 129.755n 1.1v 134.745n 1.1v 134.755n 0.0v 139.745n 0.0v 139.755n 1.1v 144.745n 1.1v 144.755n 1.1v 149.745n 1.1v 149.755n 1.1v 154.745n 1.1v 154.755n 1.1v 159.745n 1.1v 159.755n 1.1v 164.745n 1.1v 164.755n 1.1v 169.745n 1.1v 169.755n 0.0v 174.745n 0.0v 174.755n 0.0v 179.745n 0.0v 179.755n 0.0v 184.745n 0.0v 184.755n 1.1v 189.745n 1.1v 189.755n 1.1v 194.745n 1.1v 194.755n 1.1v 199.745n 1.1v 199.755n 1.1v 204.745n 1.1v 204.755n 1.1v 209.745n 1.1v 209.755n 0.0v 214.745n 0.0v 214.755n 0.0v 219.745n 0.0v 219.755n 1.1v 224.745n 1.1v 224.755n 1.1v 229.745n 1.1v 229.755n 0.0v 234.745n 0.0v 234.755n 0.0v 239.745n 0.0v 239.755n 0.0v 244.745n 0.0v 244.755n 0.0v 249.745n 0.0v 249.755n 0.0v 254.745n 0.0v 254.755n 1.1v 259.745n 1.1v 259.755n 1.1v 264.745n 1.1v 264.755n 0.0v 269.745n 0.0v 269.755n 0.0v 274.745n 0.0v 274.755n 0.0v 279.745n 0.0v 279.755n 0.0v 284.745n 0.0v 284.755n 0.0v 289.745n 0.0v 289.755n 0.0v 294.745n 0.0v 294.755n 0.0v 299.745n 0.0v 299.755n 0.0v 304.745n 0.0v 304.755n 0.0v 309.745n 0.0v 309.755n 0.0v 314.745n 0.0v 314.755n 1.1v 319.745n 1.1v 319.755n 1.1v 324.745n 1.1v 324.755n 1.1v 329.745n 1.1v 329.755n 0.0v 334.745n 0.0v 334.755n 0.0v 339.745n 0.0v 339.755n 1.1v 344.745n 1.1v 344.755n 1.1v 349.745n 1.1v 349.755n 1.1v 354.745n 1.1v 354.755n 1.1v 359.745n 1.1v 359.755n 0.0v 364.745n 0.0v 364.755n 0.0v 369.745n 0.0v 369.755n 0.0v 374.745n 0.0v 374.755n 0.0v 379.745n 0.0v 379.755n 0.0v 384.745n 0.0v 384.755n 0.0v 389.745n 0.0v 389.755n 0.0v 394.745n 0.0v 394.755n 1.1v 399.745n 1.1v 399.755n 0.0v 404.745n 0.0v 404.755n 0.0v 409.745n 0.0v 409.755n 1.1v 414.745n 1.1v 414.755n 1.1v 419.745n 1.1v 419.755n 0.0v 424.745n 0.0v 424.755n 1.1v 429.745n 1.1v 429.755n 1.1v 434.745n 1.1v 434.755n 1.1v 439.745n 1.1v 439.755n 1.1v 444.745n 1.1v 444.755n 1.1v 449.745n 1.1v 449.755n 1.1v 454.745n 1.1v 454.755n 1.1v 459.745n 1.1v 459.755n 1.1v 464.745n 1.1v 464.755n 0.0v 469.745n 0.0v 469.755n 0.0v 474.745n 0.0v 474.755n 0.0v 479.745n 0.0v 479.755n 0.0v 484.745n 0.0v 484.755n 0.0v 489.745n 0.0v 489.755n 0.0v 494.745n 0.0v 494.755n 0.0v 499.745n 0.0v 499.755n 1.1v 504.745n 1.1v 504.755n 0.0v 509.745n 0.0v 509.755n 0.0v 514.745n 0.0v 514.755n 0.0v 519.745n 0.0v 519.755n 0.0v 524.745n 0.0v 524.755n 0.0v 529.745n 0.0v 529.755n 0.0v 534.745n 0.0v 534.755n 1.1v 539.745n 1.1v 539.755n 1.1v 544.745n 1.1v 544.755n 1.1v 549.745n 1.1v 549.755n 1.1v 554.745n 1.1v 554.755n 0.0v 559.745n 0.0v 559.755n 0.0v 564.745n 0.0v 564.755n 0.0v 569.745n 0.0v 569.755n 0.0v 574.745n 0.0v 574.755n 1.1v 579.745n 1.1v 579.755n 1.1v 584.745n 1.1v 584.755n 1.1v 589.745n 1.1v 589.755n 1.1v 594.745n 1.1v 594.755n 1.1v 599.745n 1.1v 599.755n 1.1v 604.745n 1.1v 604.755n 1.1v 609.745n 1.1v 609.755n 1.1v 614.745n 1.1v 614.755n 1.1v 619.745n 1.1v 619.755n 1.1v 624.745n 1.1v 624.755n 1.1v 629.745n 1.1v 629.755n 1.1v 634.745n 1.1v 634.755n 0.0v 639.745n 0.0v 639.755n 1.1v 644.745n 1.1v 644.755n 1.1v 649.745n 1.1v 649.755n 1.1v 654.745n 1.1v 654.755n 0.0v 659.745n 0.0v 659.755n 1.1v 664.745n 1.1v 664.755n 1.1v 669.745n 1.1v 669.755n 0.0v 674.745n 0.0v 674.755n 0.0v 679.745n 0.0v 679.755n 0.0v 684.745n 0.0v 684.755n 0.0v 689.745n 0.0v 689.755n 0.0v 694.745n 0.0v 694.755n 0.0v 699.745n 0.0v 699.755n 0.0v 704.745n 0.0v 704.755n 0.0v 709.745n 0.0v 709.755n 1.1v 714.745n 1.1v 714.755n 1.1v 719.745n 1.1v 719.755n 1.1v 724.745n 1.1v 724.755n 1.1v 729.745n 1.1v 729.755n 1.1v 734.745n 1.1v 734.755n 1.1v 739.745n 1.1v 739.755n 0.0v 744.745n 0.0v 744.755n 0.0v 749.745n 0.0v 749.755n 0.0v 754.745n 0.0v 754.755n 0.0v 759.745n 0.0v 759.755n 0.0v 764.745n 0.0v 764.755n 0.0v 769.745n 0.0v 769.755n 0.0v 774.745n 0.0v 774.755n 0.0v 779.745n 0.0v 779.755n 0.0v 784.745n 0.0v 784.755n 0.0v 789.745n 0.0v 789.755n 1.1v 794.745n 1.1v 794.755n 1.1v 799.745n 1.1v 799.755n 1.1v 804.745n 1.1v 804.755n 1.1v 809.745n 1.1v 809.755n 1.1v 814.745n 1.1v 814.755n 1.1v 819.745n 1.1v 819.755n 1.1v 824.745n 1.1v 824.755n 1.1v 829.745n 1.1v 829.755n 0.0v 834.745n 0.0v 834.755n 1.1v 839.745n 1.1v 839.755n 1.1v 844.745n 1.1v 844.755n 1.1v 849.745n 1.1v 849.755n 1.1v 854.745n 1.1v 854.755n 1.1v 859.745n 1.1v 859.755n 1.1v 864.745n 1.1v 864.755n 0.0v 869.745n 0.0v 869.755n 0.0v 874.745n 0.0v 874.755n 1.1v 879.745n 1.1v 879.755n 0.0v 884.745n 0.0v 884.755n 1.1v 889.745n 1.1v 889.755n 1.1v 894.745n 1.1v 894.755n 1.1v 899.745n 1.1v 899.755n 1.1v 904.745n 1.1v 904.755n 1.1v 909.745n 1.1v 909.755n 1.1v 914.745n 1.1v 914.755n 1.1v 919.745n 1.1v 919.755n 1.1v 924.745n 1.1v 924.755n 1.1v 929.745n 1.1v 929.755n 1.1v 934.745n 1.1v 934.755n 1.1v 939.745n 1.1v 939.755n 0.0v 944.745n 0.0v 944.755n 0.0v 949.745n 0.0v 949.755n 0.0v 954.745n 0.0v 954.755n 0.0v 959.745n 0.0v 959.755n 0.0v 964.745n 0.0v 964.755n 1.1v 969.745n 1.1v 969.755n 1.1v 974.745n 1.1v 974.755n 1.1v 979.745n 1.1v 979.755n 0.0v 984.745n 0.0v 984.755n 0.0v 989.745n 0.0v 989.755n 0.0v 994.745n 0.0v 994.755n 0.0v 999.745n 0.0v 999.755n 1.1v 1004.745n 1.1v 1004.755n 1.1v 1009.745n 1.1v 1009.755n 1.1v 1014.745n 1.1v 1014.755n 1.1v 1019.745n 1.1v 1019.755n 0.0v 1024.745n 0.0v 1024.755n 0.0v )
* (time, data): [(0, 0), (5, 1), (10, 1), (15, 1), (20, 1), (25, 1), (30, 0), (35, 0), (40, 1), (45, 1), (50, 1), (55, 1), (60, 1), (65, 1), (70, 1), (75, 1), (80, 1), (85, 1), (90, 1), (95, 1), (100, 0), (105, 0), (110, 0), (115, 0), (120, 0), (125, 0), (130, 0), (135, 1), (140, 0), (145, 0), (150, 0), (155, 0), (160, 0), (165, 0), (170, 1), (175, 1), (180, 1), (185, 0), (190, 0), (195, 0), (200, 0), (205, 0), (210, 1), (215, 1), (220, 0), (225, 0), (230, 0), (235, 0), (240, 1), (245, 1), (250, 1), (255, 0), (260, 0), (265, 1), (270, 1), (275, 1), (280, 0), (285, 0), (290, 0), (295, 0), (300, 0), (305, 0), (310, 0), (315, 1), (320, 1), (325, 1), (330, 0), (335, 0), (340, 0), (345, 0), (350, 0), (355, 0), (360, 1), (365, 1), (370, 1), (375, 1), (380, 1), (385, 1), (390, 1), (395, 0), (400, 0), (405, 0), (410, 1), (415, 1), (420, 0), (425, 1), (430, 1), (435, 1), (440, 1), (445, 1), (450, 1), (455, 1), (460, 0), (465, 0), (470, 0), (475, 0), (480, 1), (485, 1), (490, 1), (495, 1), (500, 1), (505, 0), (510, 0), (515, 0), (520, 0), (525, 0), (530, 0), (535, 1), (540, 1), (545, 1), (550, 1), (555, 1), (560, 1), (565, 1), (570, 1), (575, 1), (580, 1), (585, 1), (590, 1), (595, 1), (600, 1), (605, 1), (610, 1), (615, 1), (620, 1), (625, 1), (630, 1), (635, 1), (640, 1), (645, 1), (650, 1), (655, 0), (660, 0), (665, 0), (670, 0), (675, 0), (680, 0), (685, 0), (690, 0), (695, 0), (700, 0), (705, 0), (710, 0), (715, 0), (720, 0), (725, 0), (730, 0), (735, 1), (740, 0), (745, 0), (750, 0), (755, 0), (760, 0), (765, 0), (770, 1), (775, 0), (780, 0), (785, 1), (790, 0), (795, 0), (800, 0), (805, 0), (810, 0), (815, 0), (820, 1), (825, 1), (830, 1), (835, 1), (840, 1), (845, 1), (850, 1), (855, 0), (860, 0), (865, 1), (870, 0), (875, 1), (880, 0), (885, 1), (890, 1), (895, 1), (900, 1), (905, 1), (910, 1), (915, 1), (920, 1), (925, 1), (930, 0), (935, 1), (940, 1), (945, 1), (950, 1), (955, 1), (960, 1), (965, 1), (970, 1), (975, 1), (980, 0), (985, 0), (990, 0), (995, 0), (1000, 0), (1005, 0), (1010, 0), (1015, 0), (1020, 1), (1025, 1)]
Vdin0_35  din0_35  0 PWL (0n 0.0v 4.745n 0.0v 4.755n 1.1v 9.745n 1.1v 9.755n 1.1v 14.745n 1.1v 14.755n 1.1v 19.745n 1.1v 19.755n 1.1v 24.745n 1.1v 24.755n 1.1v 29.745n 1.1v 29.755n 0.0v 34.745n 0.0v 34.755n 0.0v 39.745n 0.0v 39.755n 1.1v 44.745n 1.1v 44.755n 1.1v 49.745n 1.1v 49.755n 1.1v 54.745n 1.1v 54.755n 1.1v 59.745n 1.1v 59.755n 1.1v 64.745n 1.1v 64.755n 1.1v 69.745n 1.1v 69.755n 1.1v 74.745n 1.1v 74.755n 1.1v 79.745n 1.1v 79.755n 1.1v 84.745n 1.1v 84.755n 1.1v 89.745n 1.1v 89.755n 1.1v 94.745n 1.1v 94.755n 1.1v 99.745n 1.1v 99.755n 0.0v 104.745n 0.0v 104.755n 0.0v 109.745n 0.0v 109.755n 0.0v 114.745n 0.0v 114.755n 0.0v 119.745n 0.0v 119.755n 0.0v 124.745n 0.0v 124.755n 0.0v 129.745n 0.0v 129.755n 0.0v 134.745n 0.0v 134.755n 1.1v 139.745n 1.1v 139.755n 0.0v 144.745n 0.0v 144.755n 0.0v 149.745n 0.0v 149.755n 0.0v 154.745n 0.0v 154.755n 0.0v 159.745n 0.0v 159.755n 0.0v 164.745n 0.0v 164.755n 0.0v 169.745n 0.0v 169.755n 1.1v 174.745n 1.1v 174.755n 1.1v 179.745n 1.1v 179.755n 1.1v 184.745n 1.1v 184.755n 0.0v 189.745n 0.0v 189.755n 0.0v 194.745n 0.0v 194.755n 0.0v 199.745n 0.0v 199.755n 0.0v 204.745n 0.0v 204.755n 0.0v 209.745n 0.0v 209.755n 1.1v 214.745n 1.1v 214.755n 1.1v 219.745n 1.1v 219.755n 0.0v 224.745n 0.0v 224.755n 0.0v 229.745n 0.0v 229.755n 0.0v 234.745n 0.0v 234.755n 0.0v 239.745n 0.0v 239.755n 1.1v 244.745n 1.1v 244.755n 1.1v 249.745n 1.1v 249.755n 1.1v 254.745n 1.1v 254.755n 0.0v 259.745n 0.0v 259.755n 0.0v 264.745n 0.0v 264.755n 1.1v 269.745n 1.1v 269.755n 1.1v 274.745n 1.1v 274.755n 1.1v 279.745n 1.1v 279.755n 0.0v 284.745n 0.0v 284.755n 0.0v 289.745n 0.0v 289.755n 0.0v 294.745n 0.0v 294.755n 0.0v 299.745n 0.0v 299.755n 0.0v 304.745n 0.0v 304.755n 0.0v 309.745n 0.0v 309.755n 0.0v 314.745n 0.0v 314.755n 1.1v 319.745n 1.1v 319.755n 1.1v 324.745n 1.1v 324.755n 1.1v 329.745n 1.1v 329.755n 0.0v 334.745n 0.0v 334.755n 0.0v 339.745n 0.0v 339.755n 0.0v 344.745n 0.0v 344.755n 0.0v 349.745n 0.0v 349.755n 0.0v 354.745n 0.0v 354.755n 0.0v 359.745n 0.0v 359.755n 1.1v 364.745n 1.1v 364.755n 1.1v 369.745n 1.1v 369.755n 1.1v 374.745n 1.1v 374.755n 1.1v 379.745n 1.1v 379.755n 1.1v 384.745n 1.1v 384.755n 1.1v 389.745n 1.1v 389.755n 1.1v 394.745n 1.1v 394.755n 0.0v 399.745n 0.0v 399.755n 0.0v 404.745n 0.0v 404.755n 0.0v 409.745n 0.0v 409.755n 1.1v 414.745n 1.1v 414.755n 1.1v 419.745n 1.1v 419.755n 0.0v 424.745n 0.0v 424.755n 1.1v 429.745n 1.1v 429.755n 1.1v 434.745n 1.1v 434.755n 1.1v 439.745n 1.1v 439.755n 1.1v 444.745n 1.1v 444.755n 1.1v 449.745n 1.1v 449.755n 1.1v 454.745n 1.1v 454.755n 1.1v 459.745n 1.1v 459.755n 0.0v 464.745n 0.0v 464.755n 0.0v 469.745n 0.0v 469.755n 0.0v 474.745n 0.0v 474.755n 0.0v 479.745n 0.0v 479.755n 1.1v 484.745n 1.1v 484.755n 1.1v 489.745n 1.1v 489.755n 1.1v 494.745n 1.1v 494.755n 1.1v 499.745n 1.1v 499.755n 1.1v 504.745n 1.1v 504.755n 0.0v 509.745n 0.0v 509.755n 0.0v 514.745n 0.0v 514.755n 0.0v 519.745n 0.0v 519.755n 0.0v 524.745n 0.0v 524.755n 0.0v 529.745n 0.0v 529.755n 0.0v 534.745n 0.0v 534.755n 1.1v 539.745n 1.1v 539.755n 1.1v 544.745n 1.1v 544.755n 1.1v 549.745n 1.1v 549.755n 1.1v 554.745n 1.1v 554.755n 1.1v 559.745n 1.1v 559.755n 1.1v 564.745n 1.1v 564.755n 1.1v 569.745n 1.1v 569.755n 1.1v 574.745n 1.1v 574.755n 1.1v 579.745n 1.1v 579.755n 1.1v 584.745n 1.1v 584.755n 1.1v 589.745n 1.1v 589.755n 1.1v 594.745n 1.1v 594.755n 1.1v 599.745n 1.1v 599.755n 1.1v 604.745n 1.1v 604.755n 1.1v 609.745n 1.1v 609.755n 1.1v 614.745n 1.1v 614.755n 1.1v 619.745n 1.1v 619.755n 1.1v 624.745n 1.1v 624.755n 1.1v 629.745n 1.1v 629.755n 1.1v 634.745n 1.1v 634.755n 1.1v 639.745n 1.1v 639.755n 1.1v 644.745n 1.1v 644.755n 1.1v 649.745n 1.1v 649.755n 1.1v 654.745n 1.1v 654.755n 0.0v 659.745n 0.0v 659.755n 0.0v 664.745n 0.0v 664.755n 0.0v 669.745n 0.0v 669.755n 0.0v 674.745n 0.0v 674.755n 0.0v 679.745n 0.0v 679.755n 0.0v 684.745n 0.0v 684.755n 0.0v 689.745n 0.0v 689.755n 0.0v 694.745n 0.0v 694.755n 0.0v 699.745n 0.0v 699.755n 0.0v 704.745n 0.0v 704.755n 0.0v 709.745n 0.0v 709.755n 0.0v 714.745n 0.0v 714.755n 0.0v 719.745n 0.0v 719.755n 0.0v 724.745n 0.0v 724.755n 0.0v 729.745n 0.0v 729.755n 0.0v 734.745n 0.0v 734.755n 1.1v 739.745n 1.1v 739.755n 0.0v 744.745n 0.0v 744.755n 0.0v 749.745n 0.0v 749.755n 0.0v 754.745n 0.0v 754.755n 0.0v 759.745n 0.0v 759.755n 0.0v 764.745n 0.0v 764.755n 0.0v 769.745n 0.0v 769.755n 1.1v 774.745n 1.1v 774.755n 0.0v 779.745n 0.0v 779.755n 0.0v 784.745n 0.0v 784.755n 1.1v 789.745n 1.1v 789.755n 0.0v 794.745n 0.0v 794.755n 0.0v 799.745n 0.0v 799.755n 0.0v 804.745n 0.0v 804.755n 0.0v 809.745n 0.0v 809.755n 0.0v 814.745n 0.0v 814.755n 0.0v 819.745n 0.0v 819.755n 1.1v 824.745n 1.1v 824.755n 1.1v 829.745n 1.1v 829.755n 1.1v 834.745n 1.1v 834.755n 1.1v 839.745n 1.1v 839.755n 1.1v 844.745n 1.1v 844.755n 1.1v 849.745n 1.1v 849.755n 1.1v 854.745n 1.1v 854.755n 0.0v 859.745n 0.0v 859.755n 0.0v 864.745n 0.0v 864.755n 1.1v 869.745n 1.1v 869.755n 0.0v 874.745n 0.0v 874.755n 1.1v 879.745n 1.1v 879.755n 0.0v 884.745n 0.0v 884.755n 1.1v 889.745n 1.1v 889.755n 1.1v 894.745n 1.1v 894.755n 1.1v 899.745n 1.1v 899.755n 1.1v 904.745n 1.1v 904.755n 1.1v 909.745n 1.1v 909.755n 1.1v 914.745n 1.1v 914.755n 1.1v 919.745n 1.1v 919.755n 1.1v 924.745n 1.1v 924.755n 1.1v 929.745n 1.1v 929.755n 0.0v 934.745n 0.0v 934.755n 1.1v 939.745n 1.1v 939.755n 1.1v 944.745n 1.1v 944.755n 1.1v 949.745n 1.1v 949.755n 1.1v 954.745n 1.1v 954.755n 1.1v 959.745n 1.1v 959.755n 1.1v 964.745n 1.1v 964.755n 1.1v 969.745n 1.1v 969.755n 1.1v 974.745n 1.1v 974.755n 1.1v 979.745n 1.1v 979.755n 0.0v 984.745n 0.0v 984.755n 0.0v 989.745n 0.0v 989.755n 0.0v 994.745n 0.0v 994.755n 0.0v 999.745n 0.0v 999.755n 0.0v 1004.745n 0.0v 1004.755n 0.0v 1009.745n 0.0v 1009.755n 0.0v 1014.745n 0.0v 1014.755n 0.0v 1019.745n 0.0v 1019.755n 1.1v 1024.745n 1.1v 1024.755n 1.1v )
* (time, data): [(0, 0), (5, 1), (10, 0), (15, 1), (20, 1), (25, 1), (30, 0), (35, 0), (40, 0), (45, 0), (50, 0), (55, 0), (60, 1), (65, 1), (70, 1), (75, 1), (80, 1), (85, 1), (90, 0), (95, 0), (100, 0), (105, 0), (110, 0), (115, 0), (120, 0), (125, 0), (130, 0), (135, 1), (140, 1), (145, 1), (150, 1), (155, 1), (160, 1), (165, 1), (170, 0), (175, 0), (180, 0), (185, 0), (190, 0), (195, 0), (200, 0), (205, 0), (210, 1), (215, 1), (220, 0), (225, 0), (230, 0), (235, 0), (240, 0), (245, 0), (250, 0), (255, 0), (260, 0), (265, 0), (270, 0), (275, 0), (280, 0), (285, 0), (290, 0), (295, 0), (300, 0), (305, 0), (310, 0), (315, 0), (320, 0), (325, 0), (330, 1), (335, 1), (340, 1), (345, 1), (350, 1), (355, 1), (360, 1), (365, 1), (370, 1), (375, 1), (380, 1), (385, 1), (390, 1), (395, 0), (400, 0), (405, 0), (410, 0), (415, 0), (420, 0), (425, 0), (430, 1), (435, 1), (440, 1), (445, 1), (450, 1), (455, 1), (460, 0), (465, 1), (470, 1), (475, 1), (480, 0), (485, 0), (490, 0), (495, 1), (500, 0), (505, 1), (510, 0), (515, 1), (520, 1), (525, 1), (530, 1), (535, 1), (540, 1), (545, 1), (550, 1), (555, 0), (560, 0), (565, 0), (570, 0), (575, 0), (580, 0), (585, 0), (590, 0), (595, 0), (600, 0), (605, 0), (610, 0), (615, 0), (620, 0), (625, 0), (630, 0), (635, 1), (640, 1), (645, 1), (650, 1), (655, 0), (660, 0), (665, 0), (670, 0), (675, 0), (680, 0), (685, 0), (690, 0), (695, 0), (700, 0), (705, 0), (710, 1), (715, 1), (720, 1), (725, 1), (730, 1), (735, 1), (740, 0), (745, 0), (750, 0), (755, 0), (760, 0), (765, 0), (770, 0), (775, 1), (780, 1), (785, 1), (790, 1), (795, 1), (800, 1), (805, 1), (810, 1), (815, 1), (820, 1), (825, 1), (830, 0), (835, 0), (840, 0), (845, 0), (850, 0), (855, 0), (860, 1), (865, 1), (870, 0), (875, 1), (880, 0), (885, 0), (890, 0), (895, 0), (900, 0), (905, 0), (910, 1), (915, 1), (920, 1), (925, 1), (930, 1), (935, 1), (940, 0), (945, 0), (950, 0), (955, 0), (960, 0), (965, 0), (970, 0), (975, 0), (980, 1), (985, 1), (990, 1), (995, 1), (1000, 0), (1005, 0), (1010, 0), (1015, 0), (1020, 1), (1025, 1)]
Vdin0_36  din0_36  0 PWL (0n 0.0v 4.745n 0.0v 4.755n 1.1v 9.745n 1.1v 9.755n 0.0v 14.745n 0.0v 14.755n 1.1v 19.745n 1.1v 19.755n 1.1v 24.745n 1.1v 24.755n 1.1v 29.745n 1.1v 29.755n 0.0v 34.745n 0.0v 34.755n 0.0v 39.745n 0.0v 39.755n 0.0v 44.745n 0.0v 44.755n 0.0v 49.745n 0.0v 49.755n 0.0v 54.745n 0.0v 54.755n 0.0v 59.745n 0.0v 59.755n 1.1v 64.745n 1.1v 64.755n 1.1v 69.745n 1.1v 69.755n 1.1v 74.745n 1.1v 74.755n 1.1v 79.745n 1.1v 79.755n 1.1v 84.745n 1.1v 84.755n 1.1v 89.745n 1.1v 89.755n 0.0v 94.745n 0.0v 94.755n 0.0v 99.745n 0.0v 99.755n 0.0v 104.745n 0.0v 104.755n 0.0v 109.745n 0.0v 109.755n 0.0v 114.745n 0.0v 114.755n 0.0v 119.745n 0.0v 119.755n 0.0v 124.745n 0.0v 124.755n 0.0v 129.745n 0.0v 129.755n 0.0v 134.745n 0.0v 134.755n 1.1v 139.745n 1.1v 139.755n 1.1v 144.745n 1.1v 144.755n 1.1v 149.745n 1.1v 149.755n 1.1v 154.745n 1.1v 154.755n 1.1v 159.745n 1.1v 159.755n 1.1v 164.745n 1.1v 164.755n 1.1v 169.745n 1.1v 169.755n 0.0v 174.745n 0.0v 174.755n 0.0v 179.745n 0.0v 179.755n 0.0v 184.745n 0.0v 184.755n 0.0v 189.745n 0.0v 189.755n 0.0v 194.745n 0.0v 194.755n 0.0v 199.745n 0.0v 199.755n 0.0v 204.745n 0.0v 204.755n 0.0v 209.745n 0.0v 209.755n 1.1v 214.745n 1.1v 214.755n 1.1v 219.745n 1.1v 219.755n 0.0v 224.745n 0.0v 224.755n 0.0v 229.745n 0.0v 229.755n 0.0v 234.745n 0.0v 234.755n 0.0v 239.745n 0.0v 239.755n 0.0v 244.745n 0.0v 244.755n 0.0v 249.745n 0.0v 249.755n 0.0v 254.745n 0.0v 254.755n 0.0v 259.745n 0.0v 259.755n 0.0v 264.745n 0.0v 264.755n 0.0v 269.745n 0.0v 269.755n 0.0v 274.745n 0.0v 274.755n 0.0v 279.745n 0.0v 279.755n 0.0v 284.745n 0.0v 284.755n 0.0v 289.745n 0.0v 289.755n 0.0v 294.745n 0.0v 294.755n 0.0v 299.745n 0.0v 299.755n 0.0v 304.745n 0.0v 304.755n 0.0v 309.745n 0.0v 309.755n 0.0v 314.745n 0.0v 314.755n 0.0v 319.745n 0.0v 319.755n 0.0v 324.745n 0.0v 324.755n 0.0v 329.745n 0.0v 329.755n 1.1v 334.745n 1.1v 334.755n 1.1v 339.745n 1.1v 339.755n 1.1v 344.745n 1.1v 344.755n 1.1v 349.745n 1.1v 349.755n 1.1v 354.745n 1.1v 354.755n 1.1v 359.745n 1.1v 359.755n 1.1v 364.745n 1.1v 364.755n 1.1v 369.745n 1.1v 369.755n 1.1v 374.745n 1.1v 374.755n 1.1v 379.745n 1.1v 379.755n 1.1v 384.745n 1.1v 384.755n 1.1v 389.745n 1.1v 389.755n 1.1v 394.745n 1.1v 394.755n 0.0v 399.745n 0.0v 399.755n 0.0v 404.745n 0.0v 404.755n 0.0v 409.745n 0.0v 409.755n 0.0v 414.745n 0.0v 414.755n 0.0v 419.745n 0.0v 419.755n 0.0v 424.745n 0.0v 424.755n 0.0v 429.745n 0.0v 429.755n 1.1v 434.745n 1.1v 434.755n 1.1v 439.745n 1.1v 439.755n 1.1v 444.745n 1.1v 444.755n 1.1v 449.745n 1.1v 449.755n 1.1v 454.745n 1.1v 454.755n 1.1v 459.745n 1.1v 459.755n 0.0v 464.745n 0.0v 464.755n 1.1v 469.745n 1.1v 469.755n 1.1v 474.745n 1.1v 474.755n 1.1v 479.745n 1.1v 479.755n 0.0v 484.745n 0.0v 484.755n 0.0v 489.745n 0.0v 489.755n 0.0v 494.745n 0.0v 494.755n 1.1v 499.745n 1.1v 499.755n 0.0v 504.745n 0.0v 504.755n 1.1v 509.745n 1.1v 509.755n 0.0v 514.745n 0.0v 514.755n 1.1v 519.745n 1.1v 519.755n 1.1v 524.745n 1.1v 524.755n 1.1v 529.745n 1.1v 529.755n 1.1v 534.745n 1.1v 534.755n 1.1v 539.745n 1.1v 539.755n 1.1v 544.745n 1.1v 544.755n 1.1v 549.745n 1.1v 549.755n 1.1v 554.745n 1.1v 554.755n 0.0v 559.745n 0.0v 559.755n 0.0v 564.745n 0.0v 564.755n 0.0v 569.745n 0.0v 569.755n 0.0v 574.745n 0.0v 574.755n 0.0v 579.745n 0.0v 579.755n 0.0v 584.745n 0.0v 584.755n 0.0v 589.745n 0.0v 589.755n 0.0v 594.745n 0.0v 594.755n 0.0v 599.745n 0.0v 599.755n 0.0v 604.745n 0.0v 604.755n 0.0v 609.745n 0.0v 609.755n 0.0v 614.745n 0.0v 614.755n 0.0v 619.745n 0.0v 619.755n 0.0v 624.745n 0.0v 624.755n 0.0v 629.745n 0.0v 629.755n 0.0v 634.745n 0.0v 634.755n 1.1v 639.745n 1.1v 639.755n 1.1v 644.745n 1.1v 644.755n 1.1v 649.745n 1.1v 649.755n 1.1v 654.745n 1.1v 654.755n 0.0v 659.745n 0.0v 659.755n 0.0v 664.745n 0.0v 664.755n 0.0v 669.745n 0.0v 669.755n 0.0v 674.745n 0.0v 674.755n 0.0v 679.745n 0.0v 679.755n 0.0v 684.745n 0.0v 684.755n 0.0v 689.745n 0.0v 689.755n 0.0v 694.745n 0.0v 694.755n 0.0v 699.745n 0.0v 699.755n 0.0v 704.745n 0.0v 704.755n 0.0v 709.745n 0.0v 709.755n 1.1v 714.745n 1.1v 714.755n 1.1v 719.745n 1.1v 719.755n 1.1v 724.745n 1.1v 724.755n 1.1v 729.745n 1.1v 729.755n 1.1v 734.745n 1.1v 734.755n 1.1v 739.745n 1.1v 739.755n 0.0v 744.745n 0.0v 744.755n 0.0v 749.745n 0.0v 749.755n 0.0v 754.745n 0.0v 754.755n 0.0v 759.745n 0.0v 759.755n 0.0v 764.745n 0.0v 764.755n 0.0v 769.745n 0.0v 769.755n 0.0v 774.745n 0.0v 774.755n 1.1v 779.745n 1.1v 779.755n 1.1v 784.745n 1.1v 784.755n 1.1v 789.745n 1.1v 789.755n 1.1v 794.745n 1.1v 794.755n 1.1v 799.745n 1.1v 799.755n 1.1v 804.745n 1.1v 804.755n 1.1v 809.745n 1.1v 809.755n 1.1v 814.745n 1.1v 814.755n 1.1v 819.745n 1.1v 819.755n 1.1v 824.745n 1.1v 824.755n 1.1v 829.745n 1.1v 829.755n 0.0v 834.745n 0.0v 834.755n 0.0v 839.745n 0.0v 839.755n 0.0v 844.745n 0.0v 844.755n 0.0v 849.745n 0.0v 849.755n 0.0v 854.745n 0.0v 854.755n 0.0v 859.745n 0.0v 859.755n 1.1v 864.745n 1.1v 864.755n 1.1v 869.745n 1.1v 869.755n 0.0v 874.745n 0.0v 874.755n 1.1v 879.745n 1.1v 879.755n 0.0v 884.745n 0.0v 884.755n 0.0v 889.745n 0.0v 889.755n 0.0v 894.745n 0.0v 894.755n 0.0v 899.745n 0.0v 899.755n 0.0v 904.745n 0.0v 904.755n 0.0v 909.745n 0.0v 909.755n 1.1v 914.745n 1.1v 914.755n 1.1v 919.745n 1.1v 919.755n 1.1v 924.745n 1.1v 924.755n 1.1v 929.745n 1.1v 929.755n 1.1v 934.745n 1.1v 934.755n 1.1v 939.745n 1.1v 939.755n 0.0v 944.745n 0.0v 944.755n 0.0v 949.745n 0.0v 949.755n 0.0v 954.745n 0.0v 954.755n 0.0v 959.745n 0.0v 959.755n 0.0v 964.745n 0.0v 964.755n 0.0v 969.745n 0.0v 969.755n 0.0v 974.745n 0.0v 974.755n 0.0v 979.745n 0.0v 979.755n 1.1v 984.745n 1.1v 984.755n 1.1v 989.745n 1.1v 989.755n 1.1v 994.745n 1.1v 994.755n 1.1v 999.745n 1.1v 999.755n 0.0v 1004.745n 0.0v 1004.755n 0.0v 1009.745n 0.0v 1009.755n 0.0v 1014.745n 0.0v 1014.755n 0.0v 1019.745n 0.0v 1019.755n 1.1v 1024.745n 1.1v 1024.755n 1.1v )
* (time, data): [(0, 0), (5, 1), (10, 1), (15, 1), (20, 1), (25, 1), (30, 0), (35, 0), (40, 1), (45, 1), (50, 1), (55, 1), (60, 1), (65, 0), (70, 0), (75, 0), (80, 0), (85, 0), (90, 1), (95, 1), (100, 1), (105, 1), (110, 1), (115, 1), (120, 1), (125, 1), (130, 1), (135, 1), (140, 0), (145, 0), (150, 0), (155, 0), (160, 0), (165, 0), (170, 0), (175, 0), (180, 0), (185, 1), (190, 1), (195, 1), (200, 0), (205, 0), (210, 0), (215, 0), (220, 0), (225, 0), (230, 0), (235, 0), (240, 1), (245, 1), (250, 1), (255, 0), (260, 0), (265, 1), (270, 1), (275, 1), (280, 1), (285, 1), (290, 1), (295, 1), (300, 1), (305, 1), (310, 1), (315, 1), (320, 1), (325, 1), (330, 0), (335, 1), (340, 0), (345, 0), (350, 0), (355, 0), (360, 1), (365, 1), (370, 1), (375, 1), (380, 1), (385, 1), (390, 1), (395, 1), (400, 1), (405, 1), (410, 0), (415, 0), (420, 1), (425, 0), (430, 0), (435, 0), (440, 0), (445, 0), (450, 0), (455, 0), (460, 1), (465, 0), (470, 0), (475, 0), (480, 0), (485, 0), (490, 0), (495, 0), (500, 1), (505, 0), (510, 1), (515, 1), (520, 1), (525, 1), (530, 1), (535, 1), (540, 0), (545, 0), (550, 0), (555, 1), (560, 1), (565, 1), (570, 1), (575, 1), (580, 1), (585, 1), (590, 1), (595, 1), (600, 1), (605, 1), (610, 1), (615, 1), (620, 1), (625, 1), (630, 1), (635, 1), (640, 0), (645, 0), (650, 0), (655, 1), (660, 1), (665, 1), (670, 1), (675, 1), (680, 1), (685, 1), (690, 1), (695, 1), (700, 1), (705, 0), (710, 0), (715, 1), (720, 1), (725, 1), (730, 1), (735, 0), (740, 1), (745, 1), (750, 1), (755, 0), (760, 0), (765, 0), (770, 0), (775, 0), (780, 0), (785, 1), (790, 0), (795, 0), (800, 0), (805, 0), (810, 0), (815, 0), (820, 0), (825, 0), (830, 1), (835, 0), (840, 0), (845, 0), (850, 0), (855, 1), (860, 0), (865, 0), (870, 1), (875, 0), (880, 1), (885, 1), (890, 1), (895, 1), (900, 1), (905, 1), (910, 1), (915, 1), (920, 1), (925, 1), (930, 0), (935, 0), (940, 0), (945, 0), (950, 0), (955, 1), (960, 1), (965, 0), (970, 0), (975, 0), (980, 0), (985, 1), (990, 1), (995, 0), (1000, 0), (1005, 0), (1010, 0), (1015, 0), (1020, 0), (1025, 0)]
Vdin0_37  din0_37  0 PWL (0n 0.0v 4.745n 0.0v 4.755n 1.1v 9.745n 1.1v 9.755n 1.1v 14.745n 1.1v 14.755n 1.1v 19.745n 1.1v 19.755n 1.1v 24.745n 1.1v 24.755n 1.1v 29.745n 1.1v 29.755n 0.0v 34.745n 0.0v 34.755n 0.0v 39.745n 0.0v 39.755n 1.1v 44.745n 1.1v 44.755n 1.1v 49.745n 1.1v 49.755n 1.1v 54.745n 1.1v 54.755n 1.1v 59.745n 1.1v 59.755n 1.1v 64.745n 1.1v 64.755n 0.0v 69.745n 0.0v 69.755n 0.0v 74.745n 0.0v 74.755n 0.0v 79.745n 0.0v 79.755n 0.0v 84.745n 0.0v 84.755n 0.0v 89.745n 0.0v 89.755n 1.1v 94.745n 1.1v 94.755n 1.1v 99.745n 1.1v 99.755n 1.1v 104.745n 1.1v 104.755n 1.1v 109.745n 1.1v 109.755n 1.1v 114.745n 1.1v 114.755n 1.1v 119.745n 1.1v 119.755n 1.1v 124.745n 1.1v 124.755n 1.1v 129.745n 1.1v 129.755n 1.1v 134.745n 1.1v 134.755n 1.1v 139.745n 1.1v 139.755n 0.0v 144.745n 0.0v 144.755n 0.0v 149.745n 0.0v 149.755n 0.0v 154.745n 0.0v 154.755n 0.0v 159.745n 0.0v 159.755n 0.0v 164.745n 0.0v 164.755n 0.0v 169.745n 0.0v 169.755n 0.0v 174.745n 0.0v 174.755n 0.0v 179.745n 0.0v 179.755n 0.0v 184.745n 0.0v 184.755n 1.1v 189.745n 1.1v 189.755n 1.1v 194.745n 1.1v 194.755n 1.1v 199.745n 1.1v 199.755n 0.0v 204.745n 0.0v 204.755n 0.0v 209.745n 0.0v 209.755n 0.0v 214.745n 0.0v 214.755n 0.0v 219.745n 0.0v 219.755n 0.0v 224.745n 0.0v 224.755n 0.0v 229.745n 0.0v 229.755n 0.0v 234.745n 0.0v 234.755n 0.0v 239.745n 0.0v 239.755n 1.1v 244.745n 1.1v 244.755n 1.1v 249.745n 1.1v 249.755n 1.1v 254.745n 1.1v 254.755n 0.0v 259.745n 0.0v 259.755n 0.0v 264.745n 0.0v 264.755n 1.1v 269.745n 1.1v 269.755n 1.1v 274.745n 1.1v 274.755n 1.1v 279.745n 1.1v 279.755n 1.1v 284.745n 1.1v 284.755n 1.1v 289.745n 1.1v 289.755n 1.1v 294.745n 1.1v 294.755n 1.1v 299.745n 1.1v 299.755n 1.1v 304.745n 1.1v 304.755n 1.1v 309.745n 1.1v 309.755n 1.1v 314.745n 1.1v 314.755n 1.1v 319.745n 1.1v 319.755n 1.1v 324.745n 1.1v 324.755n 1.1v 329.745n 1.1v 329.755n 0.0v 334.745n 0.0v 334.755n 1.1v 339.745n 1.1v 339.755n 0.0v 344.745n 0.0v 344.755n 0.0v 349.745n 0.0v 349.755n 0.0v 354.745n 0.0v 354.755n 0.0v 359.745n 0.0v 359.755n 1.1v 364.745n 1.1v 364.755n 1.1v 369.745n 1.1v 369.755n 1.1v 374.745n 1.1v 374.755n 1.1v 379.745n 1.1v 379.755n 1.1v 384.745n 1.1v 384.755n 1.1v 389.745n 1.1v 389.755n 1.1v 394.745n 1.1v 394.755n 1.1v 399.745n 1.1v 399.755n 1.1v 404.745n 1.1v 404.755n 1.1v 409.745n 1.1v 409.755n 0.0v 414.745n 0.0v 414.755n 0.0v 419.745n 0.0v 419.755n 1.1v 424.745n 1.1v 424.755n 0.0v 429.745n 0.0v 429.755n 0.0v 434.745n 0.0v 434.755n 0.0v 439.745n 0.0v 439.755n 0.0v 444.745n 0.0v 444.755n 0.0v 449.745n 0.0v 449.755n 0.0v 454.745n 0.0v 454.755n 0.0v 459.745n 0.0v 459.755n 1.1v 464.745n 1.1v 464.755n 0.0v 469.745n 0.0v 469.755n 0.0v 474.745n 0.0v 474.755n 0.0v 479.745n 0.0v 479.755n 0.0v 484.745n 0.0v 484.755n 0.0v 489.745n 0.0v 489.755n 0.0v 494.745n 0.0v 494.755n 0.0v 499.745n 0.0v 499.755n 1.1v 504.745n 1.1v 504.755n 0.0v 509.745n 0.0v 509.755n 1.1v 514.745n 1.1v 514.755n 1.1v 519.745n 1.1v 519.755n 1.1v 524.745n 1.1v 524.755n 1.1v 529.745n 1.1v 529.755n 1.1v 534.745n 1.1v 534.755n 1.1v 539.745n 1.1v 539.755n 0.0v 544.745n 0.0v 544.755n 0.0v 549.745n 0.0v 549.755n 0.0v 554.745n 0.0v 554.755n 1.1v 559.745n 1.1v 559.755n 1.1v 564.745n 1.1v 564.755n 1.1v 569.745n 1.1v 569.755n 1.1v 574.745n 1.1v 574.755n 1.1v 579.745n 1.1v 579.755n 1.1v 584.745n 1.1v 584.755n 1.1v 589.745n 1.1v 589.755n 1.1v 594.745n 1.1v 594.755n 1.1v 599.745n 1.1v 599.755n 1.1v 604.745n 1.1v 604.755n 1.1v 609.745n 1.1v 609.755n 1.1v 614.745n 1.1v 614.755n 1.1v 619.745n 1.1v 619.755n 1.1v 624.745n 1.1v 624.755n 1.1v 629.745n 1.1v 629.755n 1.1v 634.745n 1.1v 634.755n 1.1v 639.745n 1.1v 639.755n 0.0v 644.745n 0.0v 644.755n 0.0v 649.745n 0.0v 649.755n 0.0v 654.745n 0.0v 654.755n 1.1v 659.745n 1.1v 659.755n 1.1v 664.745n 1.1v 664.755n 1.1v 669.745n 1.1v 669.755n 1.1v 674.745n 1.1v 674.755n 1.1v 679.745n 1.1v 679.755n 1.1v 684.745n 1.1v 684.755n 1.1v 689.745n 1.1v 689.755n 1.1v 694.745n 1.1v 694.755n 1.1v 699.745n 1.1v 699.755n 1.1v 704.745n 1.1v 704.755n 0.0v 709.745n 0.0v 709.755n 0.0v 714.745n 0.0v 714.755n 1.1v 719.745n 1.1v 719.755n 1.1v 724.745n 1.1v 724.755n 1.1v 729.745n 1.1v 729.755n 1.1v 734.745n 1.1v 734.755n 0.0v 739.745n 0.0v 739.755n 1.1v 744.745n 1.1v 744.755n 1.1v 749.745n 1.1v 749.755n 1.1v 754.745n 1.1v 754.755n 0.0v 759.745n 0.0v 759.755n 0.0v 764.745n 0.0v 764.755n 0.0v 769.745n 0.0v 769.755n 0.0v 774.745n 0.0v 774.755n 0.0v 779.745n 0.0v 779.755n 0.0v 784.745n 0.0v 784.755n 1.1v 789.745n 1.1v 789.755n 0.0v 794.745n 0.0v 794.755n 0.0v 799.745n 0.0v 799.755n 0.0v 804.745n 0.0v 804.755n 0.0v 809.745n 0.0v 809.755n 0.0v 814.745n 0.0v 814.755n 0.0v 819.745n 0.0v 819.755n 0.0v 824.745n 0.0v 824.755n 0.0v 829.745n 0.0v 829.755n 1.1v 834.745n 1.1v 834.755n 0.0v 839.745n 0.0v 839.755n 0.0v 844.745n 0.0v 844.755n 0.0v 849.745n 0.0v 849.755n 0.0v 854.745n 0.0v 854.755n 1.1v 859.745n 1.1v 859.755n 0.0v 864.745n 0.0v 864.755n 0.0v 869.745n 0.0v 869.755n 1.1v 874.745n 1.1v 874.755n 0.0v 879.745n 0.0v 879.755n 1.1v 884.745n 1.1v 884.755n 1.1v 889.745n 1.1v 889.755n 1.1v 894.745n 1.1v 894.755n 1.1v 899.745n 1.1v 899.755n 1.1v 904.745n 1.1v 904.755n 1.1v 909.745n 1.1v 909.755n 1.1v 914.745n 1.1v 914.755n 1.1v 919.745n 1.1v 919.755n 1.1v 924.745n 1.1v 924.755n 1.1v 929.745n 1.1v 929.755n 0.0v 934.745n 0.0v 934.755n 0.0v 939.745n 0.0v 939.755n 0.0v 944.745n 0.0v 944.755n 0.0v 949.745n 0.0v 949.755n 0.0v 954.745n 0.0v 954.755n 1.1v 959.745n 1.1v 959.755n 1.1v 964.745n 1.1v 964.755n 0.0v 969.745n 0.0v 969.755n 0.0v 974.745n 0.0v 974.755n 0.0v 979.745n 0.0v 979.755n 0.0v 984.745n 0.0v 984.755n 1.1v 989.745n 1.1v 989.755n 1.1v 994.745n 1.1v 994.755n 0.0v 999.745n 0.0v 999.755n 0.0v 1004.745n 0.0v 1004.755n 0.0v 1009.745n 0.0v 1009.755n 0.0v 1014.745n 0.0v 1014.755n 0.0v 1019.745n 0.0v 1019.755n 0.0v 1024.745n 0.0v 1024.755n 0.0v )
* (time, data): [(0, 0), (5, 0), (10, 0), (15, 1), (20, 1), (25, 1), (30, 1), (35, 1), (40, 1), (45, 1), (50, 1), (55, 1), (60, 0), (65, 1), (70, 1), (75, 1), (80, 1), (85, 1), (90, 1), (95, 1), (100, 0), (105, 0), (110, 0), (115, 0), (120, 0), (125, 0), (130, 0), (135, 0), (140, 0), (145, 0), (150, 0), (155, 0), (160, 0), (165, 0), (170, 0), (175, 0), (180, 0), (185, 0), (190, 0), (195, 0), (200, 1), (205, 1), (210, 0), (215, 0), (220, 1), (225, 1), (230, 1), (235, 1), (240, 1), (245, 1), (250, 1), (255, 0), (260, 0), (265, 1), (270, 1), (275, 1), (280, 1), (285, 1), (290, 1), (295, 1), (300, 1), (305, 1), (310, 1), (315, 1), (320, 1), (325, 1), (330, 0), (335, 0), (340, 0), (345, 0), (350, 0), (355, 0), (360, 0), (365, 0), (370, 0), (375, 0), (380, 0), (385, 0), (390, 0), (395, 0), (400, 1), (405, 1), (410, 1), (415, 1), (420, 0), (425, 0), (430, 0), (435, 0), (440, 0), (445, 0), (450, 1), (455, 1), (460, 0), (465, 0), (470, 0), (475, 0), (480, 0), (485, 0), (490, 0), (495, 1), (500, 0), (505, 0), (510, 1), (515, 1), (520, 1), (525, 1), (530, 1), (535, 0), (540, 0), (545, 0), (550, 0), (555, 1), (560, 1), (565, 1), (570, 1), (575, 1), (580, 1), (585, 1), (590, 1), (595, 1), (600, 1), (605, 1), (610, 1), (615, 1), (620, 1), (625, 1), (630, 0), (635, 1), (640, 1), (645, 1), (650, 1), (655, 1), (660, 1), (665, 1), (670, 0), (675, 0), (680, 0), (685, 0), (690, 0), (695, 0), (700, 0), (705, 0), (710, 1), (715, 1), (720, 1), (725, 1), (730, 1), (735, 0), (740, 1), (745, 1), (750, 1), (755, 1), (760, 1), (765, 1), (770, 1), (775, 1), (780, 1), (785, 1), (790, 0), (795, 0), (800, 0), (805, 0), (810, 0), (815, 0), (820, 1), (825, 1), (830, 0), (835, 1), (840, 1), (845, 1), (850, 1), (855, 1), (860, 0), (865, 1), (870, 0), (875, 0), (880, 0), (885, 1), (890, 1), (895, 1), (900, 1), (905, 1), (910, 1), (915, 1), (920, 1), (925, 1), (930, 0), (935, 0), (940, 0), (945, 0), (950, 0), (955, 1), (960, 1), (965, 1), (970, 1), (975, 1), (980, 1), (985, 1), (990, 1), (995, 1), (1000, 0), (1005, 0), (1010, 0), (1015, 0), (1020, 0), (1025, 0)]
Vdin0_38  din0_38  0 PWL (0n 0.0v 4.745n 0.0v 4.755n 0.0v 9.745n 0.0v 9.755n 0.0v 14.745n 0.0v 14.755n 1.1v 19.745n 1.1v 19.755n 1.1v 24.745n 1.1v 24.755n 1.1v 29.745n 1.1v 29.755n 1.1v 34.745n 1.1v 34.755n 1.1v 39.745n 1.1v 39.755n 1.1v 44.745n 1.1v 44.755n 1.1v 49.745n 1.1v 49.755n 1.1v 54.745n 1.1v 54.755n 1.1v 59.745n 1.1v 59.755n 0.0v 64.745n 0.0v 64.755n 1.1v 69.745n 1.1v 69.755n 1.1v 74.745n 1.1v 74.755n 1.1v 79.745n 1.1v 79.755n 1.1v 84.745n 1.1v 84.755n 1.1v 89.745n 1.1v 89.755n 1.1v 94.745n 1.1v 94.755n 1.1v 99.745n 1.1v 99.755n 0.0v 104.745n 0.0v 104.755n 0.0v 109.745n 0.0v 109.755n 0.0v 114.745n 0.0v 114.755n 0.0v 119.745n 0.0v 119.755n 0.0v 124.745n 0.0v 124.755n 0.0v 129.745n 0.0v 129.755n 0.0v 134.745n 0.0v 134.755n 0.0v 139.745n 0.0v 139.755n 0.0v 144.745n 0.0v 144.755n 0.0v 149.745n 0.0v 149.755n 0.0v 154.745n 0.0v 154.755n 0.0v 159.745n 0.0v 159.755n 0.0v 164.745n 0.0v 164.755n 0.0v 169.745n 0.0v 169.755n 0.0v 174.745n 0.0v 174.755n 0.0v 179.745n 0.0v 179.755n 0.0v 184.745n 0.0v 184.755n 0.0v 189.745n 0.0v 189.755n 0.0v 194.745n 0.0v 194.755n 0.0v 199.745n 0.0v 199.755n 1.1v 204.745n 1.1v 204.755n 1.1v 209.745n 1.1v 209.755n 0.0v 214.745n 0.0v 214.755n 0.0v 219.745n 0.0v 219.755n 1.1v 224.745n 1.1v 224.755n 1.1v 229.745n 1.1v 229.755n 1.1v 234.745n 1.1v 234.755n 1.1v 239.745n 1.1v 239.755n 1.1v 244.745n 1.1v 244.755n 1.1v 249.745n 1.1v 249.755n 1.1v 254.745n 1.1v 254.755n 0.0v 259.745n 0.0v 259.755n 0.0v 264.745n 0.0v 264.755n 1.1v 269.745n 1.1v 269.755n 1.1v 274.745n 1.1v 274.755n 1.1v 279.745n 1.1v 279.755n 1.1v 284.745n 1.1v 284.755n 1.1v 289.745n 1.1v 289.755n 1.1v 294.745n 1.1v 294.755n 1.1v 299.745n 1.1v 299.755n 1.1v 304.745n 1.1v 304.755n 1.1v 309.745n 1.1v 309.755n 1.1v 314.745n 1.1v 314.755n 1.1v 319.745n 1.1v 319.755n 1.1v 324.745n 1.1v 324.755n 1.1v 329.745n 1.1v 329.755n 0.0v 334.745n 0.0v 334.755n 0.0v 339.745n 0.0v 339.755n 0.0v 344.745n 0.0v 344.755n 0.0v 349.745n 0.0v 349.755n 0.0v 354.745n 0.0v 354.755n 0.0v 359.745n 0.0v 359.755n 0.0v 364.745n 0.0v 364.755n 0.0v 369.745n 0.0v 369.755n 0.0v 374.745n 0.0v 374.755n 0.0v 379.745n 0.0v 379.755n 0.0v 384.745n 0.0v 384.755n 0.0v 389.745n 0.0v 389.755n 0.0v 394.745n 0.0v 394.755n 0.0v 399.745n 0.0v 399.755n 1.1v 404.745n 1.1v 404.755n 1.1v 409.745n 1.1v 409.755n 1.1v 414.745n 1.1v 414.755n 1.1v 419.745n 1.1v 419.755n 0.0v 424.745n 0.0v 424.755n 0.0v 429.745n 0.0v 429.755n 0.0v 434.745n 0.0v 434.755n 0.0v 439.745n 0.0v 439.755n 0.0v 444.745n 0.0v 444.755n 0.0v 449.745n 0.0v 449.755n 1.1v 454.745n 1.1v 454.755n 1.1v 459.745n 1.1v 459.755n 0.0v 464.745n 0.0v 464.755n 0.0v 469.745n 0.0v 469.755n 0.0v 474.745n 0.0v 474.755n 0.0v 479.745n 0.0v 479.755n 0.0v 484.745n 0.0v 484.755n 0.0v 489.745n 0.0v 489.755n 0.0v 494.745n 0.0v 494.755n 1.1v 499.745n 1.1v 499.755n 0.0v 504.745n 0.0v 504.755n 0.0v 509.745n 0.0v 509.755n 1.1v 514.745n 1.1v 514.755n 1.1v 519.745n 1.1v 519.755n 1.1v 524.745n 1.1v 524.755n 1.1v 529.745n 1.1v 529.755n 1.1v 534.745n 1.1v 534.755n 0.0v 539.745n 0.0v 539.755n 0.0v 544.745n 0.0v 544.755n 0.0v 549.745n 0.0v 549.755n 0.0v 554.745n 0.0v 554.755n 1.1v 559.745n 1.1v 559.755n 1.1v 564.745n 1.1v 564.755n 1.1v 569.745n 1.1v 569.755n 1.1v 574.745n 1.1v 574.755n 1.1v 579.745n 1.1v 579.755n 1.1v 584.745n 1.1v 584.755n 1.1v 589.745n 1.1v 589.755n 1.1v 594.745n 1.1v 594.755n 1.1v 599.745n 1.1v 599.755n 1.1v 604.745n 1.1v 604.755n 1.1v 609.745n 1.1v 609.755n 1.1v 614.745n 1.1v 614.755n 1.1v 619.745n 1.1v 619.755n 1.1v 624.745n 1.1v 624.755n 1.1v 629.745n 1.1v 629.755n 0.0v 634.745n 0.0v 634.755n 1.1v 639.745n 1.1v 639.755n 1.1v 644.745n 1.1v 644.755n 1.1v 649.745n 1.1v 649.755n 1.1v 654.745n 1.1v 654.755n 1.1v 659.745n 1.1v 659.755n 1.1v 664.745n 1.1v 664.755n 1.1v 669.745n 1.1v 669.755n 0.0v 674.745n 0.0v 674.755n 0.0v 679.745n 0.0v 679.755n 0.0v 684.745n 0.0v 684.755n 0.0v 689.745n 0.0v 689.755n 0.0v 694.745n 0.0v 694.755n 0.0v 699.745n 0.0v 699.755n 0.0v 704.745n 0.0v 704.755n 0.0v 709.745n 0.0v 709.755n 1.1v 714.745n 1.1v 714.755n 1.1v 719.745n 1.1v 719.755n 1.1v 724.745n 1.1v 724.755n 1.1v 729.745n 1.1v 729.755n 1.1v 734.745n 1.1v 734.755n 0.0v 739.745n 0.0v 739.755n 1.1v 744.745n 1.1v 744.755n 1.1v 749.745n 1.1v 749.755n 1.1v 754.745n 1.1v 754.755n 1.1v 759.745n 1.1v 759.755n 1.1v 764.745n 1.1v 764.755n 1.1v 769.745n 1.1v 769.755n 1.1v 774.745n 1.1v 774.755n 1.1v 779.745n 1.1v 779.755n 1.1v 784.745n 1.1v 784.755n 1.1v 789.745n 1.1v 789.755n 0.0v 794.745n 0.0v 794.755n 0.0v 799.745n 0.0v 799.755n 0.0v 804.745n 0.0v 804.755n 0.0v 809.745n 0.0v 809.755n 0.0v 814.745n 0.0v 814.755n 0.0v 819.745n 0.0v 819.755n 1.1v 824.745n 1.1v 824.755n 1.1v 829.745n 1.1v 829.755n 0.0v 834.745n 0.0v 834.755n 1.1v 839.745n 1.1v 839.755n 1.1v 844.745n 1.1v 844.755n 1.1v 849.745n 1.1v 849.755n 1.1v 854.745n 1.1v 854.755n 1.1v 859.745n 1.1v 859.755n 0.0v 864.745n 0.0v 864.755n 1.1v 869.745n 1.1v 869.755n 0.0v 874.745n 0.0v 874.755n 0.0v 879.745n 0.0v 879.755n 0.0v 884.745n 0.0v 884.755n 1.1v 889.745n 1.1v 889.755n 1.1v 894.745n 1.1v 894.755n 1.1v 899.745n 1.1v 899.755n 1.1v 904.745n 1.1v 904.755n 1.1v 909.745n 1.1v 909.755n 1.1v 914.745n 1.1v 914.755n 1.1v 919.745n 1.1v 919.755n 1.1v 924.745n 1.1v 924.755n 1.1v 929.745n 1.1v 929.755n 0.0v 934.745n 0.0v 934.755n 0.0v 939.745n 0.0v 939.755n 0.0v 944.745n 0.0v 944.755n 0.0v 949.745n 0.0v 949.755n 0.0v 954.745n 0.0v 954.755n 1.1v 959.745n 1.1v 959.755n 1.1v 964.745n 1.1v 964.755n 1.1v 969.745n 1.1v 969.755n 1.1v 974.745n 1.1v 974.755n 1.1v 979.745n 1.1v 979.755n 1.1v 984.745n 1.1v 984.755n 1.1v 989.745n 1.1v 989.755n 1.1v 994.745n 1.1v 994.755n 1.1v 999.745n 1.1v 999.755n 0.0v 1004.745n 0.0v 1004.755n 0.0v 1009.745n 0.0v 1009.755n 0.0v 1014.745n 0.0v 1014.755n 0.0v 1019.745n 0.0v 1019.755n 0.0v 1024.745n 0.0v 1024.755n 0.0v )
* (time, data): [(0, 0), (5, 0), (10, 0), (15, 0), (20, 0), (25, 0), (30, 0), (35, 0), (40, 0), (45, 0), (50, 0), (55, 0), (60, 1), (65, 1), (70, 1), (75, 1), (80, 1), (85, 1), (90, 1), (95, 1), (100, 0), (105, 0), (110, 0), (115, 0), (120, 0), (125, 0), (130, 0), (135, 0), (140, 1), (145, 1), (150, 1), (155, 1), (160, 1), (165, 1), (170, 1), (175, 1), (180, 1), (185, 0), (190, 0), (195, 0), (200, 1), (205, 1), (210, 0), (215, 0), (220, 1), (225, 1), (230, 0), (235, 0), (240, 0), (245, 0), (250, 0), (255, 0), (260, 0), (265, 1), (270, 1), (275, 1), (280, 0), (285, 0), (290, 0), (295, 0), (300, 1), (305, 1), (310, 1), (315, 1), (320, 1), (325, 1), (330, 1), (335, 1), (340, 0), (345, 0), (350, 0), (355, 0), (360, 0), (365, 0), (370, 0), (375, 0), (380, 0), (385, 0), (390, 0), (395, 0), (400, 1), (405, 1), (410, 1), (415, 1), (420, 1), (425, 0), (430, 0), (435, 0), (440, 0), (445, 0), (450, 0), (455, 0), (460, 1), (465, 1), (470, 1), (475, 1), (480, 1), (485, 1), (490, 1), (495, 1), (500, 1), (505, 1), (510, 0), (515, 0), (520, 0), (525, 0), (530, 0), (535, 1), (540, 0), (545, 0), (550, 0), (555, 0), (560, 0), (565, 0), (570, 0), (575, 1), (580, 1), (585, 1), (590, 1), (595, 1), (600, 1), (605, 1), (610, 1), (615, 1), (620, 1), (625, 1), (630, 1), (635, 1), (640, 1), (645, 1), (650, 1), (655, 1), (660, 0), (665, 0), (670, 1), (675, 1), (680, 1), (685, 1), (690, 1), (695, 1), (700, 1), (705, 0), (710, 0), (715, 1), (720, 1), (725, 1), (730, 1), (735, 1), (740, 1), (745, 1), (750, 1), (755, 1), (760, 1), (765, 1), (770, 1), (775, 0), (780, 0), (785, 1), (790, 1), (795, 1), (800, 1), (805, 1), (810, 1), (815, 1), (820, 0), (825, 0), (830, 1), (835, 0), (840, 0), (845, 0), (850, 0), (855, 1), (860, 1), (865, 1), (870, 0), (875, 0), (880, 1), (885, 1), (890, 1), (895, 1), (900, 1), (905, 1), (910, 1), (915, 1), (920, 1), (925, 1), (930, 0), (935, 1), (940, 1), (945, 1), (950, 1), (955, 1), (960, 1), (965, 0), (970, 0), (975, 0), (980, 1), (985, 0), (990, 0), (995, 1), (1000, 1), (1005, 1), (1010, 1), (1015, 1), (1020, 1), (1025, 1)]
Vdin0_39  din0_39  0 PWL (0n 0.0v 4.745n 0.0v 4.755n 0.0v 9.745n 0.0v 9.755n 0.0v 14.745n 0.0v 14.755n 0.0v 19.745n 0.0v 19.755n 0.0v 24.745n 0.0v 24.755n 0.0v 29.745n 0.0v 29.755n 0.0v 34.745n 0.0v 34.755n 0.0v 39.745n 0.0v 39.755n 0.0v 44.745n 0.0v 44.755n 0.0v 49.745n 0.0v 49.755n 0.0v 54.745n 0.0v 54.755n 0.0v 59.745n 0.0v 59.755n 1.1v 64.745n 1.1v 64.755n 1.1v 69.745n 1.1v 69.755n 1.1v 74.745n 1.1v 74.755n 1.1v 79.745n 1.1v 79.755n 1.1v 84.745n 1.1v 84.755n 1.1v 89.745n 1.1v 89.755n 1.1v 94.745n 1.1v 94.755n 1.1v 99.745n 1.1v 99.755n 0.0v 104.745n 0.0v 104.755n 0.0v 109.745n 0.0v 109.755n 0.0v 114.745n 0.0v 114.755n 0.0v 119.745n 0.0v 119.755n 0.0v 124.745n 0.0v 124.755n 0.0v 129.745n 0.0v 129.755n 0.0v 134.745n 0.0v 134.755n 0.0v 139.745n 0.0v 139.755n 1.1v 144.745n 1.1v 144.755n 1.1v 149.745n 1.1v 149.755n 1.1v 154.745n 1.1v 154.755n 1.1v 159.745n 1.1v 159.755n 1.1v 164.745n 1.1v 164.755n 1.1v 169.745n 1.1v 169.755n 1.1v 174.745n 1.1v 174.755n 1.1v 179.745n 1.1v 179.755n 1.1v 184.745n 1.1v 184.755n 0.0v 189.745n 0.0v 189.755n 0.0v 194.745n 0.0v 194.755n 0.0v 199.745n 0.0v 199.755n 1.1v 204.745n 1.1v 204.755n 1.1v 209.745n 1.1v 209.755n 0.0v 214.745n 0.0v 214.755n 0.0v 219.745n 0.0v 219.755n 1.1v 224.745n 1.1v 224.755n 1.1v 229.745n 1.1v 229.755n 0.0v 234.745n 0.0v 234.755n 0.0v 239.745n 0.0v 239.755n 0.0v 244.745n 0.0v 244.755n 0.0v 249.745n 0.0v 249.755n 0.0v 254.745n 0.0v 254.755n 0.0v 259.745n 0.0v 259.755n 0.0v 264.745n 0.0v 264.755n 1.1v 269.745n 1.1v 269.755n 1.1v 274.745n 1.1v 274.755n 1.1v 279.745n 1.1v 279.755n 0.0v 284.745n 0.0v 284.755n 0.0v 289.745n 0.0v 289.755n 0.0v 294.745n 0.0v 294.755n 0.0v 299.745n 0.0v 299.755n 1.1v 304.745n 1.1v 304.755n 1.1v 309.745n 1.1v 309.755n 1.1v 314.745n 1.1v 314.755n 1.1v 319.745n 1.1v 319.755n 1.1v 324.745n 1.1v 324.755n 1.1v 329.745n 1.1v 329.755n 1.1v 334.745n 1.1v 334.755n 1.1v 339.745n 1.1v 339.755n 0.0v 344.745n 0.0v 344.755n 0.0v 349.745n 0.0v 349.755n 0.0v 354.745n 0.0v 354.755n 0.0v 359.745n 0.0v 359.755n 0.0v 364.745n 0.0v 364.755n 0.0v 369.745n 0.0v 369.755n 0.0v 374.745n 0.0v 374.755n 0.0v 379.745n 0.0v 379.755n 0.0v 384.745n 0.0v 384.755n 0.0v 389.745n 0.0v 389.755n 0.0v 394.745n 0.0v 394.755n 0.0v 399.745n 0.0v 399.755n 1.1v 404.745n 1.1v 404.755n 1.1v 409.745n 1.1v 409.755n 1.1v 414.745n 1.1v 414.755n 1.1v 419.745n 1.1v 419.755n 1.1v 424.745n 1.1v 424.755n 0.0v 429.745n 0.0v 429.755n 0.0v 434.745n 0.0v 434.755n 0.0v 439.745n 0.0v 439.755n 0.0v 444.745n 0.0v 444.755n 0.0v 449.745n 0.0v 449.755n 0.0v 454.745n 0.0v 454.755n 0.0v 459.745n 0.0v 459.755n 1.1v 464.745n 1.1v 464.755n 1.1v 469.745n 1.1v 469.755n 1.1v 474.745n 1.1v 474.755n 1.1v 479.745n 1.1v 479.755n 1.1v 484.745n 1.1v 484.755n 1.1v 489.745n 1.1v 489.755n 1.1v 494.745n 1.1v 494.755n 1.1v 499.745n 1.1v 499.755n 1.1v 504.745n 1.1v 504.755n 1.1v 509.745n 1.1v 509.755n 0.0v 514.745n 0.0v 514.755n 0.0v 519.745n 0.0v 519.755n 0.0v 524.745n 0.0v 524.755n 0.0v 529.745n 0.0v 529.755n 0.0v 534.745n 0.0v 534.755n 1.1v 539.745n 1.1v 539.755n 0.0v 544.745n 0.0v 544.755n 0.0v 549.745n 0.0v 549.755n 0.0v 554.745n 0.0v 554.755n 0.0v 559.745n 0.0v 559.755n 0.0v 564.745n 0.0v 564.755n 0.0v 569.745n 0.0v 569.755n 0.0v 574.745n 0.0v 574.755n 1.1v 579.745n 1.1v 579.755n 1.1v 584.745n 1.1v 584.755n 1.1v 589.745n 1.1v 589.755n 1.1v 594.745n 1.1v 594.755n 1.1v 599.745n 1.1v 599.755n 1.1v 604.745n 1.1v 604.755n 1.1v 609.745n 1.1v 609.755n 1.1v 614.745n 1.1v 614.755n 1.1v 619.745n 1.1v 619.755n 1.1v 624.745n 1.1v 624.755n 1.1v 629.745n 1.1v 629.755n 1.1v 634.745n 1.1v 634.755n 1.1v 639.745n 1.1v 639.755n 1.1v 644.745n 1.1v 644.755n 1.1v 649.745n 1.1v 649.755n 1.1v 654.745n 1.1v 654.755n 1.1v 659.745n 1.1v 659.755n 0.0v 664.745n 0.0v 664.755n 0.0v 669.745n 0.0v 669.755n 1.1v 674.745n 1.1v 674.755n 1.1v 679.745n 1.1v 679.755n 1.1v 684.745n 1.1v 684.755n 1.1v 689.745n 1.1v 689.755n 1.1v 694.745n 1.1v 694.755n 1.1v 699.745n 1.1v 699.755n 1.1v 704.745n 1.1v 704.755n 0.0v 709.745n 0.0v 709.755n 0.0v 714.745n 0.0v 714.755n 1.1v 719.745n 1.1v 719.755n 1.1v 724.745n 1.1v 724.755n 1.1v 729.745n 1.1v 729.755n 1.1v 734.745n 1.1v 734.755n 1.1v 739.745n 1.1v 739.755n 1.1v 744.745n 1.1v 744.755n 1.1v 749.745n 1.1v 749.755n 1.1v 754.745n 1.1v 754.755n 1.1v 759.745n 1.1v 759.755n 1.1v 764.745n 1.1v 764.755n 1.1v 769.745n 1.1v 769.755n 1.1v 774.745n 1.1v 774.755n 0.0v 779.745n 0.0v 779.755n 0.0v 784.745n 0.0v 784.755n 1.1v 789.745n 1.1v 789.755n 1.1v 794.745n 1.1v 794.755n 1.1v 799.745n 1.1v 799.755n 1.1v 804.745n 1.1v 804.755n 1.1v 809.745n 1.1v 809.755n 1.1v 814.745n 1.1v 814.755n 1.1v 819.745n 1.1v 819.755n 0.0v 824.745n 0.0v 824.755n 0.0v 829.745n 0.0v 829.755n 1.1v 834.745n 1.1v 834.755n 0.0v 839.745n 0.0v 839.755n 0.0v 844.745n 0.0v 844.755n 0.0v 849.745n 0.0v 849.755n 0.0v 854.745n 0.0v 854.755n 1.1v 859.745n 1.1v 859.755n 1.1v 864.745n 1.1v 864.755n 1.1v 869.745n 1.1v 869.755n 0.0v 874.745n 0.0v 874.755n 0.0v 879.745n 0.0v 879.755n 1.1v 884.745n 1.1v 884.755n 1.1v 889.745n 1.1v 889.755n 1.1v 894.745n 1.1v 894.755n 1.1v 899.745n 1.1v 899.755n 1.1v 904.745n 1.1v 904.755n 1.1v 909.745n 1.1v 909.755n 1.1v 914.745n 1.1v 914.755n 1.1v 919.745n 1.1v 919.755n 1.1v 924.745n 1.1v 924.755n 1.1v 929.745n 1.1v 929.755n 0.0v 934.745n 0.0v 934.755n 1.1v 939.745n 1.1v 939.755n 1.1v 944.745n 1.1v 944.755n 1.1v 949.745n 1.1v 949.755n 1.1v 954.745n 1.1v 954.755n 1.1v 959.745n 1.1v 959.755n 1.1v 964.745n 1.1v 964.755n 0.0v 969.745n 0.0v 969.755n 0.0v 974.745n 0.0v 974.755n 0.0v 979.745n 0.0v 979.755n 1.1v 984.745n 1.1v 984.755n 0.0v 989.745n 0.0v 989.755n 0.0v 994.745n 0.0v 994.755n 1.1v 999.745n 1.1v 999.755n 1.1v 1004.745n 1.1v 1004.755n 1.1v 1009.745n 1.1v 1009.755n 1.1v 1014.745n 1.1v 1014.755n 1.1v 1019.745n 1.1v 1019.755n 1.1v 1024.745n 1.1v 1024.755n 1.1v )
* (time, data): [(0, 0), (5, 0), (10, 0), (15, 0), (20, 0), (25, 0), (30, 1), (35, 1), (40, 0), (45, 0), (50, 0), (55, 0), (60, 0), (65, 0), (70, 0), (75, 0), (80, 0), (85, 0), (90, 1), (95, 1), (100, 0), (105, 0), (110, 0), (115, 0), (120, 0), (125, 0), (130, 0), (135, 1), (140, 0), (145, 0), (150, 0), (155, 0), (160, 0), (165, 0), (170, 1), (175, 1), (180, 1), (185, 1), (190, 1), (195, 1), (200, 1), (205, 1), (210, 1), (215, 1), (220, 1), (225, 1), (230, 1), (235, 1), (240, 1), (245, 1), (250, 1), (255, 0), (260, 0), (265, 0), (270, 0), (275, 0), (280, 1), (285, 1), (290, 1), (295, 1), (300, 1), (305, 1), (310, 1), (315, 0), (320, 0), (325, 0), (330, 0), (335, 0), (340, 1), (345, 1), (350, 1), (355, 1), (360, 0), (365, 0), (370, 0), (375, 0), (380, 0), (385, 0), (390, 0), (395, 0), (400, 1), (405, 1), (410, 0), (415, 1), (420, 0), (425, 1), (430, 1), (435, 1), (440, 1), (445, 1), (450, 1), (455, 1), (460, 0), (465, 0), (470, 0), (475, 0), (480, 0), (485, 0), (490, 0), (495, 0), (500, 1), (505, 0), (510, 1), (515, 1), (520, 1), (525, 1), (530, 1), (535, 0), (540, 1), (545, 1), (550, 1), (555, 0), (560, 0), (565, 0), (570, 0), (575, 1), (580, 1), (585, 1), (590, 1), (595, 1), (600, 1), (605, 1), (610, 1), (615, 1), (620, 1), (625, 1), (630, 1), (635, 0), (640, 1), (645, 1), (650, 1), (655, 0), (660, 1), (665, 1), (670, 0), (675, 0), (680, 0), (685, 0), (690, 0), (695, 0), (700, 0), (705, 0), (710, 0), (715, 0), (720, 0), (725, 0), (730, 0), (735, 1), (740, 0), (745, 0), (750, 0), (755, 1), (760, 1), (765, 1), (770, 1), (775, 1), (780, 1), (785, 0), (790, 1), (795, 1), (800, 1), (805, 1), (810, 1), (815, 1), (820, 1), (825, 1), (830, 1), (835, 1), (840, 1), (845, 1), (850, 1), (855, 1), (860, 1), (865, 1), (870, 0), (875, 1), (880, 0), (885, 1), (890, 1), (895, 1), (900, 1), (905, 1), (910, 1), (915, 1), (920, 1), (925, 1), (930, 1), (935, 1), (940, 1), (945, 1), (950, 1), (955, 1), (960, 1), (965, 0), (970, 0), (975, 0), (980, 1), (985, 0), (990, 0), (995, 0), (1000, 0), (1005, 0), (1010, 0), (1015, 0), (1020, 1), (1025, 1)]
Vdin0_40  din0_40  0 PWL (0n 0.0v 4.745n 0.0v 4.755n 0.0v 9.745n 0.0v 9.755n 0.0v 14.745n 0.0v 14.755n 0.0v 19.745n 0.0v 19.755n 0.0v 24.745n 0.0v 24.755n 0.0v 29.745n 0.0v 29.755n 1.1v 34.745n 1.1v 34.755n 1.1v 39.745n 1.1v 39.755n 0.0v 44.745n 0.0v 44.755n 0.0v 49.745n 0.0v 49.755n 0.0v 54.745n 0.0v 54.755n 0.0v 59.745n 0.0v 59.755n 0.0v 64.745n 0.0v 64.755n 0.0v 69.745n 0.0v 69.755n 0.0v 74.745n 0.0v 74.755n 0.0v 79.745n 0.0v 79.755n 0.0v 84.745n 0.0v 84.755n 0.0v 89.745n 0.0v 89.755n 1.1v 94.745n 1.1v 94.755n 1.1v 99.745n 1.1v 99.755n 0.0v 104.745n 0.0v 104.755n 0.0v 109.745n 0.0v 109.755n 0.0v 114.745n 0.0v 114.755n 0.0v 119.745n 0.0v 119.755n 0.0v 124.745n 0.0v 124.755n 0.0v 129.745n 0.0v 129.755n 0.0v 134.745n 0.0v 134.755n 1.1v 139.745n 1.1v 139.755n 0.0v 144.745n 0.0v 144.755n 0.0v 149.745n 0.0v 149.755n 0.0v 154.745n 0.0v 154.755n 0.0v 159.745n 0.0v 159.755n 0.0v 164.745n 0.0v 164.755n 0.0v 169.745n 0.0v 169.755n 1.1v 174.745n 1.1v 174.755n 1.1v 179.745n 1.1v 179.755n 1.1v 184.745n 1.1v 184.755n 1.1v 189.745n 1.1v 189.755n 1.1v 194.745n 1.1v 194.755n 1.1v 199.745n 1.1v 199.755n 1.1v 204.745n 1.1v 204.755n 1.1v 209.745n 1.1v 209.755n 1.1v 214.745n 1.1v 214.755n 1.1v 219.745n 1.1v 219.755n 1.1v 224.745n 1.1v 224.755n 1.1v 229.745n 1.1v 229.755n 1.1v 234.745n 1.1v 234.755n 1.1v 239.745n 1.1v 239.755n 1.1v 244.745n 1.1v 244.755n 1.1v 249.745n 1.1v 249.755n 1.1v 254.745n 1.1v 254.755n 0.0v 259.745n 0.0v 259.755n 0.0v 264.745n 0.0v 264.755n 0.0v 269.745n 0.0v 269.755n 0.0v 274.745n 0.0v 274.755n 0.0v 279.745n 0.0v 279.755n 1.1v 284.745n 1.1v 284.755n 1.1v 289.745n 1.1v 289.755n 1.1v 294.745n 1.1v 294.755n 1.1v 299.745n 1.1v 299.755n 1.1v 304.745n 1.1v 304.755n 1.1v 309.745n 1.1v 309.755n 1.1v 314.745n 1.1v 314.755n 0.0v 319.745n 0.0v 319.755n 0.0v 324.745n 0.0v 324.755n 0.0v 329.745n 0.0v 329.755n 0.0v 334.745n 0.0v 334.755n 0.0v 339.745n 0.0v 339.755n 1.1v 344.745n 1.1v 344.755n 1.1v 349.745n 1.1v 349.755n 1.1v 354.745n 1.1v 354.755n 1.1v 359.745n 1.1v 359.755n 0.0v 364.745n 0.0v 364.755n 0.0v 369.745n 0.0v 369.755n 0.0v 374.745n 0.0v 374.755n 0.0v 379.745n 0.0v 379.755n 0.0v 384.745n 0.0v 384.755n 0.0v 389.745n 0.0v 389.755n 0.0v 394.745n 0.0v 394.755n 0.0v 399.745n 0.0v 399.755n 1.1v 404.745n 1.1v 404.755n 1.1v 409.745n 1.1v 409.755n 0.0v 414.745n 0.0v 414.755n 1.1v 419.745n 1.1v 419.755n 0.0v 424.745n 0.0v 424.755n 1.1v 429.745n 1.1v 429.755n 1.1v 434.745n 1.1v 434.755n 1.1v 439.745n 1.1v 439.755n 1.1v 444.745n 1.1v 444.755n 1.1v 449.745n 1.1v 449.755n 1.1v 454.745n 1.1v 454.755n 1.1v 459.745n 1.1v 459.755n 0.0v 464.745n 0.0v 464.755n 0.0v 469.745n 0.0v 469.755n 0.0v 474.745n 0.0v 474.755n 0.0v 479.745n 0.0v 479.755n 0.0v 484.745n 0.0v 484.755n 0.0v 489.745n 0.0v 489.755n 0.0v 494.745n 0.0v 494.755n 0.0v 499.745n 0.0v 499.755n 1.1v 504.745n 1.1v 504.755n 0.0v 509.745n 0.0v 509.755n 1.1v 514.745n 1.1v 514.755n 1.1v 519.745n 1.1v 519.755n 1.1v 524.745n 1.1v 524.755n 1.1v 529.745n 1.1v 529.755n 1.1v 534.745n 1.1v 534.755n 0.0v 539.745n 0.0v 539.755n 1.1v 544.745n 1.1v 544.755n 1.1v 549.745n 1.1v 549.755n 1.1v 554.745n 1.1v 554.755n 0.0v 559.745n 0.0v 559.755n 0.0v 564.745n 0.0v 564.755n 0.0v 569.745n 0.0v 569.755n 0.0v 574.745n 0.0v 574.755n 1.1v 579.745n 1.1v 579.755n 1.1v 584.745n 1.1v 584.755n 1.1v 589.745n 1.1v 589.755n 1.1v 594.745n 1.1v 594.755n 1.1v 599.745n 1.1v 599.755n 1.1v 604.745n 1.1v 604.755n 1.1v 609.745n 1.1v 609.755n 1.1v 614.745n 1.1v 614.755n 1.1v 619.745n 1.1v 619.755n 1.1v 624.745n 1.1v 624.755n 1.1v 629.745n 1.1v 629.755n 1.1v 634.745n 1.1v 634.755n 0.0v 639.745n 0.0v 639.755n 1.1v 644.745n 1.1v 644.755n 1.1v 649.745n 1.1v 649.755n 1.1v 654.745n 1.1v 654.755n 0.0v 659.745n 0.0v 659.755n 1.1v 664.745n 1.1v 664.755n 1.1v 669.745n 1.1v 669.755n 0.0v 674.745n 0.0v 674.755n 0.0v 679.745n 0.0v 679.755n 0.0v 684.745n 0.0v 684.755n 0.0v 689.745n 0.0v 689.755n 0.0v 694.745n 0.0v 694.755n 0.0v 699.745n 0.0v 699.755n 0.0v 704.745n 0.0v 704.755n 0.0v 709.745n 0.0v 709.755n 0.0v 714.745n 0.0v 714.755n 0.0v 719.745n 0.0v 719.755n 0.0v 724.745n 0.0v 724.755n 0.0v 729.745n 0.0v 729.755n 0.0v 734.745n 0.0v 734.755n 1.1v 739.745n 1.1v 739.755n 0.0v 744.745n 0.0v 744.755n 0.0v 749.745n 0.0v 749.755n 0.0v 754.745n 0.0v 754.755n 1.1v 759.745n 1.1v 759.755n 1.1v 764.745n 1.1v 764.755n 1.1v 769.745n 1.1v 769.755n 1.1v 774.745n 1.1v 774.755n 1.1v 779.745n 1.1v 779.755n 1.1v 784.745n 1.1v 784.755n 0.0v 789.745n 0.0v 789.755n 1.1v 794.745n 1.1v 794.755n 1.1v 799.745n 1.1v 799.755n 1.1v 804.745n 1.1v 804.755n 1.1v 809.745n 1.1v 809.755n 1.1v 814.745n 1.1v 814.755n 1.1v 819.745n 1.1v 819.755n 1.1v 824.745n 1.1v 824.755n 1.1v 829.745n 1.1v 829.755n 1.1v 834.745n 1.1v 834.755n 1.1v 839.745n 1.1v 839.755n 1.1v 844.745n 1.1v 844.755n 1.1v 849.745n 1.1v 849.755n 1.1v 854.745n 1.1v 854.755n 1.1v 859.745n 1.1v 859.755n 1.1v 864.745n 1.1v 864.755n 1.1v 869.745n 1.1v 869.755n 0.0v 874.745n 0.0v 874.755n 1.1v 879.745n 1.1v 879.755n 0.0v 884.745n 0.0v 884.755n 1.1v 889.745n 1.1v 889.755n 1.1v 894.745n 1.1v 894.755n 1.1v 899.745n 1.1v 899.755n 1.1v 904.745n 1.1v 904.755n 1.1v 909.745n 1.1v 909.755n 1.1v 914.745n 1.1v 914.755n 1.1v 919.745n 1.1v 919.755n 1.1v 924.745n 1.1v 924.755n 1.1v 929.745n 1.1v 929.755n 1.1v 934.745n 1.1v 934.755n 1.1v 939.745n 1.1v 939.755n 1.1v 944.745n 1.1v 944.755n 1.1v 949.745n 1.1v 949.755n 1.1v 954.745n 1.1v 954.755n 1.1v 959.745n 1.1v 959.755n 1.1v 964.745n 1.1v 964.755n 0.0v 969.745n 0.0v 969.755n 0.0v 974.745n 0.0v 974.755n 0.0v 979.745n 0.0v 979.755n 1.1v 984.745n 1.1v 984.755n 0.0v 989.745n 0.0v 989.755n 0.0v 994.745n 0.0v 994.755n 0.0v 999.745n 0.0v 999.755n 0.0v 1004.745n 0.0v 1004.755n 0.0v 1009.745n 0.0v 1009.755n 0.0v 1014.745n 0.0v 1014.755n 0.0v 1019.745n 0.0v 1019.755n 1.1v 1024.745n 1.1v 1024.755n 1.1v )
* (time, data): [(0, 0), (5, 1), (10, 1), (15, 1), (20, 1), (25, 1), (30, 0), (35, 0), (40, 0), (45, 1), (50, 1), (55, 1), (60, 1), (65, 0), (70, 0), (75, 0), (80, 0), (85, 0), (90, 0), (95, 0), (100, 1), (105, 1), (110, 1), (115, 1), (120, 1), (125, 1), (130, 1), (135, 1), (140, 1), (145, 1), (150, 1), (155, 1), (160, 1), (165, 1), (170, 0), (175, 0), (180, 0), (185, 0), (190, 0), (195, 0), (200, 1), (205, 1), (210, 1), (215, 1), (220, 1), (225, 1), (230, 1), (235, 1), (240, 0), (245, 0), (250, 0), (255, 1), (260, 1), (265, 0), (270, 0), (275, 0), (280, 0), (285, 0), (290, 0), (295, 0), (300, 1), (305, 1), (310, 1), (315, 1), (320, 1), (325, 1), (330, 0), (335, 0), (340, 0), (345, 0), (350, 0), (355, 0), (360, 0), (365, 0), (370, 0), (375, 0), (380, 0), (385, 0), (390, 0), (395, 0), (400, 0), (405, 0), (410, 0), (415, 0), (420, 1), (425, 0), (430, 1), (435, 1), (440, 1), (445, 1), (450, 1), (455, 1), (460, 0), (465, 0), (470, 1), (475, 1), (480, 1), (485, 1), (490, 1), (495, 1), (500, 1), (505, 0), (510, 1), (515, 1), (520, 1), (525, 1), (530, 1), (535, 0), (540, 1), (545, 1), (550, 1), (555, 1), (560, 1), (565, 1), (570, 1), (575, 0), (580, 0), (585, 0), (590, 0), (595, 0), (600, 0), (605, 0), (610, 0), (615, 0), (620, 0), (625, 0), (630, 0), (635, 1), (640, 0), (645, 0), (650, 0), (655, 0), (660, 0), (665, 0), (670, 0), (675, 0), (680, 0), (685, 0), (690, 0), (695, 0), (700, 0), (705, 1), (710, 1), (715, 0), (720, 0), (725, 0), (730, 0), (735, 0), (740, 0), (745, 0), (750, 0), (755, 1), (760, 1), (765, 1), (770, 1), (775, 0), (780, 0), (785, 1), (790, 1), (795, 1), (800, 1), (805, 1), (810, 1), (815, 1), (820, 0), (825, 0), (830, 1), (835, 0), (840, 0), (845, 0), (850, 0), (855, 0), (860, 1), (865, 0), (870, 1), (875, 0), (880, 1), (885, 0), (890, 0), (895, 0), (900, 0), (905, 0), (910, 0), (915, 0), (920, 0), (925, 0), (930, 0), (935, 1), (940, 0), (945, 0), (950, 0), (955, 1), (960, 1), (965, 1), (970, 1), (975, 1), (980, 0), (985, 0), (990, 0), (995, 1), (1000, 0), (1005, 0), (1010, 0), (1015, 0), (1020, 1), (1025, 1)]
Vdin0_41  din0_41  0 PWL (0n 0.0v 4.745n 0.0v 4.755n 1.1v 9.745n 1.1v 9.755n 1.1v 14.745n 1.1v 14.755n 1.1v 19.745n 1.1v 19.755n 1.1v 24.745n 1.1v 24.755n 1.1v 29.745n 1.1v 29.755n 0.0v 34.745n 0.0v 34.755n 0.0v 39.745n 0.0v 39.755n 0.0v 44.745n 0.0v 44.755n 1.1v 49.745n 1.1v 49.755n 1.1v 54.745n 1.1v 54.755n 1.1v 59.745n 1.1v 59.755n 1.1v 64.745n 1.1v 64.755n 0.0v 69.745n 0.0v 69.755n 0.0v 74.745n 0.0v 74.755n 0.0v 79.745n 0.0v 79.755n 0.0v 84.745n 0.0v 84.755n 0.0v 89.745n 0.0v 89.755n 0.0v 94.745n 0.0v 94.755n 0.0v 99.745n 0.0v 99.755n 1.1v 104.745n 1.1v 104.755n 1.1v 109.745n 1.1v 109.755n 1.1v 114.745n 1.1v 114.755n 1.1v 119.745n 1.1v 119.755n 1.1v 124.745n 1.1v 124.755n 1.1v 129.745n 1.1v 129.755n 1.1v 134.745n 1.1v 134.755n 1.1v 139.745n 1.1v 139.755n 1.1v 144.745n 1.1v 144.755n 1.1v 149.745n 1.1v 149.755n 1.1v 154.745n 1.1v 154.755n 1.1v 159.745n 1.1v 159.755n 1.1v 164.745n 1.1v 164.755n 1.1v 169.745n 1.1v 169.755n 0.0v 174.745n 0.0v 174.755n 0.0v 179.745n 0.0v 179.755n 0.0v 184.745n 0.0v 184.755n 0.0v 189.745n 0.0v 189.755n 0.0v 194.745n 0.0v 194.755n 0.0v 199.745n 0.0v 199.755n 1.1v 204.745n 1.1v 204.755n 1.1v 209.745n 1.1v 209.755n 1.1v 214.745n 1.1v 214.755n 1.1v 219.745n 1.1v 219.755n 1.1v 224.745n 1.1v 224.755n 1.1v 229.745n 1.1v 229.755n 1.1v 234.745n 1.1v 234.755n 1.1v 239.745n 1.1v 239.755n 0.0v 244.745n 0.0v 244.755n 0.0v 249.745n 0.0v 249.755n 0.0v 254.745n 0.0v 254.755n 1.1v 259.745n 1.1v 259.755n 1.1v 264.745n 1.1v 264.755n 0.0v 269.745n 0.0v 269.755n 0.0v 274.745n 0.0v 274.755n 0.0v 279.745n 0.0v 279.755n 0.0v 284.745n 0.0v 284.755n 0.0v 289.745n 0.0v 289.755n 0.0v 294.745n 0.0v 294.755n 0.0v 299.745n 0.0v 299.755n 1.1v 304.745n 1.1v 304.755n 1.1v 309.745n 1.1v 309.755n 1.1v 314.745n 1.1v 314.755n 1.1v 319.745n 1.1v 319.755n 1.1v 324.745n 1.1v 324.755n 1.1v 329.745n 1.1v 329.755n 0.0v 334.745n 0.0v 334.755n 0.0v 339.745n 0.0v 339.755n 0.0v 344.745n 0.0v 344.755n 0.0v 349.745n 0.0v 349.755n 0.0v 354.745n 0.0v 354.755n 0.0v 359.745n 0.0v 359.755n 0.0v 364.745n 0.0v 364.755n 0.0v 369.745n 0.0v 369.755n 0.0v 374.745n 0.0v 374.755n 0.0v 379.745n 0.0v 379.755n 0.0v 384.745n 0.0v 384.755n 0.0v 389.745n 0.0v 389.755n 0.0v 394.745n 0.0v 394.755n 0.0v 399.745n 0.0v 399.755n 0.0v 404.745n 0.0v 404.755n 0.0v 409.745n 0.0v 409.755n 0.0v 414.745n 0.0v 414.755n 0.0v 419.745n 0.0v 419.755n 1.1v 424.745n 1.1v 424.755n 0.0v 429.745n 0.0v 429.755n 1.1v 434.745n 1.1v 434.755n 1.1v 439.745n 1.1v 439.755n 1.1v 444.745n 1.1v 444.755n 1.1v 449.745n 1.1v 449.755n 1.1v 454.745n 1.1v 454.755n 1.1v 459.745n 1.1v 459.755n 0.0v 464.745n 0.0v 464.755n 0.0v 469.745n 0.0v 469.755n 1.1v 474.745n 1.1v 474.755n 1.1v 479.745n 1.1v 479.755n 1.1v 484.745n 1.1v 484.755n 1.1v 489.745n 1.1v 489.755n 1.1v 494.745n 1.1v 494.755n 1.1v 499.745n 1.1v 499.755n 1.1v 504.745n 1.1v 504.755n 0.0v 509.745n 0.0v 509.755n 1.1v 514.745n 1.1v 514.755n 1.1v 519.745n 1.1v 519.755n 1.1v 524.745n 1.1v 524.755n 1.1v 529.745n 1.1v 529.755n 1.1v 534.745n 1.1v 534.755n 0.0v 539.745n 0.0v 539.755n 1.1v 544.745n 1.1v 544.755n 1.1v 549.745n 1.1v 549.755n 1.1v 554.745n 1.1v 554.755n 1.1v 559.745n 1.1v 559.755n 1.1v 564.745n 1.1v 564.755n 1.1v 569.745n 1.1v 569.755n 1.1v 574.745n 1.1v 574.755n 0.0v 579.745n 0.0v 579.755n 0.0v 584.745n 0.0v 584.755n 0.0v 589.745n 0.0v 589.755n 0.0v 594.745n 0.0v 594.755n 0.0v 599.745n 0.0v 599.755n 0.0v 604.745n 0.0v 604.755n 0.0v 609.745n 0.0v 609.755n 0.0v 614.745n 0.0v 614.755n 0.0v 619.745n 0.0v 619.755n 0.0v 624.745n 0.0v 624.755n 0.0v 629.745n 0.0v 629.755n 0.0v 634.745n 0.0v 634.755n 1.1v 639.745n 1.1v 639.755n 0.0v 644.745n 0.0v 644.755n 0.0v 649.745n 0.0v 649.755n 0.0v 654.745n 0.0v 654.755n 0.0v 659.745n 0.0v 659.755n 0.0v 664.745n 0.0v 664.755n 0.0v 669.745n 0.0v 669.755n 0.0v 674.745n 0.0v 674.755n 0.0v 679.745n 0.0v 679.755n 0.0v 684.745n 0.0v 684.755n 0.0v 689.745n 0.0v 689.755n 0.0v 694.745n 0.0v 694.755n 0.0v 699.745n 0.0v 699.755n 0.0v 704.745n 0.0v 704.755n 1.1v 709.745n 1.1v 709.755n 1.1v 714.745n 1.1v 714.755n 0.0v 719.745n 0.0v 719.755n 0.0v 724.745n 0.0v 724.755n 0.0v 729.745n 0.0v 729.755n 0.0v 734.745n 0.0v 734.755n 0.0v 739.745n 0.0v 739.755n 0.0v 744.745n 0.0v 744.755n 0.0v 749.745n 0.0v 749.755n 0.0v 754.745n 0.0v 754.755n 1.1v 759.745n 1.1v 759.755n 1.1v 764.745n 1.1v 764.755n 1.1v 769.745n 1.1v 769.755n 1.1v 774.745n 1.1v 774.755n 0.0v 779.745n 0.0v 779.755n 0.0v 784.745n 0.0v 784.755n 1.1v 789.745n 1.1v 789.755n 1.1v 794.745n 1.1v 794.755n 1.1v 799.745n 1.1v 799.755n 1.1v 804.745n 1.1v 804.755n 1.1v 809.745n 1.1v 809.755n 1.1v 814.745n 1.1v 814.755n 1.1v 819.745n 1.1v 819.755n 0.0v 824.745n 0.0v 824.755n 0.0v 829.745n 0.0v 829.755n 1.1v 834.745n 1.1v 834.755n 0.0v 839.745n 0.0v 839.755n 0.0v 844.745n 0.0v 844.755n 0.0v 849.745n 0.0v 849.755n 0.0v 854.745n 0.0v 854.755n 0.0v 859.745n 0.0v 859.755n 1.1v 864.745n 1.1v 864.755n 0.0v 869.745n 0.0v 869.755n 1.1v 874.745n 1.1v 874.755n 0.0v 879.745n 0.0v 879.755n 1.1v 884.745n 1.1v 884.755n 0.0v 889.745n 0.0v 889.755n 0.0v 894.745n 0.0v 894.755n 0.0v 899.745n 0.0v 899.755n 0.0v 904.745n 0.0v 904.755n 0.0v 909.745n 0.0v 909.755n 0.0v 914.745n 0.0v 914.755n 0.0v 919.745n 0.0v 919.755n 0.0v 924.745n 0.0v 924.755n 0.0v 929.745n 0.0v 929.755n 0.0v 934.745n 0.0v 934.755n 1.1v 939.745n 1.1v 939.755n 0.0v 944.745n 0.0v 944.755n 0.0v 949.745n 0.0v 949.755n 0.0v 954.745n 0.0v 954.755n 1.1v 959.745n 1.1v 959.755n 1.1v 964.745n 1.1v 964.755n 1.1v 969.745n 1.1v 969.755n 1.1v 974.745n 1.1v 974.755n 1.1v 979.745n 1.1v 979.755n 0.0v 984.745n 0.0v 984.755n 0.0v 989.745n 0.0v 989.755n 0.0v 994.745n 0.0v 994.755n 1.1v 999.745n 1.1v 999.755n 0.0v 1004.745n 0.0v 1004.755n 0.0v 1009.745n 0.0v 1009.755n 0.0v 1014.745n 0.0v 1014.755n 0.0v 1019.745n 0.0v 1019.755n 1.1v 1024.745n 1.1v 1024.755n 1.1v )
* (time, data): [(0, 0), (5, 0), (10, 0), (15, 1), (20, 1), (25, 1), (30, 1), (35, 1), (40, 0), (45, 1), (50, 1), (55, 1), (60, 0), (65, 0), (70, 0), (75, 0), (80, 0), (85, 0), (90, 0), (95, 0), (100, 0), (105, 0), (110, 0), (115, 0), (120, 0), (125, 0), (130, 0), (135, 0), (140, 0), (145, 0), (150, 0), (155, 0), (160, 0), (165, 0), (170, 1), (175, 1), (180, 1), (185, 1), (190, 1), (195, 1), (200, 1), (205, 1), (210, 0), (215, 0), (220, 0), (225, 0), (230, 0), (235, 0), (240, 0), (245, 0), (250, 0), (255, 0), (260, 0), (265, 0), (270, 0), (275, 0), (280, 0), (285, 0), (290, 0), (295, 0), (300, 0), (305, 0), (310, 0), (315, 1), (320, 1), (325, 1), (330, 0), (335, 0), (340, 0), (345, 0), (350, 0), (355, 0), (360, 1), (365, 1), (370, 1), (375, 1), (380, 1), (385, 1), (390, 1), (395, 1), (400, 0), (405, 0), (410, 1), (415, 0), (420, 0), (425, 1), (430, 0), (435, 0), (440, 0), (445, 0), (450, 1), (455, 1), (460, 1), (465, 0), (470, 0), (475, 0), (480, 1), (485, 1), (490, 1), (495, 1), (500, 1), (505, 1), (510, 0), (515, 0), (520, 0), (525, 0), (530, 0), (535, 1), (540, 1), (545, 1), (550, 1), (555, 0), (560, 0), (565, 0), (570, 0), (575, 0), (580, 0), (585, 0), (590, 0), (595, 0), (600, 0), (605, 0), (610, 0), (615, 0), (620, 0), (625, 0), (630, 1), (635, 0), (640, 0), (645, 0), (650, 0), (655, 0), (660, 1), (665, 1), (670, 1), (675, 1), (680, 1), (685, 1), (690, 1), (695, 1), (700, 1), (705, 1), (710, 1), (715, 1), (720, 1), (725, 1), (730, 1), (735, 0), (740, 0), (745, 0), (750, 0), (755, 0), (760, 0), (765, 0), (770, 0), (775, 1), (780, 1), (785, 0), (790, 1), (795, 1), (800, 1), (805, 1), (810, 1), (815, 1), (820, 1), (825, 1), (830, 0), (835, 1), (840, 1), (845, 1), (850, 1), (855, 1), (860, 0), (865, 0), (870, 0), (875, 1), (880, 1), (885, 1), (890, 1), (895, 1), (900, 1), (905, 1), (910, 1), (915, 1), (920, 1), (925, 1), (930, 1), (935, 1), (940, 1), (945, 1), (950, 1), (955, 0), (960, 0), (965, 1), (970, 1), (975, 1), (980, 0), (985, 0), (990, 0), (995, 1), (1000, 1), (1005, 1), (1010, 1), (1015, 1), (1020, 1), (1025, 1)]
Vdin0_42  din0_42  0 PWL (0n 0.0v 4.745n 0.0v 4.755n 0.0v 9.745n 0.0v 9.755n 0.0v 14.745n 0.0v 14.755n 1.1v 19.745n 1.1v 19.755n 1.1v 24.745n 1.1v 24.755n 1.1v 29.745n 1.1v 29.755n 1.1v 34.745n 1.1v 34.755n 1.1v 39.745n 1.1v 39.755n 0.0v 44.745n 0.0v 44.755n 1.1v 49.745n 1.1v 49.755n 1.1v 54.745n 1.1v 54.755n 1.1v 59.745n 1.1v 59.755n 0.0v 64.745n 0.0v 64.755n 0.0v 69.745n 0.0v 69.755n 0.0v 74.745n 0.0v 74.755n 0.0v 79.745n 0.0v 79.755n 0.0v 84.745n 0.0v 84.755n 0.0v 89.745n 0.0v 89.755n 0.0v 94.745n 0.0v 94.755n 0.0v 99.745n 0.0v 99.755n 0.0v 104.745n 0.0v 104.755n 0.0v 109.745n 0.0v 109.755n 0.0v 114.745n 0.0v 114.755n 0.0v 119.745n 0.0v 119.755n 0.0v 124.745n 0.0v 124.755n 0.0v 129.745n 0.0v 129.755n 0.0v 134.745n 0.0v 134.755n 0.0v 139.745n 0.0v 139.755n 0.0v 144.745n 0.0v 144.755n 0.0v 149.745n 0.0v 149.755n 0.0v 154.745n 0.0v 154.755n 0.0v 159.745n 0.0v 159.755n 0.0v 164.745n 0.0v 164.755n 0.0v 169.745n 0.0v 169.755n 1.1v 174.745n 1.1v 174.755n 1.1v 179.745n 1.1v 179.755n 1.1v 184.745n 1.1v 184.755n 1.1v 189.745n 1.1v 189.755n 1.1v 194.745n 1.1v 194.755n 1.1v 199.745n 1.1v 199.755n 1.1v 204.745n 1.1v 204.755n 1.1v 209.745n 1.1v 209.755n 0.0v 214.745n 0.0v 214.755n 0.0v 219.745n 0.0v 219.755n 0.0v 224.745n 0.0v 224.755n 0.0v 229.745n 0.0v 229.755n 0.0v 234.745n 0.0v 234.755n 0.0v 239.745n 0.0v 239.755n 0.0v 244.745n 0.0v 244.755n 0.0v 249.745n 0.0v 249.755n 0.0v 254.745n 0.0v 254.755n 0.0v 259.745n 0.0v 259.755n 0.0v 264.745n 0.0v 264.755n 0.0v 269.745n 0.0v 269.755n 0.0v 274.745n 0.0v 274.755n 0.0v 279.745n 0.0v 279.755n 0.0v 284.745n 0.0v 284.755n 0.0v 289.745n 0.0v 289.755n 0.0v 294.745n 0.0v 294.755n 0.0v 299.745n 0.0v 299.755n 0.0v 304.745n 0.0v 304.755n 0.0v 309.745n 0.0v 309.755n 0.0v 314.745n 0.0v 314.755n 1.1v 319.745n 1.1v 319.755n 1.1v 324.745n 1.1v 324.755n 1.1v 329.745n 1.1v 329.755n 0.0v 334.745n 0.0v 334.755n 0.0v 339.745n 0.0v 339.755n 0.0v 344.745n 0.0v 344.755n 0.0v 349.745n 0.0v 349.755n 0.0v 354.745n 0.0v 354.755n 0.0v 359.745n 0.0v 359.755n 1.1v 364.745n 1.1v 364.755n 1.1v 369.745n 1.1v 369.755n 1.1v 374.745n 1.1v 374.755n 1.1v 379.745n 1.1v 379.755n 1.1v 384.745n 1.1v 384.755n 1.1v 389.745n 1.1v 389.755n 1.1v 394.745n 1.1v 394.755n 1.1v 399.745n 1.1v 399.755n 0.0v 404.745n 0.0v 404.755n 0.0v 409.745n 0.0v 409.755n 1.1v 414.745n 1.1v 414.755n 0.0v 419.745n 0.0v 419.755n 0.0v 424.745n 0.0v 424.755n 1.1v 429.745n 1.1v 429.755n 0.0v 434.745n 0.0v 434.755n 0.0v 439.745n 0.0v 439.755n 0.0v 444.745n 0.0v 444.755n 0.0v 449.745n 0.0v 449.755n 1.1v 454.745n 1.1v 454.755n 1.1v 459.745n 1.1v 459.755n 1.1v 464.745n 1.1v 464.755n 0.0v 469.745n 0.0v 469.755n 0.0v 474.745n 0.0v 474.755n 0.0v 479.745n 0.0v 479.755n 1.1v 484.745n 1.1v 484.755n 1.1v 489.745n 1.1v 489.755n 1.1v 494.745n 1.1v 494.755n 1.1v 499.745n 1.1v 499.755n 1.1v 504.745n 1.1v 504.755n 1.1v 509.745n 1.1v 509.755n 0.0v 514.745n 0.0v 514.755n 0.0v 519.745n 0.0v 519.755n 0.0v 524.745n 0.0v 524.755n 0.0v 529.745n 0.0v 529.755n 0.0v 534.745n 0.0v 534.755n 1.1v 539.745n 1.1v 539.755n 1.1v 544.745n 1.1v 544.755n 1.1v 549.745n 1.1v 549.755n 1.1v 554.745n 1.1v 554.755n 0.0v 559.745n 0.0v 559.755n 0.0v 564.745n 0.0v 564.755n 0.0v 569.745n 0.0v 569.755n 0.0v 574.745n 0.0v 574.755n 0.0v 579.745n 0.0v 579.755n 0.0v 584.745n 0.0v 584.755n 0.0v 589.745n 0.0v 589.755n 0.0v 594.745n 0.0v 594.755n 0.0v 599.745n 0.0v 599.755n 0.0v 604.745n 0.0v 604.755n 0.0v 609.745n 0.0v 609.755n 0.0v 614.745n 0.0v 614.755n 0.0v 619.745n 0.0v 619.755n 0.0v 624.745n 0.0v 624.755n 0.0v 629.745n 0.0v 629.755n 1.1v 634.745n 1.1v 634.755n 0.0v 639.745n 0.0v 639.755n 0.0v 644.745n 0.0v 644.755n 0.0v 649.745n 0.0v 649.755n 0.0v 654.745n 0.0v 654.755n 0.0v 659.745n 0.0v 659.755n 1.1v 664.745n 1.1v 664.755n 1.1v 669.745n 1.1v 669.755n 1.1v 674.745n 1.1v 674.755n 1.1v 679.745n 1.1v 679.755n 1.1v 684.745n 1.1v 684.755n 1.1v 689.745n 1.1v 689.755n 1.1v 694.745n 1.1v 694.755n 1.1v 699.745n 1.1v 699.755n 1.1v 704.745n 1.1v 704.755n 1.1v 709.745n 1.1v 709.755n 1.1v 714.745n 1.1v 714.755n 1.1v 719.745n 1.1v 719.755n 1.1v 724.745n 1.1v 724.755n 1.1v 729.745n 1.1v 729.755n 1.1v 734.745n 1.1v 734.755n 0.0v 739.745n 0.0v 739.755n 0.0v 744.745n 0.0v 744.755n 0.0v 749.745n 0.0v 749.755n 0.0v 754.745n 0.0v 754.755n 0.0v 759.745n 0.0v 759.755n 0.0v 764.745n 0.0v 764.755n 0.0v 769.745n 0.0v 769.755n 0.0v 774.745n 0.0v 774.755n 1.1v 779.745n 1.1v 779.755n 1.1v 784.745n 1.1v 784.755n 0.0v 789.745n 0.0v 789.755n 1.1v 794.745n 1.1v 794.755n 1.1v 799.745n 1.1v 799.755n 1.1v 804.745n 1.1v 804.755n 1.1v 809.745n 1.1v 809.755n 1.1v 814.745n 1.1v 814.755n 1.1v 819.745n 1.1v 819.755n 1.1v 824.745n 1.1v 824.755n 1.1v 829.745n 1.1v 829.755n 0.0v 834.745n 0.0v 834.755n 1.1v 839.745n 1.1v 839.755n 1.1v 844.745n 1.1v 844.755n 1.1v 849.745n 1.1v 849.755n 1.1v 854.745n 1.1v 854.755n 1.1v 859.745n 1.1v 859.755n 0.0v 864.745n 0.0v 864.755n 0.0v 869.745n 0.0v 869.755n 0.0v 874.745n 0.0v 874.755n 1.1v 879.745n 1.1v 879.755n 1.1v 884.745n 1.1v 884.755n 1.1v 889.745n 1.1v 889.755n 1.1v 894.745n 1.1v 894.755n 1.1v 899.745n 1.1v 899.755n 1.1v 904.745n 1.1v 904.755n 1.1v 909.745n 1.1v 909.755n 1.1v 914.745n 1.1v 914.755n 1.1v 919.745n 1.1v 919.755n 1.1v 924.745n 1.1v 924.755n 1.1v 929.745n 1.1v 929.755n 1.1v 934.745n 1.1v 934.755n 1.1v 939.745n 1.1v 939.755n 1.1v 944.745n 1.1v 944.755n 1.1v 949.745n 1.1v 949.755n 1.1v 954.745n 1.1v 954.755n 0.0v 959.745n 0.0v 959.755n 0.0v 964.745n 0.0v 964.755n 1.1v 969.745n 1.1v 969.755n 1.1v 974.745n 1.1v 974.755n 1.1v 979.745n 1.1v 979.755n 0.0v 984.745n 0.0v 984.755n 0.0v 989.745n 0.0v 989.755n 0.0v 994.745n 0.0v 994.755n 1.1v 999.745n 1.1v 999.755n 1.1v 1004.745n 1.1v 1004.755n 1.1v 1009.745n 1.1v 1009.755n 1.1v 1014.745n 1.1v 1014.755n 1.1v 1019.745n 1.1v 1019.755n 1.1v 1024.745n 1.1v 1024.755n 1.1v )
* (time, data): [(0, 0), (5, 1), (10, 1), (15, 1), (20, 1), (25, 1), (30, 1), (35, 1), (40, 0), (45, 1), (50, 1), (55, 1), (60, 1), (65, 0), (70, 0), (75, 0), (80, 0), (85, 0), (90, 0), (95, 0), (100, 1), (105, 1), (110, 1), (115, 1), (120, 1), (125, 1), (130, 1), (135, 1), (140, 0), (145, 0), (150, 0), (155, 0), (160, 0), (165, 0), (170, 0), (175, 0), (180, 0), (185, 1), (190, 1), (195, 1), (200, 1), (205, 1), (210, 0), (215, 0), (220, 0), (225, 0), (230, 1), (235, 1), (240, 0), (245, 0), (250, 0), (255, 0), (260, 0), (265, 0), (270, 0), (275, 0), (280, 1), (285, 1), (290, 1), (295, 1), (300, 0), (305, 0), (310, 0), (315, 0), (320, 0), (325, 0), (330, 1), (335, 0), (340, 1), (345, 1), (350, 1), (355, 1), (360, 0), (365, 0), (370, 0), (375, 0), (380, 0), (385, 0), (390, 0), (395, 1), (400, 1), (405, 1), (410, 1), (415, 1), (420, 1), (425, 1), (430, 1), (435, 1), (440, 1), (445, 1), (450, 1), (455, 1), (460, 0), (465, 1), (470, 1), (475, 1), (480, 0), (485, 0), (490, 0), (495, 0), (500, 1), (505, 0), (510, 1), (515, 0), (520, 0), (525, 0), (530, 0), (535, 1), (540, 1), (545, 1), (550, 1), (555, 0), (560, 0), (565, 0), (570, 0), (575, 0), (580, 0), (585, 0), (590, 0), (595, 0), (600, 0), (605, 0), (610, 0), (615, 0), (620, 0), (625, 0), (630, 0), (635, 0), (640, 0), (645, 0), (650, 0), (655, 0), (660, 1), (665, 1), (670, 1), (675, 1), (680, 1), (685, 1), (690, 1), (695, 1), (700, 1), (705, 1), (710, 1), (715, 1), (720, 1), (725, 1), (730, 1), (735, 1), (740, 0), (745, 0), (750, 0), (755, 0), (760, 0), (765, 0), (770, 0), (775, 0), (780, 0), (785, 0), (790, 1), (795, 1), (800, 1), (805, 1), (810, 1), (815, 1), (820, 1), (825, 1), (830, 1), (835, 1), (840, 1), (845, 1), (850, 1), (855, 0), (860, 1), (865, 0), (870, 0), (875, 1), (880, 1), (885, 1), (890, 1), (895, 1), (900, 1), (905, 1), (910, 0), (915, 0), (920, 0), (925, 0), (930, 0), (935, 1), (940, 0), (945, 0), (950, 0), (955, 0), (960, 0), (965, 0), (970, 0), (975, 0), (980, 1), (985, 1), (990, 1), (995, 0), (1000, 1), (1005, 1), (1010, 1), (1015, 1), (1020, 0), (1025, 0)]
Vdin0_43  din0_43  0 PWL (0n 0.0v 4.745n 0.0v 4.755n 1.1v 9.745n 1.1v 9.755n 1.1v 14.745n 1.1v 14.755n 1.1v 19.745n 1.1v 19.755n 1.1v 24.745n 1.1v 24.755n 1.1v 29.745n 1.1v 29.755n 1.1v 34.745n 1.1v 34.755n 1.1v 39.745n 1.1v 39.755n 0.0v 44.745n 0.0v 44.755n 1.1v 49.745n 1.1v 49.755n 1.1v 54.745n 1.1v 54.755n 1.1v 59.745n 1.1v 59.755n 1.1v 64.745n 1.1v 64.755n 0.0v 69.745n 0.0v 69.755n 0.0v 74.745n 0.0v 74.755n 0.0v 79.745n 0.0v 79.755n 0.0v 84.745n 0.0v 84.755n 0.0v 89.745n 0.0v 89.755n 0.0v 94.745n 0.0v 94.755n 0.0v 99.745n 0.0v 99.755n 1.1v 104.745n 1.1v 104.755n 1.1v 109.745n 1.1v 109.755n 1.1v 114.745n 1.1v 114.755n 1.1v 119.745n 1.1v 119.755n 1.1v 124.745n 1.1v 124.755n 1.1v 129.745n 1.1v 129.755n 1.1v 134.745n 1.1v 134.755n 1.1v 139.745n 1.1v 139.755n 0.0v 144.745n 0.0v 144.755n 0.0v 149.745n 0.0v 149.755n 0.0v 154.745n 0.0v 154.755n 0.0v 159.745n 0.0v 159.755n 0.0v 164.745n 0.0v 164.755n 0.0v 169.745n 0.0v 169.755n 0.0v 174.745n 0.0v 174.755n 0.0v 179.745n 0.0v 179.755n 0.0v 184.745n 0.0v 184.755n 1.1v 189.745n 1.1v 189.755n 1.1v 194.745n 1.1v 194.755n 1.1v 199.745n 1.1v 199.755n 1.1v 204.745n 1.1v 204.755n 1.1v 209.745n 1.1v 209.755n 0.0v 214.745n 0.0v 214.755n 0.0v 219.745n 0.0v 219.755n 0.0v 224.745n 0.0v 224.755n 0.0v 229.745n 0.0v 229.755n 1.1v 234.745n 1.1v 234.755n 1.1v 239.745n 1.1v 239.755n 0.0v 244.745n 0.0v 244.755n 0.0v 249.745n 0.0v 249.755n 0.0v 254.745n 0.0v 254.755n 0.0v 259.745n 0.0v 259.755n 0.0v 264.745n 0.0v 264.755n 0.0v 269.745n 0.0v 269.755n 0.0v 274.745n 0.0v 274.755n 0.0v 279.745n 0.0v 279.755n 1.1v 284.745n 1.1v 284.755n 1.1v 289.745n 1.1v 289.755n 1.1v 294.745n 1.1v 294.755n 1.1v 299.745n 1.1v 299.755n 0.0v 304.745n 0.0v 304.755n 0.0v 309.745n 0.0v 309.755n 0.0v 314.745n 0.0v 314.755n 0.0v 319.745n 0.0v 319.755n 0.0v 324.745n 0.0v 324.755n 0.0v 329.745n 0.0v 329.755n 1.1v 334.745n 1.1v 334.755n 0.0v 339.745n 0.0v 339.755n 1.1v 344.745n 1.1v 344.755n 1.1v 349.745n 1.1v 349.755n 1.1v 354.745n 1.1v 354.755n 1.1v 359.745n 1.1v 359.755n 0.0v 364.745n 0.0v 364.755n 0.0v 369.745n 0.0v 369.755n 0.0v 374.745n 0.0v 374.755n 0.0v 379.745n 0.0v 379.755n 0.0v 384.745n 0.0v 384.755n 0.0v 389.745n 0.0v 389.755n 0.0v 394.745n 0.0v 394.755n 1.1v 399.745n 1.1v 399.755n 1.1v 404.745n 1.1v 404.755n 1.1v 409.745n 1.1v 409.755n 1.1v 414.745n 1.1v 414.755n 1.1v 419.745n 1.1v 419.755n 1.1v 424.745n 1.1v 424.755n 1.1v 429.745n 1.1v 429.755n 1.1v 434.745n 1.1v 434.755n 1.1v 439.745n 1.1v 439.755n 1.1v 444.745n 1.1v 444.755n 1.1v 449.745n 1.1v 449.755n 1.1v 454.745n 1.1v 454.755n 1.1v 459.745n 1.1v 459.755n 0.0v 464.745n 0.0v 464.755n 1.1v 469.745n 1.1v 469.755n 1.1v 474.745n 1.1v 474.755n 1.1v 479.745n 1.1v 479.755n 0.0v 484.745n 0.0v 484.755n 0.0v 489.745n 0.0v 489.755n 0.0v 494.745n 0.0v 494.755n 0.0v 499.745n 0.0v 499.755n 1.1v 504.745n 1.1v 504.755n 0.0v 509.745n 0.0v 509.755n 1.1v 514.745n 1.1v 514.755n 0.0v 519.745n 0.0v 519.755n 0.0v 524.745n 0.0v 524.755n 0.0v 529.745n 0.0v 529.755n 0.0v 534.745n 0.0v 534.755n 1.1v 539.745n 1.1v 539.755n 1.1v 544.745n 1.1v 544.755n 1.1v 549.745n 1.1v 549.755n 1.1v 554.745n 1.1v 554.755n 0.0v 559.745n 0.0v 559.755n 0.0v 564.745n 0.0v 564.755n 0.0v 569.745n 0.0v 569.755n 0.0v 574.745n 0.0v 574.755n 0.0v 579.745n 0.0v 579.755n 0.0v 584.745n 0.0v 584.755n 0.0v 589.745n 0.0v 589.755n 0.0v 594.745n 0.0v 594.755n 0.0v 599.745n 0.0v 599.755n 0.0v 604.745n 0.0v 604.755n 0.0v 609.745n 0.0v 609.755n 0.0v 614.745n 0.0v 614.755n 0.0v 619.745n 0.0v 619.755n 0.0v 624.745n 0.0v 624.755n 0.0v 629.745n 0.0v 629.755n 0.0v 634.745n 0.0v 634.755n 0.0v 639.745n 0.0v 639.755n 0.0v 644.745n 0.0v 644.755n 0.0v 649.745n 0.0v 649.755n 0.0v 654.745n 0.0v 654.755n 0.0v 659.745n 0.0v 659.755n 1.1v 664.745n 1.1v 664.755n 1.1v 669.745n 1.1v 669.755n 1.1v 674.745n 1.1v 674.755n 1.1v 679.745n 1.1v 679.755n 1.1v 684.745n 1.1v 684.755n 1.1v 689.745n 1.1v 689.755n 1.1v 694.745n 1.1v 694.755n 1.1v 699.745n 1.1v 699.755n 1.1v 704.745n 1.1v 704.755n 1.1v 709.745n 1.1v 709.755n 1.1v 714.745n 1.1v 714.755n 1.1v 719.745n 1.1v 719.755n 1.1v 724.745n 1.1v 724.755n 1.1v 729.745n 1.1v 729.755n 1.1v 734.745n 1.1v 734.755n 1.1v 739.745n 1.1v 739.755n 0.0v 744.745n 0.0v 744.755n 0.0v 749.745n 0.0v 749.755n 0.0v 754.745n 0.0v 754.755n 0.0v 759.745n 0.0v 759.755n 0.0v 764.745n 0.0v 764.755n 0.0v 769.745n 0.0v 769.755n 0.0v 774.745n 0.0v 774.755n 0.0v 779.745n 0.0v 779.755n 0.0v 784.745n 0.0v 784.755n 0.0v 789.745n 0.0v 789.755n 1.1v 794.745n 1.1v 794.755n 1.1v 799.745n 1.1v 799.755n 1.1v 804.745n 1.1v 804.755n 1.1v 809.745n 1.1v 809.755n 1.1v 814.745n 1.1v 814.755n 1.1v 819.745n 1.1v 819.755n 1.1v 824.745n 1.1v 824.755n 1.1v 829.745n 1.1v 829.755n 1.1v 834.745n 1.1v 834.755n 1.1v 839.745n 1.1v 839.755n 1.1v 844.745n 1.1v 844.755n 1.1v 849.745n 1.1v 849.755n 1.1v 854.745n 1.1v 854.755n 0.0v 859.745n 0.0v 859.755n 1.1v 864.745n 1.1v 864.755n 0.0v 869.745n 0.0v 869.755n 0.0v 874.745n 0.0v 874.755n 1.1v 879.745n 1.1v 879.755n 1.1v 884.745n 1.1v 884.755n 1.1v 889.745n 1.1v 889.755n 1.1v 894.745n 1.1v 894.755n 1.1v 899.745n 1.1v 899.755n 1.1v 904.745n 1.1v 904.755n 1.1v 909.745n 1.1v 909.755n 0.0v 914.745n 0.0v 914.755n 0.0v 919.745n 0.0v 919.755n 0.0v 924.745n 0.0v 924.755n 0.0v 929.745n 0.0v 929.755n 0.0v 934.745n 0.0v 934.755n 1.1v 939.745n 1.1v 939.755n 0.0v 944.745n 0.0v 944.755n 0.0v 949.745n 0.0v 949.755n 0.0v 954.745n 0.0v 954.755n 0.0v 959.745n 0.0v 959.755n 0.0v 964.745n 0.0v 964.755n 0.0v 969.745n 0.0v 969.755n 0.0v 974.745n 0.0v 974.755n 0.0v 979.745n 0.0v 979.755n 1.1v 984.745n 1.1v 984.755n 1.1v 989.745n 1.1v 989.755n 1.1v 994.745n 1.1v 994.755n 0.0v 999.745n 0.0v 999.755n 1.1v 1004.745n 1.1v 1004.755n 1.1v 1009.745n 1.1v 1009.755n 1.1v 1014.745n 1.1v 1014.755n 1.1v 1019.745n 1.1v 1019.755n 0.0v 1024.745n 0.0v 1024.755n 0.0v )
* (time, data): [(0, 0), (5, 1), (10, 0), (15, 1), (20, 1), (25, 1), (30, 1), (35, 1), (40, 1), (45, 0), (50, 0), (55, 0), (60, 1), (65, 0), (70, 0), (75, 0), (80, 0), (85, 0), (90, 0), (95, 0), (100, 0), (105, 0), (110, 0), (115, 0), (120, 0), (125, 0), (130, 0), (135, 0), (140, 1), (145, 1), (150, 1), (155, 1), (160, 1), (165, 1), (170, 0), (175, 0), (180, 0), (185, 0), (190, 0), (195, 0), (200, 0), (205, 0), (210, 1), (215, 1), (220, 0), (225, 0), (230, 1), (235, 1), (240, 1), (245, 1), (250, 1), (255, 0), (260, 0), (265, 0), (270, 0), (275, 0), (280, 1), (285, 1), (290, 1), (295, 1), (300, 0), (305, 0), (310, 0), (315, 1), (320, 1), (325, 1), (330, 1), (335, 1), (340, 0), (345, 0), (350, 0), (355, 0), (360, 1), (365, 1), (370, 1), (375, 1), (380, 1), (385, 1), (390, 1), (395, 0), (400, 0), (405, 0), (410, 0), (415, 1), (420, 0), (425, 0), (430, 0), (435, 0), (440, 0), (445, 0), (450, 0), (455, 0), (460, 1), (465, 0), (470, 1), (475, 1), (480, 1), (485, 1), (490, 1), (495, 0), (500, 1), (505, 0), (510, 1), (515, 1), (520, 1), (525, 1), (530, 1), (535, 0), (540, 0), (545, 0), (550, 0), (555, 1), (560, 1), (565, 1), (570, 1), (575, 1), (580, 1), (585, 1), (590, 1), (595, 1), (600, 1), (605, 1), (610, 1), (615, 1), (620, 1), (625, 1), (630, 0), (635, 0), (640, 0), (645, 0), (650, 0), (655, 1), (660, 0), (665, 0), (670, 0), (675, 0), (680, 0), (685, 0), (690, 0), (695, 0), (700, 0), (705, 1), (710, 0), (715, 1), (720, 1), (725, 1), (730, 1), (735, 1), (740, 1), (745, 1), (750, 1), (755, 1), (760, 1), (765, 1), (770, 1), (775, 1), (780, 1), (785, 1), (790, 0), (795, 0), (800, 0), (805, 0), (810, 0), (815, 0), (820, 1), (825, 1), (830, 0), (835, 1), (840, 1), (845, 1), (850, 1), (855, 1), (860, 0), (865, 0), (870, 0), (875, 1), (880, 1), (885, 0), (890, 0), (895, 0), (900, 0), (905, 0), (910, 1), (915, 1), (920, 1), (925, 1), (930, 0), (935, 0), (940, 0), (945, 0), (950, 0), (955, 0), (960, 0), (965, 0), (970, 0), (975, 0), (980, 1), (985, 1), (990, 1), (995, 0), (1000, 1), (1005, 1), (1010, 1), (1015, 1), (1020, 0), (1025, 0)]
Vdin0_44  din0_44  0 PWL (0n 0.0v 4.745n 0.0v 4.755n 1.1v 9.745n 1.1v 9.755n 0.0v 14.745n 0.0v 14.755n 1.1v 19.745n 1.1v 19.755n 1.1v 24.745n 1.1v 24.755n 1.1v 29.745n 1.1v 29.755n 1.1v 34.745n 1.1v 34.755n 1.1v 39.745n 1.1v 39.755n 1.1v 44.745n 1.1v 44.755n 0.0v 49.745n 0.0v 49.755n 0.0v 54.745n 0.0v 54.755n 0.0v 59.745n 0.0v 59.755n 1.1v 64.745n 1.1v 64.755n 0.0v 69.745n 0.0v 69.755n 0.0v 74.745n 0.0v 74.755n 0.0v 79.745n 0.0v 79.755n 0.0v 84.745n 0.0v 84.755n 0.0v 89.745n 0.0v 89.755n 0.0v 94.745n 0.0v 94.755n 0.0v 99.745n 0.0v 99.755n 0.0v 104.745n 0.0v 104.755n 0.0v 109.745n 0.0v 109.755n 0.0v 114.745n 0.0v 114.755n 0.0v 119.745n 0.0v 119.755n 0.0v 124.745n 0.0v 124.755n 0.0v 129.745n 0.0v 129.755n 0.0v 134.745n 0.0v 134.755n 0.0v 139.745n 0.0v 139.755n 1.1v 144.745n 1.1v 144.755n 1.1v 149.745n 1.1v 149.755n 1.1v 154.745n 1.1v 154.755n 1.1v 159.745n 1.1v 159.755n 1.1v 164.745n 1.1v 164.755n 1.1v 169.745n 1.1v 169.755n 0.0v 174.745n 0.0v 174.755n 0.0v 179.745n 0.0v 179.755n 0.0v 184.745n 0.0v 184.755n 0.0v 189.745n 0.0v 189.755n 0.0v 194.745n 0.0v 194.755n 0.0v 199.745n 0.0v 199.755n 0.0v 204.745n 0.0v 204.755n 0.0v 209.745n 0.0v 209.755n 1.1v 214.745n 1.1v 214.755n 1.1v 219.745n 1.1v 219.755n 0.0v 224.745n 0.0v 224.755n 0.0v 229.745n 0.0v 229.755n 1.1v 234.745n 1.1v 234.755n 1.1v 239.745n 1.1v 239.755n 1.1v 244.745n 1.1v 244.755n 1.1v 249.745n 1.1v 249.755n 1.1v 254.745n 1.1v 254.755n 0.0v 259.745n 0.0v 259.755n 0.0v 264.745n 0.0v 264.755n 0.0v 269.745n 0.0v 269.755n 0.0v 274.745n 0.0v 274.755n 0.0v 279.745n 0.0v 279.755n 1.1v 284.745n 1.1v 284.755n 1.1v 289.745n 1.1v 289.755n 1.1v 294.745n 1.1v 294.755n 1.1v 299.745n 1.1v 299.755n 0.0v 304.745n 0.0v 304.755n 0.0v 309.745n 0.0v 309.755n 0.0v 314.745n 0.0v 314.755n 1.1v 319.745n 1.1v 319.755n 1.1v 324.745n 1.1v 324.755n 1.1v 329.745n 1.1v 329.755n 1.1v 334.745n 1.1v 334.755n 1.1v 339.745n 1.1v 339.755n 0.0v 344.745n 0.0v 344.755n 0.0v 349.745n 0.0v 349.755n 0.0v 354.745n 0.0v 354.755n 0.0v 359.745n 0.0v 359.755n 1.1v 364.745n 1.1v 364.755n 1.1v 369.745n 1.1v 369.755n 1.1v 374.745n 1.1v 374.755n 1.1v 379.745n 1.1v 379.755n 1.1v 384.745n 1.1v 384.755n 1.1v 389.745n 1.1v 389.755n 1.1v 394.745n 1.1v 394.755n 0.0v 399.745n 0.0v 399.755n 0.0v 404.745n 0.0v 404.755n 0.0v 409.745n 0.0v 409.755n 0.0v 414.745n 0.0v 414.755n 1.1v 419.745n 1.1v 419.755n 0.0v 424.745n 0.0v 424.755n 0.0v 429.745n 0.0v 429.755n 0.0v 434.745n 0.0v 434.755n 0.0v 439.745n 0.0v 439.755n 0.0v 444.745n 0.0v 444.755n 0.0v 449.745n 0.0v 449.755n 0.0v 454.745n 0.0v 454.755n 0.0v 459.745n 0.0v 459.755n 1.1v 464.745n 1.1v 464.755n 0.0v 469.745n 0.0v 469.755n 1.1v 474.745n 1.1v 474.755n 1.1v 479.745n 1.1v 479.755n 1.1v 484.745n 1.1v 484.755n 1.1v 489.745n 1.1v 489.755n 1.1v 494.745n 1.1v 494.755n 0.0v 499.745n 0.0v 499.755n 1.1v 504.745n 1.1v 504.755n 0.0v 509.745n 0.0v 509.755n 1.1v 514.745n 1.1v 514.755n 1.1v 519.745n 1.1v 519.755n 1.1v 524.745n 1.1v 524.755n 1.1v 529.745n 1.1v 529.755n 1.1v 534.745n 1.1v 534.755n 0.0v 539.745n 0.0v 539.755n 0.0v 544.745n 0.0v 544.755n 0.0v 549.745n 0.0v 549.755n 0.0v 554.745n 0.0v 554.755n 1.1v 559.745n 1.1v 559.755n 1.1v 564.745n 1.1v 564.755n 1.1v 569.745n 1.1v 569.755n 1.1v 574.745n 1.1v 574.755n 1.1v 579.745n 1.1v 579.755n 1.1v 584.745n 1.1v 584.755n 1.1v 589.745n 1.1v 589.755n 1.1v 594.745n 1.1v 594.755n 1.1v 599.745n 1.1v 599.755n 1.1v 604.745n 1.1v 604.755n 1.1v 609.745n 1.1v 609.755n 1.1v 614.745n 1.1v 614.755n 1.1v 619.745n 1.1v 619.755n 1.1v 624.745n 1.1v 624.755n 1.1v 629.745n 1.1v 629.755n 0.0v 634.745n 0.0v 634.755n 0.0v 639.745n 0.0v 639.755n 0.0v 644.745n 0.0v 644.755n 0.0v 649.745n 0.0v 649.755n 0.0v 654.745n 0.0v 654.755n 1.1v 659.745n 1.1v 659.755n 0.0v 664.745n 0.0v 664.755n 0.0v 669.745n 0.0v 669.755n 0.0v 674.745n 0.0v 674.755n 0.0v 679.745n 0.0v 679.755n 0.0v 684.745n 0.0v 684.755n 0.0v 689.745n 0.0v 689.755n 0.0v 694.745n 0.0v 694.755n 0.0v 699.745n 0.0v 699.755n 0.0v 704.745n 0.0v 704.755n 1.1v 709.745n 1.1v 709.755n 0.0v 714.745n 0.0v 714.755n 1.1v 719.745n 1.1v 719.755n 1.1v 724.745n 1.1v 724.755n 1.1v 729.745n 1.1v 729.755n 1.1v 734.745n 1.1v 734.755n 1.1v 739.745n 1.1v 739.755n 1.1v 744.745n 1.1v 744.755n 1.1v 749.745n 1.1v 749.755n 1.1v 754.745n 1.1v 754.755n 1.1v 759.745n 1.1v 759.755n 1.1v 764.745n 1.1v 764.755n 1.1v 769.745n 1.1v 769.755n 1.1v 774.745n 1.1v 774.755n 1.1v 779.745n 1.1v 779.755n 1.1v 784.745n 1.1v 784.755n 1.1v 789.745n 1.1v 789.755n 0.0v 794.745n 0.0v 794.755n 0.0v 799.745n 0.0v 799.755n 0.0v 804.745n 0.0v 804.755n 0.0v 809.745n 0.0v 809.755n 0.0v 814.745n 0.0v 814.755n 0.0v 819.745n 0.0v 819.755n 1.1v 824.745n 1.1v 824.755n 1.1v 829.745n 1.1v 829.755n 0.0v 834.745n 0.0v 834.755n 1.1v 839.745n 1.1v 839.755n 1.1v 844.745n 1.1v 844.755n 1.1v 849.745n 1.1v 849.755n 1.1v 854.745n 1.1v 854.755n 1.1v 859.745n 1.1v 859.755n 0.0v 864.745n 0.0v 864.755n 0.0v 869.745n 0.0v 869.755n 0.0v 874.745n 0.0v 874.755n 1.1v 879.745n 1.1v 879.755n 1.1v 884.745n 1.1v 884.755n 0.0v 889.745n 0.0v 889.755n 0.0v 894.745n 0.0v 894.755n 0.0v 899.745n 0.0v 899.755n 0.0v 904.745n 0.0v 904.755n 0.0v 909.745n 0.0v 909.755n 1.1v 914.745n 1.1v 914.755n 1.1v 919.745n 1.1v 919.755n 1.1v 924.745n 1.1v 924.755n 1.1v 929.745n 1.1v 929.755n 0.0v 934.745n 0.0v 934.755n 0.0v 939.745n 0.0v 939.755n 0.0v 944.745n 0.0v 944.755n 0.0v 949.745n 0.0v 949.755n 0.0v 954.745n 0.0v 954.755n 0.0v 959.745n 0.0v 959.755n 0.0v 964.745n 0.0v 964.755n 0.0v 969.745n 0.0v 969.755n 0.0v 974.745n 0.0v 974.755n 0.0v 979.745n 0.0v 979.755n 1.1v 984.745n 1.1v 984.755n 1.1v 989.745n 1.1v 989.755n 1.1v 994.745n 1.1v 994.755n 0.0v 999.745n 0.0v 999.755n 1.1v 1004.745n 1.1v 1004.755n 1.1v 1009.745n 1.1v 1009.755n 1.1v 1014.745n 1.1v 1014.755n 1.1v 1019.745n 1.1v 1019.755n 0.0v 1024.745n 0.0v 1024.755n 0.0v )
* (time, data): [(0, 0), (5, 1), (10, 0), (15, 0), (20, 0), (25, 0), (30, 0), (35, 0), (40, 0), (45, 1), (50, 1), (55, 1), (60, 1), (65, 1), (70, 1), (75, 1), (80, 1), (85, 1), (90, 1), (95, 1), (100, 0), (105, 0), (110, 0), (115, 0), (120, 0), (125, 0), (130, 0), (135, 0), (140, 0), (145, 0), (150, 0), (155, 0), (160, 0), (165, 0), (170, 0), (175, 0), (180, 0), (185, 0), (190, 0), (195, 0), (200, 0), (205, 0), (210, 1), (215, 1), (220, 0), (225, 0), (230, 0), (235, 0), (240, 1), (245, 1), (250, 1), (255, 1), (260, 1), (265, 1), (270, 1), (275, 1), (280, 1), (285, 1), (290, 1), (295, 1), (300, 0), (305, 0), (310, 0), (315, 1), (320, 1), (325, 1), (330, 0), (335, 0), (340, 0), (345, 0), (350, 0), (355, 0), (360, 1), (365, 1), (370, 1), (375, 1), (380, 1), (385, 1), (390, 1), (395, 0), (400, 0), (405, 0), (410, 1), (415, 1), (420, 0), (425, 1), (430, 1), (435, 1), (440, 1), (445, 1), (450, 0), (455, 0), (460, 1), (465, 1), (470, 0), (475, 0), (480, 1), (485, 1), (490, 1), (495, 1), (500, 0), (505, 0), (510, 0), (515, 1), (520, 1), (525, 1), (530, 1), (535, 1), (540, 0), (545, 0), (550, 0), (555, 1), (560, 1), (565, 1), (570, 1), (575, 1), (580, 1), (585, 1), (590, 1), (595, 1), (600, 1), (605, 1), (610, 1), (615, 1), (620, 1), (625, 1), (630, 0), (635, 0), (640, 1), (645, 1), (650, 1), (655, 0), (660, 0), (665, 0), (670, 1), (675, 1), (680, 1), (685, 1), (690, 1), (695, 1), (700, 1), (705, 0), (710, 1), (715, 1), (720, 1), (725, 1), (730, 1), (735, 0), (740, 0), (745, 0), (750, 0), (755, 0), (760, 0), (765, 0), (770, 1), (775, 1), (780, 1), (785, 0), (790, 0), (795, 0), (800, 0), (805, 0), (810, 0), (815, 0), (820, 0), (825, 0), (830, 1), (835, 1), (840, 1), (845, 1), (850, 1), (855, 1), (860, 1), (865, 1), (870, 1), (875, 0), (880, 0), (885, 1), (890, 1), (895, 1), (900, 1), (905, 1), (910, 0), (915, 0), (920, 0), (925, 0), (930, 1), (935, 0), (940, 0), (945, 0), (950, 0), (955, 0), (960, 0), (965, 1), (970, 1), (975, 1), (980, 0), (985, 0), (990, 0), (995, 0), (1000, 0), (1005, 0), (1010, 0), (1015, 0), (1020, 0), (1025, 0)]
Vdin0_45  din0_45  0 PWL (0n 0.0v 4.745n 0.0v 4.755n 1.1v 9.745n 1.1v 9.755n 0.0v 14.745n 0.0v 14.755n 0.0v 19.745n 0.0v 19.755n 0.0v 24.745n 0.0v 24.755n 0.0v 29.745n 0.0v 29.755n 0.0v 34.745n 0.0v 34.755n 0.0v 39.745n 0.0v 39.755n 0.0v 44.745n 0.0v 44.755n 1.1v 49.745n 1.1v 49.755n 1.1v 54.745n 1.1v 54.755n 1.1v 59.745n 1.1v 59.755n 1.1v 64.745n 1.1v 64.755n 1.1v 69.745n 1.1v 69.755n 1.1v 74.745n 1.1v 74.755n 1.1v 79.745n 1.1v 79.755n 1.1v 84.745n 1.1v 84.755n 1.1v 89.745n 1.1v 89.755n 1.1v 94.745n 1.1v 94.755n 1.1v 99.745n 1.1v 99.755n 0.0v 104.745n 0.0v 104.755n 0.0v 109.745n 0.0v 109.755n 0.0v 114.745n 0.0v 114.755n 0.0v 119.745n 0.0v 119.755n 0.0v 124.745n 0.0v 124.755n 0.0v 129.745n 0.0v 129.755n 0.0v 134.745n 0.0v 134.755n 0.0v 139.745n 0.0v 139.755n 0.0v 144.745n 0.0v 144.755n 0.0v 149.745n 0.0v 149.755n 0.0v 154.745n 0.0v 154.755n 0.0v 159.745n 0.0v 159.755n 0.0v 164.745n 0.0v 164.755n 0.0v 169.745n 0.0v 169.755n 0.0v 174.745n 0.0v 174.755n 0.0v 179.745n 0.0v 179.755n 0.0v 184.745n 0.0v 184.755n 0.0v 189.745n 0.0v 189.755n 0.0v 194.745n 0.0v 194.755n 0.0v 199.745n 0.0v 199.755n 0.0v 204.745n 0.0v 204.755n 0.0v 209.745n 0.0v 209.755n 1.1v 214.745n 1.1v 214.755n 1.1v 219.745n 1.1v 219.755n 0.0v 224.745n 0.0v 224.755n 0.0v 229.745n 0.0v 229.755n 0.0v 234.745n 0.0v 234.755n 0.0v 239.745n 0.0v 239.755n 1.1v 244.745n 1.1v 244.755n 1.1v 249.745n 1.1v 249.755n 1.1v 254.745n 1.1v 254.755n 1.1v 259.745n 1.1v 259.755n 1.1v 264.745n 1.1v 264.755n 1.1v 269.745n 1.1v 269.755n 1.1v 274.745n 1.1v 274.755n 1.1v 279.745n 1.1v 279.755n 1.1v 284.745n 1.1v 284.755n 1.1v 289.745n 1.1v 289.755n 1.1v 294.745n 1.1v 294.755n 1.1v 299.745n 1.1v 299.755n 0.0v 304.745n 0.0v 304.755n 0.0v 309.745n 0.0v 309.755n 0.0v 314.745n 0.0v 314.755n 1.1v 319.745n 1.1v 319.755n 1.1v 324.745n 1.1v 324.755n 1.1v 329.745n 1.1v 329.755n 0.0v 334.745n 0.0v 334.755n 0.0v 339.745n 0.0v 339.755n 0.0v 344.745n 0.0v 344.755n 0.0v 349.745n 0.0v 349.755n 0.0v 354.745n 0.0v 354.755n 0.0v 359.745n 0.0v 359.755n 1.1v 364.745n 1.1v 364.755n 1.1v 369.745n 1.1v 369.755n 1.1v 374.745n 1.1v 374.755n 1.1v 379.745n 1.1v 379.755n 1.1v 384.745n 1.1v 384.755n 1.1v 389.745n 1.1v 389.755n 1.1v 394.745n 1.1v 394.755n 0.0v 399.745n 0.0v 399.755n 0.0v 404.745n 0.0v 404.755n 0.0v 409.745n 0.0v 409.755n 1.1v 414.745n 1.1v 414.755n 1.1v 419.745n 1.1v 419.755n 0.0v 424.745n 0.0v 424.755n 1.1v 429.745n 1.1v 429.755n 1.1v 434.745n 1.1v 434.755n 1.1v 439.745n 1.1v 439.755n 1.1v 444.745n 1.1v 444.755n 1.1v 449.745n 1.1v 449.755n 0.0v 454.745n 0.0v 454.755n 0.0v 459.745n 0.0v 459.755n 1.1v 464.745n 1.1v 464.755n 1.1v 469.745n 1.1v 469.755n 0.0v 474.745n 0.0v 474.755n 0.0v 479.745n 0.0v 479.755n 1.1v 484.745n 1.1v 484.755n 1.1v 489.745n 1.1v 489.755n 1.1v 494.745n 1.1v 494.755n 1.1v 499.745n 1.1v 499.755n 0.0v 504.745n 0.0v 504.755n 0.0v 509.745n 0.0v 509.755n 0.0v 514.745n 0.0v 514.755n 1.1v 519.745n 1.1v 519.755n 1.1v 524.745n 1.1v 524.755n 1.1v 529.745n 1.1v 529.755n 1.1v 534.745n 1.1v 534.755n 1.1v 539.745n 1.1v 539.755n 0.0v 544.745n 0.0v 544.755n 0.0v 549.745n 0.0v 549.755n 0.0v 554.745n 0.0v 554.755n 1.1v 559.745n 1.1v 559.755n 1.1v 564.745n 1.1v 564.755n 1.1v 569.745n 1.1v 569.755n 1.1v 574.745n 1.1v 574.755n 1.1v 579.745n 1.1v 579.755n 1.1v 584.745n 1.1v 584.755n 1.1v 589.745n 1.1v 589.755n 1.1v 594.745n 1.1v 594.755n 1.1v 599.745n 1.1v 599.755n 1.1v 604.745n 1.1v 604.755n 1.1v 609.745n 1.1v 609.755n 1.1v 614.745n 1.1v 614.755n 1.1v 619.745n 1.1v 619.755n 1.1v 624.745n 1.1v 624.755n 1.1v 629.745n 1.1v 629.755n 0.0v 634.745n 0.0v 634.755n 0.0v 639.745n 0.0v 639.755n 1.1v 644.745n 1.1v 644.755n 1.1v 649.745n 1.1v 649.755n 1.1v 654.745n 1.1v 654.755n 0.0v 659.745n 0.0v 659.755n 0.0v 664.745n 0.0v 664.755n 0.0v 669.745n 0.0v 669.755n 1.1v 674.745n 1.1v 674.755n 1.1v 679.745n 1.1v 679.755n 1.1v 684.745n 1.1v 684.755n 1.1v 689.745n 1.1v 689.755n 1.1v 694.745n 1.1v 694.755n 1.1v 699.745n 1.1v 699.755n 1.1v 704.745n 1.1v 704.755n 0.0v 709.745n 0.0v 709.755n 1.1v 714.745n 1.1v 714.755n 1.1v 719.745n 1.1v 719.755n 1.1v 724.745n 1.1v 724.755n 1.1v 729.745n 1.1v 729.755n 1.1v 734.745n 1.1v 734.755n 0.0v 739.745n 0.0v 739.755n 0.0v 744.745n 0.0v 744.755n 0.0v 749.745n 0.0v 749.755n 0.0v 754.745n 0.0v 754.755n 0.0v 759.745n 0.0v 759.755n 0.0v 764.745n 0.0v 764.755n 0.0v 769.745n 0.0v 769.755n 1.1v 774.745n 1.1v 774.755n 1.1v 779.745n 1.1v 779.755n 1.1v 784.745n 1.1v 784.755n 0.0v 789.745n 0.0v 789.755n 0.0v 794.745n 0.0v 794.755n 0.0v 799.745n 0.0v 799.755n 0.0v 804.745n 0.0v 804.755n 0.0v 809.745n 0.0v 809.755n 0.0v 814.745n 0.0v 814.755n 0.0v 819.745n 0.0v 819.755n 0.0v 824.745n 0.0v 824.755n 0.0v 829.745n 0.0v 829.755n 1.1v 834.745n 1.1v 834.755n 1.1v 839.745n 1.1v 839.755n 1.1v 844.745n 1.1v 844.755n 1.1v 849.745n 1.1v 849.755n 1.1v 854.745n 1.1v 854.755n 1.1v 859.745n 1.1v 859.755n 1.1v 864.745n 1.1v 864.755n 1.1v 869.745n 1.1v 869.755n 1.1v 874.745n 1.1v 874.755n 0.0v 879.745n 0.0v 879.755n 0.0v 884.745n 0.0v 884.755n 1.1v 889.745n 1.1v 889.755n 1.1v 894.745n 1.1v 894.755n 1.1v 899.745n 1.1v 899.755n 1.1v 904.745n 1.1v 904.755n 1.1v 909.745n 1.1v 909.755n 0.0v 914.745n 0.0v 914.755n 0.0v 919.745n 0.0v 919.755n 0.0v 924.745n 0.0v 924.755n 0.0v 929.745n 0.0v 929.755n 1.1v 934.745n 1.1v 934.755n 0.0v 939.745n 0.0v 939.755n 0.0v 944.745n 0.0v 944.755n 0.0v 949.745n 0.0v 949.755n 0.0v 954.745n 0.0v 954.755n 0.0v 959.745n 0.0v 959.755n 0.0v 964.745n 0.0v 964.755n 1.1v 969.745n 1.1v 969.755n 1.1v 974.745n 1.1v 974.755n 1.1v 979.745n 1.1v 979.755n 0.0v 984.745n 0.0v 984.755n 0.0v 989.745n 0.0v 989.755n 0.0v 994.745n 0.0v 994.755n 0.0v 999.745n 0.0v 999.755n 0.0v 1004.745n 0.0v 1004.755n 0.0v 1009.745n 0.0v 1009.755n 0.0v 1014.745n 0.0v 1014.755n 0.0v 1019.745n 0.0v 1019.755n 0.0v 1024.745n 0.0v 1024.755n 0.0v )
* (time, data): [(0, 0), (5, 1), (10, 1), (15, 0), (20, 0), (25, 0), (30, 0), (35, 0), (40, 1), (45, 1), (50, 1), (55, 1), (60, 0), (65, 1), (70, 1), (75, 1), (80, 1), (85, 1), (90, 1), (95, 1), (100, 0), (105, 0), (110, 0), (115, 0), (120, 0), (125, 0), (130, 0), (135, 1), (140, 0), (145, 0), (150, 0), (155, 0), (160, 0), (165, 0), (170, 0), (175, 0), (180, 0), (185, 1), (190, 1), (195, 1), (200, 0), (205, 0), (210, 0), (215, 0), (220, 0), (225, 0), (230, 1), (235, 1), (240, 0), (245, 0), (250, 0), (255, 1), (260, 1), (265, 0), (270, 0), (275, 0), (280, 1), (285, 1), (290, 1), (295, 1), (300, 1), (305, 1), (310, 1), (315, 1), (320, 1), (325, 1), (330, 0), (335, 1), (340, 1), (345, 1), (350, 1), (355, 1), (360, 0), (365, 0), (370, 0), (375, 0), (380, 0), (385, 0), (390, 0), (395, 1), (400, 0), (405, 0), (410, 1), (415, 0), (420, 1), (425, 0), (430, 0), (435, 0), (440, 0), (445, 0), (450, 0), (455, 0), (460, 0), (465, 0), (470, 0), (475, 0), (480, 1), (485, 1), (490, 1), (495, 1), (500, 1), (505, 1), (510, 1), (515, 1), (520, 1), (525, 1), (530, 1), (535, 1), (540, 1), (545, 1), (550, 1), (555, 1), (560, 1), (565, 1), (570, 1), (575, 0), (580, 0), (585, 0), (590, 0), (595, 0), (600, 0), (605, 0), (610, 0), (615, 0), (620, 0), (625, 0), (630, 0), (635, 1), (640, 1), (645, 1), (650, 1), (655, 1), (660, 1), (665, 1), (670, 1), (675, 1), (680, 1), (685, 1), (690, 1), (695, 1), (700, 1), (705, 1), (710, 0), (715, 1), (720, 1), (725, 1), (730, 1), (735, 1), (740, 0), (745, 0), (750, 0), (755, 0), (760, 0), (765, 0), (770, 0), (775, 0), (780, 0), (785, 1), (790, 0), (795, 0), (800, 0), (805, 0), (810, 0), (815, 0), (820, 0), (825, 0), (830, 0), (835, 1), (840, 1), (845, 1), (850, 1), (855, 1), (860, 1), (865, 0), (870, 1), (875, 0), (880, 1), (885, 0), (890, 0), (895, 0), (900, 0), (905, 0), (910, 1), (915, 1), (920, 1), (925, 1), (930, 0), (935, 0), (940, 0), (945, 0), (950, 0), (955, 0), (960, 0), (965, 0), (970, 0), (975, 0), (980, 1), (985, 0), (990, 0), (995, 1), (1000, 0), (1005, 0), (1010, 0), (1015, 0), (1020, 0), (1025, 0)]
Vdin0_46  din0_46  0 PWL (0n 0.0v 4.745n 0.0v 4.755n 1.1v 9.745n 1.1v 9.755n 1.1v 14.745n 1.1v 14.755n 0.0v 19.745n 0.0v 19.755n 0.0v 24.745n 0.0v 24.755n 0.0v 29.745n 0.0v 29.755n 0.0v 34.745n 0.0v 34.755n 0.0v 39.745n 0.0v 39.755n 1.1v 44.745n 1.1v 44.755n 1.1v 49.745n 1.1v 49.755n 1.1v 54.745n 1.1v 54.755n 1.1v 59.745n 1.1v 59.755n 0.0v 64.745n 0.0v 64.755n 1.1v 69.745n 1.1v 69.755n 1.1v 74.745n 1.1v 74.755n 1.1v 79.745n 1.1v 79.755n 1.1v 84.745n 1.1v 84.755n 1.1v 89.745n 1.1v 89.755n 1.1v 94.745n 1.1v 94.755n 1.1v 99.745n 1.1v 99.755n 0.0v 104.745n 0.0v 104.755n 0.0v 109.745n 0.0v 109.755n 0.0v 114.745n 0.0v 114.755n 0.0v 119.745n 0.0v 119.755n 0.0v 124.745n 0.0v 124.755n 0.0v 129.745n 0.0v 129.755n 0.0v 134.745n 0.0v 134.755n 1.1v 139.745n 1.1v 139.755n 0.0v 144.745n 0.0v 144.755n 0.0v 149.745n 0.0v 149.755n 0.0v 154.745n 0.0v 154.755n 0.0v 159.745n 0.0v 159.755n 0.0v 164.745n 0.0v 164.755n 0.0v 169.745n 0.0v 169.755n 0.0v 174.745n 0.0v 174.755n 0.0v 179.745n 0.0v 179.755n 0.0v 184.745n 0.0v 184.755n 1.1v 189.745n 1.1v 189.755n 1.1v 194.745n 1.1v 194.755n 1.1v 199.745n 1.1v 199.755n 0.0v 204.745n 0.0v 204.755n 0.0v 209.745n 0.0v 209.755n 0.0v 214.745n 0.0v 214.755n 0.0v 219.745n 0.0v 219.755n 0.0v 224.745n 0.0v 224.755n 0.0v 229.745n 0.0v 229.755n 1.1v 234.745n 1.1v 234.755n 1.1v 239.745n 1.1v 239.755n 0.0v 244.745n 0.0v 244.755n 0.0v 249.745n 0.0v 249.755n 0.0v 254.745n 0.0v 254.755n 1.1v 259.745n 1.1v 259.755n 1.1v 264.745n 1.1v 264.755n 0.0v 269.745n 0.0v 269.755n 0.0v 274.745n 0.0v 274.755n 0.0v 279.745n 0.0v 279.755n 1.1v 284.745n 1.1v 284.755n 1.1v 289.745n 1.1v 289.755n 1.1v 294.745n 1.1v 294.755n 1.1v 299.745n 1.1v 299.755n 1.1v 304.745n 1.1v 304.755n 1.1v 309.745n 1.1v 309.755n 1.1v 314.745n 1.1v 314.755n 1.1v 319.745n 1.1v 319.755n 1.1v 324.745n 1.1v 324.755n 1.1v 329.745n 1.1v 329.755n 0.0v 334.745n 0.0v 334.755n 1.1v 339.745n 1.1v 339.755n 1.1v 344.745n 1.1v 344.755n 1.1v 349.745n 1.1v 349.755n 1.1v 354.745n 1.1v 354.755n 1.1v 359.745n 1.1v 359.755n 0.0v 364.745n 0.0v 364.755n 0.0v 369.745n 0.0v 369.755n 0.0v 374.745n 0.0v 374.755n 0.0v 379.745n 0.0v 379.755n 0.0v 384.745n 0.0v 384.755n 0.0v 389.745n 0.0v 389.755n 0.0v 394.745n 0.0v 394.755n 1.1v 399.745n 1.1v 399.755n 0.0v 404.745n 0.0v 404.755n 0.0v 409.745n 0.0v 409.755n 1.1v 414.745n 1.1v 414.755n 0.0v 419.745n 0.0v 419.755n 1.1v 424.745n 1.1v 424.755n 0.0v 429.745n 0.0v 429.755n 0.0v 434.745n 0.0v 434.755n 0.0v 439.745n 0.0v 439.755n 0.0v 444.745n 0.0v 444.755n 0.0v 449.745n 0.0v 449.755n 0.0v 454.745n 0.0v 454.755n 0.0v 459.745n 0.0v 459.755n 0.0v 464.745n 0.0v 464.755n 0.0v 469.745n 0.0v 469.755n 0.0v 474.745n 0.0v 474.755n 0.0v 479.745n 0.0v 479.755n 1.1v 484.745n 1.1v 484.755n 1.1v 489.745n 1.1v 489.755n 1.1v 494.745n 1.1v 494.755n 1.1v 499.745n 1.1v 499.755n 1.1v 504.745n 1.1v 504.755n 1.1v 509.745n 1.1v 509.755n 1.1v 514.745n 1.1v 514.755n 1.1v 519.745n 1.1v 519.755n 1.1v 524.745n 1.1v 524.755n 1.1v 529.745n 1.1v 529.755n 1.1v 534.745n 1.1v 534.755n 1.1v 539.745n 1.1v 539.755n 1.1v 544.745n 1.1v 544.755n 1.1v 549.745n 1.1v 549.755n 1.1v 554.745n 1.1v 554.755n 1.1v 559.745n 1.1v 559.755n 1.1v 564.745n 1.1v 564.755n 1.1v 569.745n 1.1v 569.755n 1.1v 574.745n 1.1v 574.755n 0.0v 579.745n 0.0v 579.755n 0.0v 584.745n 0.0v 584.755n 0.0v 589.745n 0.0v 589.755n 0.0v 594.745n 0.0v 594.755n 0.0v 599.745n 0.0v 599.755n 0.0v 604.745n 0.0v 604.755n 0.0v 609.745n 0.0v 609.755n 0.0v 614.745n 0.0v 614.755n 0.0v 619.745n 0.0v 619.755n 0.0v 624.745n 0.0v 624.755n 0.0v 629.745n 0.0v 629.755n 0.0v 634.745n 0.0v 634.755n 1.1v 639.745n 1.1v 639.755n 1.1v 644.745n 1.1v 644.755n 1.1v 649.745n 1.1v 649.755n 1.1v 654.745n 1.1v 654.755n 1.1v 659.745n 1.1v 659.755n 1.1v 664.745n 1.1v 664.755n 1.1v 669.745n 1.1v 669.755n 1.1v 674.745n 1.1v 674.755n 1.1v 679.745n 1.1v 679.755n 1.1v 684.745n 1.1v 684.755n 1.1v 689.745n 1.1v 689.755n 1.1v 694.745n 1.1v 694.755n 1.1v 699.745n 1.1v 699.755n 1.1v 704.745n 1.1v 704.755n 1.1v 709.745n 1.1v 709.755n 0.0v 714.745n 0.0v 714.755n 1.1v 719.745n 1.1v 719.755n 1.1v 724.745n 1.1v 724.755n 1.1v 729.745n 1.1v 729.755n 1.1v 734.745n 1.1v 734.755n 1.1v 739.745n 1.1v 739.755n 0.0v 744.745n 0.0v 744.755n 0.0v 749.745n 0.0v 749.755n 0.0v 754.745n 0.0v 754.755n 0.0v 759.745n 0.0v 759.755n 0.0v 764.745n 0.0v 764.755n 0.0v 769.745n 0.0v 769.755n 0.0v 774.745n 0.0v 774.755n 0.0v 779.745n 0.0v 779.755n 0.0v 784.745n 0.0v 784.755n 1.1v 789.745n 1.1v 789.755n 0.0v 794.745n 0.0v 794.755n 0.0v 799.745n 0.0v 799.755n 0.0v 804.745n 0.0v 804.755n 0.0v 809.745n 0.0v 809.755n 0.0v 814.745n 0.0v 814.755n 0.0v 819.745n 0.0v 819.755n 0.0v 824.745n 0.0v 824.755n 0.0v 829.745n 0.0v 829.755n 0.0v 834.745n 0.0v 834.755n 1.1v 839.745n 1.1v 839.755n 1.1v 844.745n 1.1v 844.755n 1.1v 849.745n 1.1v 849.755n 1.1v 854.745n 1.1v 854.755n 1.1v 859.745n 1.1v 859.755n 1.1v 864.745n 1.1v 864.755n 0.0v 869.745n 0.0v 869.755n 1.1v 874.745n 1.1v 874.755n 0.0v 879.745n 0.0v 879.755n 1.1v 884.745n 1.1v 884.755n 0.0v 889.745n 0.0v 889.755n 0.0v 894.745n 0.0v 894.755n 0.0v 899.745n 0.0v 899.755n 0.0v 904.745n 0.0v 904.755n 0.0v 909.745n 0.0v 909.755n 1.1v 914.745n 1.1v 914.755n 1.1v 919.745n 1.1v 919.755n 1.1v 924.745n 1.1v 924.755n 1.1v 929.745n 1.1v 929.755n 0.0v 934.745n 0.0v 934.755n 0.0v 939.745n 0.0v 939.755n 0.0v 944.745n 0.0v 944.755n 0.0v 949.745n 0.0v 949.755n 0.0v 954.745n 0.0v 954.755n 0.0v 959.745n 0.0v 959.755n 0.0v 964.745n 0.0v 964.755n 0.0v 969.745n 0.0v 969.755n 0.0v 974.745n 0.0v 974.755n 0.0v 979.745n 0.0v 979.755n 1.1v 984.745n 1.1v 984.755n 0.0v 989.745n 0.0v 989.755n 0.0v 994.745n 0.0v 994.755n 1.1v 999.745n 1.1v 999.755n 0.0v 1004.745n 0.0v 1004.755n 0.0v 1009.745n 0.0v 1009.755n 0.0v 1014.745n 0.0v 1014.755n 0.0v 1019.745n 0.0v 1019.755n 0.0v 1024.745n 0.0v 1024.755n 0.0v )
* (time, data): [(0, 0), (5, 1), (10, 0), (15, 0), (20, 0), (25, 0), (30, 0), (35, 0), (40, 0), (45, 1), (50, 1), (55, 1), (60, 1), (65, 0), (70, 0), (75, 0), (80, 0), (85, 0), (90, 1), (95, 1), (100, 1), (105, 1), (110, 1), (115, 1), (120, 1), (125, 1), (130, 1), (135, 0), (140, 1), (145, 1), (150, 1), (155, 1), (160, 1), (165, 1), (170, 0), (175, 0), (180, 0), (185, 0), (190, 0), (195, 0), (200, 1), (205, 1), (210, 1), (215, 1), (220, 0), (225, 0), (230, 1), (235, 1), (240, 1), (245, 1), (250, 1), (255, 1), (260, 1), (265, 1), (270, 1), (275, 1), (280, 1), (285, 1), (290, 1), (295, 1), (300, 0), (305, 0), (310, 0), (315, 0), (320, 0), (325, 0), (330, 0), (335, 0), (340, 1), (345, 1), (350, 1), (355, 1), (360, 1), (365, 1), (370, 1), (375, 1), (380, 1), (385, 1), (390, 1), (395, 0), (400, 1), (405, 1), (410, 0), (415, 1), (420, 1), (425, 0), (430, 1), (435, 1), (440, 1), (445, 1), (450, 0), (455, 0), (460, 1), (465, 0), (470, 0), (475, 0), (480, 1), (485, 1), (490, 1), (495, 0), (500, 0), (505, 0), (510, 1), (515, 0), (520, 0), (525, 0), (530, 0), (535, 0), (540, 0), (545, 0), (550, 0), (555, 1), (560, 1), (565, 1), (570, 1), (575, 0), (580, 0), (585, 0), (590, 0), (595, 0), (600, 0), (605, 0), (610, 0), (615, 0), (620, 0), (625, 0), (630, 0), (635, 0), (640, 1), (645, 1), (650, 1), (655, 1), (660, 0), (665, 0), (670, 1), (675, 1), (680, 1), (685, 1), (690, 1), (695, 1), (700, 1), (705, 0), (710, 1), (715, 0), (720, 0), (725, 0), (730, 0), (735, 0), (740, 0), (745, 0), (750, 0), (755, 0), (760, 0), (765, 0), (770, 1), (775, 0), (780, 0), (785, 0), (790, 1), (795, 1), (800, 1), (805, 1), (810, 1), (815, 1), (820, 1), (825, 1), (830, 1), (835, 0), (840, 0), (845, 0), (850, 0), (855, 1), (860, 1), (865, 0), (870, 0), (875, 0), (880, 0), (885, 0), (890, 0), (895, 0), (900, 0), (905, 0), (910, 1), (915, 1), (920, 1), (925, 1), (930, 1), (935, 0), (940, 0), (945, 0), (950, 0), (955, 1), (960, 1), (965, 1), (970, 1), (975, 1), (980, 1), (985, 0), (990, 0), (995, 0), (1000, 0), (1005, 0), (1010, 0), (1015, 0), (1020, 0), (1025, 0)]
Vdin0_47  din0_47  0 PWL (0n 0.0v 4.745n 0.0v 4.755n 1.1v 9.745n 1.1v 9.755n 0.0v 14.745n 0.0v 14.755n 0.0v 19.745n 0.0v 19.755n 0.0v 24.745n 0.0v 24.755n 0.0v 29.745n 0.0v 29.755n 0.0v 34.745n 0.0v 34.755n 0.0v 39.745n 0.0v 39.755n 0.0v 44.745n 0.0v 44.755n 1.1v 49.745n 1.1v 49.755n 1.1v 54.745n 1.1v 54.755n 1.1v 59.745n 1.1v 59.755n 1.1v 64.745n 1.1v 64.755n 0.0v 69.745n 0.0v 69.755n 0.0v 74.745n 0.0v 74.755n 0.0v 79.745n 0.0v 79.755n 0.0v 84.745n 0.0v 84.755n 0.0v 89.745n 0.0v 89.755n 1.1v 94.745n 1.1v 94.755n 1.1v 99.745n 1.1v 99.755n 1.1v 104.745n 1.1v 104.755n 1.1v 109.745n 1.1v 109.755n 1.1v 114.745n 1.1v 114.755n 1.1v 119.745n 1.1v 119.755n 1.1v 124.745n 1.1v 124.755n 1.1v 129.745n 1.1v 129.755n 1.1v 134.745n 1.1v 134.755n 0.0v 139.745n 0.0v 139.755n 1.1v 144.745n 1.1v 144.755n 1.1v 149.745n 1.1v 149.755n 1.1v 154.745n 1.1v 154.755n 1.1v 159.745n 1.1v 159.755n 1.1v 164.745n 1.1v 164.755n 1.1v 169.745n 1.1v 169.755n 0.0v 174.745n 0.0v 174.755n 0.0v 179.745n 0.0v 179.755n 0.0v 184.745n 0.0v 184.755n 0.0v 189.745n 0.0v 189.755n 0.0v 194.745n 0.0v 194.755n 0.0v 199.745n 0.0v 199.755n 1.1v 204.745n 1.1v 204.755n 1.1v 209.745n 1.1v 209.755n 1.1v 214.745n 1.1v 214.755n 1.1v 219.745n 1.1v 219.755n 0.0v 224.745n 0.0v 224.755n 0.0v 229.745n 0.0v 229.755n 1.1v 234.745n 1.1v 234.755n 1.1v 239.745n 1.1v 239.755n 1.1v 244.745n 1.1v 244.755n 1.1v 249.745n 1.1v 249.755n 1.1v 254.745n 1.1v 254.755n 1.1v 259.745n 1.1v 259.755n 1.1v 264.745n 1.1v 264.755n 1.1v 269.745n 1.1v 269.755n 1.1v 274.745n 1.1v 274.755n 1.1v 279.745n 1.1v 279.755n 1.1v 284.745n 1.1v 284.755n 1.1v 289.745n 1.1v 289.755n 1.1v 294.745n 1.1v 294.755n 1.1v 299.745n 1.1v 299.755n 0.0v 304.745n 0.0v 304.755n 0.0v 309.745n 0.0v 309.755n 0.0v 314.745n 0.0v 314.755n 0.0v 319.745n 0.0v 319.755n 0.0v 324.745n 0.0v 324.755n 0.0v 329.745n 0.0v 329.755n 0.0v 334.745n 0.0v 334.755n 0.0v 339.745n 0.0v 339.755n 1.1v 344.745n 1.1v 344.755n 1.1v 349.745n 1.1v 349.755n 1.1v 354.745n 1.1v 354.755n 1.1v 359.745n 1.1v 359.755n 1.1v 364.745n 1.1v 364.755n 1.1v 369.745n 1.1v 369.755n 1.1v 374.745n 1.1v 374.755n 1.1v 379.745n 1.1v 379.755n 1.1v 384.745n 1.1v 384.755n 1.1v 389.745n 1.1v 389.755n 1.1v 394.745n 1.1v 394.755n 0.0v 399.745n 0.0v 399.755n 1.1v 404.745n 1.1v 404.755n 1.1v 409.745n 1.1v 409.755n 0.0v 414.745n 0.0v 414.755n 1.1v 419.745n 1.1v 419.755n 1.1v 424.745n 1.1v 424.755n 0.0v 429.745n 0.0v 429.755n 1.1v 434.745n 1.1v 434.755n 1.1v 439.745n 1.1v 439.755n 1.1v 444.745n 1.1v 444.755n 1.1v 449.745n 1.1v 449.755n 0.0v 454.745n 0.0v 454.755n 0.0v 459.745n 0.0v 459.755n 1.1v 464.745n 1.1v 464.755n 0.0v 469.745n 0.0v 469.755n 0.0v 474.745n 0.0v 474.755n 0.0v 479.745n 0.0v 479.755n 1.1v 484.745n 1.1v 484.755n 1.1v 489.745n 1.1v 489.755n 1.1v 494.745n 1.1v 494.755n 0.0v 499.745n 0.0v 499.755n 0.0v 504.745n 0.0v 504.755n 0.0v 509.745n 0.0v 509.755n 1.1v 514.745n 1.1v 514.755n 0.0v 519.745n 0.0v 519.755n 0.0v 524.745n 0.0v 524.755n 0.0v 529.745n 0.0v 529.755n 0.0v 534.745n 0.0v 534.755n 0.0v 539.745n 0.0v 539.755n 0.0v 544.745n 0.0v 544.755n 0.0v 549.745n 0.0v 549.755n 0.0v 554.745n 0.0v 554.755n 1.1v 559.745n 1.1v 559.755n 1.1v 564.745n 1.1v 564.755n 1.1v 569.745n 1.1v 569.755n 1.1v 574.745n 1.1v 574.755n 0.0v 579.745n 0.0v 579.755n 0.0v 584.745n 0.0v 584.755n 0.0v 589.745n 0.0v 589.755n 0.0v 594.745n 0.0v 594.755n 0.0v 599.745n 0.0v 599.755n 0.0v 604.745n 0.0v 604.755n 0.0v 609.745n 0.0v 609.755n 0.0v 614.745n 0.0v 614.755n 0.0v 619.745n 0.0v 619.755n 0.0v 624.745n 0.0v 624.755n 0.0v 629.745n 0.0v 629.755n 0.0v 634.745n 0.0v 634.755n 0.0v 639.745n 0.0v 639.755n 1.1v 644.745n 1.1v 644.755n 1.1v 649.745n 1.1v 649.755n 1.1v 654.745n 1.1v 654.755n 1.1v 659.745n 1.1v 659.755n 0.0v 664.745n 0.0v 664.755n 0.0v 669.745n 0.0v 669.755n 1.1v 674.745n 1.1v 674.755n 1.1v 679.745n 1.1v 679.755n 1.1v 684.745n 1.1v 684.755n 1.1v 689.745n 1.1v 689.755n 1.1v 694.745n 1.1v 694.755n 1.1v 699.745n 1.1v 699.755n 1.1v 704.745n 1.1v 704.755n 0.0v 709.745n 0.0v 709.755n 1.1v 714.745n 1.1v 714.755n 0.0v 719.745n 0.0v 719.755n 0.0v 724.745n 0.0v 724.755n 0.0v 729.745n 0.0v 729.755n 0.0v 734.745n 0.0v 734.755n 0.0v 739.745n 0.0v 739.755n 0.0v 744.745n 0.0v 744.755n 0.0v 749.745n 0.0v 749.755n 0.0v 754.745n 0.0v 754.755n 0.0v 759.745n 0.0v 759.755n 0.0v 764.745n 0.0v 764.755n 0.0v 769.745n 0.0v 769.755n 1.1v 774.745n 1.1v 774.755n 0.0v 779.745n 0.0v 779.755n 0.0v 784.745n 0.0v 784.755n 0.0v 789.745n 0.0v 789.755n 1.1v 794.745n 1.1v 794.755n 1.1v 799.745n 1.1v 799.755n 1.1v 804.745n 1.1v 804.755n 1.1v 809.745n 1.1v 809.755n 1.1v 814.745n 1.1v 814.755n 1.1v 819.745n 1.1v 819.755n 1.1v 824.745n 1.1v 824.755n 1.1v 829.745n 1.1v 829.755n 1.1v 834.745n 1.1v 834.755n 0.0v 839.745n 0.0v 839.755n 0.0v 844.745n 0.0v 844.755n 0.0v 849.745n 0.0v 849.755n 0.0v 854.745n 0.0v 854.755n 1.1v 859.745n 1.1v 859.755n 1.1v 864.745n 1.1v 864.755n 0.0v 869.745n 0.0v 869.755n 0.0v 874.745n 0.0v 874.755n 0.0v 879.745n 0.0v 879.755n 0.0v 884.745n 0.0v 884.755n 0.0v 889.745n 0.0v 889.755n 0.0v 894.745n 0.0v 894.755n 0.0v 899.745n 0.0v 899.755n 0.0v 904.745n 0.0v 904.755n 0.0v 909.745n 0.0v 909.755n 1.1v 914.745n 1.1v 914.755n 1.1v 919.745n 1.1v 919.755n 1.1v 924.745n 1.1v 924.755n 1.1v 929.745n 1.1v 929.755n 1.1v 934.745n 1.1v 934.755n 0.0v 939.745n 0.0v 939.755n 0.0v 944.745n 0.0v 944.755n 0.0v 949.745n 0.0v 949.755n 0.0v 954.745n 0.0v 954.755n 1.1v 959.745n 1.1v 959.755n 1.1v 964.745n 1.1v 964.755n 1.1v 969.745n 1.1v 969.755n 1.1v 974.745n 1.1v 974.755n 1.1v 979.745n 1.1v 979.755n 1.1v 984.745n 1.1v 984.755n 0.0v 989.745n 0.0v 989.755n 0.0v 994.745n 0.0v 994.755n 0.0v 999.745n 0.0v 999.755n 0.0v 1004.745n 0.0v 1004.755n 0.0v 1009.745n 0.0v 1009.755n 0.0v 1014.745n 0.0v 1014.755n 0.0v 1019.745n 0.0v 1019.755n 0.0v 1024.745n 0.0v 1024.755n 0.0v )
* (time, data): [(0, 0), (5, 0), (10, 1), (15, 0), (20, 0), (25, 0), (30, 1), (35, 1), (40, 1), (45, 0), (50, 0), (55, 0), (60, 1), (65, 1), (70, 1), (75, 1), (80, 1), (85, 1), (90, 0), (95, 0), (100, 1), (105, 1), (110, 1), (115, 1), (120, 1), (125, 1), (130, 1), (135, 0), (140, 0), (145, 0), (150, 0), (155, 0), (160, 0), (165, 0), (170, 1), (175, 1), (180, 1), (185, 1), (190, 1), (195, 1), (200, 0), (205, 0), (210, 0), (215, 0), (220, 1), (225, 1), (230, 0), (235, 0), (240, 1), (245, 1), (250, 1), (255, 0), (260, 0), (265, 1), (270, 1), (275, 1), (280, 0), (285, 0), (290, 0), (295, 0), (300, 0), (305, 0), (310, 0), (315, 0), (320, 0), (325, 0), (330, 1), (335, 0), (340, 0), (345, 0), (350, 0), (355, 0), (360, 0), (365, 0), (370, 0), (375, 0), (380, 0), (385, 0), (390, 0), (395, 0), (400, 1), (405, 1), (410, 1), (415, 0), (420, 1), (425, 1), (430, 1), (435, 1), (440, 1), (445, 1), (450, 1), (455, 1), (460, 0), (465, 1), (470, 1), (475, 1), (480, 0), (485, 0), (490, 0), (495, 0), (500, 1), (505, 1), (510, 0), (515, 1), (520, 1), (525, 1), (530, 1), (535, 0), (540, 0), (545, 0), (550, 0), (555, 1), (560, 1), (565, 1), (570, 1), (575, 0), (580, 0), (585, 0), (590, 0), (595, 0), (600, 0), (605, 0), (610, 0), (615, 0), (620, 0), (625, 0), (630, 1), (635, 1), (640, 1), (645, 1), (650, 1), (655, 1), (660, 1), (665, 1), (670, 0), (675, 0), (680, 0), (685, 0), (690, 0), (695, 0), (700, 0), (705, 1), (710, 0), (715, 1), (720, 1), (725, 1), (730, 1), (735, 0), (740, 1), (745, 1), (750, 1), (755, 0), (760, 0), (765, 0), (770, 0), (775, 0), (780, 0), (785, 0), (790, 0), (795, 0), (800, 0), (805, 0), (810, 0), (815, 0), (820, 1), (825, 1), (830, 1), (835, 0), (840, 0), (845, 0), (850, 0), (855, 1), (860, 0), (865, 0), (870, 0), (875, 1), (880, 0), (885, 0), (890, 0), (895, 0), (900, 0), (905, 0), (910, 1), (915, 1), (920, 1), (925, 1), (930, 0), (935, 0), (940, 1), (945, 1), (950, 1), (955, 1), (960, 1), (965, 1), (970, 1), (975, 1), (980, 0), (985, 0), (990, 0), (995, 1), (1000, 1), (1005, 1), (1010, 1), (1015, 1), (1020, 0), (1025, 0)]
Vdin0_48  din0_48  0 PWL (0n 0.0v 4.745n 0.0v 4.755n 0.0v 9.745n 0.0v 9.755n 1.1v 14.745n 1.1v 14.755n 0.0v 19.745n 0.0v 19.755n 0.0v 24.745n 0.0v 24.755n 0.0v 29.745n 0.0v 29.755n 1.1v 34.745n 1.1v 34.755n 1.1v 39.745n 1.1v 39.755n 1.1v 44.745n 1.1v 44.755n 0.0v 49.745n 0.0v 49.755n 0.0v 54.745n 0.0v 54.755n 0.0v 59.745n 0.0v 59.755n 1.1v 64.745n 1.1v 64.755n 1.1v 69.745n 1.1v 69.755n 1.1v 74.745n 1.1v 74.755n 1.1v 79.745n 1.1v 79.755n 1.1v 84.745n 1.1v 84.755n 1.1v 89.745n 1.1v 89.755n 0.0v 94.745n 0.0v 94.755n 0.0v 99.745n 0.0v 99.755n 1.1v 104.745n 1.1v 104.755n 1.1v 109.745n 1.1v 109.755n 1.1v 114.745n 1.1v 114.755n 1.1v 119.745n 1.1v 119.755n 1.1v 124.745n 1.1v 124.755n 1.1v 129.745n 1.1v 129.755n 1.1v 134.745n 1.1v 134.755n 0.0v 139.745n 0.0v 139.755n 0.0v 144.745n 0.0v 144.755n 0.0v 149.745n 0.0v 149.755n 0.0v 154.745n 0.0v 154.755n 0.0v 159.745n 0.0v 159.755n 0.0v 164.745n 0.0v 164.755n 0.0v 169.745n 0.0v 169.755n 1.1v 174.745n 1.1v 174.755n 1.1v 179.745n 1.1v 179.755n 1.1v 184.745n 1.1v 184.755n 1.1v 189.745n 1.1v 189.755n 1.1v 194.745n 1.1v 194.755n 1.1v 199.745n 1.1v 199.755n 0.0v 204.745n 0.0v 204.755n 0.0v 209.745n 0.0v 209.755n 0.0v 214.745n 0.0v 214.755n 0.0v 219.745n 0.0v 219.755n 1.1v 224.745n 1.1v 224.755n 1.1v 229.745n 1.1v 229.755n 0.0v 234.745n 0.0v 234.755n 0.0v 239.745n 0.0v 239.755n 1.1v 244.745n 1.1v 244.755n 1.1v 249.745n 1.1v 249.755n 1.1v 254.745n 1.1v 254.755n 0.0v 259.745n 0.0v 259.755n 0.0v 264.745n 0.0v 264.755n 1.1v 269.745n 1.1v 269.755n 1.1v 274.745n 1.1v 274.755n 1.1v 279.745n 1.1v 279.755n 0.0v 284.745n 0.0v 284.755n 0.0v 289.745n 0.0v 289.755n 0.0v 294.745n 0.0v 294.755n 0.0v 299.745n 0.0v 299.755n 0.0v 304.745n 0.0v 304.755n 0.0v 309.745n 0.0v 309.755n 0.0v 314.745n 0.0v 314.755n 0.0v 319.745n 0.0v 319.755n 0.0v 324.745n 0.0v 324.755n 0.0v 329.745n 0.0v 329.755n 1.1v 334.745n 1.1v 334.755n 0.0v 339.745n 0.0v 339.755n 0.0v 344.745n 0.0v 344.755n 0.0v 349.745n 0.0v 349.755n 0.0v 354.745n 0.0v 354.755n 0.0v 359.745n 0.0v 359.755n 0.0v 364.745n 0.0v 364.755n 0.0v 369.745n 0.0v 369.755n 0.0v 374.745n 0.0v 374.755n 0.0v 379.745n 0.0v 379.755n 0.0v 384.745n 0.0v 384.755n 0.0v 389.745n 0.0v 389.755n 0.0v 394.745n 0.0v 394.755n 0.0v 399.745n 0.0v 399.755n 1.1v 404.745n 1.1v 404.755n 1.1v 409.745n 1.1v 409.755n 1.1v 414.745n 1.1v 414.755n 0.0v 419.745n 0.0v 419.755n 1.1v 424.745n 1.1v 424.755n 1.1v 429.745n 1.1v 429.755n 1.1v 434.745n 1.1v 434.755n 1.1v 439.745n 1.1v 439.755n 1.1v 444.745n 1.1v 444.755n 1.1v 449.745n 1.1v 449.755n 1.1v 454.745n 1.1v 454.755n 1.1v 459.745n 1.1v 459.755n 0.0v 464.745n 0.0v 464.755n 1.1v 469.745n 1.1v 469.755n 1.1v 474.745n 1.1v 474.755n 1.1v 479.745n 1.1v 479.755n 0.0v 484.745n 0.0v 484.755n 0.0v 489.745n 0.0v 489.755n 0.0v 494.745n 0.0v 494.755n 0.0v 499.745n 0.0v 499.755n 1.1v 504.745n 1.1v 504.755n 1.1v 509.745n 1.1v 509.755n 0.0v 514.745n 0.0v 514.755n 1.1v 519.745n 1.1v 519.755n 1.1v 524.745n 1.1v 524.755n 1.1v 529.745n 1.1v 529.755n 1.1v 534.745n 1.1v 534.755n 0.0v 539.745n 0.0v 539.755n 0.0v 544.745n 0.0v 544.755n 0.0v 549.745n 0.0v 549.755n 0.0v 554.745n 0.0v 554.755n 1.1v 559.745n 1.1v 559.755n 1.1v 564.745n 1.1v 564.755n 1.1v 569.745n 1.1v 569.755n 1.1v 574.745n 1.1v 574.755n 0.0v 579.745n 0.0v 579.755n 0.0v 584.745n 0.0v 584.755n 0.0v 589.745n 0.0v 589.755n 0.0v 594.745n 0.0v 594.755n 0.0v 599.745n 0.0v 599.755n 0.0v 604.745n 0.0v 604.755n 0.0v 609.745n 0.0v 609.755n 0.0v 614.745n 0.0v 614.755n 0.0v 619.745n 0.0v 619.755n 0.0v 624.745n 0.0v 624.755n 0.0v 629.745n 0.0v 629.755n 1.1v 634.745n 1.1v 634.755n 1.1v 639.745n 1.1v 639.755n 1.1v 644.745n 1.1v 644.755n 1.1v 649.745n 1.1v 649.755n 1.1v 654.745n 1.1v 654.755n 1.1v 659.745n 1.1v 659.755n 1.1v 664.745n 1.1v 664.755n 1.1v 669.745n 1.1v 669.755n 0.0v 674.745n 0.0v 674.755n 0.0v 679.745n 0.0v 679.755n 0.0v 684.745n 0.0v 684.755n 0.0v 689.745n 0.0v 689.755n 0.0v 694.745n 0.0v 694.755n 0.0v 699.745n 0.0v 699.755n 0.0v 704.745n 0.0v 704.755n 1.1v 709.745n 1.1v 709.755n 0.0v 714.745n 0.0v 714.755n 1.1v 719.745n 1.1v 719.755n 1.1v 724.745n 1.1v 724.755n 1.1v 729.745n 1.1v 729.755n 1.1v 734.745n 1.1v 734.755n 0.0v 739.745n 0.0v 739.755n 1.1v 744.745n 1.1v 744.755n 1.1v 749.745n 1.1v 749.755n 1.1v 754.745n 1.1v 754.755n 0.0v 759.745n 0.0v 759.755n 0.0v 764.745n 0.0v 764.755n 0.0v 769.745n 0.0v 769.755n 0.0v 774.745n 0.0v 774.755n 0.0v 779.745n 0.0v 779.755n 0.0v 784.745n 0.0v 784.755n 0.0v 789.745n 0.0v 789.755n 0.0v 794.745n 0.0v 794.755n 0.0v 799.745n 0.0v 799.755n 0.0v 804.745n 0.0v 804.755n 0.0v 809.745n 0.0v 809.755n 0.0v 814.745n 0.0v 814.755n 0.0v 819.745n 0.0v 819.755n 1.1v 824.745n 1.1v 824.755n 1.1v 829.745n 1.1v 829.755n 1.1v 834.745n 1.1v 834.755n 0.0v 839.745n 0.0v 839.755n 0.0v 844.745n 0.0v 844.755n 0.0v 849.745n 0.0v 849.755n 0.0v 854.745n 0.0v 854.755n 1.1v 859.745n 1.1v 859.755n 0.0v 864.745n 0.0v 864.755n 0.0v 869.745n 0.0v 869.755n 0.0v 874.745n 0.0v 874.755n 1.1v 879.745n 1.1v 879.755n 0.0v 884.745n 0.0v 884.755n 0.0v 889.745n 0.0v 889.755n 0.0v 894.745n 0.0v 894.755n 0.0v 899.745n 0.0v 899.755n 0.0v 904.745n 0.0v 904.755n 0.0v 909.745n 0.0v 909.755n 1.1v 914.745n 1.1v 914.755n 1.1v 919.745n 1.1v 919.755n 1.1v 924.745n 1.1v 924.755n 1.1v 929.745n 1.1v 929.755n 0.0v 934.745n 0.0v 934.755n 0.0v 939.745n 0.0v 939.755n 1.1v 944.745n 1.1v 944.755n 1.1v 949.745n 1.1v 949.755n 1.1v 954.745n 1.1v 954.755n 1.1v 959.745n 1.1v 959.755n 1.1v 964.745n 1.1v 964.755n 1.1v 969.745n 1.1v 969.755n 1.1v 974.745n 1.1v 974.755n 1.1v 979.745n 1.1v 979.755n 0.0v 984.745n 0.0v 984.755n 0.0v 989.745n 0.0v 989.755n 0.0v 994.745n 0.0v 994.755n 1.1v 999.745n 1.1v 999.755n 1.1v 1004.745n 1.1v 1004.755n 1.1v 1009.745n 1.1v 1009.755n 1.1v 1014.745n 1.1v 1014.755n 1.1v 1019.745n 1.1v 1019.755n 0.0v 1024.745n 0.0v 1024.755n 0.0v )
* (time, data): [(0, 0), (5, 0), (10, 0), (15, 1), (20, 1), (25, 1), (30, 0), (35, 0), (40, 1), (45, 1), (50, 1), (55, 1), (60, 0), (65, 1), (70, 1), (75, 1), (80, 1), (85, 1), (90, 0), (95, 0), (100, 0), (105, 0), (110, 0), (115, 0), (120, 0), (125, 0), (130, 0), (135, 1), (140, 0), (145, 0), (150, 0), (155, 0), (160, 0), (165, 0), (170, 1), (175, 1), (180, 1), (185, 1), (190, 1), (195, 1), (200, 1), (205, 1), (210, 1), (215, 1), (220, 0), (225, 0), (230, 0), (235, 0), (240, 0), (245, 0), (250, 0), (255, 1), (260, 1), (265, 1), (270, 1), (275, 1), (280, 0), (285, 0), (290, 0), (295, 0), (300, 0), (305, 0), (310, 0), (315, 1), (320, 1), (325, 1), (330, 0), (335, 1), (340, 0), (345, 0), (350, 0), (355, 0), (360, 1), (365, 1), (370, 1), (375, 1), (380, 1), (385, 1), (390, 1), (395, 1), (400, 1), (405, 1), (410, 1), (415, 0), (420, 1), (425, 0), (430, 0), (435, 0), (440, 0), (445, 0), (450, 0), (455, 0), (460, 1), (465, 0), (470, 0), (475, 0), (480, 0), (485, 0), (490, 0), (495, 1), (500, 1), (505, 1), (510, 1), (515, 0), (520, 0), (525, 0), (530, 0), (535, 1), (540, 1), (545, 1), (550, 1), (555, 0), (560, 0), (565, 0), (570, 0), (575, 1), (580, 1), (585, 1), (590, 1), (595, 1), (600, 1), (605, 1), (610, 1), (615, 1), (620, 1), (625, 1), (630, 1), (635, 0), (640, 0), (645, 0), (650, 0), (655, 1), (660, 0), (665, 0), (670, 1), (675, 1), (680, 1), (685, 1), (690, 1), (695, 1), (700, 1), (705, 0), (710, 1), (715, 1), (720, 1), (725, 1), (730, 1), (735, 1), (740, 0), (745, 0), (750, 0), (755, 0), (760, 0), (765, 0), (770, 0), (775, 1), (780, 1), (785, 1), (790, 1), (795, 1), (800, 1), (805, 1), (810, 1), (815, 1), (820, 1), (825, 1), (830, 0), (835, 0), (840, 0), (845, 0), (850, 0), (855, 0), (860, 1), (865, 0), (870, 1), (875, 0), (880, 1), (885, 0), (890, 0), (895, 0), (900, 0), (905, 0), (910, 0), (915, 0), (920, 0), (925, 0), (930, 1), (935, 0), (940, 0), (945, 0), (950, 0), (955, 0), (960, 0), (965, 1), (970, 1), (975, 1), (980, 1), (985, 0), (990, 0), (995, 0), (1000, 0), (1005, 0), (1010, 0), (1015, 0), (1020, 1), (1025, 1)]
Vdin0_49  din0_49  0 PWL (0n 0.0v 4.745n 0.0v 4.755n 0.0v 9.745n 0.0v 9.755n 0.0v 14.745n 0.0v 14.755n 1.1v 19.745n 1.1v 19.755n 1.1v 24.745n 1.1v 24.755n 1.1v 29.745n 1.1v 29.755n 0.0v 34.745n 0.0v 34.755n 0.0v 39.745n 0.0v 39.755n 1.1v 44.745n 1.1v 44.755n 1.1v 49.745n 1.1v 49.755n 1.1v 54.745n 1.1v 54.755n 1.1v 59.745n 1.1v 59.755n 0.0v 64.745n 0.0v 64.755n 1.1v 69.745n 1.1v 69.755n 1.1v 74.745n 1.1v 74.755n 1.1v 79.745n 1.1v 79.755n 1.1v 84.745n 1.1v 84.755n 1.1v 89.745n 1.1v 89.755n 0.0v 94.745n 0.0v 94.755n 0.0v 99.745n 0.0v 99.755n 0.0v 104.745n 0.0v 104.755n 0.0v 109.745n 0.0v 109.755n 0.0v 114.745n 0.0v 114.755n 0.0v 119.745n 0.0v 119.755n 0.0v 124.745n 0.0v 124.755n 0.0v 129.745n 0.0v 129.755n 0.0v 134.745n 0.0v 134.755n 1.1v 139.745n 1.1v 139.755n 0.0v 144.745n 0.0v 144.755n 0.0v 149.745n 0.0v 149.755n 0.0v 154.745n 0.0v 154.755n 0.0v 159.745n 0.0v 159.755n 0.0v 164.745n 0.0v 164.755n 0.0v 169.745n 0.0v 169.755n 1.1v 174.745n 1.1v 174.755n 1.1v 179.745n 1.1v 179.755n 1.1v 184.745n 1.1v 184.755n 1.1v 189.745n 1.1v 189.755n 1.1v 194.745n 1.1v 194.755n 1.1v 199.745n 1.1v 199.755n 1.1v 204.745n 1.1v 204.755n 1.1v 209.745n 1.1v 209.755n 1.1v 214.745n 1.1v 214.755n 1.1v 219.745n 1.1v 219.755n 0.0v 224.745n 0.0v 224.755n 0.0v 229.745n 0.0v 229.755n 0.0v 234.745n 0.0v 234.755n 0.0v 239.745n 0.0v 239.755n 0.0v 244.745n 0.0v 244.755n 0.0v 249.745n 0.0v 249.755n 0.0v 254.745n 0.0v 254.755n 1.1v 259.745n 1.1v 259.755n 1.1v 264.745n 1.1v 264.755n 1.1v 269.745n 1.1v 269.755n 1.1v 274.745n 1.1v 274.755n 1.1v 279.745n 1.1v 279.755n 0.0v 284.745n 0.0v 284.755n 0.0v 289.745n 0.0v 289.755n 0.0v 294.745n 0.0v 294.755n 0.0v 299.745n 0.0v 299.755n 0.0v 304.745n 0.0v 304.755n 0.0v 309.745n 0.0v 309.755n 0.0v 314.745n 0.0v 314.755n 1.1v 319.745n 1.1v 319.755n 1.1v 324.745n 1.1v 324.755n 1.1v 329.745n 1.1v 329.755n 0.0v 334.745n 0.0v 334.755n 1.1v 339.745n 1.1v 339.755n 0.0v 344.745n 0.0v 344.755n 0.0v 349.745n 0.0v 349.755n 0.0v 354.745n 0.0v 354.755n 0.0v 359.745n 0.0v 359.755n 1.1v 364.745n 1.1v 364.755n 1.1v 369.745n 1.1v 369.755n 1.1v 374.745n 1.1v 374.755n 1.1v 379.745n 1.1v 379.755n 1.1v 384.745n 1.1v 384.755n 1.1v 389.745n 1.1v 389.755n 1.1v 394.745n 1.1v 394.755n 1.1v 399.745n 1.1v 399.755n 1.1v 404.745n 1.1v 404.755n 1.1v 409.745n 1.1v 409.755n 1.1v 414.745n 1.1v 414.755n 0.0v 419.745n 0.0v 419.755n 1.1v 424.745n 1.1v 424.755n 0.0v 429.745n 0.0v 429.755n 0.0v 434.745n 0.0v 434.755n 0.0v 439.745n 0.0v 439.755n 0.0v 444.745n 0.0v 444.755n 0.0v 449.745n 0.0v 449.755n 0.0v 454.745n 0.0v 454.755n 0.0v 459.745n 0.0v 459.755n 1.1v 464.745n 1.1v 464.755n 0.0v 469.745n 0.0v 469.755n 0.0v 474.745n 0.0v 474.755n 0.0v 479.745n 0.0v 479.755n 0.0v 484.745n 0.0v 484.755n 0.0v 489.745n 0.0v 489.755n 0.0v 494.745n 0.0v 494.755n 1.1v 499.745n 1.1v 499.755n 1.1v 504.745n 1.1v 504.755n 1.1v 509.745n 1.1v 509.755n 1.1v 514.745n 1.1v 514.755n 0.0v 519.745n 0.0v 519.755n 0.0v 524.745n 0.0v 524.755n 0.0v 529.745n 0.0v 529.755n 0.0v 534.745n 0.0v 534.755n 1.1v 539.745n 1.1v 539.755n 1.1v 544.745n 1.1v 544.755n 1.1v 549.745n 1.1v 549.755n 1.1v 554.745n 1.1v 554.755n 0.0v 559.745n 0.0v 559.755n 0.0v 564.745n 0.0v 564.755n 0.0v 569.745n 0.0v 569.755n 0.0v 574.745n 0.0v 574.755n 1.1v 579.745n 1.1v 579.755n 1.1v 584.745n 1.1v 584.755n 1.1v 589.745n 1.1v 589.755n 1.1v 594.745n 1.1v 594.755n 1.1v 599.745n 1.1v 599.755n 1.1v 604.745n 1.1v 604.755n 1.1v 609.745n 1.1v 609.755n 1.1v 614.745n 1.1v 614.755n 1.1v 619.745n 1.1v 619.755n 1.1v 624.745n 1.1v 624.755n 1.1v 629.745n 1.1v 629.755n 1.1v 634.745n 1.1v 634.755n 0.0v 639.745n 0.0v 639.755n 0.0v 644.745n 0.0v 644.755n 0.0v 649.745n 0.0v 649.755n 0.0v 654.745n 0.0v 654.755n 1.1v 659.745n 1.1v 659.755n 0.0v 664.745n 0.0v 664.755n 0.0v 669.745n 0.0v 669.755n 1.1v 674.745n 1.1v 674.755n 1.1v 679.745n 1.1v 679.755n 1.1v 684.745n 1.1v 684.755n 1.1v 689.745n 1.1v 689.755n 1.1v 694.745n 1.1v 694.755n 1.1v 699.745n 1.1v 699.755n 1.1v 704.745n 1.1v 704.755n 0.0v 709.745n 0.0v 709.755n 1.1v 714.745n 1.1v 714.755n 1.1v 719.745n 1.1v 719.755n 1.1v 724.745n 1.1v 724.755n 1.1v 729.745n 1.1v 729.755n 1.1v 734.745n 1.1v 734.755n 1.1v 739.745n 1.1v 739.755n 0.0v 744.745n 0.0v 744.755n 0.0v 749.745n 0.0v 749.755n 0.0v 754.745n 0.0v 754.755n 0.0v 759.745n 0.0v 759.755n 0.0v 764.745n 0.0v 764.755n 0.0v 769.745n 0.0v 769.755n 0.0v 774.745n 0.0v 774.755n 1.1v 779.745n 1.1v 779.755n 1.1v 784.745n 1.1v 784.755n 1.1v 789.745n 1.1v 789.755n 1.1v 794.745n 1.1v 794.755n 1.1v 799.745n 1.1v 799.755n 1.1v 804.745n 1.1v 804.755n 1.1v 809.745n 1.1v 809.755n 1.1v 814.745n 1.1v 814.755n 1.1v 819.745n 1.1v 819.755n 1.1v 824.745n 1.1v 824.755n 1.1v 829.745n 1.1v 829.755n 0.0v 834.745n 0.0v 834.755n 0.0v 839.745n 0.0v 839.755n 0.0v 844.745n 0.0v 844.755n 0.0v 849.745n 0.0v 849.755n 0.0v 854.745n 0.0v 854.755n 0.0v 859.745n 0.0v 859.755n 1.1v 864.745n 1.1v 864.755n 0.0v 869.745n 0.0v 869.755n 1.1v 874.745n 1.1v 874.755n 0.0v 879.745n 0.0v 879.755n 1.1v 884.745n 1.1v 884.755n 0.0v 889.745n 0.0v 889.755n 0.0v 894.745n 0.0v 894.755n 0.0v 899.745n 0.0v 899.755n 0.0v 904.745n 0.0v 904.755n 0.0v 909.745n 0.0v 909.755n 0.0v 914.745n 0.0v 914.755n 0.0v 919.745n 0.0v 919.755n 0.0v 924.745n 0.0v 924.755n 0.0v 929.745n 0.0v 929.755n 1.1v 934.745n 1.1v 934.755n 0.0v 939.745n 0.0v 939.755n 0.0v 944.745n 0.0v 944.755n 0.0v 949.745n 0.0v 949.755n 0.0v 954.745n 0.0v 954.755n 0.0v 959.745n 0.0v 959.755n 0.0v 964.745n 0.0v 964.755n 1.1v 969.745n 1.1v 969.755n 1.1v 974.745n 1.1v 974.755n 1.1v 979.745n 1.1v 979.755n 1.1v 984.745n 1.1v 984.755n 0.0v 989.745n 0.0v 989.755n 0.0v 994.745n 0.0v 994.755n 0.0v 999.745n 0.0v 999.755n 0.0v 1004.745n 0.0v 1004.755n 0.0v 1009.745n 0.0v 1009.755n 0.0v 1014.745n 0.0v 1014.755n 0.0v 1019.745n 0.0v 1019.755n 1.1v 1024.745n 1.1v 1024.755n 1.1v )
* (time, data): [(0, 0), (5, 0), (10, 0), (15, 0), (20, 0), (25, 0), (30, 0), (35, 0), (40, 0), (45, 0), (50, 0), (55, 0), (60, 1), (65, 0), (70, 0), (75, 0), (80, 0), (85, 0), (90, 0), (95, 0), (100, 1), (105, 1), (110, 1), (115, 1), (120, 1), (125, 1), (130, 1), (135, 1), (140, 0), (145, 0), (150, 0), (155, 0), (160, 0), (165, 0), (170, 0), (175, 0), (180, 0), (185, 1), (190, 1), (195, 1), (200, 0), (205, 0), (210, 1), (215, 1), (220, 1), (225, 1), (230, 0), (235, 0), (240, 0), (245, 0), (250, 0), (255, 0), (260, 0), (265, 1), (270, 1), (275, 1), (280, 1), (285, 1), (290, 1), (295, 1), (300, 0), (305, 0), (310, 0), (315, 1), (320, 1), (325, 1), (330, 1), (335, 1), (340, 1), (345, 1), (350, 1), (355, 1), (360, 0), (365, 0), (370, 0), (375, 0), (380, 0), (385, 0), (390, 0), (395, 1), (400, 1), (405, 1), (410, 0), (415, 1), (420, 0), (425, 1), (430, 1), (435, 1), (440, 1), (445, 1), (450, 0), (455, 0), (460, 1), (465, 0), (470, 1), (475, 1), (480, 1), (485, 1), (490, 1), (495, 0), (500, 0), (505, 1), (510, 1), (515, 1), (520, 1), (525, 1), (530, 1), (535, 1), (540, 1), (545, 1), (550, 1), (555, 1), (560, 1), (565, 1), (570, 1), (575, 1), (580, 1), (585, 1), (590, 1), (595, 1), (600, 1), (605, 1), (610, 1), (615, 1), (620, 1), (625, 1), (630, 0), (635, 0), (640, 1), (645, 1), (650, 1), (655, 1), (660, 0), (665, 0), (670, 1), (675, 1), (680, 1), (685, 1), (690, 1), (695, 1), (700, 1), (705, 0), (710, 0), (715, 0), (720, 0), (725, 0), (730, 0), (735, 0), (740, 1), (745, 1), (750, 1), (755, 0), (760, 0), (765, 0), (770, 1), (775, 0), (780, 0), (785, 1), (790, 1), (795, 1), (800, 1), (805, 1), (810, 1), (815, 1), (820, 0), (825, 0), (830, 0), (835, 0), (840, 0), (845, 0), (850, 0), (855, 0), (860, 1), (865, 1), (870, 0), (875, 0), (880, 0), (885, 0), (890, 0), (895, 0), (900, 0), (905, 0), (910, 0), (915, 0), (920, 0), (925, 0), (930, 1), (935, 1), (940, 1), (945, 1), (950, 1), (955, 1), (960, 1), (965, 0), (970, 0), (975, 0), (980, 0), (985, 0), (990, 0), (995, 0), (1000, 0), (1005, 0), (1010, 0), (1015, 0), (1020, 1), (1025, 1)]
Vdin0_50  din0_50  0 PWL (0n 0.0v 4.745n 0.0v 4.755n 0.0v 9.745n 0.0v 9.755n 0.0v 14.745n 0.0v 14.755n 0.0v 19.745n 0.0v 19.755n 0.0v 24.745n 0.0v 24.755n 0.0v 29.745n 0.0v 29.755n 0.0v 34.745n 0.0v 34.755n 0.0v 39.745n 0.0v 39.755n 0.0v 44.745n 0.0v 44.755n 0.0v 49.745n 0.0v 49.755n 0.0v 54.745n 0.0v 54.755n 0.0v 59.745n 0.0v 59.755n 1.1v 64.745n 1.1v 64.755n 0.0v 69.745n 0.0v 69.755n 0.0v 74.745n 0.0v 74.755n 0.0v 79.745n 0.0v 79.755n 0.0v 84.745n 0.0v 84.755n 0.0v 89.745n 0.0v 89.755n 0.0v 94.745n 0.0v 94.755n 0.0v 99.745n 0.0v 99.755n 1.1v 104.745n 1.1v 104.755n 1.1v 109.745n 1.1v 109.755n 1.1v 114.745n 1.1v 114.755n 1.1v 119.745n 1.1v 119.755n 1.1v 124.745n 1.1v 124.755n 1.1v 129.745n 1.1v 129.755n 1.1v 134.745n 1.1v 134.755n 1.1v 139.745n 1.1v 139.755n 0.0v 144.745n 0.0v 144.755n 0.0v 149.745n 0.0v 149.755n 0.0v 154.745n 0.0v 154.755n 0.0v 159.745n 0.0v 159.755n 0.0v 164.745n 0.0v 164.755n 0.0v 169.745n 0.0v 169.755n 0.0v 174.745n 0.0v 174.755n 0.0v 179.745n 0.0v 179.755n 0.0v 184.745n 0.0v 184.755n 1.1v 189.745n 1.1v 189.755n 1.1v 194.745n 1.1v 194.755n 1.1v 199.745n 1.1v 199.755n 0.0v 204.745n 0.0v 204.755n 0.0v 209.745n 0.0v 209.755n 1.1v 214.745n 1.1v 214.755n 1.1v 219.745n 1.1v 219.755n 1.1v 224.745n 1.1v 224.755n 1.1v 229.745n 1.1v 229.755n 0.0v 234.745n 0.0v 234.755n 0.0v 239.745n 0.0v 239.755n 0.0v 244.745n 0.0v 244.755n 0.0v 249.745n 0.0v 249.755n 0.0v 254.745n 0.0v 254.755n 0.0v 259.745n 0.0v 259.755n 0.0v 264.745n 0.0v 264.755n 1.1v 269.745n 1.1v 269.755n 1.1v 274.745n 1.1v 274.755n 1.1v 279.745n 1.1v 279.755n 1.1v 284.745n 1.1v 284.755n 1.1v 289.745n 1.1v 289.755n 1.1v 294.745n 1.1v 294.755n 1.1v 299.745n 1.1v 299.755n 0.0v 304.745n 0.0v 304.755n 0.0v 309.745n 0.0v 309.755n 0.0v 314.745n 0.0v 314.755n 1.1v 319.745n 1.1v 319.755n 1.1v 324.745n 1.1v 324.755n 1.1v 329.745n 1.1v 329.755n 1.1v 334.745n 1.1v 334.755n 1.1v 339.745n 1.1v 339.755n 1.1v 344.745n 1.1v 344.755n 1.1v 349.745n 1.1v 349.755n 1.1v 354.745n 1.1v 354.755n 1.1v 359.745n 1.1v 359.755n 0.0v 364.745n 0.0v 364.755n 0.0v 369.745n 0.0v 369.755n 0.0v 374.745n 0.0v 374.755n 0.0v 379.745n 0.0v 379.755n 0.0v 384.745n 0.0v 384.755n 0.0v 389.745n 0.0v 389.755n 0.0v 394.745n 0.0v 394.755n 1.1v 399.745n 1.1v 399.755n 1.1v 404.745n 1.1v 404.755n 1.1v 409.745n 1.1v 409.755n 0.0v 414.745n 0.0v 414.755n 1.1v 419.745n 1.1v 419.755n 0.0v 424.745n 0.0v 424.755n 1.1v 429.745n 1.1v 429.755n 1.1v 434.745n 1.1v 434.755n 1.1v 439.745n 1.1v 439.755n 1.1v 444.745n 1.1v 444.755n 1.1v 449.745n 1.1v 449.755n 0.0v 454.745n 0.0v 454.755n 0.0v 459.745n 0.0v 459.755n 1.1v 464.745n 1.1v 464.755n 0.0v 469.745n 0.0v 469.755n 1.1v 474.745n 1.1v 474.755n 1.1v 479.745n 1.1v 479.755n 1.1v 484.745n 1.1v 484.755n 1.1v 489.745n 1.1v 489.755n 1.1v 494.745n 1.1v 494.755n 0.0v 499.745n 0.0v 499.755n 0.0v 504.745n 0.0v 504.755n 1.1v 509.745n 1.1v 509.755n 1.1v 514.745n 1.1v 514.755n 1.1v 519.745n 1.1v 519.755n 1.1v 524.745n 1.1v 524.755n 1.1v 529.745n 1.1v 529.755n 1.1v 534.745n 1.1v 534.755n 1.1v 539.745n 1.1v 539.755n 1.1v 544.745n 1.1v 544.755n 1.1v 549.745n 1.1v 549.755n 1.1v 554.745n 1.1v 554.755n 1.1v 559.745n 1.1v 559.755n 1.1v 564.745n 1.1v 564.755n 1.1v 569.745n 1.1v 569.755n 1.1v 574.745n 1.1v 574.755n 1.1v 579.745n 1.1v 579.755n 1.1v 584.745n 1.1v 584.755n 1.1v 589.745n 1.1v 589.755n 1.1v 594.745n 1.1v 594.755n 1.1v 599.745n 1.1v 599.755n 1.1v 604.745n 1.1v 604.755n 1.1v 609.745n 1.1v 609.755n 1.1v 614.745n 1.1v 614.755n 1.1v 619.745n 1.1v 619.755n 1.1v 624.745n 1.1v 624.755n 1.1v 629.745n 1.1v 629.755n 0.0v 634.745n 0.0v 634.755n 0.0v 639.745n 0.0v 639.755n 1.1v 644.745n 1.1v 644.755n 1.1v 649.745n 1.1v 649.755n 1.1v 654.745n 1.1v 654.755n 1.1v 659.745n 1.1v 659.755n 0.0v 664.745n 0.0v 664.755n 0.0v 669.745n 0.0v 669.755n 1.1v 674.745n 1.1v 674.755n 1.1v 679.745n 1.1v 679.755n 1.1v 684.745n 1.1v 684.755n 1.1v 689.745n 1.1v 689.755n 1.1v 694.745n 1.1v 694.755n 1.1v 699.745n 1.1v 699.755n 1.1v 704.745n 1.1v 704.755n 0.0v 709.745n 0.0v 709.755n 0.0v 714.745n 0.0v 714.755n 0.0v 719.745n 0.0v 719.755n 0.0v 724.745n 0.0v 724.755n 0.0v 729.745n 0.0v 729.755n 0.0v 734.745n 0.0v 734.755n 0.0v 739.745n 0.0v 739.755n 1.1v 744.745n 1.1v 744.755n 1.1v 749.745n 1.1v 749.755n 1.1v 754.745n 1.1v 754.755n 0.0v 759.745n 0.0v 759.755n 0.0v 764.745n 0.0v 764.755n 0.0v 769.745n 0.0v 769.755n 1.1v 774.745n 1.1v 774.755n 0.0v 779.745n 0.0v 779.755n 0.0v 784.745n 0.0v 784.755n 1.1v 789.745n 1.1v 789.755n 1.1v 794.745n 1.1v 794.755n 1.1v 799.745n 1.1v 799.755n 1.1v 804.745n 1.1v 804.755n 1.1v 809.745n 1.1v 809.755n 1.1v 814.745n 1.1v 814.755n 1.1v 819.745n 1.1v 819.755n 0.0v 824.745n 0.0v 824.755n 0.0v 829.745n 0.0v 829.755n 0.0v 834.745n 0.0v 834.755n 0.0v 839.745n 0.0v 839.755n 0.0v 844.745n 0.0v 844.755n 0.0v 849.745n 0.0v 849.755n 0.0v 854.745n 0.0v 854.755n 0.0v 859.745n 0.0v 859.755n 1.1v 864.745n 1.1v 864.755n 1.1v 869.745n 1.1v 869.755n 0.0v 874.745n 0.0v 874.755n 0.0v 879.745n 0.0v 879.755n 0.0v 884.745n 0.0v 884.755n 0.0v 889.745n 0.0v 889.755n 0.0v 894.745n 0.0v 894.755n 0.0v 899.745n 0.0v 899.755n 0.0v 904.745n 0.0v 904.755n 0.0v 909.745n 0.0v 909.755n 0.0v 914.745n 0.0v 914.755n 0.0v 919.745n 0.0v 919.755n 0.0v 924.745n 0.0v 924.755n 0.0v 929.745n 0.0v 929.755n 1.1v 934.745n 1.1v 934.755n 1.1v 939.745n 1.1v 939.755n 1.1v 944.745n 1.1v 944.755n 1.1v 949.745n 1.1v 949.755n 1.1v 954.745n 1.1v 954.755n 1.1v 959.745n 1.1v 959.755n 1.1v 964.745n 1.1v 964.755n 0.0v 969.745n 0.0v 969.755n 0.0v 974.745n 0.0v 974.755n 0.0v 979.745n 0.0v 979.755n 0.0v 984.745n 0.0v 984.755n 0.0v 989.745n 0.0v 989.755n 0.0v 994.745n 0.0v 994.755n 0.0v 999.745n 0.0v 999.755n 0.0v 1004.745n 0.0v 1004.755n 0.0v 1009.745n 0.0v 1009.755n 0.0v 1014.745n 0.0v 1014.755n 0.0v 1019.745n 0.0v 1019.755n 1.1v 1024.745n 1.1v 1024.755n 1.1v )
* (time, data): [(0, 0), (5, 0), (10, 0), (15, 0), (20, 0), (25, 0), (30, 1), (35, 1), (40, 0), (45, 0), (50, 0), (55, 0), (60, 0), (65, 1), (70, 1), (75, 1), (80, 1), (85, 1), (90, 0), (95, 0), (100, 0), (105, 0), (110, 0), (115, 0), (120, 0), (125, 0), (130, 0), (135, 1), (140, 0), (145, 0), (150, 0), (155, 0), (160, 0), (165, 0), (170, 0), (175, 0), (180, 0), (185, 1), (190, 1), (195, 1), (200, 0), (205, 0), (210, 1), (215, 1), (220, 1), (225, 1), (230, 1), (235, 1), (240, 1), (245, 1), (250, 1), (255, 1), (260, 1), (265, 0), (270, 0), (275, 0), (280, 0), (285, 0), (290, 0), (295, 0), (300, 1), (305, 1), (310, 1), (315, 1), (320, 1), (325, 1), (330, 0), (335, 0), (340, 0), (345, 0), (350, 0), (355, 0), (360, 0), (365, 0), (370, 0), (375, 0), (380, 0), (385, 0), (390, 0), (395, 1), (400, 0), (405, 0), (410, 0), (415, 0), (420, 1), (425, 0), (430, 1), (435, 1), (440, 1), (445, 1), (450, 1), (455, 1), (460, 0), (465, 1), (470, 0), (475, 0), (480, 0), (485, 0), (490, 0), (495, 1), (500, 1), (505, 1), (510, 0), (515, 0), (520, 0), (525, 0), (530, 0), (535, 1), (540, 0), (545, 0), (550, 0), (555, 0), (560, 0), (565, 0), (570, 0), (575, 1), (580, 1), (585, 1), (590, 1), (595, 1), (600, 1), (605, 1), (610, 1), (615, 1), (620, 1), (625, 1), (630, 1), (635, 1), (640, 1), (645, 1), (650, 1), (655, 0), (660, 1), (665, 1), (670, 1), (675, 1), (680, 1), (685, 1), (690, 1), (695, 1), (700, 1), (705, 0), (710, 1), (715, 0), (720, 0), (725, 0), (730, 0), (735, 0), (740, 0), (745, 0), (750, 0), (755, 0), (760, 0), (765, 0), (770, 0), (775, 0), (780, 0), (785, 0), (790, 0), (795, 0), (800, 0), (805, 0), (810, 0), (815, 0), (820, 1), (825, 1), (830, 1), (835, 0), (840, 0), (845, 0), (850, 0), (855, 0), (860, 1), (865, 1), (870, 1), (875, 0), (880, 0), (885, 0), (890, 0), (895, 0), (900, 0), (905, 0), (910, 0), (915, 0), (920, 0), (925, 0), (930, 1), (935, 0), (940, 1), (945, 1), (950, 1), (955, 1), (960, 1), (965, 0), (970, 0), (975, 0), (980, 1), (985, 0), (990, 0), (995, 0), (1000, 0), (1005, 0), (1010, 0), (1015, 0), (1020, 0), (1025, 0)]
Vdin0_51  din0_51  0 PWL (0n 0.0v 4.745n 0.0v 4.755n 0.0v 9.745n 0.0v 9.755n 0.0v 14.745n 0.0v 14.755n 0.0v 19.745n 0.0v 19.755n 0.0v 24.745n 0.0v 24.755n 0.0v 29.745n 0.0v 29.755n 1.1v 34.745n 1.1v 34.755n 1.1v 39.745n 1.1v 39.755n 0.0v 44.745n 0.0v 44.755n 0.0v 49.745n 0.0v 49.755n 0.0v 54.745n 0.0v 54.755n 0.0v 59.745n 0.0v 59.755n 0.0v 64.745n 0.0v 64.755n 1.1v 69.745n 1.1v 69.755n 1.1v 74.745n 1.1v 74.755n 1.1v 79.745n 1.1v 79.755n 1.1v 84.745n 1.1v 84.755n 1.1v 89.745n 1.1v 89.755n 0.0v 94.745n 0.0v 94.755n 0.0v 99.745n 0.0v 99.755n 0.0v 104.745n 0.0v 104.755n 0.0v 109.745n 0.0v 109.755n 0.0v 114.745n 0.0v 114.755n 0.0v 119.745n 0.0v 119.755n 0.0v 124.745n 0.0v 124.755n 0.0v 129.745n 0.0v 129.755n 0.0v 134.745n 0.0v 134.755n 1.1v 139.745n 1.1v 139.755n 0.0v 144.745n 0.0v 144.755n 0.0v 149.745n 0.0v 149.755n 0.0v 154.745n 0.0v 154.755n 0.0v 159.745n 0.0v 159.755n 0.0v 164.745n 0.0v 164.755n 0.0v 169.745n 0.0v 169.755n 0.0v 174.745n 0.0v 174.755n 0.0v 179.745n 0.0v 179.755n 0.0v 184.745n 0.0v 184.755n 1.1v 189.745n 1.1v 189.755n 1.1v 194.745n 1.1v 194.755n 1.1v 199.745n 1.1v 199.755n 0.0v 204.745n 0.0v 204.755n 0.0v 209.745n 0.0v 209.755n 1.1v 214.745n 1.1v 214.755n 1.1v 219.745n 1.1v 219.755n 1.1v 224.745n 1.1v 224.755n 1.1v 229.745n 1.1v 229.755n 1.1v 234.745n 1.1v 234.755n 1.1v 239.745n 1.1v 239.755n 1.1v 244.745n 1.1v 244.755n 1.1v 249.745n 1.1v 249.755n 1.1v 254.745n 1.1v 254.755n 1.1v 259.745n 1.1v 259.755n 1.1v 264.745n 1.1v 264.755n 0.0v 269.745n 0.0v 269.755n 0.0v 274.745n 0.0v 274.755n 0.0v 279.745n 0.0v 279.755n 0.0v 284.745n 0.0v 284.755n 0.0v 289.745n 0.0v 289.755n 0.0v 294.745n 0.0v 294.755n 0.0v 299.745n 0.0v 299.755n 1.1v 304.745n 1.1v 304.755n 1.1v 309.745n 1.1v 309.755n 1.1v 314.745n 1.1v 314.755n 1.1v 319.745n 1.1v 319.755n 1.1v 324.745n 1.1v 324.755n 1.1v 329.745n 1.1v 329.755n 0.0v 334.745n 0.0v 334.755n 0.0v 339.745n 0.0v 339.755n 0.0v 344.745n 0.0v 344.755n 0.0v 349.745n 0.0v 349.755n 0.0v 354.745n 0.0v 354.755n 0.0v 359.745n 0.0v 359.755n 0.0v 364.745n 0.0v 364.755n 0.0v 369.745n 0.0v 369.755n 0.0v 374.745n 0.0v 374.755n 0.0v 379.745n 0.0v 379.755n 0.0v 384.745n 0.0v 384.755n 0.0v 389.745n 0.0v 389.755n 0.0v 394.745n 0.0v 394.755n 1.1v 399.745n 1.1v 399.755n 0.0v 404.745n 0.0v 404.755n 0.0v 409.745n 0.0v 409.755n 0.0v 414.745n 0.0v 414.755n 0.0v 419.745n 0.0v 419.755n 1.1v 424.745n 1.1v 424.755n 0.0v 429.745n 0.0v 429.755n 1.1v 434.745n 1.1v 434.755n 1.1v 439.745n 1.1v 439.755n 1.1v 444.745n 1.1v 444.755n 1.1v 449.745n 1.1v 449.755n 1.1v 454.745n 1.1v 454.755n 1.1v 459.745n 1.1v 459.755n 0.0v 464.745n 0.0v 464.755n 1.1v 469.745n 1.1v 469.755n 0.0v 474.745n 0.0v 474.755n 0.0v 479.745n 0.0v 479.755n 0.0v 484.745n 0.0v 484.755n 0.0v 489.745n 0.0v 489.755n 0.0v 494.745n 0.0v 494.755n 1.1v 499.745n 1.1v 499.755n 1.1v 504.745n 1.1v 504.755n 1.1v 509.745n 1.1v 509.755n 0.0v 514.745n 0.0v 514.755n 0.0v 519.745n 0.0v 519.755n 0.0v 524.745n 0.0v 524.755n 0.0v 529.745n 0.0v 529.755n 0.0v 534.745n 0.0v 534.755n 1.1v 539.745n 1.1v 539.755n 0.0v 544.745n 0.0v 544.755n 0.0v 549.745n 0.0v 549.755n 0.0v 554.745n 0.0v 554.755n 0.0v 559.745n 0.0v 559.755n 0.0v 564.745n 0.0v 564.755n 0.0v 569.745n 0.0v 569.755n 0.0v 574.745n 0.0v 574.755n 1.1v 579.745n 1.1v 579.755n 1.1v 584.745n 1.1v 584.755n 1.1v 589.745n 1.1v 589.755n 1.1v 594.745n 1.1v 594.755n 1.1v 599.745n 1.1v 599.755n 1.1v 604.745n 1.1v 604.755n 1.1v 609.745n 1.1v 609.755n 1.1v 614.745n 1.1v 614.755n 1.1v 619.745n 1.1v 619.755n 1.1v 624.745n 1.1v 624.755n 1.1v 629.745n 1.1v 629.755n 1.1v 634.745n 1.1v 634.755n 1.1v 639.745n 1.1v 639.755n 1.1v 644.745n 1.1v 644.755n 1.1v 649.745n 1.1v 649.755n 1.1v 654.745n 1.1v 654.755n 0.0v 659.745n 0.0v 659.755n 1.1v 664.745n 1.1v 664.755n 1.1v 669.745n 1.1v 669.755n 1.1v 674.745n 1.1v 674.755n 1.1v 679.745n 1.1v 679.755n 1.1v 684.745n 1.1v 684.755n 1.1v 689.745n 1.1v 689.755n 1.1v 694.745n 1.1v 694.755n 1.1v 699.745n 1.1v 699.755n 1.1v 704.745n 1.1v 704.755n 0.0v 709.745n 0.0v 709.755n 1.1v 714.745n 1.1v 714.755n 0.0v 719.745n 0.0v 719.755n 0.0v 724.745n 0.0v 724.755n 0.0v 729.745n 0.0v 729.755n 0.0v 734.745n 0.0v 734.755n 0.0v 739.745n 0.0v 739.755n 0.0v 744.745n 0.0v 744.755n 0.0v 749.745n 0.0v 749.755n 0.0v 754.745n 0.0v 754.755n 0.0v 759.745n 0.0v 759.755n 0.0v 764.745n 0.0v 764.755n 0.0v 769.745n 0.0v 769.755n 0.0v 774.745n 0.0v 774.755n 0.0v 779.745n 0.0v 779.755n 0.0v 784.745n 0.0v 784.755n 0.0v 789.745n 0.0v 789.755n 0.0v 794.745n 0.0v 794.755n 0.0v 799.745n 0.0v 799.755n 0.0v 804.745n 0.0v 804.755n 0.0v 809.745n 0.0v 809.755n 0.0v 814.745n 0.0v 814.755n 0.0v 819.745n 0.0v 819.755n 1.1v 824.745n 1.1v 824.755n 1.1v 829.745n 1.1v 829.755n 1.1v 834.745n 1.1v 834.755n 0.0v 839.745n 0.0v 839.755n 0.0v 844.745n 0.0v 844.755n 0.0v 849.745n 0.0v 849.755n 0.0v 854.745n 0.0v 854.755n 0.0v 859.745n 0.0v 859.755n 1.1v 864.745n 1.1v 864.755n 1.1v 869.745n 1.1v 869.755n 1.1v 874.745n 1.1v 874.755n 0.0v 879.745n 0.0v 879.755n 0.0v 884.745n 0.0v 884.755n 0.0v 889.745n 0.0v 889.755n 0.0v 894.745n 0.0v 894.755n 0.0v 899.745n 0.0v 899.755n 0.0v 904.745n 0.0v 904.755n 0.0v 909.745n 0.0v 909.755n 0.0v 914.745n 0.0v 914.755n 0.0v 919.745n 0.0v 919.755n 0.0v 924.745n 0.0v 924.755n 0.0v 929.745n 0.0v 929.755n 1.1v 934.745n 1.1v 934.755n 0.0v 939.745n 0.0v 939.755n 1.1v 944.745n 1.1v 944.755n 1.1v 949.745n 1.1v 949.755n 1.1v 954.745n 1.1v 954.755n 1.1v 959.745n 1.1v 959.755n 1.1v 964.745n 1.1v 964.755n 0.0v 969.745n 0.0v 969.755n 0.0v 974.745n 0.0v 974.755n 0.0v 979.745n 0.0v 979.755n 1.1v 984.745n 1.1v 984.755n 0.0v 989.745n 0.0v 989.755n 0.0v 994.745n 0.0v 994.755n 0.0v 999.745n 0.0v 999.755n 0.0v 1004.745n 0.0v 1004.755n 0.0v 1009.745n 0.0v 1009.755n 0.0v 1014.745n 0.0v 1014.755n 0.0v 1019.745n 0.0v 1019.755n 0.0v 1024.745n 0.0v 1024.755n 0.0v )
* (time, data): [(0, 0), (5, 1), (10, 0), (15, 1), (20, 1), (25, 1), (30, 1), (35, 1), (40, 0), (45, 1), (50, 1), (55, 1), (60, 0), (65, 1), (70, 1), (75, 1), (80, 1), (85, 1), (90, 0), (95, 0), (100, 0), (105, 0), (110, 0), (115, 0), (120, 0), (125, 0), (130, 0), (135, 0), (140, 1), (145, 1), (150, 1), (155, 1), (160, 1), (165, 1), (170, 0), (175, 0), (180, 0), (185, 0), (190, 0), (195, 0), (200, 0), (205, 0), (210, 1), (215, 1), (220, 0), (225, 0), (230, 0), (235, 0), (240, 1), (245, 1), (250, 1), (255, 1), (260, 1), (265, 1), (270, 1), (275, 1), (280, 0), (285, 0), (290, 0), (295, 0), (300, 0), (305, 0), (310, 0), (315, 0), (320, 0), (325, 0), (330, 1), (335, 1), (340, 1), (345, 1), (350, 1), (355, 1), (360, 1), (365, 1), (370, 1), (375, 1), (380, 1), (385, 1), (390, 1), (395, 0), (400, 1), (405, 1), (410, 0), (415, 0), (420, 0), (425, 1), (430, 1), (435, 1), (440, 1), (445, 1), (450, 1), (455, 1), (460, 0), (465, 0), (470, 0), (475, 0), (480, 1), (485, 1), (490, 1), (495, 0), (500, 0), (505, 1), (510, 1), (515, 0), (520, 0), (525, 0), (530, 0), (535, 1), (540, 1), (545, 1), (550, 1), (555, 1), (560, 1), (565, 1), (570, 1), (575, 1), (580, 1), (585, 1), (590, 1), (595, 1), (600, 1), (605, 1), (610, 1), (615, 1), (620, 1), (625, 1), (630, 1), (635, 0), (640, 1), (645, 1), (650, 1), (655, 0), (660, 1), (665, 1), (670, 1), (675, 1), (680, 1), (685, 1), (690, 1), (695, 1), (700, 1), (705, 0), (710, 0), (715, 0), (720, 0), (725, 0), (730, 0), (735, 0), (740, 1), (745, 1), (750, 1), (755, 0), (760, 0), (765, 0), (770, 0), (775, 1), (780, 1), (785, 0), (790, 1), (795, 1), (800, 1), (805, 1), (810, 1), (815, 1), (820, 1), (825, 1), (830, 1), (835, 0), (840, 0), (845, 0), (850, 0), (855, 1), (860, 0), (865, 1), (870, 1), (875, 0), (880, 1), (885, 0), (890, 0), (895, 0), (900, 0), (905, 0), (910, 1), (915, 1), (920, 1), (925, 1), (930, 1), (935, 1), (940, 0), (945, 0), (950, 0), (955, 1), (960, 1), (965, 1), (970, 1), (975, 1), (980, 0), (985, 0), (990, 0), (995, 1), (1000, 1), (1005, 1), (1010, 1), (1015, 1), (1020, 1), (1025, 1)]
Vdin0_52  din0_52  0 PWL (0n 0.0v 4.745n 0.0v 4.755n 1.1v 9.745n 1.1v 9.755n 0.0v 14.745n 0.0v 14.755n 1.1v 19.745n 1.1v 19.755n 1.1v 24.745n 1.1v 24.755n 1.1v 29.745n 1.1v 29.755n 1.1v 34.745n 1.1v 34.755n 1.1v 39.745n 1.1v 39.755n 0.0v 44.745n 0.0v 44.755n 1.1v 49.745n 1.1v 49.755n 1.1v 54.745n 1.1v 54.755n 1.1v 59.745n 1.1v 59.755n 0.0v 64.745n 0.0v 64.755n 1.1v 69.745n 1.1v 69.755n 1.1v 74.745n 1.1v 74.755n 1.1v 79.745n 1.1v 79.755n 1.1v 84.745n 1.1v 84.755n 1.1v 89.745n 1.1v 89.755n 0.0v 94.745n 0.0v 94.755n 0.0v 99.745n 0.0v 99.755n 0.0v 104.745n 0.0v 104.755n 0.0v 109.745n 0.0v 109.755n 0.0v 114.745n 0.0v 114.755n 0.0v 119.745n 0.0v 119.755n 0.0v 124.745n 0.0v 124.755n 0.0v 129.745n 0.0v 129.755n 0.0v 134.745n 0.0v 134.755n 0.0v 139.745n 0.0v 139.755n 1.1v 144.745n 1.1v 144.755n 1.1v 149.745n 1.1v 149.755n 1.1v 154.745n 1.1v 154.755n 1.1v 159.745n 1.1v 159.755n 1.1v 164.745n 1.1v 164.755n 1.1v 169.745n 1.1v 169.755n 0.0v 174.745n 0.0v 174.755n 0.0v 179.745n 0.0v 179.755n 0.0v 184.745n 0.0v 184.755n 0.0v 189.745n 0.0v 189.755n 0.0v 194.745n 0.0v 194.755n 0.0v 199.745n 0.0v 199.755n 0.0v 204.745n 0.0v 204.755n 0.0v 209.745n 0.0v 209.755n 1.1v 214.745n 1.1v 214.755n 1.1v 219.745n 1.1v 219.755n 0.0v 224.745n 0.0v 224.755n 0.0v 229.745n 0.0v 229.755n 0.0v 234.745n 0.0v 234.755n 0.0v 239.745n 0.0v 239.755n 1.1v 244.745n 1.1v 244.755n 1.1v 249.745n 1.1v 249.755n 1.1v 254.745n 1.1v 254.755n 1.1v 259.745n 1.1v 259.755n 1.1v 264.745n 1.1v 264.755n 1.1v 269.745n 1.1v 269.755n 1.1v 274.745n 1.1v 274.755n 1.1v 279.745n 1.1v 279.755n 0.0v 284.745n 0.0v 284.755n 0.0v 289.745n 0.0v 289.755n 0.0v 294.745n 0.0v 294.755n 0.0v 299.745n 0.0v 299.755n 0.0v 304.745n 0.0v 304.755n 0.0v 309.745n 0.0v 309.755n 0.0v 314.745n 0.0v 314.755n 0.0v 319.745n 0.0v 319.755n 0.0v 324.745n 0.0v 324.755n 0.0v 329.745n 0.0v 329.755n 1.1v 334.745n 1.1v 334.755n 1.1v 339.745n 1.1v 339.755n 1.1v 344.745n 1.1v 344.755n 1.1v 349.745n 1.1v 349.755n 1.1v 354.745n 1.1v 354.755n 1.1v 359.745n 1.1v 359.755n 1.1v 364.745n 1.1v 364.755n 1.1v 369.745n 1.1v 369.755n 1.1v 374.745n 1.1v 374.755n 1.1v 379.745n 1.1v 379.755n 1.1v 384.745n 1.1v 384.755n 1.1v 389.745n 1.1v 389.755n 1.1v 394.745n 1.1v 394.755n 0.0v 399.745n 0.0v 399.755n 1.1v 404.745n 1.1v 404.755n 1.1v 409.745n 1.1v 409.755n 0.0v 414.745n 0.0v 414.755n 0.0v 419.745n 0.0v 419.755n 0.0v 424.745n 0.0v 424.755n 1.1v 429.745n 1.1v 429.755n 1.1v 434.745n 1.1v 434.755n 1.1v 439.745n 1.1v 439.755n 1.1v 444.745n 1.1v 444.755n 1.1v 449.745n 1.1v 449.755n 1.1v 454.745n 1.1v 454.755n 1.1v 459.745n 1.1v 459.755n 0.0v 464.745n 0.0v 464.755n 0.0v 469.745n 0.0v 469.755n 0.0v 474.745n 0.0v 474.755n 0.0v 479.745n 0.0v 479.755n 1.1v 484.745n 1.1v 484.755n 1.1v 489.745n 1.1v 489.755n 1.1v 494.745n 1.1v 494.755n 0.0v 499.745n 0.0v 499.755n 0.0v 504.745n 0.0v 504.755n 1.1v 509.745n 1.1v 509.755n 1.1v 514.745n 1.1v 514.755n 0.0v 519.745n 0.0v 519.755n 0.0v 524.745n 0.0v 524.755n 0.0v 529.745n 0.0v 529.755n 0.0v 534.745n 0.0v 534.755n 1.1v 539.745n 1.1v 539.755n 1.1v 544.745n 1.1v 544.755n 1.1v 549.745n 1.1v 549.755n 1.1v 554.745n 1.1v 554.755n 1.1v 559.745n 1.1v 559.755n 1.1v 564.745n 1.1v 564.755n 1.1v 569.745n 1.1v 569.755n 1.1v 574.745n 1.1v 574.755n 1.1v 579.745n 1.1v 579.755n 1.1v 584.745n 1.1v 584.755n 1.1v 589.745n 1.1v 589.755n 1.1v 594.745n 1.1v 594.755n 1.1v 599.745n 1.1v 599.755n 1.1v 604.745n 1.1v 604.755n 1.1v 609.745n 1.1v 609.755n 1.1v 614.745n 1.1v 614.755n 1.1v 619.745n 1.1v 619.755n 1.1v 624.745n 1.1v 624.755n 1.1v 629.745n 1.1v 629.755n 1.1v 634.745n 1.1v 634.755n 0.0v 639.745n 0.0v 639.755n 1.1v 644.745n 1.1v 644.755n 1.1v 649.745n 1.1v 649.755n 1.1v 654.745n 1.1v 654.755n 0.0v 659.745n 0.0v 659.755n 1.1v 664.745n 1.1v 664.755n 1.1v 669.745n 1.1v 669.755n 1.1v 674.745n 1.1v 674.755n 1.1v 679.745n 1.1v 679.755n 1.1v 684.745n 1.1v 684.755n 1.1v 689.745n 1.1v 689.755n 1.1v 694.745n 1.1v 694.755n 1.1v 699.745n 1.1v 699.755n 1.1v 704.745n 1.1v 704.755n 0.0v 709.745n 0.0v 709.755n 0.0v 714.745n 0.0v 714.755n 0.0v 719.745n 0.0v 719.755n 0.0v 724.745n 0.0v 724.755n 0.0v 729.745n 0.0v 729.755n 0.0v 734.745n 0.0v 734.755n 0.0v 739.745n 0.0v 739.755n 1.1v 744.745n 1.1v 744.755n 1.1v 749.745n 1.1v 749.755n 1.1v 754.745n 1.1v 754.755n 0.0v 759.745n 0.0v 759.755n 0.0v 764.745n 0.0v 764.755n 0.0v 769.745n 0.0v 769.755n 0.0v 774.745n 0.0v 774.755n 1.1v 779.745n 1.1v 779.755n 1.1v 784.745n 1.1v 784.755n 0.0v 789.745n 0.0v 789.755n 1.1v 794.745n 1.1v 794.755n 1.1v 799.745n 1.1v 799.755n 1.1v 804.745n 1.1v 804.755n 1.1v 809.745n 1.1v 809.755n 1.1v 814.745n 1.1v 814.755n 1.1v 819.745n 1.1v 819.755n 1.1v 824.745n 1.1v 824.755n 1.1v 829.745n 1.1v 829.755n 1.1v 834.745n 1.1v 834.755n 0.0v 839.745n 0.0v 839.755n 0.0v 844.745n 0.0v 844.755n 0.0v 849.745n 0.0v 849.755n 0.0v 854.745n 0.0v 854.755n 1.1v 859.745n 1.1v 859.755n 0.0v 864.745n 0.0v 864.755n 1.1v 869.745n 1.1v 869.755n 1.1v 874.745n 1.1v 874.755n 0.0v 879.745n 0.0v 879.755n 1.1v 884.745n 1.1v 884.755n 0.0v 889.745n 0.0v 889.755n 0.0v 894.745n 0.0v 894.755n 0.0v 899.745n 0.0v 899.755n 0.0v 904.745n 0.0v 904.755n 0.0v 909.745n 0.0v 909.755n 1.1v 914.745n 1.1v 914.755n 1.1v 919.745n 1.1v 919.755n 1.1v 924.745n 1.1v 924.755n 1.1v 929.745n 1.1v 929.755n 1.1v 934.745n 1.1v 934.755n 1.1v 939.745n 1.1v 939.755n 0.0v 944.745n 0.0v 944.755n 0.0v 949.745n 0.0v 949.755n 0.0v 954.745n 0.0v 954.755n 1.1v 959.745n 1.1v 959.755n 1.1v 964.745n 1.1v 964.755n 1.1v 969.745n 1.1v 969.755n 1.1v 974.745n 1.1v 974.755n 1.1v 979.745n 1.1v 979.755n 0.0v 984.745n 0.0v 984.755n 0.0v 989.745n 0.0v 989.755n 0.0v 994.745n 0.0v 994.755n 1.1v 999.745n 1.1v 999.755n 1.1v 1004.745n 1.1v 1004.755n 1.1v 1009.745n 1.1v 1009.755n 1.1v 1014.745n 1.1v 1014.755n 1.1v 1019.745n 1.1v 1019.755n 1.1v 1024.745n 1.1v 1024.755n 1.1v )
* (time, data): [(0, 0), (5, 0), (10, 1), (15, 0), (20, 0), (25, 0), (30, 0), (35, 0), (40, 0), (45, 0), (50, 0), (55, 0), (60, 0), (65, 0), (70, 0), (75, 0), (80, 0), (85, 0), (90, 0), (95, 0), (100, 1), (105, 1), (110, 1), (115, 1), (120, 1), (125, 1), (130, 1), (135, 0), (140, 1), (145, 1), (150, 1), (155, 1), (160, 1), (165, 1), (170, 1), (175, 1), (180, 1), (185, 0), (190, 0), (195, 0), (200, 0), (205, 0), (210, 0), (215, 0), (220, 1), (225, 1), (230, 0), (235, 0), (240, 1), (245, 1), (250, 1), (255, 1), (260, 1), (265, 0), (270, 0), (275, 0), (280, 0), (285, 0), (290, 0), (295, 0), (300, 0), (305, 0), (310, 0), (315, 0), (320, 0), (325, 0), (330, 0), (335, 0), (340, 1), (345, 1), (350, 1), (355, 1), (360, 0), (365, 0), (370, 0), (375, 0), (380, 0), (385, 0), (390, 0), (395, 1), (400, 0), (405, 0), (410, 1), (415, 1), (420, 0), (425, 0), (430, 1), (435, 1), (440, 1), (445, 1), (450, 1), (455, 1), (460, 0), (465, 1), (470, 1), (475, 1), (480, 1), (485, 1), (490, 1), (495, 0), (500, 0), (505, 1), (510, 0), (515, 0), (520, 0), (525, 0), (530, 0), (535, 1), (540, 1), (545, 1), (550, 1), (555, 1), (560, 1), (565, 1), (570, 1), (575, 1), (580, 1), (585, 1), (590, 1), (595, 1), (600, 1), (605, 1), (610, 1), (615, 1), (620, 1), (625, 1), (630, 0), (635, 1), (640, 0), (645, 0), (650, 0), (655, 1), (660, 0), (665, 0), (670, 0), (675, 0), (680, 0), (685, 0), (690, 0), (695, 0), (700, 0), (705, 0), (710, 1), (715, 0), (720, 0), (725, 0), (730, 0), (735, 0), (740, 0), (745, 0), (750, 0), (755, 1), (760, 1), (765, 1), (770, 1), (775, 1), (780, 1), (785, 0), (790, 1), (795, 1), (800, 1), (805, 1), (810, 1), (815, 1), (820, 0), (825, 0), (830, 1), (835, 1), (840, 1), (845, 1), (850, 1), (855, 1), (860, 0), (865, 1), (870, 1), (875, 1), (880, 1), (885, 1), (890, 1), (895, 1), (900, 1), (905, 1), (910, 1), (915, 1), (920, 1), (925, 1), (930, 1), (935, 1), (940, 1), (945, 1), (950, 1), (955, 1), (960, 1), (965, 1), (970, 1), (975, 1), (980, 0), (985, 0), (990, 0), (995, 1), (1000, 1), (1005, 1), (1010, 1), (1015, 1), (1020, 1), (1025, 1)]
Vdin0_53  din0_53  0 PWL (0n 0.0v 4.745n 0.0v 4.755n 0.0v 9.745n 0.0v 9.755n 1.1v 14.745n 1.1v 14.755n 0.0v 19.745n 0.0v 19.755n 0.0v 24.745n 0.0v 24.755n 0.0v 29.745n 0.0v 29.755n 0.0v 34.745n 0.0v 34.755n 0.0v 39.745n 0.0v 39.755n 0.0v 44.745n 0.0v 44.755n 0.0v 49.745n 0.0v 49.755n 0.0v 54.745n 0.0v 54.755n 0.0v 59.745n 0.0v 59.755n 0.0v 64.745n 0.0v 64.755n 0.0v 69.745n 0.0v 69.755n 0.0v 74.745n 0.0v 74.755n 0.0v 79.745n 0.0v 79.755n 0.0v 84.745n 0.0v 84.755n 0.0v 89.745n 0.0v 89.755n 0.0v 94.745n 0.0v 94.755n 0.0v 99.745n 0.0v 99.755n 1.1v 104.745n 1.1v 104.755n 1.1v 109.745n 1.1v 109.755n 1.1v 114.745n 1.1v 114.755n 1.1v 119.745n 1.1v 119.755n 1.1v 124.745n 1.1v 124.755n 1.1v 129.745n 1.1v 129.755n 1.1v 134.745n 1.1v 134.755n 0.0v 139.745n 0.0v 139.755n 1.1v 144.745n 1.1v 144.755n 1.1v 149.745n 1.1v 149.755n 1.1v 154.745n 1.1v 154.755n 1.1v 159.745n 1.1v 159.755n 1.1v 164.745n 1.1v 164.755n 1.1v 169.745n 1.1v 169.755n 1.1v 174.745n 1.1v 174.755n 1.1v 179.745n 1.1v 179.755n 1.1v 184.745n 1.1v 184.755n 0.0v 189.745n 0.0v 189.755n 0.0v 194.745n 0.0v 194.755n 0.0v 199.745n 0.0v 199.755n 0.0v 204.745n 0.0v 204.755n 0.0v 209.745n 0.0v 209.755n 0.0v 214.745n 0.0v 214.755n 0.0v 219.745n 0.0v 219.755n 1.1v 224.745n 1.1v 224.755n 1.1v 229.745n 1.1v 229.755n 0.0v 234.745n 0.0v 234.755n 0.0v 239.745n 0.0v 239.755n 1.1v 244.745n 1.1v 244.755n 1.1v 249.745n 1.1v 249.755n 1.1v 254.745n 1.1v 254.755n 1.1v 259.745n 1.1v 259.755n 1.1v 264.745n 1.1v 264.755n 0.0v 269.745n 0.0v 269.755n 0.0v 274.745n 0.0v 274.755n 0.0v 279.745n 0.0v 279.755n 0.0v 284.745n 0.0v 284.755n 0.0v 289.745n 0.0v 289.755n 0.0v 294.745n 0.0v 294.755n 0.0v 299.745n 0.0v 299.755n 0.0v 304.745n 0.0v 304.755n 0.0v 309.745n 0.0v 309.755n 0.0v 314.745n 0.0v 314.755n 0.0v 319.745n 0.0v 319.755n 0.0v 324.745n 0.0v 324.755n 0.0v 329.745n 0.0v 329.755n 0.0v 334.745n 0.0v 334.755n 0.0v 339.745n 0.0v 339.755n 1.1v 344.745n 1.1v 344.755n 1.1v 349.745n 1.1v 349.755n 1.1v 354.745n 1.1v 354.755n 1.1v 359.745n 1.1v 359.755n 0.0v 364.745n 0.0v 364.755n 0.0v 369.745n 0.0v 369.755n 0.0v 374.745n 0.0v 374.755n 0.0v 379.745n 0.0v 379.755n 0.0v 384.745n 0.0v 384.755n 0.0v 389.745n 0.0v 389.755n 0.0v 394.745n 0.0v 394.755n 1.1v 399.745n 1.1v 399.755n 0.0v 404.745n 0.0v 404.755n 0.0v 409.745n 0.0v 409.755n 1.1v 414.745n 1.1v 414.755n 1.1v 419.745n 1.1v 419.755n 0.0v 424.745n 0.0v 424.755n 0.0v 429.745n 0.0v 429.755n 1.1v 434.745n 1.1v 434.755n 1.1v 439.745n 1.1v 439.755n 1.1v 444.745n 1.1v 444.755n 1.1v 449.745n 1.1v 449.755n 1.1v 454.745n 1.1v 454.755n 1.1v 459.745n 1.1v 459.755n 0.0v 464.745n 0.0v 464.755n 1.1v 469.745n 1.1v 469.755n 1.1v 474.745n 1.1v 474.755n 1.1v 479.745n 1.1v 479.755n 1.1v 484.745n 1.1v 484.755n 1.1v 489.745n 1.1v 489.755n 1.1v 494.745n 1.1v 494.755n 0.0v 499.745n 0.0v 499.755n 0.0v 504.745n 0.0v 504.755n 1.1v 509.745n 1.1v 509.755n 0.0v 514.745n 0.0v 514.755n 0.0v 519.745n 0.0v 519.755n 0.0v 524.745n 0.0v 524.755n 0.0v 529.745n 0.0v 529.755n 0.0v 534.745n 0.0v 534.755n 1.1v 539.745n 1.1v 539.755n 1.1v 544.745n 1.1v 544.755n 1.1v 549.745n 1.1v 549.755n 1.1v 554.745n 1.1v 554.755n 1.1v 559.745n 1.1v 559.755n 1.1v 564.745n 1.1v 564.755n 1.1v 569.745n 1.1v 569.755n 1.1v 574.745n 1.1v 574.755n 1.1v 579.745n 1.1v 579.755n 1.1v 584.745n 1.1v 584.755n 1.1v 589.745n 1.1v 589.755n 1.1v 594.745n 1.1v 594.755n 1.1v 599.745n 1.1v 599.755n 1.1v 604.745n 1.1v 604.755n 1.1v 609.745n 1.1v 609.755n 1.1v 614.745n 1.1v 614.755n 1.1v 619.745n 1.1v 619.755n 1.1v 624.745n 1.1v 624.755n 1.1v 629.745n 1.1v 629.755n 0.0v 634.745n 0.0v 634.755n 1.1v 639.745n 1.1v 639.755n 0.0v 644.745n 0.0v 644.755n 0.0v 649.745n 0.0v 649.755n 0.0v 654.745n 0.0v 654.755n 1.1v 659.745n 1.1v 659.755n 0.0v 664.745n 0.0v 664.755n 0.0v 669.745n 0.0v 669.755n 0.0v 674.745n 0.0v 674.755n 0.0v 679.745n 0.0v 679.755n 0.0v 684.745n 0.0v 684.755n 0.0v 689.745n 0.0v 689.755n 0.0v 694.745n 0.0v 694.755n 0.0v 699.745n 0.0v 699.755n 0.0v 704.745n 0.0v 704.755n 0.0v 709.745n 0.0v 709.755n 1.1v 714.745n 1.1v 714.755n 0.0v 719.745n 0.0v 719.755n 0.0v 724.745n 0.0v 724.755n 0.0v 729.745n 0.0v 729.755n 0.0v 734.745n 0.0v 734.755n 0.0v 739.745n 0.0v 739.755n 0.0v 744.745n 0.0v 744.755n 0.0v 749.745n 0.0v 749.755n 0.0v 754.745n 0.0v 754.755n 1.1v 759.745n 1.1v 759.755n 1.1v 764.745n 1.1v 764.755n 1.1v 769.745n 1.1v 769.755n 1.1v 774.745n 1.1v 774.755n 1.1v 779.745n 1.1v 779.755n 1.1v 784.745n 1.1v 784.755n 0.0v 789.745n 0.0v 789.755n 1.1v 794.745n 1.1v 794.755n 1.1v 799.745n 1.1v 799.755n 1.1v 804.745n 1.1v 804.755n 1.1v 809.745n 1.1v 809.755n 1.1v 814.745n 1.1v 814.755n 1.1v 819.745n 1.1v 819.755n 0.0v 824.745n 0.0v 824.755n 0.0v 829.745n 0.0v 829.755n 1.1v 834.745n 1.1v 834.755n 1.1v 839.745n 1.1v 839.755n 1.1v 844.745n 1.1v 844.755n 1.1v 849.745n 1.1v 849.755n 1.1v 854.745n 1.1v 854.755n 1.1v 859.745n 1.1v 859.755n 0.0v 864.745n 0.0v 864.755n 1.1v 869.745n 1.1v 869.755n 1.1v 874.745n 1.1v 874.755n 1.1v 879.745n 1.1v 879.755n 1.1v 884.745n 1.1v 884.755n 1.1v 889.745n 1.1v 889.755n 1.1v 894.745n 1.1v 894.755n 1.1v 899.745n 1.1v 899.755n 1.1v 904.745n 1.1v 904.755n 1.1v 909.745n 1.1v 909.755n 1.1v 914.745n 1.1v 914.755n 1.1v 919.745n 1.1v 919.755n 1.1v 924.745n 1.1v 924.755n 1.1v 929.745n 1.1v 929.755n 1.1v 934.745n 1.1v 934.755n 1.1v 939.745n 1.1v 939.755n 1.1v 944.745n 1.1v 944.755n 1.1v 949.745n 1.1v 949.755n 1.1v 954.745n 1.1v 954.755n 1.1v 959.745n 1.1v 959.755n 1.1v 964.745n 1.1v 964.755n 1.1v 969.745n 1.1v 969.755n 1.1v 974.745n 1.1v 974.755n 1.1v 979.745n 1.1v 979.755n 0.0v 984.745n 0.0v 984.755n 0.0v 989.745n 0.0v 989.755n 0.0v 994.745n 0.0v 994.755n 1.1v 999.745n 1.1v 999.755n 1.1v 1004.745n 1.1v 1004.755n 1.1v 1009.745n 1.1v 1009.755n 1.1v 1014.745n 1.1v 1014.755n 1.1v 1019.745n 1.1v 1019.755n 1.1v 1024.745n 1.1v 1024.755n 1.1v )
* (time, data): [(0, 0), (5, 0), (10, 0), (15, 1), (20, 1), (25, 1), (30, 0), (35, 0), (40, 0), (45, 1), (50, 1), (55, 1), (60, 0), (65, 0), (70, 0), (75, 0), (80, 0), (85, 0), (90, 1), (95, 1), (100, 1), (105, 1), (110, 1), (115, 1), (120, 1), (125, 1), (130, 1), (135, 0), (140, 0), (145, 0), (150, 0), (155, 0), (160, 0), (165, 0), (170, 0), (175, 0), (180, 0), (185, 1), (190, 1), (195, 1), (200, 0), (205, 0), (210, 1), (215, 1), (220, 0), (225, 0), (230, 1), (235, 1), (240, 0), (245, 0), (250, 0), (255, 1), (260, 1), (265, 0), (270, 0), (275, 0), (280, 1), (285, 1), (290, 1), (295, 1), (300, 0), (305, 0), (310, 0), (315, 1), (320, 1), (325, 1), (330, 0), (335, 1), (340, 1), (345, 1), (350, 1), (355, 1), (360, 0), (365, 0), (370, 0), (375, 0), (380, 0), (385, 0), (390, 0), (395, 1), (400, 0), (405, 0), (410, 1), (415, 0), (420, 1), (425, 1), (430, 0), (435, 0), (440, 0), (445, 0), (450, 1), (455, 1), (460, 1), (465, 0), (470, 1), (475, 1), (480, 0), (485, 0), (490, 0), (495, 1), (500, 1), (505, 1), (510, 1), (515, 1), (520, 1), (525, 1), (530, 1), (535, 0), (540, 0), (545, 0), (550, 0), (555, 0), (560, 0), (565, 0), (570, 0), (575, 1), (580, 1), (585, 1), (590, 1), (595, 1), (600, 1), (605, 1), (610, 1), (615, 1), (620, 1), (625, 1), (630, 0), (635, 0), (640, 1), (645, 1), (650, 1), (655, 0), (660, 1), (665, 1), (670, 1), (675, 1), (680, 1), (685, 1), (690, 1), (695, 1), (700, 1), (705, 0), (710, 0), (715, 0), (720, 0), (725, 0), (730, 0), (735, 0), (740, 0), (745, 0), (750, 0), (755, 1), (760, 1), (765, 1), (770, 1), (775, 0), (780, 0), (785, 1), (790, 0), (795, 0), (800, 0), (805, 0), (810, 0), (815, 0), (820, 1), (825, 1), (830, 0), (835, 0), (840, 0), (845, 0), (850, 0), (855, 1), (860, 1), (865, 1), (870, 1), (875, 1), (880, 1), (885, 1), (890, 1), (895, 1), (900, 1), (905, 1), (910, 0), (915, 0), (920, 0), (925, 0), (930, 1), (935, 0), (940, 1), (945, 1), (950, 1), (955, 0), (960, 0), (965, 0), (970, 0), (975, 0), (980, 1), (985, 1), (990, 1), (995, 1), (1000, 0), (1005, 0), (1010, 0), (1015, 0), (1020, 0), (1025, 0)]
Vdin0_54  din0_54  0 PWL (0n 0.0v 4.745n 0.0v 4.755n 0.0v 9.745n 0.0v 9.755n 0.0v 14.745n 0.0v 14.755n 1.1v 19.745n 1.1v 19.755n 1.1v 24.745n 1.1v 24.755n 1.1v 29.745n 1.1v 29.755n 0.0v 34.745n 0.0v 34.755n 0.0v 39.745n 0.0v 39.755n 0.0v 44.745n 0.0v 44.755n 1.1v 49.745n 1.1v 49.755n 1.1v 54.745n 1.1v 54.755n 1.1v 59.745n 1.1v 59.755n 0.0v 64.745n 0.0v 64.755n 0.0v 69.745n 0.0v 69.755n 0.0v 74.745n 0.0v 74.755n 0.0v 79.745n 0.0v 79.755n 0.0v 84.745n 0.0v 84.755n 0.0v 89.745n 0.0v 89.755n 1.1v 94.745n 1.1v 94.755n 1.1v 99.745n 1.1v 99.755n 1.1v 104.745n 1.1v 104.755n 1.1v 109.745n 1.1v 109.755n 1.1v 114.745n 1.1v 114.755n 1.1v 119.745n 1.1v 119.755n 1.1v 124.745n 1.1v 124.755n 1.1v 129.745n 1.1v 129.755n 1.1v 134.745n 1.1v 134.755n 0.0v 139.745n 0.0v 139.755n 0.0v 144.745n 0.0v 144.755n 0.0v 149.745n 0.0v 149.755n 0.0v 154.745n 0.0v 154.755n 0.0v 159.745n 0.0v 159.755n 0.0v 164.745n 0.0v 164.755n 0.0v 169.745n 0.0v 169.755n 0.0v 174.745n 0.0v 174.755n 0.0v 179.745n 0.0v 179.755n 0.0v 184.745n 0.0v 184.755n 1.1v 189.745n 1.1v 189.755n 1.1v 194.745n 1.1v 194.755n 1.1v 199.745n 1.1v 199.755n 0.0v 204.745n 0.0v 204.755n 0.0v 209.745n 0.0v 209.755n 1.1v 214.745n 1.1v 214.755n 1.1v 219.745n 1.1v 219.755n 0.0v 224.745n 0.0v 224.755n 0.0v 229.745n 0.0v 229.755n 1.1v 234.745n 1.1v 234.755n 1.1v 239.745n 1.1v 239.755n 0.0v 244.745n 0.0v 244.755n 0.0v 249.745n 0.0v 249.755n 0.0v 254.745n 0.0v 254.755n 1.1v 259.745n 1.1v 259.755n 1.1v 264.745n 1.1v 264.755n 0.0v 269.745n 0.0v 269.755n 0.0v 274.745n 0.0v 274.755n 0.0v 279.745n 0.0v 279.755n 1.1v 284.745n 1.1v 284.755n 1.1v 289.745n 1.1v 289.755n 1.1v 294.745n 1.1v 294.755n 1.1v 299.745n 1.1v 299.755n 0.0v 304.745n 0.0v 304.755n 0.0v 309.745n 0.0v 309.755n 0.0v 314.745n 0.0v 314.755n 1.1v 319.745n 1.1v 319.755n 1.1v 324.745n 1.1v 324.755n 1.1v 329.745n 1.1v 329.755n 0.0v 334.745n 0.0v 334.755n 1.1v 339.745n 1.1v 339.755n 1.1v 344.745n 1.1v 344.755n 1.1v 349.745n 1.1v 349.755n 1.1v 354.745n 1.1v 354.755n 1.1v 359.745n 1.1v 359.755n 0.0v 364.745n 0.0v 364.755n 0.0v 369.745n 0.0v 369.755n 0.0v 374.745n 0.0v 374.755n 0.0v 379.745n 0.0v 379.755n 0.0v 384.745n 0.0v 384.755n 0.0v 389.745n 0.0v 389.755n 0.0v 394.745n 0.0v 394.755n 1.1v 399.745n 1.1v 399.755n 0.0v 404.745n 0.0v 404.755n 0.0v 409.745n 0.0v 409.755n 1.1v 414.745n 1.1v 414.755n 0.0v 419.745n 0.0v 419.755n 1.1v 424.745n 1.1v 424.755n 1.1v 429.745n 1.1v 429.755n 0.0v 434.745n 0.0v 434.755n 0.0v 439.745n 0.0v 439.755n 0.0v 444.745n 0.0v 444.755n 0.0v 449.745n 0.0v 449.755n 1.1v 454.745n 1.1v 454.755n 1.1v 459.745n 1.1v 459.755n 1.1v 464.745n 1.1v 464.755n 0.0v 469.745n 0.0v 469.755n 1.1v 474.745n 1.1v 474.755n 1.1v 479.745n 1.1v 479.755n 0.0v 484.745n 0.0v 484.755n 0.0v 489.745n 0.0v 489.755n 0.0v 494.745n 0.0v 494.755n 1.1v 499.745n 1.1v 499.755n 1.1v 504.745n 1.1v 504.755n 1.1v 509.745n 1.1v 509.755n 1.1v 514.745n 1.1v 514.755n 1.1v 519.745n 1.1v 519.755n 1.1v 524.745n 1.1v 524.755n 1.1v 529.745n 1.1v 529.755n 1.1v 534.745n 1.1v 534.755n 0.0v 539.745n 0.0v 539.755n 0.0v 544.745n 0.0v 544.755n 0.0v 549.745n 0.0v 549.755n 0.0v 554.745n 0.0v 554.755n 0.0v 559.745n 0.0v 559.755n 0.0v 564.745n 0.0v 564.755n 0.0v 569.745n 0.0v 569.755n 0.0v 574.745n 0.0v 574.755n 1.1v 579.745n 1.1v 579.755n 1.1v 584.745n 1.1v 584.755n 1.1v 589.745n 1.1v 589.755n 1.1v 594.745n 1.1v 594.755n 1.1v 599.745n 1.1v 599.755n 1.1v 604.745n 1.1v 604.755n 1.1v 609.745n 1.1v 609.755n 1.1v 614.745n 1.1v 614.755n 1.1v 619.745n 1.1v 619.755n 1.1v 624.745n 1.1v 624.755n 1.1v 629.745n 1.1v 629.755n 0.0v 634.745n 0.0v 634.755n 0.0v 639.745n 0.0v 639.755n 1.1v 644.745n 1.1v 644.755n 1.1v 649.745n 1.1v 649.755n 1.1v 654.745n 1.1v 654.755n 0.0v 659.745n 0.0v 659.755n 1.1v 664.745n 1.1v 664.755n 1.1v 669.745n 1.1v 669.755n 1.1v 674.745n 1.1v 674.755n 1.1v 679.745n 1.1v 679.755n 1.1v 684.745n 1.1v 684.755n 1.1v 689.745n 1.1v 689.755n 1.1v 694.745n 1.1v 694.755n 1.1v 699.745n 1.1v 699.755n 1.1v 704.745n 1.1v 704.755n 0.0v 709.745n 0.0v 709.755n 0.0v 714.745n 0.0v 714.755n 0.0v 719.745n 0.0v 719.755n 0.0v 724.745n 0.0v 724.755n 0.0v 729.745n 0.0v 729.755n 0.0v 734.745n 0.0v 734.755n 0.0v 739.745n 0.0v 739.755n 0.0v 744.745n 0.0v 744.755n 0.0v 749.745n 0.0v 749.755n 0.0v 754.745n 0.0v 754.755n 1.1v 759.745n 1.1v 759.755n 1.1v 764.745n 1.1v 764.755n 1.1v 769.745n 1.1v 769.755n 1.1v 774.745n 1.1v 774.755n 0.0v 779.745n 0.0v 779.755n 0.0v 784.745n 0.0v 784.755n 1.1v 789.745n 1.1v 789.755n 0.0v 794.745n 0.0v 794.755n 0.0v 799.745n 0.0v 799.755n 0.0v 804.745n 0.0v 804.755n 0.0v 809.745n 0.0v 809.755n 0.0v 814.745n 0.0v 814.755n 0.0v 819.745n 0.0v 819.755n 1.1v 824.745n 1.1v 824.755n 1.1v 829.745n 1.1v 829.755n 0.0v 834.745n 0.0v 834.755n 0.0v 839.745n 0.0v 839.755n 0.0v 844.745n 0.0v 844.755n 0.0v 849.745n 0.0v 849.755n 0.0v 854.745n 0.0v 854.755n 1.1v 859.745n 1.1v 859.755n 1.1v 864.745n 1.1v 864.755n 1.1v 869.745n 1.1v 869.755n 1.1v 874.745n 1.1v 874.755n 1.1v 879.745n 1.1v 879.755n 1.1v 884.745n 1.1v 884.755n 1.1v 889.745n 1.1v 889.755n 1.1v 894.745n 1.1v 894.755n 1.1v 899.745n 1.1v 899.755n 1.1v 904.745n 1.1v 904.755n 1.1v 909.745n 1.1v 909.755n 0.0v 914.745n 0.0v 914.755n 0.0v 919.745n 0.0v 919.755n 0.0v 924.745n 0.0v 924.755n 0.0v 929.745n 0.0v 929.755n 1.1v 934.745n 1.1v 934.755n 0.0v 939.745n 0.0v 939.755n 1.1v 944.745n 1.1v 944.755n 1.1v 949.745n 1.1v 949.755n 1.1v 954.745n 1.1v 954.755n 0.0v 959.745n 0.0v 959.755n 0.0v 964.745n 0.0v 964.755n 0.0v 969.745n 0.0v 969.755n 0.0v 974.745n 0.0v 974.755n 0.0v 979.745n 0.0v 979.755n 1.1v 984.745n 1.1v 984.755n 1.1v 989.745n 1.1v 989.755n 1.1v 994.745n 1.1v 994.755n 1.1v 999.745n 1.1v 999.755n 0.0v 1004.745n 0.0v 1004.755n 0.0v 1009.745n 0.0v 1009.755n 0.0v 1014.745n 0.0v 1014.755n 0.0v 1019.745n 0.0v 1019.755n 0.0v 1024.745n 0.0v 1024.755n 0.0v )
* (time, data): [(0, 0), (5, 0), (10, 1), (15, 0), (20, 0), (25, 0), (30, 0), (35, 0), (40, 0), (45, 1), (50, 1), (55, 1), (60, 1), (65, 1), (70, 1), (75, 1), (80, 1), (85, 1), (90, 0), (95, 0), (100, 1), (105, 1), (110, 1), (115, 1), (120, 1), (125, 1), (130, 1), (135, 0), (140, 0), (145, 0), (150, 0), (155, 0), (160, 0), (165, 0), (170, 1), (175, 1), (180, 1), (185, 1), (190, 1), (195, 1), (200, 1), (205, 1), (210, 0), (215, 0), (220, 0), (225, 0), (230, 1), (235, 1), (240, 0), (245, 0), (250, 0), (255, 0), (260, 0), (265, 1), (270, 1), (275, 1), (280, 0), (285, 0), (290, 0), (295, 0), (300, 0), (305, 0), (310, 0), (315, 1), (320, 1), (325, 1), (330, 0), (335, 0), (340, 0), (345, 0), (350, 0), (355, 0), (360, 1), (365, 1), (370, 1), (375, 1), (380, 1), (385, 1), (390, 1), (395, 1), (400, 0), (405, 0), (410, 1), (415, 0), (420, 0), (425, 1), (430, 1), (435, 1), (440, 1), (445, 1), (450, 0), (455, 0), (460, 0), (465, 1), (470, 1), (475, 1), (480, 0), (485, 0), (490, 0), (495, 0), (500, 0), (505, 1), (510, 0), (515, 1), (520, 1), (525, 1), (530, 1), (535, 0), (540, 0), (545, 0), (550, 0), (555, 0), (560, 0), (565, 0), (570, 0), (575, 1), (580, 1), (585, 1), (590, 1), (595, 1), (600, 1), (605, 1), (610, 1), (615, 1), (620, 1), (625, 1), (630, 1), (635, 1), (640, 1), (645, 1), (650, 1), (655, 1), (660, 1), (665, 1), (670, 1), (675, 1), (680, 1), (685, 1), (690, 1), (695, 1), (700, 1), (705, 0), (710, 1), (715, 0), (720, 0), (725, 0), (730, 0), (735, 1), (740, 1), (745, 1), (750, 1), (755, 0), (760, 0), (765, 0), (770, 1), (775, 0), (780, 0), (785, 1), (790, 1), (795, 1), (800, 1), (805, 1), (810, 1), (815, 1), (820, 1), (825, 1), (830, 1), (835, 0), (840, 0), (845, 0), (850, 0), (855, 1), (860, 0), (865, 0), (870, 0), (875, 1), (880, 0), (885, 1), (890, 1), (895, 1), (900, 1), (905, 1), (910, 1), (915, 1), (920, 1), (925, 1), (930, 1), (935, 1), (940, 1), (945, 1), (950, 1), (955, 0), (960, 0), (965, 1), (970, 1), (975, 1), (980, 1), (985, 1), (990, 1), (995, 0), (1000, 0), (1005, 0), (1010, 0), (1015, 0), (1020, 1), (1025, 1)]
Vdin0_55  din0_55  0 PWL (0n 0.0v 4.745n 0.0v 4.755n 0.0v 9.745n 0.0v 9.755n 1.1v 14.745n 1.1v 14.755n 0.0v 19.745n 0.0v 19.755n 0.0v 24.745n 0.0v 24.755n 0.0v 29.745n 0.0v 29.755n 0.0v 34.745n 0.0v 34.755n 0.0v 39.745n 0.0v 39.755n 0.0v 44.745n 0.0v 44.755n 1.1v 49.745n 1.1v 49.755n 1.1v 54.745n 1.1v 54.755n 1.1v 59.745n 1.1v 59.755n 1.1v 64.745n 1.1v 64.755n 1.1v 69.745n 1.1v 69.755n 1.1v 74.745n 1.1v 74.755n 1.1v 79.745n 1.1v 79.755n 1.1v 84.745n 1.1v 84.755n 1.1v 89.745n 1.1v 89.755n 0.0v 94.745n 0.0v 94.755n 0.0v 99.745n 0.0v 99.755n 1.1v 104.745n 1.1v 104.755n 1.1v 109.745n 1.1v 109.755n 1.1v 114.745n 1.1v 114.755n 1.1v 119.745n 1.1v 119.755n 1.1v 124.745n 1.1v 124.755n 1.1v 129.745n 1.1v 129.755n 1.1v 134.745n 1.1v 134.755n 0.0v 139.745n 0.0v 139.755n 0.0v 144.745n 0.0v 144.755n 0.0v 149.745n 0.0v 149.755n 0.0v 154.745n 0.0v 154.755n 0.0v 159.745n 0.0v 159.755n 0.0v 164.745n 0.0v 164.755n 0.0v 169.745n 0.0v 169.755n 1.1v 174.745n 1.1v 174.755n 1.1v 179.745n 1.1v 179.755n 1.1v 184.745n 1.1v 184.755n 1.1v 189.745n 1.1v 189.755n 1.1v 194.745n 1.1v 194.755n 1.1v 199.745n 1.1v 199.755n 1.1v 204.745n 1.1v 204.755n 1.1v 209.745n 1.1v 209.755n 0.0v 214.745n 0.0v 214.755n 0.0v 219.745n 0.0v 219.755n 0.0v 224.745n 0.0v 224.755n 0.0v 229.745n 0.0v 229.755n 1.1v 234.745n 1.1v 234.755n 1.1v 239.745n 1.1v 239.755n 0.0v 244.745n 0.0v 244.755n 0.0v 249.745n 0.0v 249.755n 0.0v 254.745n 0.0v 254.755n 0.0v 259.745n 0.0v 259.755n 0.0v 264.745n 0.0v 264.755n 1.1v 269.745n 1.1v 269.755n 1.1v 274.745n 1.1v 274.755n 1.1v 279.745n 1.1v 279.755n 0.0v 284.745n 0.0v 284.755n 0.0v 289.745n 0.0v 289.755n 0.0v 294.745n 0.0v 294.755n 0.0v 299.745n 0.0v 299.755n 0.0v 304.745n 0.0v 304.755n 0.0v 309.745n 0.0v 309.755n 0.0v 314.745n 0.0v 314.755n 1.1v 319.745n 1.1v 319.755n 1.1v 324.745n 1.1v 324.755n 1.1v 329.745n 1.1v 329.755n 0.0v 334.745n 0.0v 334.755n 0.0v 339.745n 0.0v 339.755n 0.0v 344.745n 0.0v 344.755n 0.0v 349.745n 0.0v 349.755n 0.0v 354.745n 0.0v 354.755n 0.0v 359.745n 0.0v 359.755n 1.1v 364.745n 1.1v 364.755n 1.1v 369.745n 1.1v 369.755n 1.1v 374.745n 1.1v 374.755n 1.1v 379.745n 1.1v 379.755n 1.1v 384.745n 1.1v 384.755n 1.1v 389.745n 1.1v 389.755n 1.1v 394.745n 1.1v 394.755n 1.1v 399.745n 1.1v 399.755n 0.0v 404.745n 0.0v 404.755n 0.0v 409.745n 0.0v 409.755n 1.1v 414.745n 1.1v 414.755n 0.0v 419.745n 0.0v 419.755n 0.0v 424.745n 0.0v 424.755n 1.1v 429.745n 1.1v 429.755n 1.1v 434.745n 1.1v 434.755n 1.1v 439.745n 1.1v 439.755n 1.1v 444.745n 1.1v 444.755n 1.1v 449.745n 1.1v 449.755n 0.0v 454.745n 0.0v 454.755n 0.0v 459.745n 0.0v 459.755n 0.0v 464.745n 0.0v 464.755n 1.1v 469.745n 1.1v 469.755n 1.1v 474.745n 1.1v 474.755n 1.1v 479.745n 1.1v 479.755n 0.0v 484.745n 0.0v 484.755n 0.0v 489.745n 0.0v 489.755n 0.0v 494.745n 0.0v 494.755n 0.0v 499.745n 0.0v 499.755n 0.0v 504.745n 0.0v 504.755n 1.1v 509.745n 1.1v 509.755n 0.0v 514.745n 0.0v 514.755n 1.1v 519.745n 1.1v 519.755n 1.1v 524.745n 1.1v 524.755n 1.1v 529.745n 1.1v 529.755n 1.1v 534.745n 1.1v 534.755n 0.0v 539.745n 0.0v 539.755n 0.0v 544.745n 0.0v 544.755n 0.0v 549.745n 0.0v 549.755n 0.0v 554.745n 0.0v 554.755n 0.0v 559.745n 0.0v 559.755n 0.0v 564.745n 0.0v 564.755n 0.0v 569.745n 0.0v 569.755n 0.0v 574.745n 0.0v 574.755n 1.1v 579.745n 1.1v 579.755n 1.1v 584.745n 1.1v 584.755n 1.1v 589.745n 1.1v 589.755n 1.1v 594.745n 1.1v 594.755n 1.1v 599.745n 1.1v 599.755n 1.1v 604.745n 1.1v 604.755n 1.1v 609.745n 1.1v 609.755n 1.1v 614.745n 1.1v 614.755n 1.1v 619.745n 1.1v 619.755n 1.1v 624.745n 1.1v 624.755n 1.1v 629.745n 1.1v 629.755n 1.1v 634.745n 1.1v 634.755n 1.1v 639.745n 1.1v 639.755n 1.1v 644.745n 1.1v 644.755n 1.1v 649.745n 1.1v 649.755n 1.1v 654.745n 1.1v 654.755n 1.1v 659.745n 1.1v 659.755n 1.1v 664.745n 1.1v 664.755n 1.1v 669.745n 1.1v 669.755n 1.1v 674.745n 1.1v 674.755n 1.1v 679.745n 1.1v 679.755n 1.1v 684.745n 1.1v 684.755n 1.1v 689.745n 1.1v 689.755n 1.1v 694.745n 1.1v 694.755n 1.1v 699.745n 1.1v 699.755n 1.1v 704.745n 1.1v 704.755n 0.0v 709.745n 0.0v 709.755n 1.1v 714.745n 1.1v 714.755n 0.0v 719.745n 0.0v 719.755n 0.0v 724.745n 0.0v 724.755n 0.0v 729.745n 0.0v 729.755n 0.0v 734.745n 0.0v 734.755n 1.1v 739.745n 1.1v 739.755n 1.1v 744.745n 1.1v 744.755n 1.1v 749.745n 1.1v 749.755n 1.1v 754.745n 1.1v 754.755n 0.0v 759.745n 0.0v 759.755n 0.0v 764.745n 0.0v 764.755n 0.0v 769.745n 0.0v 769.755n 1.1v 774.745n 1.1v 774.755n 0.0v 779.745n 0.0v 779.755n 0.0v 784.745n 0.0v 784.755n 1.1v 789.745n 1.1v 789.755n 1.1v 794.745n 1.1v 794.755n 1.1v 799.745n 1.1v 799.755n 1.1v 804.745n 1.1v 804.755n 1.1v 809.745n 1.1v 809.755n 1.1v 814.745n 1.1v 814.755n 1.1v 819.745n 1.1v 819.755n 1.1v 824.745n 1.1v 824.755n 1.1v 829.745n 1.1v 829.755n 1.1v 834.745n 1.1v 834.755n 0.0v 839.745n 0.0v 839.755n 0.0v 844.745n 0.0v 844.755n 0.0v 849.745n 0.0v 849.755n 0.0v 854.745n 0.0v 854.755n 1.1v 859.745n 1.1v 859.755n 0.0v 864.745n 0.0v 864.755n 0.0v 869.745n 0.0v 869.755n 0.0v 874.745n 0.0v 874.755n 1.1v 879.745n 1.1v 879.755n 0.0v 884.745n 0.0v 884.755n 1.1v 889.745n 1.1v 889.755n 1.1v 894.745n 1.1v 894.755n 1.1v 899.745n 1.1v 899.755n 1.1v 904.745n 1.1v 904.755n 1.1v 909.745n 1.1v 909.755n 1.1v 914.745n 1.1v 914.755n 1.1v 919.745n 1.1v 919.755n 1.1v 924.745n 1.1v 924.755n 1.1v 929.745n 1.1v 929.755n 1.1v 934.745n 1.1v 934.755n 1.1v 939.745n 1.1v 939.755n 1.1v 944.745n 1.1v 944.755n 1.1v 949.745n 1.1v 949.755n 1.1v 954.745n 1.1v 954.755n 0.0v 959.745n 0.0v 959.755n 0.0v 964.745n 0.0v 964.755n 1.1v 969.745n 1.1v 969.755n 1.1v 974.745n 1.1v 974.755n 1.1v 979.745n 1.1v 979.755n 1.1v 984.745n 1.1v 984.755n 1.1v 989.745n 1.1v 989.755n 1.1v 994.745n 1.1v 994.755n 0.0v 999.745n 0.0v 999.755n 0.0v 1004.745n 0.0v 1004.755n 0.0v 1009.745n 0.0v 1009.755n 0.0v 1014.745n 0.0v 1014.755n 0.0v 1019.745n 0.0v 1019.755n 1.1v 1024.745n 1.1v 1024.755n 1.1v )
* (time, data): [(0, 0), (5, 0), (10, 1), (15, 1), (20, 1), (25, 1), (30, 0), (35, 0), (40, 1), (45, 0), (50, 0), (55, 0), (60, 1), (65, 0), (70, 0), (75, 0), (80, 0), (85, 0), (90, 0), (95, 0), (100, 1), (105, 1), (110, 1), (115, 1), (120, 1), (125, 1), (130, 1), (135, 1), (140, 1), (145, 1), (150, 1), (155, 1), (160, 1), (165, 1), (170, 1), (175, 1), (180, 1), (185, 1), (190, 1), (195, 1), (200, 1), (205, 1), (210, 1), (215, 1), (220, 0), (225, 0), (230, 0), (235, 0), (240, 1), (245, 1), (250, 1), (255, 1), (260, 1), (265, 1), (270, 1), (275, 1), (280, 1), (285, 1), (290, 1), (295, 1), (300, 1), (305, 1), (310, 1), (315, 1), (320, 1), (325, 1), (330, 1), (335, 0), (340, 1), (345, 1), (350, 1), (355, 1), (360, 1), (365, 1), (370, 1), (375, 1), (380, 1), (385, 1), (390, 1), (395, 0), (400, 0), (405, 0), (410, 1), (415, 0), (420, 0), (425, 0), (430, 0), (435, 0), (440, 0), (445, 0), (450, 0), (455, 0), (460, 1), (465, 1), (470, 1), (475, 1), (480, 1), (485, 1), (490, 1), (495, 0), (500, 1), (505, 1), (510, 1), (515, 0), (520, 0), (525, 0), (530, 0), (535, 0), (540, 0), (545, 0), (550, 0), (555, 0), (560, 0), (565, 0), (570, 0), (575, 0), (580, 0), (585, 0), (590, 0), (595, 0), (600, 0), (605, 0), (610, 0), (615, 0), (620, 0), (625, 0), (630, 0), (635, 0), (640, 1), (645, 1), (650, 1), (655, 0), (660, 1), (665, 1), (670, 1), (675, 1), (680, 1), (685, 1), (690, 1), (695, 1), (700, 1), (705, 1), (710, 0), (715, 1), (720, 1), (725, 1), (730, 1), (735, 0), (740, 1), (745, 1), (750, 1), (755, 0), (760, 0), (765, 0), (770, 1), (775, 0), (780, 0), (785, 1), (790, 0), (795, 0), (800, 0), (805, 0), (810, 0), (815, 0), (820, 0), (825, 0), (830, 1), (835, 0), (840, 0), (845, 0), (850, 0), (855, 0), (860, 0), (865, 0), (870, 1), (875, 0), (880, 0), (885, 0), (890, 0), (895, 0), (900, 0), (905, 0), (910, 0), (915, 0), (920, 0), (925, 0), (930, 0), (935, 1), (940, 1), (945, 1), (950, 1), (955, 1), (960, 1), (965, 1), (970, 1), (975, 1), (980, 1), (985, 0), (990, 0), (995, 0), (1000, 0), (1005, 0), (1010, 0), (1015, 0), (1020, 1), (1025, 1)]
Vdin0_56  din0_56  0 PWL (0n 0.0v 4.745n 0.0v 4.755n 0.0v 9.745n 0.0v 9.755n 1.1v 14.745n 1.1v 14.755n 1.1v 19.745n 1.1v 19.755n 1.1v 24.745n 1.1v 24.755n 1.1v 29.745n 1.1v 29.755n 0.0v 34.745n 0.0v 34.755n 0.0v 39.745n 0.0v 39.755n 1.1v 44.745n 1.1v 44.755n 0.0v 49.745n 0.0v 49.755n 0.0v 54.745n 0.0v 54.755n 0.0v 59.745n 0.0v 59.755n 1.1v 64.745n 1.1v 64.755n 0.0v 69.745n 0.0v 69.755n 0.0v 74.745n 0.0v 74.755n 0.0v 79.745n 0.0v 79.755n 0.0v 84.745n 0.0v 84.755n 0.0v 89.745n 0.0v 89.755n 0.0v 94.745n 0.0v 94.755n 0.0v 99.745n 0.0v 99.755n 1.1v 104.745n 1.1v 104.755n 1.1v 109.745n 1.1v 109.755n 1.1v 114.745n 1.1v 114.755n 1.1v 119.745n 1.1v 119.755n 1.1v 124.745n 1.1v 124.755n 1.1v 129.745n 1.1v 129.755n 1.1v 134.745n 1.1v 134.755n 1.1v 139.745n 1.1v 139.755n 1.1v 144.745n 1.1v 144.755n 1.1v 149.745n 1.1v 149.755n 1.1v 154.745n 1.1v 154.755n 1.1v 159.745n 1.1v 159.755n 1.1v 164.745n 1.1v 164.755n 1.1v 169.745n 1.1v 169.755n 1.1v 174.745n 1.1v 174.755n 1.1v 179.745n 1.1v 179.755n 1.1v 184.745n 1.1v 184.755n 1.1v 189.745n 1.1v 189.755n 1.1v 194.745n 1.1v 194.755n 1.1v 199.745n 1.1v 199.755n 1.1v 204.745n 1.1v 204.755n 1.1v 209.745n 1.1v 209.755n 1.1v 214.745n 1.1v 214.755n 1.1v 219.745n 1.1v 219.755n 0.0v 224.745n 0.0v 224.755n 0.0v 229.745n 0.0v 229.755n 0.0v 234.745n 0.0v 234.755n 0.0v 239.745n 0.0v 239.755n 1.1v 244.745n 1.1v 244.755n 1.1v 249.745n 1.1v 249.755n 1.1v 254.745n 1.1v 254.755n 1.1v 259.745n 1.1v 259.755n 1.1v 264.745n 1.1v 264.755n 1.1v 269.745n 1.1v 269.755n 1.1v 274.745n 1.1v 274.755n 1.1v 279.745n 1.1v 279.755n 1.1v 284.745n 1.1v 284.755n 1.1v 289.745n 1.1v 289.755n 1.1v 294.745n 1.1v 294.755n 1.1v 299.745n 1.1v 299.755n 1.1v 304.745n 1.1v 304.755n 1.1v 309.745n 1.1v 309.755n 1.1v 314.745n 1.1v 314.755n 1.1v 319.745n 1.1v 319.755n 1.1v 324.745n 1.1v 324.755n 1.1v 329.745n 1.1v 329.755n 1.1v 334.745n 1.1v 334.755n 0.0v 339.745n 0.0v 339.755n 1.1v 344.745n 1.1v 344.755n 1.1v 349.745n 1.1v 349.755n 1.1v 354.745n 1.1v 354.755n 1.1v 359.745n 1.1v 359.755n 1.1v 364.745n 1.1v 364.755n 1.1v 369.745n 1.1v 369.755n 1.1v 374.745n 1.1v 374.755n 1.1v 379.745n 1.1v 379.755n 1.1v 384.745n 1.1v 384.755n 1.1v 389.745n 1.1v 389.755n 1.1v 394.745n 1.1v 394.755n 0.0v 399.745n 0.0v 399.755n 0.0v 404.745n 0.0v 404.755n 0.0v 409.745n 0.0v 409.755n 1.1v 414.745n 1.1v 414.755n 0.0v 419.745n 0.0v 419.755n 0.0v 424.745n 0.0v 424.755n 0.0v 429.745n 0.0v 429.755n 0.0v 434.745n 0.0v 434.755n 0.0v 439.745n 0.0v 439.755n 0.0v 444.745n 0.0v 444.755n 0.0v 449.745n 0.0v 449.755n 0.0v 454.745n 0.0v 454.755n 0.0v 459.745n 0.0v 459.755n 1.1v 464.745n 1.1v 464.755n 1.1v 469.745n 1.1v 469.755n 1.1v 474.745n 1.1v 474.755n 1.1v 479.745n 1.1v 479.755n 1.1v 484.745n 1.1v 484.755n 1.1v 489.745n 1.1v 489.755n 1.1v 494.745n 1.1v 494.755n 0.0v 499.745n 0.0v 499.755n 1.1v 504.745n 1.1v 504.755n 1.1v 509.745n 1.1v 509.755n 1.1v 514.745n 1.1v 514.755n 0.0v 519.745n 0.0v 519.755n 0.0v 524.745n 0.0v 524.755n 0.0v 529.745n 0.0v 529.755n 0.0v 534.745n 0.0v 534.755n 0.0v 539.745n 0.0v 539.755n 0.0v 544.745n 0.0v 544.755n 0.0v 549.745n 0.0v 549.755n 0.0v 554.745n 0.0v 554.755n 0.0v 559.745n 0.0v 559.755n 0.0v 564.745n 0.0v 564.755n 0.0v 569.745n 0.0v 569.755n 0.0v 574.745n 0.0v 574.755n 0.0v 579.745n 0.0v 579.755n 0.0v 584.745n 0.0v 584.755n 0.0v 589.745n 0.0v 589.755n 0.0v 594.745n 0.0v 594.755n 0.0v 599.745n 0.0v 599.755n 0.0v 604.745n 0.0v 604.755n 0.0v 609.745n 0.0v 609.755n 0.0v 614.745n 0.0v 614.755n 0.0v 619.745n 0.0v 619.755n 0.0v 624.745n 0.0v 624.755n 0.0v 629.745n 0.0v 629.755n 0.0v 634.745n 0.0v 634.755n 0.0v 639.745n 0.0v 639.755n 1.1v 644.745n 1.1v 644.755n 1.1v 649.745n 1.1v 649.755n 1.1v 654.745n 1.1v 654.755n 0.0v 659.745n 0.0v 659.755n 1.1v 664.745n 1.1v 664.755n 1.1v 669.745n 1.1v 669.755n 1.1v 674.745n 1.1v 674.755n 1.1v 679.745n 1.1v 679.755n 1.1v 684.745n 1.1v 684.755n 1.1v 689.745n 1.1v 689.755n 1.1v 694.745n 1.1v 694.755n 1.1v 699.745n 1.1v 699.755n 1.1v 704.745n 1.1v 704.755n 1.1v 709.745n 1.1v 709.755n 0.0v 714.745n 0.0v 714.755n 1.1v 719.745n 1.1v 719.755n 1.1v 724.745n 1.1v 724.755n 1.1v 729.745n 1.1v 729.755n 1.1v 734.745n 1.1v 734.755n 0.0v 739.745n 0.0v 739.755n 1.1v 744.745n 1.1v 744.755n 1.1v 749.745n 1.1v 749.755n 1.1v 754.745n 1.1v 754.755n 0.0v 759.745n 0.0v 759.755n 0.0v 764.745n 0.0v 764.755n 0.0v 769.745n 0.0v 769.755n 1.1v 774.745n 1.1v 774.755n 0.0v 779.745n 0.0v 779.755n 0.0v 784.745n 0.0v 784.755n 1.1v 789.745n 1.1v 789.755n 0.0v 794.745n 0.0v 794.755n 0.0v 799.745n 0.0v 799.755n 0.0v 804.745n 0.0v 804.755n 0.0v 809.745n 0.0v 809.755n 0.0v 814.745n 0.0v 814.755n 0.0v 819.745n 0.0v 819.755n 0.0v 824.745n 0.0v 824.755n 0.0v 829.745n 0.0v 829.755n 1.1v 834.745n 1.1v 834.755n 0.0v 839.745n 0.0v 839.755n 0.0v 844.745n 0.0v 844.755n 0.0v 849.745n 0.0v 849.755n 0.0v 854.745n 0.0v 854.755n 0.0v 859.745n 0.0v 859.755n 0.0v 864.745n 0.0v 864.755n 0.0v 869.745n 0.0v 869.755n 1.1v 874.745n 1.1v 874.755n 0.0v 879.745n 0.0v 879.755n 0.0v 884.745n 0.0v 884.755n 0.0v 889.745n 0.0v 889.755n 0.0v 894.745n 0.0v 894.755n 0.0v 899.745n 0.0v 899.755n 0.0v 904.745n 0.0v 904.755n 0.0v 909.745n 0.0v 909.755n 0.0v 914.745n 0.0v 914.755n 0.0v 919.745n 0.0v 919.755n 0.0v 924.745n 0.0v 924.755n 0.0v 929.745n 0.0v 929.755n 0.0v 934.745n 0.0v 934.755n 1.1v 939.745n 1.1v 939.755n 1.1v 944.745n 1.1v 944.755n 1.1v 949.745n 1.1v 949.755n 1.1v 954.745n 1.1v 954.755n 1.1v 959.745n 1.1v 959.755n 1.1v 964.745n 1.1v 964.755n 1.1v 969.745n 1.1v 969.755n 1.1v 974.745n 1.1v 974.755n 1.1v 979.745n 1.1v 979.755n 1.1v 984.745n 1.1v 984.755n 0.0v 989.745n 0.0v 989.755n 0.0v 994.745n 0.0v 994.755n 0.0v 999.745n 0.0v 999.755n 0.0v 1004.745n 0.0v 1004.755n 0.0v 1009.745n 0.0v 1009.755n 0.0v 1014.745n 0.0v 1014.755n 0.0v 1019.745n 0.0v 1019.755n 1.1v 1024.745n 1.1v 1024.755n 1.1v )
* (time, data): [(0, 0), (5, 0), (10, 0), (15, 1), (20, 1), (25, 1), (30, 0), (35, 0), (40, 0), (45, 1), (50, 1), (55, 1), (60, 1), (65, 1), (70, 1), (75, 1), (80, 1), (85, 1), (90, 1), (95, 1), (100, 1), (105, 1), (110, 1), (115, 1), (120, 1), (125, 1), (130, 1), (135, 1), (140, 1), (145, 1), (150, 1), (155, 1), (160, 1), (165, 1), (170, 0), (175, 0), (180, 0), (185, 1), (190, 1), (195, 1), (200, 1), (205, 1), (210, 0), (215, 0), (220, 1), (225, 1), (230, 1), (235, 1), (240, 0), (245, 0), (250, 0), (255, 1), (260, 1), (265, 0), (270, 0), (275, 0), (280, 0), (285, 0), (290, 0), (295, 0), (300, 1), (305, 1), (310, 1), (315, 0), (320, 0), (325, 0), (330, 0), (335, 0), (340, 1), (345, 1), (350, 1), (355, 1), (360, 1), (365, 1), (370, 1), (375, 1), (380, 1), (385, 1), (390, 1), (395, 0), (400, 1), (405, 1), (410, 1), (415, 0), (420, 0), (425, 1), (430, 1), (435, 1), (440, 1), (445, 1), (450, 0), (455, 0), (460, 0), (465, 1), (470, 0), (475, 0), (480, 0), (485, 0), (490, 0), (495, 1), (500, 1), (505, 0), (510, 1), (515, 0), (520, 0), (525, 0), (530, 0), (535, 1), (540, 0), (545, 0), (550, 0), (555, 0), (560, 0), (565, 0), (570, 0), (575, 1), (580, 1), (585, 1), (590, 1), (595, 1), (600, 1), (605, 1), (610, 1), (615, 1), (620, 1), (625, 1), (630, 1), (635, 1), (640, 0), (645, 0), (650, 0), (655, 1), (660, 1), (665, 1), (670, 0), (675, 0), (680, 0), (685, 0), (690, 0), (695, 0), (700, 0), (705, 1), (710, 1), (715, 0), (720, 0), (725, 0), (730, 0), (735, 0), (740, 0), (745, 0), (750, 0), (755, 0), (760, 0), (765, 0), (770, 0), (775, 1), (780, 1), (785, 0), (790, 1), (795, 1), (800, 1), (805, 1), (810, 1), (815, 1), (820, 0), (825, 0), (830, 0), (835, 0), (840, 0), (845, 0), (850, 0), (855, 0), (860, 0), (865, 1), (870, 1), (875, 0), (880, 0), (885, 0), (890, 0), (895, 0), (900, 0), (905, 0), (910, 1), (915, 1), (920, 1), (925, 1), (930, 1), (935, 0), (940, 1), (945, 1), (950, 1), (955, 0), (960, 0), (965, 1), (970, 1), (975, 1), (980, 0), (985, 1), (990, 1), (995, 0), (1000, 0), (1005, 0), (1010, 0), (1015, 0), (1020, 0), (1025, 0)]
Vdin0_57  din0_57  0 PWL (0n 0.0v 4.745n 0.0v 4.755n 0.0v 9.745n 0.0v 9.755n 0.0v 14.745n 0.0v 14.755n 1.1v 19.745n 1.1v 19.755n 1.1v 24.745n 1.1v 24.755n 1.1v 29.745n 1.1v 29.755n 0.0v 34.745n 0.0v 34.755n 0.0v 39.745n 0.0v 39.755n 0.0v 44.745n 0.0v 44.755n 1.1v 49.745n 1.1v 49.755n 1.1v 54.745n 1.1v 54.755n 1.1v 59.745n 1.1v 59.755n 1.1v 64.745n 1.1v 64.755n 1.1v 69.745n 1.1v 69.755n 1.1v 74.745n 1.1v 74.755n 1.1v 79.745n 1.1v 79.755n 1.1v 84.745n 1.1v 84.755n 1.1v 89.745n 1.1v 89.755n 1.1v 94.745n 1.1v 94.755n 1.1v 99.745n 1.1v 99.755n 1.1v 104.745n 1.1v 104.755n 1.1v 109.745n 1.1v 109.755n 1.1v 114.745n 1.1v 114.755n 1.1v 119.745n 1.1v 119.755n 1.1v 124.745n 1.1v 124.755n 1.1v 129.745n 1.1v 129.755n 1.1v 134.745n 1.1v 134.755n 1.1v 139.745n 1.1v 139.755n 1.1v 144.745n 1.1v 144.755n 1.1v 149.745n 1.1v 149.755n 1.1v 154.745n 1.1v 154.755n 1.1v 159.745n 1.1v 159.755n 1.1v 164.745n 1.1v 164.755n 1.1v 169.745n 1.1v 169.755n 0.0v 174.745n 0.0v 174.755n 0.0v 179.745n 0.0v 179.755n 0.0v 184.745n 0.0v 184.755n 1.1v 189.745n 1.1v 189.755n 1.1v 194.745n 1.1v 194.755n 1.1v 199.745n 1.1v 199.755n 1.1v 204.745n 1.1v 204.755n 1.1v 209.745n 1.1v 209.755n 0.0v 214.745n 0.0v 214.755n 0.0v 219.745n 0.0v 219.755n 1.1v 224.745n 1.1v 224.755n 1.1v 229.745n 1.1v 229.755n 1.1v 234.745n 1.1v 234.755n 1.1v 239.745n 1.1v 239.755n 0.0v 244.745n 0.0v 244.755n 0.0v 249.745n 0.0v 249.755n 0.0v 254.745n 0.0v 254.755n 1.1v 259.745n 1.1v 259.755n 1.1v 264.745n 1.1v 264.755n 0.0v 269.745n 0.0v 269.755n 0.0v 274.745n 0.0v 274.755n 0.0v 279.745n 0.0v 279.755n 0.0v 284.745n 0.0v 284.755n 0.0v 289.745n 0.0v 289.755n 0.0v 294.745n 0.0v 294.755n 0.0v 299.745n 0.0v 299.755n 1.1v 304.745n 1.1v 304.755n 1.1v 309.745n 1.1v 309.755n 1.1v 314.745n 1.1v 314.755n 0.0v 319.745n 0.0v 319.755n 0.0v 324.745n 0.0v 324.755n 0.0v 329.745n 0.0v 329.755n 0.0v 334.745n 0.0v 334.755n 0.0v 339.745n 0.0v 339.755n 1.1v 344.745n 1.1v 344.755n 1.1v 349.745n 1.1v 349.755n 1.1v 354.745n 1.1v 354.755n 1.1v 359.745n 1.1v 359.755n 1.1v 364.745n 1.1v 364.755n 1.1v 369.745n 1.1v 369.755n 1.1v 374.745n 1.1v 374.755n 1.1v 379.745n 1.1v 379.755n 1.1v 384.745n 1.1v 384.755n 1.1v 389.745n 1.1v 389.755n 1.1v 394.745n 1.1v 394.755n 0.0v 399.745n 0.0v 399.755n 1.1v 404.745n 1.1v 404.755n 1.1v 409.745n 1.1v 409.755n 1.1v 414.745n 1.1v 414.755n 0.0v 419.745n 0.0v 419.755n 0.0v 424.745n 0.0v 424.755n 1.1v 429.745n 1.1v 429.755n 1.1v 434.745n 1.1v 434.755n 1.1v 439.745n 1.1v 439.755n 1.1v 444.745n 1.1v 444.755n 1.1v 449.745n 1.1v 449.755n 0.0v 454.745n 0.0v 454.755n 0.0v 459.745n 0.0v 459.755n 0.0v 464.745n 0.0v 464.755n 1.1v 469.745n 1.1v 469.755n 0.0v 474.745n 0.0v 474.755n 0.0v 479.745n 0.0v 479.755n 0.0v 484.745n 0.0v 484.755n 0.0v 489.745n 0.0v 489.755n 0.0v 494.745n 0.0v 494.755n 1.1v 499.745n 1.1v 499.755n 1.1v 504.745n 1.1v 504.755n 0.0v 509.745n 0.0v 509.755n 1.1v 514.745n 1.1v 514.755n 0.0v 519.745n 0.0v 519.755n 0.0v 524.745n 0.0v 524.755n 0.0v 529.745n 0.0v 529.755n 0.0v 534.745n 0.0v 534.755n 1.1v 539.745n 1.1v 539.755n 0.0v 544.745n 0.0v 544.755n 0.0v 549.745n 0.0v 549.755n 0.0v 554.745n 0.0v 554.755n 0.0v 559.745n 0.0v 559.755n 0.0v 564.745n 0.0v 564.755n 0.0v 569.745n 0.0v 569.755n 0.0v 574.745n 0.0v 574.755n 1.1v 579.745n 1.1v 579.755n 1.1v 584.745n 1.1v 584.755n 1.1v 589.745n 1.1v 589.755n 1.1v 594.745n 1.1v 594.755n 1.1v 599.745n 1.1v 599.755n 1.1v 604.745n 1.1v 604.755n 1.1v 609.745n 1.1v 609.755n 1.1v 614.745n 1.1v 614.755n 1.1v 619.745n 1.1v 619.755n 1.1v 624.745n 1.1v 624.755n 1.1v 629.745n 1.1v 629.755n 1.1v 634.745n 1.1v 634.755n 1.1v 639.745n 1.1v 639.755n 0.0v 644.745n 0.0v 644.755n 0.0v 649.745n 0.0v 649.755n 0.0v 654.745n 0.0v 654.755n 1.1v 659.745n 1.1v 659.755n 1.1v 664.745n 1.1v 664.755n 1.1v 669.745n 1.1v 669.755n 0.0v 674.745n 0.0v 674.755n 0.0v 679.745n 0.0v 679.755n 0.0v 684.745n 0.0v 684.755n 0.0v 689.745n 0.0v 689.755n 0.0v 694.745n 0.0v 694.755n 0.0v 699.745n 0.0v 699.755n 0.0v 704.745n 0.0v 704.755n 1.1v 709.745n 1.1v 709.755n 1.1v 714.745n 1.1v 714.755n 0.0v 719.745n 0.0v 719.755n 0.0v 724.745n 0.0v 724.755n 0.0v 729.745n 0.0v 729.755n 0.0v 734.745n 0.0v 734.755n 0.0v 739.745n 0.0v 739.755n 0.0v 744.745n 0.0v 744.755n 0.0v 749.745n 0.0v 749.755n 0.0v 754.745n 0.0v 754.755n 0.0v 759.745n 0.0v 759.755n 0.0v 764.745n 0.0v 764.755n 0.0v 769.745n 0.0v 769.755n 0.0v 774.745n 0.0v 774.755n 1.1v 779.745n 1.1v 779.755n 1.1v 784.745n 1.1v 784.755n 0.0v 789.745n 0.0v 789.755n 1.1v 794.745n 1.1v 794.755n 1.1v 799.745n 1.1v 799.755n 1.1v 804.745n 1.1v 804.755n 1.1v 809.745n 1.1v 809.755n 1.1v 814.745n 1.1v 814.755n 1.1v 819.745n 1.1v 819.755n 0.0v 824.745n 0.0v 824.755n 0.0v 829.745n 0.0v 829.755n 0.0v 834.745n 0.0v 834.755n 0.0v 839.745n 0.0v 839.755n 0.0v 844.745n 0.0v 844.755n 0.0v 849.745n 0.0v 849.755n 0.0v 854.745n 0.0v 854.755n 0.0v 859.745n 0.0v 859.755n 0.0v 864.745n 0.0v 864.755n 1.1v 869.745n 1.1v 869.755n 1.1v 874.745n 1.1v 874.755n 0.0v 879.745n 0.0v 879.755n 0.0v 884.745n 0.0v 884.755n 0.0v 889.745n 0.0v 889.755n 0.0v 894.745n 0.0v 894.755n 0.0v 899.745n 0.0v 899.755n 0.0v 904.745n 0.0v 904.755n 0.0v 909.745n 0.0v 909.755n 1.1v 914.745n 1.1v 914.755n 1.1v 919.745n 1.1v 919.755n 1.1v 924.745n 1.1v 924.755n 1.1v 929.745n 1.1v 929.755n 1.1v 934.745n 1.1v 934.755n 0.0v 939.745n 0.0v 939.755n 1.1v 944.745n 1.1v 944.755n 1.1v 949.745n 1.1v 949.755n 1.1v 954.745n 1.1v 954.755n 0.0v 959.745n 0.0v 959.755n 0.0v 964.745n 0.0v 964.755n 1.1v 969.745n 1.1v 969.755n 1.1v 974.745n 1.1v 974.755n 1.1v 979.745n 1.1v 979.755n 0.0v 984.745n 0.0v 984.755n 1.1v 989.745n 1.1v 989.755n 1.1v 994.745n 1.1v 994.755n 0.0v 999.745n 0.0v 999.755n 0.0v 1004.745n 0.0v 1004.755n 0.0v 1009.745n 0.0v 1009.755n 0.0v 1014.745n 0.0v 1014.755n 0.0v 1019.745n 0.0v 1019.755n 0.0v 1024.745n 0.0v 1024.755n 0.0v )
* (time, data): [(0, 0), (5, 0), (10, 0), (15, 1), (20, 1), (25, 1), (30, 0), (35, 0), (40, 0), (45, 0), (50, 0), (55, 0), (60, 0), (65, 0), (70, 0), (75, 0), (80, 0), (85, 0), (90, 1), (95, 1), (100, 0), (105, 0), (110, 0), (115, 0), (120, 0), (125, 0), (130, 0), (135, 1), (140, 0), (145, 0), (150, 0), (155, 0), (160, 0), (165, 0), (170, 1), (175, 1), (180, 1), (185, 1), (190, 1), (195, 1), (200, 0), (205, 0), (210, 1), (215, 1), (220, 1), (225, 1), (230, 1), (235, 1), (240, 1), (245, 1), (250, 1), (255, 0), (260, 0), (265, 0), (270, 0), (275, 0), (280, 0), (285, 0), (290, 0), (295, 0), (300, 0), (305, 0), (310, 0), (315, 0), (320, 0), (325, 0), (330, 1), (335, 1), (340, 1), (345, 1), (350, 1), (355, 1), (360, 0), (365, 0), (370, 0), (375, 0), (380, 0), (385, 0), (390, 0), (395, 0), (400, 1), (405, 1), (410, 0), (415, 0), (420, 1), (425, 0), (430, 0), (435, 0), (440, 0), (445, 0), (450, 1), (455, 1), (460, 1), (465, 1), (470, 1), (475, 1), (480, 0), (485, 0), (490, 0), (495, 1), (500, 1), (505, 0), (510, 1), (515, 1), (520, 1), (525, 1), (530, 1), (535, 1), (540, 0), (545, 0), (550, 0), (555, 1), (560, 1), (565, 1), (570, 1), (575, 0), (580, 0), (585, 0), (590, 0), (595, 0), (600, 0), (605, 0), (610, 0), (615, 0), (620, 0), (625, 0), (630, 1), (635, 0), (640, 1), (645, 1), (650, 1), (655, 0), (660, 1), (665, 1), (670, 0), (675, 0), (680, 0), (685, 0), (690, 0), (695, 0), (700, 0), (705, 0), (710, 1), (715, 1), (720, 1), (725, 1), (730, 1), (735, 0), (740, 0), (745, 0), (750, 0), (755, 1), (760, 1), (765, 1), (770, 0), (775, 1), (780, 1), (785, 0), (790, 0), (795, 0), (800, 0), (805, 0), (810, 0), (815, 0), (820, 1), (825, 1), (830, 0), (835, 0), (840, 0), (845, 0), (850, 0), (855, 0), (860, 0), (865, 1), (870, 0), (875, 1), (880, 1), (885, 1), (890, 1), (895, 1), (900, 1), (905, 1), (910, 0), (915, 0), (920, 0), (925, 0), (930, 0), (935, 0), (940, 1), (945, 1), (950, 1), (955, 1), (960, 1), (965, 1), (970, 1), (975, 1), (980, 0), (985, 0), (990, 0), (995, 1), (1000, 0), (1005, 0), (1010, 0), (1015, 0), (1020, 1), (1025, 1)]
Vdin0_58  din0_58  0 PWL (0n 0.0v 4.745n 0.0v 4.755n 0.0v 9.745n 0.0v 9.755n 0.0v 14.745n 0.0v 14.755n 1.1v 19.745n 1.1v 19.755n 1.1v 24.745n 1.1v 24.755n 1.1v 29.745n 1.1v 29.755n 0.0v 34.745n 0.0v 34.755n 0.0v 39.745n 0.0v 39.755n 0.0v 44.745n 0.0v 44.755n 0.0v 49.745n 0.0v 49.755n 0.0v 54.745n 0.0v 54.755n 0.0v 59.745n 0.0v 59.755n 0.0v 64.745n 0.0v 64.755n 0.0v 69.745n 0.0v 69.755n 0.0v 74.745n 0.0v 74.755n 0.0v 79.745n 0.0v 79.755n 0.0v 84.745n 0.0v 84.755n 0.0v 89.745n 0.0v 89.755n 1.1v 94.745n 1.1v 94.755n 1.1v 99.745n 1.1v 99.755n 0.0v 104.745n 0.0v 104.755n 0.0v 109.745n 0.0v 109.755n 0.0v 114.745n 0.0v 114.755n 0.0v 119.745n 0.0v 119.755n 0.0v 124.745n 0.0v 124.755n 0.0v 129.745n 0.0v 129.755n 0.0v 134.745n 0.0v 134.755n 1.1v 139.745n 1.1v 139.755n 0.0v 144.745n 0.0v 144.755n 0.0v 149.745n 0.0v 149.755n 0.0v 154.745n 0.0v 154.755n 0.0v 159.745n 0.0v 159.755n 0.0v 164.745n 0.0v 164.755n 0.0v 169.745n 0.0v 169.755n 1.1v 174.745n 1.1v 174.755n 1.1v 179.745n 1.1v 179.755n 1.1v 184.745n 1.1v 184.755n 1.1v 189.745n 1.1v 189.755n 1.1v 194.745n 1.1v 194.755n 1.1v 199.745n 1.1v 199.755n 0.0v 204.745n 0.0v 204.755n 0.0v 209.745n 0.0v 209.755n 1.1v 214.745n 1.1v 214.755n 1.1v 219.745n 1.1v 219.755n 1.1v 224.745n 1.1v 224.755n 1.1v 229.745n 1.1v 229.755n 1.1v 234.745n 1.1v 234.755n 1.1v 239.745n 1.1v 239.755n 1.1v 244.745n 1.1v 244.755n 1.1v 249.745n 1.1v 249.755n 1.1v 254.745n 1.1v 254.755n 0.0v 259.745n 0.0v 259.755n 0.0v 264.745n 0.0v 264.755n 0.0v 269.745n 0.0v 269.755n 0.0v 274.745n 0.0v 274.755n 0.0v 279.745n 0.0v 279.755n 0.0v 284.745n 0.0v 284.755n 0.0v 289.745n 0.0v 289.755n 0.0v 294.745n 0.0v 294.755n 0.0v 299.745n 0.0v 299.755n 0.0v 304.745n 0.0v 304.755n 0.0v 309.745n 0.0v 309.755n 0.0v 314.745n 0.0v 314.755n 0.0v 319.745n 0.0v 319.755n 0.0v 324.745n 0.0v 324.755n 0.0v 329.745n 0.0v 329.755n 1.1v 334.745n 1.1v 334.755n 1.1v 339.745n 1.1v 339.755n 1.1v 344.745n 1.1v 344.755n 1.1v 349.745n 1.1v 349.755n 1.1v 354.745n 1.1v 354.755n 1.1v 359.745n 1.1v 359.755n 0.0v 364.745n 0.0v 364.755n 0.0v 369.745n 0.0v 369.755n 0.0v 374.745n 0.0v 374.755n 0.0v 379.745n 0.0v 379.755n 0.0v 384.745n 0.0v 384.755n 0.0v 389.745n 0.0v 389.755n 0.0v 394.745n 0.0v 394.755n 0.0v 399.745n 0.0v 399.755n 1.1v 404.745n 1.1v 404.755n 1.1v 409.745n 1.1v 409.755n 0.0v 414.745n 0.0v 414.755n 0.0v 419.745n 0.0v 419.755n 1.1v 424.745n 1.1v 424.755n 0.0v 429.745n 0.0v 429.755n 0.0v 434.745n 0.0v 434.755n 0.0v 439.745n 0.0v 439.755n 0.0v 444.745n 0.0v 444.755n 0.0v 449.745n 0.0v 449.755n 1.1v 454.745n 1.1v 454.755n 1.1v 459.745n 1.1v 459.755n 1.1v 464.745n 1.1v 464.755n 1.1v 469.745n 1.1v 469.755n 1.1v 474.745n 1.1v 474.755n 1.1v 479.745n 1.1v 479.755n 0.0v 484.745n 0.0v 484.755n 0.0v 489.745n 0.0v 489.755n 0.0v 494.745n 0.0v 494.755n 1.1v 499.745n 1.1v 499.755n 1.1v 504.745n 1.1v 504.755n 0.0v 509.745n 0.0v 509.755n 1.1v 514.745n 1.1v 514.755n 1.1v 519.745n 1.1v 519.755n 1.1v 524.745n 1.1v 524.755n 1.1v 529.745n 1.1v 529.755n 1.1v 534.745n 1.1v 534.755n 1.1v 539.745n 1.1v 539.755n 0.0v 544.745n 0.0v 544.755n 0.0v 549.745n 0.0v 549.755n 0.0v 554.745n 0.0v 554.755n 1.1v 559.745n 1.1v 559.755n 1.1v 564.745n 1.1v 564.755n 1.1v 569.745n 1.1v 569.755n 1.1v 574.745n 1.1v 574.755n 0.0v 579.745n 0.0v 579.755n 0.0v 584.745n 0.0v 584.755n 0.0v 589.745n 0.0v 589.755n 0.0v 594.745n 0.0v 594.755n 0.0v 599.745n 0.0v 599.755n 0.0v 604.745n 0.0v 604.755n 0.0v 609.745n 0.0v 609.755n 0.0v 614.745n 0.0v 614.755n 0.0v 619.745n 0.0v 619.755n 0.0v 624.745n 0.0v 624.755n 0.0v 629.745n 0.0v 629.755n 1.1v 634.745n 1.1v 634.755n 0.0v 639.745n 0.0v 639.755n 1.1v 644.745n 1.1v 644.755n 1.1v 649.745n 1.1v 649.755n 1.1v 654.745n 1.1v 654.755n 0.0v 659.745n 0.0v 659.755n 1.1v 664.745n 1.1v 664.755n 1.1v 669.745n 1.1v 669.755n 0.0v 674.745n 0.0v 674.755n 0.0v 679.745n 0.0v 679.755n 0.0v 684.745n 0.0v 684.755n 0.0v 689.745n 0.0v 689.755n 0.0v 694.745n 0.0v 694.755n 0.0v 699.745n 0.0v 699.755n 0.0v 704.745n 0.0v 704.755n 0.0v 709.745n 0.0v 709.755n 1.1v 714.745n 1.1v 714.755n 1.1v 719.745n 1.1v 719.755n 1.1v 724.745n 1.1v 724.755n 1.1v 729.745n 1.1v 729.755n 1.1v 734.745n 1.1v 734.755n 0.0v 739.745n 0.0v 739.755n 0.0v 744.745n 0.0v 744.755n 0.0v 749.745n 0.0v 749.755n 0.0v 754.745n 0.0v 754.755n 1.1v 759.745n 1.1v 759.755n 1.1v 764.745n 1.1v 764.755n 1.1v 769.745n 1.1v 769.755n 0.0v 774.745n 0.0v 774.755n 1.1v 779.745n 1.1v 779.755n 1.1v 784.745n 1.1v 784.755n 0.0v 789.745n 0.0v 789.755n 0.0v 794.745n 0.0v 794.755n 0.0v 799.745n 0.0v 799.755n 0.0v 804.745n 0.0v 804.755n 0.0v 809.745n 0.0v 809.755n 0.0v 814.745n 0.0v 814.755n 0.0v 819.745n 0.0v 819.755n 1.1v 824.745n 1.1v 824.755n 1.1v 829.745n 1.1v 829.755n 0.0v 834.745n 0.0v 834.755n 0.0v 839.745n 0.0v 839.755n 0.0v 844.745n 0.0v 844.755n 0.0v 849.745n 0.0v 849.755n 0.0v 854.745n 0.0v 854.755n 0.0v 859.745n 0.0v 859.755n 0.0v 864.745n 0.0v 864.755n 1.1v 869.745n 1.1v 869.755n 0.0v 874.745n 0.0v 874.755n 1.1v 879.745n 1.1v 879.755n 1.1v 884.745n 1.1v 884.755n 1.1v 889.745n 1.1v 889.755n 1.1v 894.745n 1.1v 894.755n 1.1v 899.745n 1.1v 899.755n 1.1v 904.745n 1.1v 904.755n 1.1v 909.745n 1.1v 909.755n 0.0v 914.745n 0.0v 914.755n 0.0v 919.745n 0.0v 919.755n 0.0v 924.745n 0.0v 924.755n 0.0v 929.745n 0.0v 929.755n 0.0v 934.745n 0.0v 934.755n 0.0v 939.745n 0.0v 939.755n 1.1v 944.745n 1.1v 944.755n 1.1v 949.745n 1.1v 949.755n 1.1v 954.745n 1.1v 954.755n 1.1v 959.745n 1.1v 959.755n 1.1v 964.745n 1.1v 964.755n 1.1v 969.745n 1.1v 969.755n 1.1v 974.745n 1.1v 974.755n 1.1v 979.745n 1.1v 979.755n 0.0v 984.745n 0.0v 984.755n 0.0v 989.745n 0.0v 989.755n 0.0v 994.745n 0.0v 994.755n 1.1v 999.745n 1.1v 999.755n 0.0v 1004.745n 0.0v 1004.755n 0.0v 1009.745n 0.0v 1009.755n 0.0v 1014.745n 0.0v 1014.755n 0.0v 1019.745n 0.0v 1019.755n 1.1v 1024.745n 1.1v 1024.755n 1.1v )
* (time, data): [(0, 0), (5, 0), (10, 0), (15, 1), (20, 1), (25, 1), (30, 1), (35, 1), (40, 1), (45, 1), (50, 1), (55, 1), (60, 0), (65, 1), (70, 1), (75, 1), (80, 1), (85, 1), (90, 1), (95, 1), (100, 1), (105, 1), (110, 1), (115, 1), (120, 1), (125, 1), (130, 1), (135, 0), (140, 1), (145, 1), (150, 1), (155, 1), (160, 1), (165, 1), (170, 1), (175, 1), (180, 1), (185, 0), (190, 0), (195, 0), (200, 0), (205, 0), (210, 1), (215, 1), (220, 0), (225, 0), (230, 1), (235, 1), (240, 0), (245, 0), (250, 0), (255, 1), (260, 1), (265, 1), (270, 1), (275, 1), (280, 0), (285, 0), (290, 0), (295, 0), (300, 1), (305, 1), (310, 1), (315, 1), (320, 1), (325, 1), (330, 1), (335, 1), (340, 0), (345, 0), (350, 0), (355, 0), (360, 1), (365, 1), (370, 1), (375, 1), (380, 1), (385, 1), (390, 1), (395, 0), (400, 0), (405, 0), (410, 1), (415, 1), (420, 1), (425, 1), (430, 1), (435, 1), (440, 1), (445, 1), (450, 0), (455, 0), (460, 0), (465, 0), (470, 1), (475, 1), (480, 0), (485, 0), (490, 0), (495, 1), (500, 0), (505, 0), (510, 0), (515, 1), (520, 1), (525, 1), (530, 1), (535, 0), (540, 0), (545, 0), (550, 0), (555, 1), (560, 1), (565, 1), (570, 1), (575, 0), (580, 0), (585, 0), (590, 0), (595, 0), (600, 0), (605, 0), (610, 0), (615, 0), (620, 0), (625, 0), (630, 0), (635, 1), (640, 1), (645, 1), (650, 1), (655, 0), (660, 0), (665, 0), (670, 0), (675, 0), (680, 0), (685, 0), (690, 0), (695, 0), (700, 0), (705, 0), (710, 1), (715, 1), (720, 1), (725, 1), (730, 1), (735, 1), (740, 1), (745, 1), (750, 1), (755, 1), (760, 1), (765, 1), (770, 1), (775, 1), (780, 1), (785, 0), (790, 0), (795, 0), (800, 0), (805, 0), (810, 0), (815, 0), (820, 0), (825, 0), (830, 0), (835, 0), (840, 0), (845, 0), (850, 0), (855, 1), (860, 1), (865, 0), (870, 1), (875, 0), (880, 1), (885, 0), (890, 0), (895, 0), (900, 0), (905, 0), (910, 1), (915, 1), (920, 1), (925, 1), (930, 1), (935, 0), (940, 1), (945, 1), (950, 1), (955, 1), (960, 1), (965, 0), (970, 0), (975, 0), (980, 1), (985, 1), (990, 1), (995, 1), (1000, 1), (1005, 1), (1010, 1), (1015, 1), (1020, 1), (1025, 1)]
Vdin0_59  din0_59  0 PWL (0n 0.0v 4.745n 0.0v 4.755n 0.0v 9.745n 0.0v 9.755n 0.0v 14.745n 0.0v 14.755n 1.1v 19.745n 1.1v 19.755n 1.1v 24.745n 1.1v 24.755n 1.1v 29.745n 1.1v 29.755n 1.1v 34.745n 1.1v 34.755n 1.1v 39.745n 1.1v 39.755n 1.1v 44.745n 1.1v 44.755n 1.1v 49.745n 1.1v 49.755n 1.1v 54.745n 1.1v 54.755n 1.1v 59.745n 1.1v 59.755n 0.0v 64.745n 0.0v 64.755n 1.1v 69.745n 1.1v 69.755n 1.1v 74.745n 1.1v 74.755n 1.1v 79.745n 1.1v 79.755n 1.1v 84.745n 1.1v 84.755n 1.1v 89.745n 1.1v 89.755n 1.1v 94.745n 1.1v 94.755n 1.1v 99.745n 1.1v 99.755n 1.1v 104.745n 1.1v 104.755n 1.1v 109.745n 1.1v 109.755n 1.1v 114.745n 1.1v 114.755n 1.1v 119.745n 1.1v 119.755n 1.1v 124.745n 1.1v 124.755n 1.1v 129.745n 1.1v 129.755n 1.1v 134.745n 1.1v 134.755n 0.0v 139.745n 0.0v 139.755n 1.1v 144.745n 1.1v 144.755n 1.1v 149.745n 1.1v 149.755n 1.1v 154.745n 1.1v 154.755n 1.1v 159.745n 1.1v 159.755n 1.1v 164.745n 1.1v 164.755n 1.1v 169.745n 1.1v 169.755n 1.1v 174.745n 1.1v 174.755n 1.1v 179.745n 1.1v 179.755n 1.1v 184.745n 1.1v 184.755n 0.0v 189.745n 0.0v 189.755n 0.0v 194.745n 0.0v 194.755n 0.0v 199.745n 0.0v 199.755n 0.0v 204.745n 0.0v 204.755n 0.0v 209.745n 0.0v 209.755n 1.1v 214.745n 1.1v 214.755n 1.1v 219.745n 1.1v 219.755n 0.0v 224.745n 0.0v 224.755n 0.0v 229.745n 0.0v 229.755n 1.1v 234.745n 1.1v 234.755n 1.1v 239.745n 1.1v 239.755n 0.0v 244.745n 0.0v 244.755n 0.0v 249.745n 0.0v 249.755n 0.0v 254.745n 0.0v 254.755n 1.1v 259.745n 1.1v 259.755n 1.1v 264.745n 1.1v 264.755n 1.1v 269.745n 1.1v 269.755n 1.1v 274.745n 1.1v 274.755n 1.1v 279.745n 1.1v 279.755n 0.0v 284.745n 0.0v 284.755n 0.0v 289.745n 0.0v 289.755n 0.0v 294.745n 0.0v 294.755n 0.0v 299.745n 0.0v 299.755n 1.1v 304.745n 1.1v 304.755n 1.1v 309.745n 1.1v 309.755n 1.1v 314.745n 1.1v 314.755n 1.1v 319.745n 1.1v 319.755n 1.1v 324.745n 1.1v 324.755n 1.1v 329.745n 1.1v 329.755n 1.1v 334.745n 1.1v 334.755n 1.1v 339.745n 1.1v 339.755n 0.0v 344.745n 0.0v 344.755n 0.0v 349.745n 0.0v 349.755n 0.0v 354.745n 0.0v 354.755n 0.0v 359.745n 0.0v 359.755n 1.1v 364.745n 1.1v 364.755n 1.1v 369.745n 1.1v 369.755n 1.1v 374.745n 1.1v 374.755n 1.1v 379.745n 1.1v 379.755n 1.1v 384.745n 1.1v 384.755n 1.1v 389.745n 1.1v 389.755n 1.1v 394.745n 1.1v 394.755n 0.0v 399.745n 0.0v 399.755n 0.0v 404.745n 0.0v 404.755n 0.0v 409.745n 0.0v 409.755n 1.1v 414.745n 1.1v 414.755n 1.1v 419.745n 1.1v 419.755n 1.1v 424.745n 1.1v 424.755n 1.1v 429.745n 1.1v 429.755n 1.1v 434.745n 1.1v 434.755n 1.1v 439.745n 1.1v 439.755n 1.1v 444.745n 1.1v 444.755n 1.1v 449.745n 1.1v 449.755n 0.0v 454.745n 0.0v 454.755n 0.0v 459.745n 0.0v 459.755n 0.0v 464.745n 0.0v 464.755n 0.0v 469.745n 0.0v 469.755n 1.1v 474.745n 1.1v 474.755n 1.1v 479.745n 1.1v 479.755n 0.0v 484.745n 0.0v 484.755n 0.0v 489.745n 0.0v 489.755n 0.0v 494.745n 0.0v 494.755n 1.1v 499.745n 1.1v 499.755n 0.0v 504.745n 0.0v 504.755n 0.0v 509.745n 0.0v 509.755n 0.0v 514.745n 0.0v 514.755n 1.1v 519.745n 1.1v 519.755n 1.1v 524.745n 1.1v 524.755n 1.1v 529.745n 1.1v 529.755n 1.1v 534.745n 1.1v 534.755n 0.0v 539.745n 0.0v 539.755n 0.0v 544.745n 0.0v 544.755n 0.0v 549.745n 0.0v 549.755n 0.0v 554.745n 0.0v 554.755n 1.1v 559.745n 1.1v 559.755n 1.1v 564.745n 1.1v 564.755n 1.1v 569.745n 1.1v 569.755n 1.1v 574.745n 1.1v 574.755n 0.0v 579.745n 0.0v 579.755n 0.0v 584.745n 0.0v 584.755n 0.0v 589.745n 0.0v 589.755n 0.0v 594.745n 0.0v 594.755n 0.0v 599.745n 0.0v 599.755n 0.0v 604.745n 0.0v 604.755n 0.0v 609.745n 0.0v 609.755n 0.0v 614.745n 0.0v 614.755n 0.0v 619.745n 0.0v 619.755n 0.0v 624.745n 0.0v 624.755n 0.0v 629.745n 0.0v 629.755n 0.0v 634.745n 0.0v 634.755n 1.1v 639.745n 1.1v 639.755n 1.1v 644.745n 1.1v 644.755n 1.1v 649.745n 1.1v 649.755n 1.1v 654.745n 1.1v 654.755n 0.0v 659.745n 0.0v 659.755n 0.0v 664.745n 0.0v 664.755n 0.0v 669.745n 0.0v 669.755n 0.0v 674.745n 0.0v 674.755n 0.0v 679.745n 0.0v 679.755n 0.0v 684.745n 0.0v 684.755n 0.0v 689.745n 0.0v 689.755n 0.0v 694.745n 0.0v 694.755n 0.0v 699.745n 0.0v 699.755n 0.0v 704.745n 0.0v 704.755n 0.0v 709.745n 0.0v 709.755n 1.1v 714.745n 1.1v 714.755n 1.1v 719.745n 1.1v 719.755n 1.1v 724.745n 1.1v 724.755n 1.1v 729.745n 1.1v 729.755n 1.1v 734.745n 1.1v 734.755n 1.1v 739.745n 1.1v 739.755n 1.1v 744.745n 1.1v 744.755n 1.1v 749.745n 1.1v 749.755n 1.1v 754.745n 1.1v 754.755n 1.1v 759.745n 1.1v 759.755n 1.1v 764.745n 1.1v 764.755n 1.1v 769.745n 1.1v 769.755n 1.1v 774.745n 1.1v 774.755n 1.1v 779.745n 1.1v 779.755n 1.1v 784.745n 1.1v 784.755n 0.0v 789.745n 0.0v 789.755n 0.0v 794.745n 0.0v 794.755n 0.0v 799.745n 0.0v 799.755n 0.0v 804.745n 0.0v 804.755n 0.0v 809.745n 0.0v 809.755n 0.0v 814.745n 0.0v 814.755n 0.0v 819.745n 0.0v 819.755n 0.0v 824.745n 0.0v 824.755n 0.0v 829.745n 0.0v 829.755n 0.0v 834.745n 0.0v 834.755n 0.0v 839.745n 0.0v 839.755n 0.0v 844.745n 0.0v 844.755n 0.0v 849.745n 0.0v 849.755n 0.0v 854.745n 0.0v 854.755n 1.1v 859.745n 1.1v 859.755n 1.1v 864.745n 1.1v 864.755n 0.0v 869.745n 0.0v 869.755n 1.1v 874.745n 1.1v 874.755n 0.0v 879.745n 0.0v 879.755n 1.1v 884.745n 1.1v 884.755n 0.0v 889.745n 0.0v 889.755n 0.0v 894.745n 0.0v 894.755n 0.0v 899.745n 0.0v 899.755n 0.0v 904.745n 0.0v 904.755n 0.0v 909.745n 0.0v 909.755n 1.1v 914.745n 1.1v 914.755n 1.1v 919.745n 1.1v 919.755n 1.1v 924.745n 1.1v 924.755n 1.1v 929.745n 1.1v 929.755n 1.1v 934.745n 1.1v 934.755n 0.0v 939.745n 0.0v 939.755n 1.1v 944.745n 1.1v 944.755n 1.1v 949.745n 1.1v 949.755n 1.1v 954.745n 1.1v 954.755n 1.1v 959.745n 1.1v 959.755n 1.1v 964.745n 1.1v 964.755n 0.0v 969.745n 0.0v 969.755n 0.0v 974.745n 0.0v 974.755n 0.0v 979.745n 0.0v 979.755n 1.1v 984.745n 1.1v 984.755n 1.1v 989.745n 1.1v 989.755n 1.1v 994.745n 1.1v 994.755n 1.1v 999.745n 1.1v 999.755n 1.1v 1004.745n 1.1v 1004.755n 1.1v 1009.745n 1.1v 1009.755n 1.1v 1014.745n 1.1v 1014.755n 1.1v 1019.745n 1.1v 1019.755n 1.1v 1024.745n 1.1v 1024.755n 1.1v )
* (time, data): [(0, 0), (5, 0), (10, 1), (15, 0), (20, 0), (25, 0), (30, 1), (35, 1), (40, 0), (45, 0), (50, 0), (55, 0), (60, 0), (65, 0), (70, 0), (75, 0), (80, 0), (85, 0), (90, 1), (95, 1), (100, 1), (105, 1), (110, 1), (115, 1), (120, 1), (125, 1), (130, 1), (135, 0), (140, 0), (145, 0), (150, 0), (155, 0), (160, 0), (165, 0), (170, 1), (175, 1), (180, 1), (185, 0), (190, 0), (195, 0), (200, 1), (205, 1), (210, 1), (215, 1), (220, 0), (225, 0), (230, 0), (235, 0), (240, 0), (245, 0), (250, 0), (255, 1), (260, 1), (265, 1), (270, 1), (275, 1), (280, 0), (285, 0), (290, 0), (295, 0), (300, 0), (305, 0), (310, 0), (315, 1), (320, 1), (325, 1), (330, 0), (335, 1), (340, 1), (345, 1), (350, 1), (355, 1), (360, 1), (365, 1), (370, 1), (375, 1), (380, 1), (385, 1), (390, 1), (395, 0), (400, 0), (405, 0), (410, 0), (415, 1), (420, 1), (425, 1), (430, 0), (435, 0), (440, 0), (445, 0), (450, 1), (455, 1), (460, 1), (465, 0), (470, 1), (475, 1), (480, 1), (485, 1), (490, 1), (495, 1), (500, 1), (505, 0), (510, 0), (515, 0), (520, 0), (525, 0), (530, 0), (535, 0), (540, 0), (545, 0), (550, 0), (555, 0), (560, 0), (565, 0), (570, 0), (575, 0), (580, 0), (585, 0), (590, 0), (595, 0), (600, 0), (605, 0), (610, 0), (615, 0), (620, 0), (625, 0), (630, 0), (635, 0), (640, 1), (645, 1), (650, 1), (655, 1), (660, 1), (665, 1), (670, 1), (675, 1), (680, 1), (685, 1), (690, 1), (695, 1), (700, 1), (705, 0), (710, 0), (715, 1), (720, 1), (725, 1), (730, 1), (735, 0), (740, 1), (745, 1), (750, 1), (755, 0), (760, 0), (765, 0), (770, 1), (775, 0), (780, 0), (785, 1), (790, 1), (795, 1), (800, 1), (805, 1), (810, 1), (815, 1), (820, 1), (825, 1), (830, 0), (835, 1), (840, 1), (845, 1), (850, 1), (855, 0), (860, 0), (865, 0), (870, 1), (875, 1), (880, 1), (885, 0), (890, 0), (895, 0), (900, 0), (905, 0), (910, 1), (915, 1), (920, 1), (925, 1), (930, 0), (935, 0), (940, 0), (945, 0), (950, 0), (955, 1), (960, 1), (965, 1), (970, 1), (975, 1), (980, 0), (985, 0), (990, 0), (995, 0), (1000, 1), (1005, 1), (1010, 1), (1015, 1), (1020, 1), (1025, 1)]
Vdin0_60  din0_60  0 PWL (0n 0.0v 4.745n 0.0v 4.755n 0.0v 9.745n 0.0v 9.755n 1.1v 14.745n 1.1v 14.755n 0.0v 19.745n 0.0v 19.755n 0.0v 24.745n 0.0v 24.755n 0.0v 29.745n 0.0v 29.755n 1.1v 34.745n 1.1v 34.755n 1.1v 39.745n 1.1v 39.755n 0.0v 44.745n 0.0v 44.755n 0.0v 49.745n 0.0v 49.755n 0.0v 54.745n 0.0v 54.755n 0.0v 59.745n 0.0v 59.755n 0.0v 64.745n 0.0v 64.755n 0.0v 69.745n 0.0v 69.755n 0.0v 74.745n 0.0v 74.755n 0.0v 79.745n 0.0v 79.755n 0.0v 84.745n 0.0v 84.755n 0.0v 89.745n 0.0v 89.755n 1.1v 94.745n 1.1v 94.755n 1.1v 99.745n 1.1v 99.755n 1.1v 104.745n 1.1v 104.755n 1.1v 109.745n 1.1v 109.755n 1.1v 114.745n 1.1v 114.755n 1.1v 119.745n 1.1v 119.755n 1.1v 124.745n 1.1v 124.755n 1.1v 129.745n 1.1v 129.755n 1.1v 134.745n 1.1v 134.755n 0.0v 139.745n 0.0v 139.755n 0.0v 144.745n 0.0v 144.755n 0.0v 149.745n 0.0v 149.755n 0.0v 154.745n 0.0v 154.755n 0.0v 159.745n 0.0v 159.755n 0.0v 164.745n 0.0v 164.755n 0.0v 169.745n 0.0v 169.755n 1.1v 174.745n 1.1v 174.755n 1.1v 179.745n 1.1v 179.755n 1.1v 184.745n 1.1v 184.755n 0.0v 189.745n 0.0v 189.755n 0.0v 194.745n 0.0v 194.755n 0.0v 199.745n 0.0v 199.755n 1.1v 204.745n 1.1v 204.755n 1.1v 209.745n 1.1v 209.755n 1.1v 214.745n 1.1v 214.755n 1.1v 219.745n 1.1v 219.755n 0.0v 224.745n 0.0v 224.755n 0.0v 229.745n 0.0v 229.755n 0.0v 234.745n 0.0v 234.755n 0.0v 239.745n 0.0v 239.755n 0.0v 244.745n 0.0v 244.755n 0.0v 249.745n 0.0v 249.755n 0.0v 254.745n 0.0v 254.755n 1.1v 259.745n 1.1v 259.755n 1.1v 264.745n 1.1v 264.755n 1.1v 269.745n 1.1v 269.755n 1.1v 274.745n 1.1v 274.755n 1.1v 279.745n 1.1v 279.755n 0.0v 284.745n 0.0v 284.755n 0.0v 289.745n 0.0v 289.755n 0.0v 294.745n 0.0v 294.755n 0.0v 299.745n 0.0v 299.755n 0.0v 304.745n 0.0v 304.755n 0.0v 309.745n 0.0v 309.755n 0.0v 314.745n 0.0v 314.755n 1.1v 319.745n 1.1v 319.755n 1.1v 324.745n 1.1v 324.755n 1.1v 329.745n 1.1v 329.755n 0.0v 334.745n 0.0v 334.755n 1.1v 339.745n 1.1v 339.755n 1.1v 344.745n 1.1v 344.755n 1.1v 349.745n 1.1v 349.755n 1.1v 354.745n 1.1v 354.755n 1.1v 359.745n 1.1v 359.755n 1.1v 364.745n 1.1v 364.755n 1.1v 369.745n 1.1v 369.755n 1.1v 374.745n 1.1v 374.755n 1.1v 379.745n 1.1v 379.755n 1.1v 384.745n 1.1v 384.755n 1.1v 389.745n 1.1v 389.755n 1.1v 394.745n 1.1v 394.755n 0.0v 399.745n 0.0v 399.755n 0.0v 404.745n 0.0v 404.755n 0.0v 409.745n 0.0v 409.755n 0.0v 414.745n 0.0v 414.755n 1.1v 419.745n 1.1v 419.755n 1.1v 424.745n 1.1v 424.755n 1.1v 429.745n 1.1v 429.755n 0.0v 434.745n 0.0v 434.755n 0.0v 439.745n 0.0v 439.755n 0.0v 444.745n 0.0v 444.755n 0.0v 449.745n 0.0v 449.755n 1.1v 454.745n 1.1v 454.755n 1.1v 459.745n 1.1v 459.755n 1.1v 464.745n 1.1v 464.755n 0.0v 469.745n 0.0v 469.755n 1.1v 474.745n 1.1v 474.755n 1.1v 479.745n 1.1v 479.755n 1.1v 484.745n 1.1v 484.755n 1.1v 489.745n 1.1v 489.755n 1.1v 494.745n 1.1v 494.755n 1.1v 499.745n 1.1v 499.755n 1.1v 504.745n 1.1v 504.755n 0.0v 509.745n 0.0v 509.755n 0.0v 514.745n 0.0v 514.755n 0.0v 519.745n 0.0v 519.755n 0.0v 524.745n 0.0v 524.755n 0.0v 529.745n 0.0v 529.755n 0.0v 534.745n 0.0v 534.755n 0.0v 539.745n 0.0v 539.755n 0.0v 544.745n 0.0v 544.755n 0.0v 549.745n 0.0v 549.755n 0.0v 554.745n 0.0v 554.755n 0.0v 559.745n 0.0v 559.755n 0.0v 564.745n 0.0v 564.755n 0.0v 569.745n 0.0v 569.755n 0.0v 574.745n 0.0v 574.755n 0.0v 579.745n 0.0v 579.755n 0.0v 584.745n 0.0v 584.755n 0.0v 589.745n 0.0v 589.755n 0.0v 594.745n 0.0v 594.755n 0.0v 599.745n 0.0v 599.755n 0.0v 604.745n 0.0v 604.755n 0.0v 609.745n 0.0v 609.755n 0.0v 614.745n 0.0v 614.755n 0.0v 619.745n 0.0v 619.755n 0.0v 624.745n 0.0v 624.755n 0.0v 629.745n 0.0v 629.755n 0.0v 634.745n 0.0v 634.755n 0.0v 639.745n 0.0v 639.755n 1.1v 644.745n 1.1v 644.755n 1.1v 649.745n 1.1v 649.755n 1.1v 654.745n 1.1v 654.755n 1.1v 659.745n 1.1v 659.755n 1.1v 664.745n 1.1v 664.755n 1.1v 669.745n 1.1v 669.755n 1.1v 674.745n 1.1v 674.755n 1.1v 679.745n 1.1v 679.755n 1.1v 684.745n 1.1v 684.755n 1.1v 689.745n 1.1v 689.755n 1.1v 694.745n 1.1v 694.755n 1.1v 699.745n 1.1v 699.755n 1.1v 704.745n 1.1v 704.755n 0.0v 709.745n 0.0v 709.755n 0.0v 714.745n 0.0v 714.755n 1.1v 719.745n 1.1v 719.755n 1.1v 724.745n 1.1v 724.755n 1.1v 729.745n 1.1v 729.755n 1.1v 734.745n 1.1v 734.755n 0.0v 739.745n 0.0v 739.755n 1.1v 744.745n 1.1v 744.755n 1.1v 749.745n 1.1v 749.755n 1.1v 754.745n 1.1v 754.755n 0.0v 759.745n 0.0v 759.755n 0.0v 764.745n 0.0v 764.755n 0.0v 769.745n 0.0v 769.755n 1.1v 774.745n 1.1v 774.755n 0.0v 779.745n 0.0v 779.755n 0.0v 784.745n 0.0v 784.755n 1.1v 789.745n 1.1v 789.755n 1.1v 794.745n 1.1v 794.755n 1.1v 799.745n 1.1v 799.755n 1.1v 804.745n 1.1v 804.755n 1.1v 809.745n 1.1v 809.755n 1.1v 814.745n 1.1v 814.755n 1.1v 819.745n 1.1v 819.755n 1.1v 824.745n 1.1v 824.755n 1.1v 829.745n 1.1v 829.755n 0.0v 834.745n 0.0v 834.755n 1.1v 839.745n 1.1v 839.755n 1.1v 844.745n 1.1v 844.755n 1.1v 849.745n 1.1v 849.755n 1.1v 854.745n 1.1v 854.755n 0.0v 859.745n 0.0v 859.755n 0.0v 864.745n 0.0v 864.755n 0.0v 869.745n 0.0v 869.755n 1.1v 874.745n 1.1v 874.755n 1.1v 879.745n 1.1v 879.755n 1.1v 884.745n 1.1v 884.755n 0.0v 889.745n 0.0v 889.755n 0.0v 894.745n 0.0v 894.755n 0.0v 899.745n 0.0v 899.755n 0.0v 904.745n 0.0v 904.755n 0.0v 909.745n 0.0v 909.755n 1.1v 914.745n 1.1v 914.755n 1.1v 919.745n 1.1v 919.755n 1.1v 924.745n 1.1v 924.755n 1.1v 929.745n 1.1v 929.755n 0.0v 934.745n 0.0v 934.755n 0.0v 939.745n 0.0v 939.755n 0.0v 944.745n 0.0v 944.755n 0.0v 949.745n 0.0v 949.755n 0.0v 954.745n 0.0v 954.755n 1.1v 959.745n 1.1v 959.755n 1.1v 964.745n 1.1v 964.755n 1.1v 969.745n 1.1v 969.755n 1.1v 974.745n 1.1v 974.755n 1.1v 979.745n 1.1v 979.755n 0.0v 984.745n 0.0v 984.755n 0.0v 989.745n 0.0v 989.755n 0.0v 994.745n 0.0v 994.755n 0.0v 999.745n 0.0v 999.755n 1.1v 1004.745n 1.1v 1004.755n 1.1v 1009.745n 1.1v 1009.755n 1.1v 1014.745n 1.1v 1014.755n 1.1v 1019.745n 1.1v 1019.755n 1.1v 1024.745n 1.1v 1024.755n 1.1v )
* (time, data): [(0, 0), (5, 1), (10, 0), (15, 1), (20, 1), (25, 1), (30, 1), (35, 1), (40, 1), (45, 1), (50, 1), (55, 1), (60, 0), (65, 0), (70, 0), (75, 0), (80, 0), (85, 0), (90, 0), (95, 0), (100, 1), (105, 1), (110, 1), (115, 1), (120, 1), (125, 1), (130, 1), (135, 0), (140, 0), (145, 0), (150, 0), (155, 0), (160, 0), (165, 0), (170, 1), (175, 1), (180, 1), (185, 1), (190, 1), (195, 1), (200, 1), (205, 1), (210, 0), (215, 0), (220, 1), (225, 1), (230, 1), (235, 1), (240, 1), (245, 1), (250, 1), (255, 1), (260, 1), (265, 0), (270, 0), (275, 0), (280, 1), (285, 1), (290, 1), (295, 1), (300, 0), (305, 0), (310, 0), (315, 1), (320, 1), (325, 1), (330, 1), (335, 1), (340, 1), (345, 1), (350, 1), (355, 1), (360, 1), (365, 1), (370, 1), (375, 1), (380, 1), (385, 1), (390, 1), (395, 1), (400, 1), (405, 1), (410, 1), (415, 0), (420, 1), (425, 1), (430, 0), (435, 0), (440, 0), (445, 0), (450, 1), (455, 1), (460, 1), (465, 0), (470, 1), (475, 1), (480, 0), (485, 0), (490, 0), (495, 1), (500, 1), (505, 1), (510, 0), (515, 1), (520, 1), (525, 1), (530, 1), (535, 1), (540, 1), (545, 1), (550, 1), (555, 0), (560, 0), (565, 0), (570, 0), (575, 1), (580, 1), (585, 1), (590, 1), (595, 1), (600, 1), (605, 1), (610, 1), (615, 1), (620, 1), (625, 1), (630, 0), (635, 0), (640, 0), (645, 0), (650, 0), (655, 1), (660, 0), (665, 0), (670, 0), (675, 0), (680, 0), (685, 0), (690, 0), (695, 0), (700, 0), (705, 1), (710, 1), (715, 0), (720, 0), (725, 0), (730, 0), (735, 0), (740, 1), (745, 1), (750, 1), (755, 0), (760, 0), (765, 0), (770, 0), (775, 1), (780, 1), (785, 1), (790, 1), (795, 1), (800, 1), (805, 1), (810, 1), (815, 1), (820, 1), (825, 1), (830, 1), (835, 0), (840, 0), (845, 0), (850, 0), (855, 0), (860, 1), (865, 1), (870, 1), (875, 1), (880, 0), (885, 0), (890, 0), (895, 0), (900, 0), (905, 0), (910, 0), (915, 0), (920, 0), (925, 0), (930, 0), (935, 0), (940, 1), (945, 1), (950, 1), (955, 0), (960, 0), (965, 1), (970, 1), (975, 1), (980, 0), (985, 0), (990, 0), (995, 1), (1000, 1), (1005, 1), (1010, 1), (1015, 1), (1020, 1), (1025, 1)]
Vdin0_61  din0_61  0 PWL (0n 0.0v 4.745n 0.0v 4.755n 1.1v 9.745n 1.1v 9.755n 0.0v 14.745n 0.0v 14.755n 1.1v 19.745n 1.1v 19.755n 1.1v 24.745n 1.1v 24.755n 1.1v 29.745n 1.1v 29.755n 1.1v 34.745n 1.1v 34.755n 1.1v 39.745n 1.1v 39.755n 1.1v 44.745n 1.1v 44.755n 1.1v 49.745n 1.1v 49.755n 1.1v 54.745n 1.1v 54.755n 1.1v 59.745n 1.1v 59.755n 0.0v 64.745n 0.0v 64.755n 0.0v 69.745n 0.0v 69.755n 0.0v 74.745n 0.0v 74.755n 0.0v 79.745n 0.0v 79.755n 0.0v 84.745n 0.0v 84.755n 0.0v 89.745n 0.0v 89.755n 0.0v 94.745n 0.0v 94.755n 0.0v 99.745n 0.0v 99.755n 1.1v 104.745n 1.1v 104.755n 1.1v 109.745n 1.1v 109.755n 1.1v 114.745n 1.1v 114.755n 1.1v 119.745n 1.1v 119.755n 1.1v 124.745n 1.1v 124.755n 1.1v 129.745n 1.1v 129.755n 1.1v 134.745n 1.1v 134.755n 0.0v 139.745n 0.0v 139.755n 0.0v 144.745n 0.0v 144.755n 0.0v 149.745n 0.0v 149.755n 0.0v 154.745n 0.0v 154.755n 0.0v 159.745n 0.0v 159.755n 0.0v 164.745n 0.0v 164.755n 0.0v 169.745n 0.0v 169.755n 1.1v 174.745n 1.1v 174.755n 1.1v 179.745n 1.1v 179.755n 1.1v 184.745n 1.1v 184.755n 1.1v 189.745n 1.1v 189.755n 1.1v 194.745n 1.1v 194.755n 1.1v 199.745n 1.1v 199.755n 1.1v 204.745n 1.1v 204.755n 1.1v 209.745n 1.1v 209.755n 0.0v 214.745n 0.0v 214.755n 0.0v 219.745n 0.0v 219.755n 1.1v 224.745n 1.1v 224.755n 1.1v 229.745n 1.1v 229.755n 1.1v 234.745n 1.1v 234.755n 1.1v 239.745n 1.1v 239.755n 1.1v 244.745n 1.1v 244.755n 1.1v 249.745n 1.1v 249.755n 1.1v 254.745n 1.1v 254.755n 1.1v 259.745n 1.1v 259.755n 1.1v 264.745n 1.1v 264.755n 0.0v 269.745n 0.0v 269.755n 0.0v 274.745n 0.0v 274.755n 0.0v 279.745n 0.0v 279.755n 1.1v 284.745n 1.1v 284.755n 1.1v 289.745n 1.1v 289.755n 1.1v 294.745n 1.1v 294.755n 1.1v 299.745n 1.1v 299.755n 0.0v 304.745n 0.0v 304.755n 0.0v 309.745n 0.0v 309.755n 0.0v 314.745n 0.0v 314.755n 1.1v 319.745n 1.1v 319.755n 1.1v 324.745n 1.1v 324.755n 1.1v 329.745n 1.1v 329.755n 1.1v 334.745n 1.1v 334.755n 1.1v 339.745n 1.1v 339.755n 1.1v 344.745n 1.1v 344.755n 1.1v 349.745n 1.1v 349.755n 1.1v 354.745n 1.1v 354.755n 1.1v 359.745n 1.1v 359.755n 1.1v 364.745n 1.1v 364.755n 1.1v 369.745n 1.1v 369.755n 1.1v 374.745n 1.1v 374.755n 1.1v 379.745n 1.1v 379.755n 1.1v 384.745n 1.1v 384.755n 1.1v 389.745n 1.1v 389.755n 1.1v 394.745n 1.1v 394.755n 1.1v 399.745n 1.1v 399.755n 1.1v 404.745n 1.1v 404.755n 1.1v 409.745n 1.1v 409.755n 1.1v 414.745n 1.1v 414.755n 0.0v 419.745n 0.0v 419.755n 1.1v 424.745n 1.1v 424.755n 1.1v 429.745n 1.1v 429.755n 0.0v 434.745n 0.0v 434.755n 0.0v 439.745n 0.0v 439.755n 0.0v 444.745n 0.0v 444.755n 0.0v 449.745n 0.0v 449.755n 1.1v 454.745n 1.1v 454.755n 1.1v 459.745n 1.1v 459.755n 1.1v 464.745n 1.1v 464.755n 0.0v 469.745n 0.0v 469.755n 1.1v 474.745n 1.1v 474.755n 1.1v 479.745n 1.1v 479.755n 0.0v 484.745n 0.0v 484.755n 0.0v 489.745n 0.0v 489.755n 0.0v 494.745n 0.0v 494.755n 1.1v 499.745n 1.1v 499.755n 1.1v 504.745n 1.1v 504.755n 1.1v 509.745n 1.1v 509.755n 0.0v 514.745n 0.0v 514.755n 1.1v 519.745n 1.1v 519.755n 1.1v 524.745n 1.1v 524.755n 1.1v 529.745n 1.1v 529.755n 1.1v 534.745n 1.1v 534.755n 1.1v 539.745n 1.1v 539.755n 1.1v 544.745n 1.1v 544.755n 1.1v 549.745n 1.1v 549.755n 1.1v 554.745n 1.1v 554.755n 0.0v 559.745n 0.0v 559.755n 0.0v 564.745n 0.0v 564.755n 0.0v 569.745n 0.0v 569.755n 0.0v 574.745n 0.0v 574.755n 1.1v 579.745n 1.1v 579.755n 1.1v 584.745n 1.1v 584.755n 1.1v 589.745n 1.1v 589.755n 1.1v 594.745n 1.1v 594.755n 1.1v 599.745n 1.1v 599.755n 1.1v 604.745n 1.1v 604.755n 1.1v 609.745n 1.1v 609.755n 1.1v 614.745n 1.1v 614.755n 1.1v 619.745n 1.1v 619.755n 1.1v 624.745n 1.1v 624.755n 1.1v 629.745n 1.1v 629.755n 0.0v 634.745n 0.0v 634.755n 0.0v 639.745n 0.0v 639.755n 0.0v 644.745n 0.0v 644.755n 0.0v 649.745n 0.0v 649.755n 0.0v 654.745n 0.0v 654.755n 1.1v 659.745n 1.1v 659.755n 0.0v 664.745n 0.0v 664.755n 0.0v 669.745n 0.0v 669.755n 0.0v 674.745n 0.0v 674.755n 0.0v 679.745n 0.0v 679.755n 0.0v 684.745n 0.0v 684.755n 0.0v 689.745n 0.0v 689.755n 0.0v 694.745n 0.0v 694.755n 0.0v 699.745n 0.0v 699.755n 0.0v 704.745n 0.0v 704.755n 1.1v 709.745n 1.1v 709.755n 1.1v 714.745n 1.1v 714.755n 0.0v 719.745n 0.0v 719.755n 0.0v 724.745n 0.0v 724.755n 0.0v 729.745n 0.0v 729.755n 0.0v 734.745n 0.0v 734.755n 0.0v 739.745n 0.0v 739.755n 1.1v 744.745n 1.1v 744.755n 1.1v 749.745n 1.1v 749.755n 1.1v 754.745n 1.1v 754.755n 0.0v 759.745n 0.0v 759.755n 0.0v 764.745n 0.0v 764.755n 0.0v 769.745n 0.0v 769.755n 0.0v 774.745n 0.0v 774.755n 1.1v 779.745n 1.1v 779.755n 1.1v 784.745n 1.1v 784.755n 1.1v 789.745n 1.1v 789.755n 1.1v 794.745n 1.1v 794.755n 1.1v 799.745n 1.1v 799.755n 1.1v 804.745n 1.1v 804.755n 1.1v 809.745n 1.1v 809.755n 1.1v 814.745n 1.1v 814.755n 1.1v 819.745n 1.1v 819.755n 1.1v 824.745n 1.1v 824.755n 1.1v 829.745n 1.1v 829.755n 1.1v 834.745n 1.1v 834.755n 0.0v 839.745n 0.0v 839.755n 0.0v 844.745n 0.0v 844.755n 0.0v 849.745n 0.0v 849.755n 0.0v 854.745n 0.0v 854.755n 0.0v 859.745n 0.0v 859.755n 1.1v 864.745n 1.1v 864.755n 1.1v 869.745n 1.1v 869.755n 1.1v 874.745n 1.1v 874.755n 1.1v 879.745n 1.1v 879.755n 0.0v 884.745n 0.0v 884.755n 0.0v 889.745n 0.0v 889.755n 0.0v 894.745n 0.0v 894.755n 0.0v 899.745n 0.0v 899.755n 0.0v 904.745n 0.0v 904.755n 0.0v 909.745n 0.0v 909.755n 0.0v 914.745n 0.0v 914.755n 0.0v 919.745n 0.0v 919.755n 0.0v 924.745n 0.0v 924.755n 0.0v 929.745n 0.0v 929.755n 0.0v 934.745n 0.0v 934.755n 0.0v 939.745n 0.0v 939.755n 1.1v 944.745n 1.1v 944.755n 1.1v 949.745n 1.1v 949.755n 1.1v 954.745n 1.1v 954.755n 0.0v 959.745n 0.0v 959.755n 0.0v 964.745n 0.0v 964.755n 1.1v 969.745n 1.1v 969.755n 1.1v 974.745n 1.1v 974.755n 1.1v 979.745n 1.1v 979.755n 0.0v 984.745n 0.0v 984.755n 0.0v 989.745n 0.0v 989.755n 0.0v 994.745n 0.0v 994.755n 1.1v 999.745n 1.1v 999.755n 1.1v 1004.745n 1.1v 1004.755n 1.1v 1009.745n 1.1v 1009.755n 1.1v 1014.745n 1.1v 1014.755n 1.1v 1019.745n 1.1v 1019.755n 1.1v 1024.745n 1.1v 1024.755n 1.1v )
* (time, data): [(0, 0), (5, 0), (10, 1), (15, 0), (20, 0), (25, 0), (30, 1), (35, 1), (40, 0), (45, 0), (50, 0), (55, 0), (60, 1), (65, 1), (70, 1), (75, 1), (80, 1), (85, 1), (90, 0), (95, 0), (100, 1), (105, 1), (110, 1), (115, 1), (120, 1), (125, 1), (130, 1), (135, 1), (140, 0), (145, 0), (150, 0), (155, 0), (160, 0), (165, 0), (170, 1), (175, 1), (180, 1), (185, 1), (190, 1), (195, 1), (200, 1), (205, 1), (210, 1), (215, 1), (220, 1), (225, 1), (230, 1), (235, 1), (240, 0), (245, 0), (250, 0), (255, 1), (260, 1), (265, 1), (270, 1), (275, 1), (280, 1), (285, 1), (290, 1), (295, 1), (300, 1), (305, 1), (310, 1), (315, 1), (320, 1), (325, 1), (330, 0), (335, 0), (340, 1), (345, 1), (350, 1), (355, 1), (360, 0), (365, 0), (370, 0), (375, 0), (380, 0), (385, 0), (390, 0), (395, 0), (400, 1), (405, 1), (410, 0), (415, 0), (420, 0), (425, 1), (430, 1), (435, 1), (440, 1), (445, 1), (450, 1), (455, 1), (460, 0), (465, 0), (470, 1), (475, 1), (480, 0), (485, 0), (490, 0), (495, 0), (500, 0), (505, 1), (510, 1), (515, 0), (520, 0), (525, 0), (530, 0), (535, 0), (540, 1), (545, 1), (550, 1), (555, 1), (560, 1), (565, 1), (570, 1), (575, 0), (580, 0), (585, 0), (590, 0), (595, 0), (600, 0), (605, 0), (610, 0), (615, 0), (620, 0), (625, 0), (630, 1), (635, 1), (640, 1), (645, 1), (650, 1), (655, 0), (660, 0), (665, 0), (670, 1), (675, 1), (680, 1), (685, 1), (690, 1), (695, 1), (700, 1), (705, 1), (710, 1), (715, 1), (720, 1), (725, 1), (730, 1), (735, 1), (740, 0), (745, 0), (750, 0), (755, 1), (760, 1), (765, 1), (770, 1), (775, 1), (780, 1), (785, 0), (790, 0), (795, 0), (800, 0), (805, 0), (810, 0), (815, 0), (820, 0), (825, 0), (830, 0), (835, 0), (840, 0), (845, 0), (850, 0), (855, 0), (860, 1), (865, 0), (870, 1), (875, 1), (880, 1), (885, 0), (890, 0), (895, 0), (900, 0), (905, 0), (910, 1), (915, 1), (920, 1), (925, 1), (930, 1), (935, 0), (940, 1), (945, 1), (950, 1), (955, 0), (960, 0), (965, 1), (970, 1), (975, 1), (980, 0), (985, 1), (990, 1), (995, 1), (1000, 1), (1005, 1), (1010, 1), (1015, 1), (1020, 1), (1025, 1)]
Vdin0_62  din0_62  0 PWL (0n 0.0v 4.745n 0.0v 4.755n 0.0v 9.745n 0.0v 9.755n 1.1v 14.745n 1.1v 14.755n 0.0v 19.745n 0.0v 19.755n 0.0v 24.745n 0.0v 24.755n 0.0v 29.745n 0.0v 29.755n 1.1v 34.745n 1.1v 34.755n 1.1v 39.745n 1.1v 39.755n 0.0v 44.745n 0.0v 44.755n 0.0v 49.745n 0.0v 49.755n 0.0v 54.745n 0.0v 54.755n 0.0v 59.745n 0.0v 59.755n 1.1v 64.745n 1.1v 64.755n 1.1v 69.745n 1.1v 69.755n 1.1v 74.745n 1.1v 74.755n 1.1v 79.745n 1.1v 79.755n 1.1v 84.745n 1.1v 84.755n 1.1v 89.745n 1.1v 89.755n 0.0v 94.745n 0.0v 94.755n 0.0v 99.745n 0.0v 99.755n 1.1v 104.745n 1.1v 104.755n 1.1v 109.745n 1.1v 109.755n 1.1v 114.745n 1.1v 114.755n 1.1v 119.745n 1.1v 119.755n 1.1v 124.745n 1.1v 124.755n 1.1v 129.745n 1.1v 129.755n 1.1v 134.745n 1.1v 134.755n 1.1v 139.745n 1.1v 139.755n 0.0v 144.745n 0.0v 144.755n 0.0v 149.745n 0.0v 149.755n 0.0v 154.745n 0.0v 154.755n 0.0v 159.745n 0.0v 159.755n 0.0v 164.745n 0.0v 164.755n 0.0v 169.745n 0.0v 169.755n 1.1v 174.745n 1.1v 174.755n 1.1v 179.745n 1.1v 179.755n 1.1v 184.745n 1.1v 184.755n 1.1v 189.745n 1.1v 189.755n 1.1v 194.745n 1.1v 194.755n 1.1v 199.745n 1.1v 199.755n 1.1v 204.745n 1.1v 204.755n 1.1v 209.745n 1.1v 209.755n 1.1v 214.745n 1.1v 214.755n 1.1v 219.745n 1.1v 219.755n 1.1v 224.745n 1.1v 224.755n 1.1v 229.745n 1.1v 229.755n 1.1v 234.745n 1.1v 234.755n 1.1v 239.745n 1.1v 239.755n 0.0v 244.745n 0.0v 244.755n 0.0v 249.745n 0.0v 249.755n 0.0v 254.745n 0.0v 254.755n 1.1v 259.745n 1.1v 259.755n 1.1v 264.745n 1.1v 264.755n 1.1v 269.745n 1.1v 269.755n 1.1v 274.745n 1.1v 274.755n 1.1v 279.745n 1.1v 279.755n 1.1v 284.745n 1.1v 284.755n 1.1v 289.745n 1.1v 289.755n 1.1v 294.745n 1.1v 294.755n 1.1v 299.745n 1.1v 299.755n 1.1v 304.745n 1.1v 304.755n 1.1v 309.745n 1.1v 309.755n 1.1v 314.745n 1.1v 314.755n 1.1v 319.745n 1.1v 319.755n 1.1v 324.745n 1.1v 324.755n 1.1v 329.745n 1.1v 329.755n 0.0v 334.745n 0.0v 334.755n 0.0v 339.745n 0.0v 339.755n 1.1v 344.745n 1.1v 344.755n 1.1v 349.745n 1.1v 349.755n 1.1v 354.745n 1.1v 354.755n 1.1v 359.745n 1.1v 359.755n 0.0v 364.745n 0.0v 364.755n 0.0v 369.745n 0.0v 369.755n 0.0v 374.745n 0.0v 374.755n 0.0v 379.745n 0.0v 379.755n 0.0v 384.745n 0.0v 384.755n 0.0v 389.745n 0.0v 389.755n 0.0v 394.745n 0.0v 394.755n 0.0v 399.745n 0.0v 399.755n 1.1v 404.745n 1.1v 404.755n 1.1v 409.745n 1.1v 409.755n 0.0v 414.745n 0.0v 414.755n 0.0v 419.745n 0.0v 419.755n 0.0v 424.745n 0.0v 424.755n 1.1v 429.745n 1.1v 429.755n 1.1v 434.745n 1.1v 434.755n 1.1v 439.745n 1.1v 439.755n 1.1v 444.745n 1.1v 444.755n 1.1v 449.745n 1.1v 449.755n 1.1v 454.745n 1.1v 454.755n 1.1v 459.745n 1.1v 459.755n 0.0v 464.745n 0.0v 464.755n 0.0v 469.745n 0.0v 469.755n 1.1v 474.745n 1.1v 474.755n 1.1v 479.745n 1.1v 479.755n 0.0v 484.745n 0.0v 484.755n 0.0v 489.745n 0.0v 489.755n 0.0v 494.745n 0.0v 494.755n 0.0v 499.745n 0.0v 499.755n 0.0v 504.745n 0.0v 504.755n 1.1v 509.745n 1.1v 509.755n 1.1v 514.745n 1.1v 514.755n 0.0v 519.745n 0.0v 519.755n 0.0v 524.745n 0.0v 524.755n 0.0v 529.745n 0.0v 529.755n 0.0v 534.745n 0.0v 534.755n 0.0v 539.745n 0.0v 539.755n 1.1v 544.745n 1.1v 544.755n 1.1v 549.745n 1.1v 549.755n 1.1v 554.745n 1.1v 554.755n 1.1v 559.745n 1.1v 559.755n 1.1v 564.745n 1.1v 564.755n 1.1v 569.745n 1.1v 569.755n 1.1v 574.745n 1.1v 574.755n 0.0v 579.745n 0.0v 579.755n 0.0v 584.745n 0.0v 584.755n 0.0v 589.745n 0.0v 589.755n 0.0v 594.745n 0.0v 594.755n 0.0v 599.745n 0.0v 599.755n 0.0v 604.745n 0.0v 604.755n 0.0v 609.745n 0.0v 609.755n 0.0v 614.745n 0.0v 614.755n 0.0v 619.745n 0.0v 619.755n 0.0v 624.745n 0.0v 624.755n 0.0v 629.745n 0.0v 629.755n 1.1v 634.745n 1.1v 634.755n 1.1v 639.745n 1.1v 639.755n 1.1v 644.745n 1.1v 644.755n 1.1v 649.745n 1.1v 649.755n 1.1v 654.745n 1.1v 654.755n 0.0v 659.745n 0.0v 659.755n 0.0v 664.745n 0.0v 664.755n 0.0v 669.745n 0.0v 669.755n 1.1v 674.745n 1.1v 674.755n 1.1v 679.745n 1.1v 679.755n 1.1v 684.745n 1.1v 684.755n 1.1v 689.745n 1.1v 689.755n 1.1v 694.745n 1.1v 694.755n 1.1v 699.745n 1.1v 699.755n 1.1v 704.745n 1.1v 704.755n 1.1v 709.745n 1.1v 709.755n 1.1v 714.745n 1.1v 714.755n 1.1v 719.745n 1.1v 719.755n 1.1v 724.745n 1.1v 724.755n 1.1v 729.745n 1.1v 729.755n 1.1v 734.745n 1.1v 734.755n 1.1v 739.745n 1.1v 739.755n 0.0v 744.745n 0.0v 744.755n 0.0v 749.745n 0.0v 749.755n 0.0v 754.745n 0.0v 754.755n 1.1v 759.745n 1.1v 759.755n 1.1v 764.745n 1.1v 764.755n 1.1v 769.745n 1.1v 769.755n 1.1v 774.745n 1.1v 774.755n 1.1v 779.745n 1.1v 779.755n 1.1v 784.745n 1.1v 784.755n 0.0v 789.745n 0.0v 789.755n 0.0v 794.745n 0.0v 794.755n 0.0v 799.745n 0.0v 799.755n 0.0v 804.745n 0.0v 804.755n 0.0v 809.745n 0.0v 809.755n 0.0v 814.745n 0.0v 814.755n 0.0v 819.745n 0.0v 819.755n 0.0v 824.745n 0.0v 824.755n 0.0v 829.745n 0.0v 829.755n 0.0v 834.745n 0.0v 834.755n 0.0v 839.745n 0.0v 839.755n 0.0v 844.745n 0.0v 844.755n 0.0v 849.745n 0.0v 849.755n 0.0v 854.745n 0.0v 854.755n 0.0v 859.745n 0.0v 859.755n 1.1v 864.745n 1.1v 864.755n 0.0v 869.745n 0.0v 869.755n 1.1v 874.745n 1.1v 874.755n 1.1v 879.745n 1.1v 879.755n 1.1v 884.745n 1.1v 884.755n 0.0v 889.745n 0.0v 889.755n 0.0v 894.745n 0.0v 894.755n 0.0v 899.745n 0.0v 899.755n 0.0v 904.745n 0.0v 904.755n 0.0v 909.745n 0.0v 909.755n 1.1v 914.745n 1.1v 914.755n 1.1v 919.745n 1.1v 919.755n 1.1v 924.745n 1.1v 924.755n 1.1v 929.745n 1.1v 929.755n 1.1v 934.745n 1.1v 934.755n 0.0v 939.745n 0.0v 939.755n 1.1v 944.745n 1.1v 944.755n 1.1v 949.745n 1.1v 949.755n 1.1v 954.745n 1.1v 954.755n 0.0v 959.745n 0.0v 959.755n 0.0v 964.745n 0.0v 964.755n 1.1v 969.745n 1.1v 969.755n 1.1v 974.745n 1.1v 974.755n 1.1v 979.745n 1.1v 979.755n 0.0v 984.745n 0.0v 984.755n 1.1v 989.745n 1.1v 989.755n 1.1v 994.745n 1.1v 994.755n 1.1v 999.745n 1.1v 999.755n 1.1v 1004.745n 1.1v 1004.755n 1.1v 1009.745n 1.1v 1009.755n 1.1v 1014.745n 1.1v 1014.755n 1.1v 1019.745n 1.1v 1019.755n 1.1v 1024.745n 1.1v 1024.755n 1.1v )
* (time, data): [(0, 0), (5, 1), (10, 0), (15, 1), (20, 1), (25, 1), (30, 0), (35, 0), (40, 1), (45, 1), (50, 1), (55, 1), (60, 0), (65, 0), (70, 0), (75, 0), (80, 0), (85, 0), (90, 0), (95, 0), (100, 0), (105, 0), (110, 0), (115, 0), (120, 0), (125, 0), (130, 0), (135, 1), (140, 0), (145, 0), (150, 0), (155, 0), (160, 0), (165, 0), (170, 0), (175, 0), (180, 0), (185, 1), (190, 1), (195, 1), (200, 0), (205, 0), (210, 0), (215, 0), (220, 1), (225, 1), (230, 1), (235, 1), (240, 0), (245, 0), (250, 0), (255, 1), (260, 1), (265, 0), (270, 0), (275, 0), (280, 0), (285, 0), (290, 0), (295, 0), (300, 0), (305, 0), (310, 0), (315, 1), (320, 1), (325, 1), (330, 1), (335, 1), (340, 0), (345, 0), (350, 0), (355, 0), (360, 0), (365, 0), (370, 0), (375, 0), (380, 0), (385, 0), (390, 0), (395, 0), (400, 0), (405, 0), (410, 1), (415, 0), (420, 1), (425, 1), (430, 1), (435, 1), (440, 1), (445, 1), (450, 0), (455, 0), (460, 0), (465, 0), (470, 0), (475, 0), (480, 0), (485, 0), (490, 0), (495, 0), (500, 1), (505, 1), (510, 1), (515, 1), (520, 1), (525, 1), (530, 1), (535, 1), (540, 0), (545, 0), (550, 0), (555, 0), (560, 0), (565, 0), (570, 0), (575, 1), (580, 1), (585, 1), (590, 1), (595, 1), (600, 1), (605, 1), (610, 1), (615, 1), (620, 1), (625, 1), (630, 0), (635, 0), (640, 0), (645, 0), (650, 0), (655, 1), (660, 0), (665, 0), (670, 1), (675, 1), (680, 1), (685, 1), (690, 1), (695, 1), (700, 1), (705, 0), (710, 0), (715, 1), (720, 1), (725, 1), (730, 1), (735, 0), (740, 1), (745, 1), (750, 1), (755, 0), (760, 0), (765, 0), (770, 1), (775, 1), (780, 1), (785, 1), (790, 1), (795, 1), (800, 1), (805, 1), (810, 1), (815, 1), (820, 0), (825, 0), (830, 1), (835, 1), (840, 1), (845, 1), (850, 1), (855, 0), (860, 0), (865, 1), (870, 0), (875, 0), (880, 1), (885, 0), (890, 0), (895, 0), (900, 0), (905, 0), (910, 0), (915, 0), (920, 0), (925, 0), (930, 1), (935, 1), (940, 1), (945, 1), (950, 1), (955, 1), (960, 1), (965, 1), (970, 1), (975, 1), (980, 0), (985, 0), (990, 0), (995, 1), (1000, 0), (1005, 0), (1010, 0), (1015, 0), (1020, 0), (1025, 0)]
Vdin0_63  din0_63  0 PWL (0n 0.0v 4.745n 0.0v 4.755n 1.1v 9.745n 1.1v 9.755n 0.0v 14.745n 0.0v 14.755n 1.1v 19.745n 1.1v 19.755n 1.1v 24.745n 1.1v 24.755n 1.1v 29.745n 1.1v 29.755n 0.0v 34.745n 0.0v 34.755n 0.0v 39.745n 0.0v 39.755n 1.1v 44.745n 1.1v 44.755n 1.1v 49.745n 1.1v 49.755n 1.1v 54.745n 1.1v 54.755n 1.1v 59.745n 1.1v 59.755n 0.0v 64.745n 0.0v 64.755n 0.0v 69.745n 0.0v 69.755n 0.0v 74.745n 0.0v 74.755n 0.0v 79.745n 0.0v 79.755n 0.0v 84.745n 0.0v 84.755n 0.0v 89.745n 0.0v 89.755n 0.0v 94.745n 0.0v 94.755n 0.0v 99.745n 0.0v 99.755n 0.0v 104.745n 0.0v 104.755n 0.0v 109.745n 0.0v 109.755n 0.0v 114.745n 0.0v 114.755n 0.0v 119.745n 0.0v 119.755n 0.0v 124.745n 0.0v 124.755n 0.0v 129.745n 0.0v 129.755n 0.0v 134.745n 0.0v 134.755n 1.1v 139.745n 1.1v 139.755n 0.0v 144.745n 0.0v 144.755n 0.0v 149.745n 0.0v 149.755n 0.0v 154.745n 0.0v 154.755n 0.0v 159.745n 0.0v 159.755n 0.0v 164.745n 0.0v 164.755n 0.0v 169.745n 0.0v 169.755n 0.0v 174.745n 0.0v 174.755n 0.0v 179.745n 0.0v 179.755n 0.0v 184.745n 0.0v 184.755n 1.1v 189.745n 1.1v 189.755n 1.1v 194.745n 1.1v 194.755n 1.1v 199.745n 1.1v 199.755n 0.0v 204.745n 0.0v 204.755n 0.0v 209.745n 0.0v 209.755n 0.0v 214.745n 0.0v 214.755n 0.0v 219.745n 0.0v 219.755n 1.1v 224.745n 1.1v 224.755n 1.1v 229.745n 1.1v 229.755n 1.1v 234.745n 1.1v 234.755n 1.1v 239.745n 1.1v 239.755n 0.0v 244.745n 0.0v 244.755n 0.0v 249.745n 0.0v 249.755n 0.0v 254.745n 0.0v 254.755n 1.1v 259.745n 1.1v 259.755n 1.1v 264.745n 1.1v 264.755n 0.0v 269.745n 0.0v 269.755n 0.0v 274.745n 0.0v 274.755n 0.0v 279.745n 0.0v 279.755n 0.0v 284.745n 0.0v 284.755n 0.0v 289.745n 0.0v 289.755n 0.0v 294.745n 0.0v 294.755n 0.0v 299.745n 0.0v 299.755n 0.0v 304.745n 0.0v 304.755n 0.0v 309.745n 0.0v 309.755n 0.0v 314.745n 0.0v 314.755n 1.1v 319.745n 1.1v 319.755n 1.1v 324.745n 1.1v 324.755n 1.1v 329.745n 1.1v 329.755n 1.1v 334.745n 1.1v 334.755n 1.1v 339.745n 1.1v 339.755n 0.0v 344.745n 0.0v 344.755n 0.0v 349.745n 0.0v 349.755n 0.0v 354.745n 0.0v 354.755n 0.0v 359.745n 0.0v 359.755n 0.0v 364.745n 0.0v 364.755n 0.0v 369.745n 0.0v 369.755n 0.0v 374.745n 0.0v 374.755n 0.0v 379.745n 0.0v 379.755n 0.0v 384.745n 0.0v 384.755n 0.0v 389.745n 0.0v 389.755n 0.0v 394.745n 0.0v 394.755n 0.0v 399.745n 0.0v 399.755n 0.0v 404.745n 0.0v 404.755n 0.0v 409.745n 0.0v 409.755n 1.1v 414.745n 1.1v 414.755n 0.0v 419.745n 0.0v 419.755n 1.1v 424.745n 1.1v 424.755n 1.1v 429.745n 1.1v 429.755n 1.1v 434.745n 1.1v 434.755n 1.1v 439.745n 1.1v 439.755n 1.1v 444.745n 1.1v 444.755n 1.1v 449.745n 1.1v 449.755n 0.0v 454.745n 0.0v 454.755n 0.0v 459.745n 0.0v 459.755n 0.0v 464.745n 0.0v 464.755n 0.0v 469.745n 0.0v 469.755n 0.0v 474.745n 0.0v 474.755n 0.0v 479.745n 0.0v 479.755n 0.0v 484.745n 0.0v 484.755n 0.0v 489.745n 0.0v 489.755n 0.0v 494.745n 0.0v 494.755n 0.0v 499.745n 0.0v 499.755n 1.1v 504.745n 1.1v 504.755n 1.1v 509.745n 1.1v 509.755n 1.1v 514.745n 1.1v 514.755n 1.1v 519.745n 1.1v 519.755n 1.1v 524.745n 1.1v 524.755n 1.1v 529.745n 1.1v 529.755n 1.1v 534.745n 1.1v 534.755n 1.1v 539.745n 1.1v 539.755n 0.0v 544.745n 0.0v 544.755n 0.0v 549.745n 0.0v 549.755n 0.0v 554.745n 0.0v 554.755n 0.0v 559.745n 0.0v 559.755n 0.0v 564.745n 0.0v 564.755n 0.0v 569.745n 0.0v 569.755n 0.0v 574.745n 0.0v 574.755n 1.1v 579.745n 1.1v 579.755n 1.1v 584.745n 1.1v 584.755n 1.1v 589.745n 1.1v 589.755n 1.1v 594.745n 1.1v 594.755n 1.1v 599.745n 1.1v 599.755n 1.1v 604.745n 1.1v 604.755n 1.1v 609.745n 1.1v 609.755n 1.1v 614.745n 1.1v 614.755n 1.1v 619.745n 1.1v 619.755n 1.1v 624.745n 1.1v 624.755n 1.1v 629.745n 1.1v 629.755n 0.0v 634.745n 0.0v 634.755n 0.0v 639.745n 0.0v 639.755n 0.0v 644.745n 0.0v 644.755n 0.0v 649.745n 0.0v 649.755n 0.0v 654.745n 0.0v 654.755n 1.1v 659.745n 1.1v 659.755n 0.0v 664.745n 0.0v 664.755n 0.0v 669.745n 0.0v 669.755n 1.1v 674.745n 1.1v 674.755n 1.1v 679.745n 1.1v 679.755n 1.1v 684.745n 1.1v 684.755n 1.1v 689.745n 1.1v 689.755n 1.1v 694.745n 1.1v 694.755n 1.1v 699.745n 1.1v 699.755n 1.1v 704.745n 1.1v 704.755n 0.0v 709.745n 0.0v 709.755n 0.0v 714.745n 0.0v 714.755n 1.1v 719.745n 1.1v 719.755n 1.1v 724.745n 1.1v 724.755n 1.1v 729.745n 1.1v 729.755n 1.1v 734.745n 1.1v 734.755n 0.0v 739.745n 0.0v 739.755n 1.1v 744.745n 1.1v 744.755n 1.1v 749.745n 1.1v 749.755n 1.1v 754.745n 1.1v 754.755n 0.0v 759.745n 0.0v 759.755n 0.0v 764.745n 0.0v 764.755n 0.0v 769.745n 0.0v 769.755n 1.1v 774.745n 1.1v 774.755n 1.1v 779.745n 1.1v 779.755n 1.1v 784.745n 1.1v 784.755n 1.1v 789.745n 1.1v 789.755n 1.1v 794.745n 1.1v 794.755n 1.1v 799.745n 1.1v 799.755n 1.1v 804.745n 1.1v 804.755n 1.1v 809.745n 1.1v 809.755n 1.1v 814.745n 1.1v 814.755n 1.1v 819.745n 1.1v 819.755n 0.0v 824.745n 0.0v 824.755n 0.0v 829.745n 0.0v 829.755n 1.1v 834.745n 1.1v 834.755n 1.1v 839.745n 1.1v 839.755n 1.1v 844.745n 1.1v 844.755n 1.1v 849.745n 1.1v 849.755n 1.1v 854.745n 1.1v 854.755n 0.0v 859.745n 0.0v 859.755n 0.0v 864.745n 0.0v 864.755n 1.1v 869.745n 1.1v 869.755n 0.0v 874.745n 0.0v 874.755n 0.0v 879.745n 0.0v 879.755n 1.1v 884.745n 1.1v 884.755n 0.0v 889.745n 0.0v 889.755n 0.0v 894.745n 0.0v 894.755n 0.0v 899.745n 0.0v 899.755n 0.0v 904.745n 0.0v 904.755n 0.0v 909.745n 0.0v 909.755n 0.0v 914.745n 0.0v 914.755n 0.0v 919.745n 0.0v 919.755n 0.0v 924.745n 0.0v 924.755n 0.0v 929.745n 0.0v 929.755n 1.1v 934.745n 1.1v 934.755n 1.1v 939.745n 1.1v 939.755n 1.1v 944.745n 1.1v 944.755n 1.1v 949.745n 1.1v 949.755n 1.1v 954.745n 1.1v 954.755n 1.1v 959.745n 1.1v 959.755n 1.1v 964.745n 1.1v 964.755n 1.1v 969.745n 1.1v 969.755n 1.1v 974.745n 1.1v 974.755n 1.1v 979.745n 1.1v 979.755n 0.0v 984.745n 0.0v 984.755n 0.0v 989.745n 0.0v 989.755n 0.0v 994.745n 0.0v 994.755n 1.1v 999.745n 1.1v 999.755n 0.0v 1004.745n 0.0v 1004.755n 0.0v 1009.745n 0.0v 1009.755n 0.0v 1014.745n 0.0v 1014.755n 0.0v 1019.745n 0.0v 1019.755n 0.0v 1024.745n 0.0v 1024.755n 0.0v )
* (time, data): [(0, 0), (5, 0), (10, 0), (15, 1), (20, 0), (25, 0), (30, 1), (35, 1), (40, 0), (45, 1), (50, 1), (55, 1), (60, 0), (65, 0), (70, 0), (75, 0), (80, 0), (85, 0), (90, 0), (95, 0), (100, 0), (105, 0), (110, 0), (115, 0), (120, 0), (125, 0), (130, 1), (135, 1), (140, 0), (145, 0), (150, 0), (155, 1), (160, 1), (165, 0), (170, 1), (175, 1), (180, 0), (185, 1), (190, 0), (195, 0), (200, 1), (205, 1), (210, 0), (215, 1), (220, 0), (225, 0), (230, 0), (235, 1), (240, 0), (245, 0), (250, 0), (255, 0), (260, 0), (265, 0), (270, 0), (275, 0), (280, 0), (285, 0), (290, 0), (295, 0), (300, 0), (305, 0), (310, 0), (315, 1), (320, 1), (325, 1), (330, 0), (335, 0), (340, 1), (345, 1), (350, 1), (355, 1), (360, 0), (365, 0), (370, 0), (375, 0), (380, 0), (385, 0), (390, 0), (395, 1), (400, 1), (405, 1), (410, 1), (415, 0), (420, 1), (425, 0), (430, 1), (435, 1), (440, 1), (445, 1), (450, 1), (455, 0), (460, 1), (465, 1), (470, 0), (475, 0), (480, 0), (485, 0), (490, 0), (495, 1), (500, 1), (505, 1), (510, 0), (515, 0), (520, 0), (525, 0), (530, 0), (535, 0), (540, 0), (545, 0), (550, 0), (555, 1), (560, 1), (565, 0), (570, 0), (575, 1), (580, 1), (585, 0), (590, 1), (595, 1), (600, 0), (605, 1), (610, 1), (615, 1), (620, 1), (625, 1), (630, 1), (635, 1), (640, 1), (645, 1), (650, 1), (655, 0), (660, 0), (665, 0), (670, 1), (675, 1), (680, 0), (685, 1), (690, 0), (695, 1), (700, 1), (705, 1), (710, 1), (715, 1), (720, 0), (725, 1), (730, 1), (735, 0), (740, 0), (745, 1), (750, 1), (755, 0), (760, 0), (765, 0), (770, 0), (775, 1), (780, 0), (785, 0), (790, 0), (795, 0), (800, 0), (805, 0), (810, 0), (815, 0), (820, 1), (825, 0), (830, 1), (835, 1), (840, 0), (845, 0), (850, 0), (855, 0), (860, 1), (865, 0), (870, 1), (875, 0), (880, 1), (885, 0), (890, 0), (895, 0), (900, 0), (905, 0), (910, 1), (915, 1), (920, 0), (925, 0), (930, 0), (935, 1), (940, 0), (945, 0), (950, 0), (955, 1), (960, 1), (965, 0), (970, 0), (975, 1), (980, 1), (985, 0), (990, 0), (995, 1), (1000, 0), (1005, 0), (1010, 1), (1015, 1), (1020, 0), (1025, 0)]
Va0_0  a0_0  0 PWL (0n 0.0v 4.745n 0.0v 4.755n 0.0v 9.745n 0.0v 9.755n 0.0v 14.745n 0.0v 14.755n 1.1v 19.745n 1.1v 19.755n 0.0v 24.745n 0.0v 24.755n 0.0v 29.745n 0.0v 29.755n 1.1v 34.745n 1.1v 34.755n 1.1v 39.745n 1.1v 39.755n 0.0v 44.745n 0.0v 44.755n 1.1v 49.745n 1.1v 49.755n 1.1v 54.745n 1.1v 54.755n 1.1v 59.745n 1.1v 59.755n 0.0v 64.745n 0.0v 64.755n 0.0v 69.745n 0.0v 69.755n 0.0v 74.745n 0.0v 74.755n 0.0v 79.745n 0.0v 79.755n 0.0v 84.745n 0.0v 84.755n 0.0v 89.745n 0.0v 89.755n 0.0v 94.745n 0.0v 94.755n 0.0v 99.745n 0.0v 99.755n 0.0v 104.745n 0.0v 104.755n 0.0v 109.745n 0.0v 109.755n 0.0v 114.745n 0.0v 114.755n 0.0v 119.745n 0.0v 119.755n 0.0v 124.745n 0.0v 124.755n 0.0v 129.745n 0.0v 129.755n 1.1v 134.745n 1.1v 134.755n 1.1v 139.745n 1.1v 139.755n 0.0v 144.745n 0.0v 144.755n 0.0v 149.745n 0.0v 149.755n 0.0v 154.745n 0.0v 154.755n 1.1v 159.745n 1.1v 159.755n 1.1v 164.745n 1.1v 164.755n 0.0v 169.745n 0.0v 169.755n 1.1v 174.745n 1.1v 174.755n 1.1v 179.745n 1.1v 179.755n 0.0v 184.745n 0.0v 184.755n 1.1v 189.745n 1.1v 189.755n 0.0v 194.745n 0.0v 194.755n 0.0v 199.745n 0.0v 199.755n 1.1v 204.745n 1.1v 204.755n 1.1v 209.745n 1.1v 209.755n 0.0v 214.745n 0.0v 214.755n 1.1v 219.745n 1.1v 219.755n 0.0v 224.745n 0.0v 224.755n 0.0v 229.745n 0.0v 229.755n 0.0v 234.745n 0.0v 234.755n 1.1v 239.745n 1.1v 239.755n 0.0v 244.745n 0.0v 244.755n 0.0v 249.745n 0.0v 249.755n 0.0v 254.745n 0.0v 254.755n 0.0v 259.745n 0.0v 259.755n 0.0v 264.745n 0.0v 264.755n 0.0v 269.745n 0.0v 269.755n 0.0v 274.745n 0.0v 274.755n 0.0v 279.745n 0.0v 279.755n 0.0v 284.745n 0.0v 284.755n 0.0v 289.745n 0.0v 289.755n 0.0v 294.745n 0.0v 294.755n 0.0v 299.745n 0.0v 299.755n 0.0v 304.745n 0.0v 304.755n 0.0v 309.745n 0.0v 309.755n 0.0v 314.745n 0.0v 314.755n 1.1v 319.745n 1.1v 319.755n 1.1v 324.745n 1.1v 324.755n 1.1v 329.745n 1.1v 329.755n 0.0v 334.745n 0.0v 334.755n 0.0v 339.745n 0.0v 339.755n 1.1v 344.745n 1.1v 344.755n 1.1v 349.745n 1.1v 349.755n 1.1v 354.745n 1.1v 354.755n 1.1v 359.745n 1.1v 359.755n 0.0v 364.745n 0.0v 364.755n 0.0v 369.745n 0.0v 369.755n 0.0v 374.745n 0.0v 374.755n 0.0v 379.745n 0.0v 379.755n 0.0v 384.745n 0.0v 384.755n 0.0v 389.745n 0.0v 389.755n 0.0v 394.745n 0.0v 394.755n 1.1v 399.745n 1.1v 399.755n 1.1v 404.745n 1.1v 404.755n 1.1v 409.745n 1.1v 409.755n 1.1v 414.745n 1.1v 414.755n 0.0v 419.745n 0.0v 419.755n 1.1v 424.745n 1.1v 424.755n 0.0v 429.745n 0.0v 429.755n 1.1v 434.745n 1.1v 434.755n 1.1v 439.745n 1.1v 439.755n 1.1v 444.745n 1.1v 444.755n 1.1v 449.745n 1.1v 449.755n 1.1v 454.745n 1.1v 454.755n 0.0v 459.745n 0.0v 459.755n 1.1v 464.745n 1.1v 464.755n 1.1v 469.745n 1.1v 469.755n 0.0v 474.745n 0.0v 474.755n 0.0v 479.745n 0.0v 479.755n 0.0v 484.745n 0.0v 484.755n 0.0v 489.745n 0.0v 489.755n 0.0v 494.745n 0.0v 494.755n 1.1v 499.745n 1.1v 499.755n 1.1v 504.745n 1.1v 504.755n 1.1v 509.745n 1.1v 509.755n 0.0v 514.745n 0.0v 514.755n 0.0v 519.745n 0.0v 519.755n 0.0v 524.745n 0.0v 524.755n 0.0v 529.745n 0.0v 529.755n 0.0v 534.745n 0.0v 534.755n 0.0v 539.745n 0.0v 539.755n 0.0v 544.745n 0.0v 544.755n 0.0v 549.745n 0.0v 549.755n 0.0v 554.745n 0.0v 554.755n 1.1v 559.745n 1.1v 559.755n 1.1v 564.745n 1.1v 564.755n 0.0v 569.745n 0.0v 569.755n 0.0v 574.745n 0.0v 574.755n 1.1v 579.745n 1.1v 579.755n 1.1v 584.745n 1.1v 584.755n 0.0v 589.745n 0.0v 589.755n 1.1v 594.745n 1.1v 594.755n 1.1v 599.745n 1.1v 599.755n 0.0v 604.745n 0.0v 604.755n 1.1v 609.745n 1.1v 609.755n 1.1v 614.745n 1.1v 614.755n 1.1v 619.745n 1.1v 619.755n 1.1v 624.745n 1.1v 624.755n 1.1v 629.745n 1.1v 629.755n 1.1v 634.745n 1.1v 634.755n 1.1v 639.745n 1.1v 639.755n 1.1v 644.745n 1.1v 644.755n 1.1v 649.745n 1.1v 649.755n 1.1v 654.745n 1.1v 654.755n 0.0v 659.745n 0.0v 659.755n 0.0v 664.745n 0.0v 664.755n 0.0v 669.745n 0.0v 669.755n 1.1v 674.745n 1.1v 674.755n 1.1v 679.745n 1.1v 679.755n 0.0v 684.745n 0.0v 684.755n 1.1v 689.745n 1.1v 689.755n 0.0v 694.745n 0.0v 694.755n 1.1v 699.745n 1.1v 699.755n 1.1v 704.745n 1.1v 704.755n 1.1v 709.745n 1.1v 709.755n 1.1v 714.745n 1.1v 714.755n 1.1v 719.745n 1.1v 719.755n 0.0v 724.745n 0.0v 724.755n 1.1v 729.745n 1.1v 729.755n 1.1v 734.745n 1.1v 734.755n 0.0v 739.745n 0.0v 739.755n 0.0v 744.745n 0.0v 744.755n 1.1v 749.745n 1.1v 749.755n 1.1v 754.745n 1.1v 754.755n 0.0v 759.745n 0.0v 759.755n 0.0v 764.745n 0.0v 764.755n 0.0v 769.745n 0.0v 769.755n 0.0v 774.745n 0.0v 774.755n 1.1v 779.745n 1.1v 779.755n 0.0v 784.745n 0.0v 784.755n 0.0v 789.745n 0.0v 789.755n 0.0v 794.745n 0.0v 794.755n 0.0v 799.745n 0.0v 799.755n 0.0v 804.745n 0.0v 804.755n 0.0v 809.745n 0.0v 809.755n 0.0v 814.745n 0.0v 814.755n 0.0v 819.745n 0.0v 819.755n 1.1v 824.745n 1.1v 824.755n 0.0v 829.745n 0.0v 829.755n 1.1v 834.745n 1.1v 834.755n 1.1v 839.745n 1.1v 839.755n 0.0v 844.745n 0.0v 844.755n 0.0v 849.745n 0.0v 849.755n 0.0v 854.745n 0.0v 854.755n 0.0v 859.745n 0.0v 859.755n 1.1v 864.745n 1.1v 864.755n 0.0v 869.745n 0.0v 869.755n 1.1v 874.745n 1.1v 874.755n 0.0v 879.745n 0.0v 879.755n 1.1v 884.745n 1.1v 884.755n 0.0v 889.745n 0.0v 889.755n 0.0v 894.745n 0.0v 894.755n 0.0v 899.745n 0.0v 899.755n 0.0v 904.745n 0.0v 904.755n 0.0v 909.745n 0.0v 909.755n 1.1v 914.745n 1.1v 914.755n 1.1v 919.745n 1.1v 919.755n 0.0v 924.745n 0.0v 924.755n 0.0v 929.745n 0.0v 929.755n 0.0v 934.745n 0.0v 934.755n 1.1v 939.745n 1.1v 939.755n 0.0v 944.745n 0.0v 944.755n 0.0v 949.745n 0.0v 949.755n 0.0v 954.745n 0.0v 954.755n 1.1v 959.745n 1.1v 959.755n 1.1v 964.745n 1.1v 964.755n 0.0v 969.745n 0.0v 969.755n 0.0v 974.745n 0.0v 974.755n 1.1v 979.745n 1.1v 979.755n 1.1v 984.745n 1.1v 984.755n 0.0v 989.745n 0.0v 989.755n 0.0v 994.745n 0.0v 994.755n 1.1v 999.745n 1.1v 999.755n 0.0v 1004.745n 0.0v 1004.755n 0.0v 1009.745n 0.0v 1009.755n 1.1v 1014.745n 1.1v 1014.755n 1.1v 1019.745n 1.1v 1019.755n 0.0v 1024.745n 0.0v 1024.755n 0.0v )
* (time, data): [(0, 0), (5, 1), (10, 1), (15, 0), (20, 1), (25, 1), (30, 0), (35, 0), (40, 1), (45, 0), (50, 0), (55, 0), (60, 1), (65, 1), (70, 1), (75, 1), (80, 1), (85, 1), (90, 1), (95, 1), (100, 1), (105, 1), (110, 1), (115, 1), (120, 1), (125, 1), (130, 0), (135, 0), (140, 1), (145, 1), (150, 1), (155, 0), (160, 0), (165, 1), (170, 0), (175, 0), (180, 1), (185, 0), (190, 1), (195, 1), (200, 0), (205, 0), (210, 1), (215, 0), (220, 1), (225, 1), (230, 1), (235, 0), (240, 0), (245, 0), (250, 0), (255, 1), (260, 1), (265, 1), (270, 1), (275, 1), (280, 0), (285, 1), (290, 1), (295, 1), (300, 0), (305, 0), (310, 0), (315, 0), (320, 0), (325, 0), (330, 0), (335, 1), (340, 0), (345, 0), (350, 0), (355, 0), (360, 0), (365, 0), (370, 0), (375, 0), (380, 0), (385, 0), (390, 1), (395, 0), (400, 0), (405, 0), (410, 0), (415, 1), (420, 0), (425, 1), (430, 0), (435, 0), (440, 0), (445, 0), (450, 0), (455, 1), (460, 0), (465, 0), (470, 1), (475, 1), (480, 0), (485, 0), (490, 1), (495, 0), (500, 0), (505, 0), (510, 0), (515, 0), (520, 1), (525, 1), (530, 1), (535, 1), (540, 1), (545, 1), (550, 0), (555, 0), (560, 0), (565, 1), (570, 1), (575, 0), (580, 0), (585, 1), (590, 0), (595, 0), (600, 1), (605, 0), (610, 0), (615, 0), (620, 0), (625, 0), (630, 0), (635, 0), (640, 0), (645, 0), (650, 0), (655, 1), (660, 1), (665, 1), (670, 0), (675, 0), (680, 1), (685, 0), (690, 0), (695, 0), (700, 0), (705, 0), (710, 0), (715, 0), (720, 0), (725, 0), (730, 0), (735, 0), (740, 1), (745, 0), (750, 0), (755, 1), (760, 0), (765, 0), (770, 0), (775, 0), (780, 0), (785, 0), (790, 0), (795, 0), (800, 0), (805, 0), (810, 1), (815, 0), (820, 0), (825, 0), (830, 0), (835, 0), (840, 1), (845, 1), (850, 1), (855, 0), (860, 0), (865, 0), (870, 0), (875, 1), (880, 0), (885, 1), (890, 0), (895, 0), (900, 0), (905, 1), (910, 0), (915, 0), (920, 1), (925, 0), (930, 1), (935, 0), (940, 0), (945, 0), (950, 0), (955, 0), (960, 0), (965, 0), (970, 0), (975, 0), (980, 0), (985, 0), (990, 0), (995, 0), (1000, 0), (1005, 1), (1010, 0), (1015, 0), (1020, 1), (1025, 1)]
Va0_1  a0_1  0 PWL (0n 0.0v 4.745n 0.0v 4.755n 1.1v 9.745n 1.1v 9.755n 1.1v 14.745n 1.1v 14.755n 0.0v 19.745n 0.0v 19.755n 1.1v 24.745n 1.1v 24.755n 1.1v 29.745n 1.1v 29.755n 0.0v 34.745n 0.0v 34.755n 0.0v 39.745n 0.0v 39.755n 1.1v 44.745n 1.1v 44.755n 0.0v 49.745n 0.0v 49.755n 0.0v 54.745n 0.0v 54.755n 0.0v 59.745n 0.0v 59.755n 1.1v 64.745n 1.1v 64.755n 1.1v 69.745n 1.1v 69.755n 1.1v 74.745n 1.1v 74.755n 1.1v 79.745n 1.1v 79.755n 1.1v 84.745n 1.1v 84.755n 1.1v 89.745n 1.1v 89.755n 1.1v 94.745n 1.1v 94.755n 1.1v 99.745n 1.1v 99.755n 1.1v 104.745n 1.1v 104.755n 1.1v 109.745n 1.1v 109.755n 1.1v 114.745n 1.1v 114.755n 1.1v 119.745n 1.1v 119.755n 1.1v 124.745n 1.1v 124.755n 1.1v 129.745n 1.1v 129.755n 0.0v 134.745n 0.0v 134.755n 0.0v 139.745n 0.0v 139.755n 1.1v 144.745n 1.1v 144.755n 1.1v 149.745n 1.1v 149.755n 1.1v 154.745n 1.1v 154.755n 0.0v 159.745n 0.0v 159.755n 0.0v 164.745n 0.0v 164.755n 1.1v 169.745n 1.1v 169.755n 0.0v 174.745n 0.0v 174.755n 0.0v 179.745n 0.0v 179.755n 1.1v 184.745n 1.1v 184.755n 0.0v 189.745n 0.0v 189.755n 1.1v 194.745n 1.1v 194.755n 1.1v 199.745n 1.1v 199.755n 0.0v 204.745n 0.0v 204.755n 0.0v 209.745n 0.0v 209.755n 1.1v 214.745n 1.1v 214.755n 0.0v 219.745n 0.0v 219.755n 1.1v 224.745n 1.1v 224.755n 1.1v 229.745n 1.1v 229.755n 1.1v 234.745n 1.1v 234.755n 0.0v 239.745n 0.0v 239.755n 0.0v 244.745n 0.0v 244.755n 0.0v 249.745n 0.0v 249.755n 0.0v 254.745n 0.0v 254.755n 1.1v 259.745n 1.1v 259.755n 1.1v 264.745n 1.1v 264.755n 1.1v 269.745n 1.1v 269.755n 1.1v 274.745n 1.1v 274.755n 1.1v 279.745n 1.1v 279.755n 0.0v 284.745n 0.0v 284.755n 1.1v 289.745n 1.1v 289.755n 1.1v 294.745n 1.1v 294.755n 1.1v 299.745n 1.1v 299.755n 0.0v 304.745n 0.0v 304.755n 0.0v 309.745n 0.0v 309.755n 0.0v 314.745n 0.0v 314.755n 0.0v 319.745n 0.0v 319.755n 0.0v 324.745n 0.0v 324.755n 0.0v 329.745n 0.0v 329.755n 0.0v 334.745n 0.0v 334.755n 1.1v 339.745n 1.1v 339.755n 0.0v 344.745n 0.0v 344.755n 0.0v 349.745n 0.0v 349.755n 0.0v 354.745n 0.0v 354.755n 0.0v 359.745n 0.0v 359.755n 0.0v 364.745n 0.0v 364.755n 0.0v 369.745n 0.0v 369.755n 0.0v 374.745n 0.0v 374.755n 0.0v 379.745n 0.0v 379.755n 0.0v 384.745n 0.0v 384.755n 0.0v 389.745n 0.0v 389.755n 1.1v 394.745n 1.1v 394.755n 0.0v 399.745n 0.0v 399.755n 0.0v 404.745n 0.0v 404.755n 0.0v 409.745n 0.0v 409.755n 0.0v 414.745n 0.0v 414.755n 1.1v 419.745n 1.1v 419.755n 0.0v 424.745n 0.0v 424.755n 1.1v 429.745n 1.1v 429.755n 0.0v 434.745n 0.0v 434.755n 0.0v 439.745n 0.0v 439.755n 0.0v 444.745n 0.0v 444.755n 0.0v 449.745n 0.0v 449.755n 0.0v 454.745n 0.0v 454.755n 1.1v 459.745n 1.1v 459.755n 0.0v 464.745n 0.0v 464.755n 0.0v 469.745n 0.0v 469.755n 1.1v 474.745n 1.1v 474.755n 1.1v 479.745n 1.1v 479.755n 0.0v 484.745n 0.0v 484.755n 0.0v 489.745n 0.0v 489.755n 1.1v 494.745n 1.1v 494.755n 0.0v 499.745n 0.0v 499.755n 0.0v 504.745n 0.0v 504.755n 0.0v 509.745n 0.0v 509.755n 0.0v 514.745n 0.0v 514.755n 0.0v 519.745n 0.0v 519.755n 1.1v 524.745n 1.1v 524.755n 1.1v 529.745n 1.1v 529.755n 1.1v 534.745n 1.1v 534.755n 1.1v 539.745n 1.1v 539.755n 1.1v 544.745n 1.1v 544.755n 1.1v 549.745n 1.1v 549.755n 0.0v 554.745n 0.0v 554.755n 0.0v 559.745n 0.0v 559.755n 0.0v 564.745n 0.0v 564.755n 1.1v 569.745n 1.1v 569.755n 1.1v 574.745n 1.1v 574.755n 0.0v 579.745n 0.0v 579.755n 0.0v 584.745n 0.0v 584.755n 1.1v 589.745n 1.1v 589.755n 0.0v 594.745n 0.0v 594.755n 0.0v 599.745n 0.0v 599.755n 1.1v 604.745n 1.1v 604.755n 0.0v 609.745n 0.0v 609.755n 0.0v 614.745n 0.0v 614.755n 0.0v 619.745n 0.0v 619.755n 0.0v 624.745n 0.0v 624.755n 0.0v 629.745n 0.0v 629.755n 0.0v 634.745n 0.0v 634.755n 0.0v 639.745n 0.0v 639.755n 0.0v 644.745n 0.0v 644.755n 0.0v 649.745n 0.0v 649.755n 0.0v 654.745n 0.0v 654.755n 1.1v 659.745n 1.1v 659.755n 1.1v 664.745n 1.1v 664.755n 1.1v 669.745n 1.1v 669.755n 0.0v 674.745n 0.0v 674.755n 0.0v 679.745n 0.0v 679.755n 1.1v 684.745n 1.1v 684.755n 0.0v 689.745n 0.0v 689.755n 0.0v 694.745n 0.0v 694.755n 0.0v 699.745n 0.0v 699.755n 0.0v 704.745n 0.0v 704.755n 0.0v 709.745n 0.0v 709.755n 0.0v 714.745n 0.0v 714.755n 0.0v 719.745n 0.0v 719.755n 0.0v 724.745n 0.0v 724.755n 0.0v 729.745n 0.0v 729.755n 0.0v 734.745n 0.0v 734.755n 0.0v 739.745n 0.0v 739.755n 1.1v 744.745n 1.1v 744.755n 0.0v 749.745n 0.0v 749.755n 0.0v 754.745n 0.0v 754.755n 1.1v 759.745n 1.1v 759.755n 0.0v 764.745n 0.0v 764.755n 0.0v 769.745n 0.0v 769.755n 0.0v 774.745n 0.0v 774.755n 0.0v 779.745n 0.0v 779.755n 0.0v 784.745n 0.0v 784.755n 0.0v 789.745n 0.0v 789.755n 0.0v 794.745n 0.0v 794.755n 0.0v 799.745n 0.0v 799.755n 0.0v 804.745n 0.0v 804.755n 0.0v 809.745n 0.0v 809.755n 1.1v 814.745n 1.1v 814.755n 0.0v 819.745n 0.0v 819.755n 0.0v 824.745n 0.0v 824.755n 0.0v 829.745n 0.0v 829.755n 0.0v 834.745n 0.0v 834.755n 0.0v 839.745n 0.0v 839.755n 1.1v 844.745n 1.1v 844.755n 1.1v 849.745n 1.1v 849.755n 1.1v 854.745n 1.1v 854.755n 0.0v 859.745n 0.0v 859.755n 0.0v 864.745n 0.0v 864.755n 0.0v 869.745n 0.0v 869.755n 0.0v 874.745n 0.0v 874.755n 1.1v 879.745n 1.1v 879.755n 0.0v 884.745n 0.0v 884.755n 1.1v 889.745n 1.1v 889.755n 0.0v 894.745n 0.0v 894.755n 0.0v 899.745n 0.0v 899.755n 0.0v 904.745n 0.0v 904.755n 1.1v 909.745n 1.1v 909.755n 0.0v 914.745n 0.0v 914.755n 0.0v 919.745n 0.0v 919.755n 1.1v 924.745n 1.1v 924.755n 0.0v 929.745n 0.0v 929.755n 1.1v 934.745n 1.1v 934.755n 0.0v 939.745n 0.0v 939.755n 0.0v 944.745n 0.0v 944.755n 0.0v 949.745n 0.0v 949.755n 0.0v 954.745n 0.0v 954.755n 0.0v 959.745n 0.0v 959.755n 0.0v 964.745n 0.0v 964.755n 0.0v 969.745n 0.0v 969.755n 0.0v 974.745n 0.0v 974.755n 0.0v 979.745n 0.0v 979.755n 0.0v 984.745n 0.0v 984.755n 0.0v 989.745n 0.0v 989.755n 0.0v 994.745n 0.0v 994.755n 0.0v 999.745n 0.0v 999.755n 0.0v 1004.745n 0.0v 1004.755n 1.1v 1009.745n 1.1v 1009.755n 0.0v 1014.745n 0.0v 1014.755n 0.0v 1019.745n 0.0v 1019.755n 1.1v 1024.745n 1.1v 1024.755n 1.1v )
* (time, data): [(0, 0), (5, 1), (10, 1), (15, 0), (20, 1), (25, 1), (30, 0), (35, 0), (40, 1), (45, 0), (50, 0), (55, 0), (60, 1), (65, 1), (70, 1), (75, 1), (80, 1), (85, 1), (90, 1), (95, 1), (100, 1), (105, 1), (110, 1), (115, 1), (120, 1), (125, 1), (130, 0), (135, 0), (140, 1), (145, 1), (150, 1), (155, 0), (160, 0), (165, 1), (170, 0), (175, 0), (180, 1), (185, 0), (190, 1), (195, 1), (200, 0), (205, 0), (210, 1), (215, 0), (220, 1), (225, 1), (230, 1), (235, 0), (240, 0), (245, 0), (250, 0), (255, 1), (260, 1), (265, 1), (270, 1), (275, 1), (280, 0), (285, 1), (290, 1), (295, 1), (300, 0), (305, 0), (310, 0), (315, 1), (320, 1), (325, 1), (330, 0), (335, 1), (340, 0), (345, 0), (350, 0), (355, 1), (360, 0), (365, 0), (370, 0), (375, 0), (380, 0), (385, 0), (390, 1), (395, 1), (400, 1), (405, 1), (410, 0), (415, 1), (420, 0), (425, 1), (430, 0), (435, 0), (440, 0), (445, 0), (450, 1), (455, 1), (460, 1), (465, 1), (470, 1), (475, 1), (480, 0), (485, 0), (490, 1), (495, 1), (500, 1), (505, 0), (510, 0), (515, 0), (520, 1), (525, 1), (530, 1), (535, 1), (540, 1), (545, 1), (550, 0), (555, 0), (560, 1), (565, 1), (570, 1), (575, 1), (580, 1), (585, 1), (590, 0), (595, 1), (600, 1), (605, 0), (610, 1), (615, 1), (620, 1), (625, 1), (630, 0), (635, 0), (640, 1), (645, 0), (650, 1), (655, 1), (660, 1), (665, 1), (670, 1), (675, 1), (680, 1), (685, 0), (690, 0), (695, 1), (700, 1), (705, 0), (710, 1), (715, 1), (720, 0), (725, 1), (730, 1), (735, 0), (740, 1), (745, 0), (750, 0), (755, 1), (760, 0), (765, 0), (770, 0), (775, 0), (780, 0), (785, 0), (790, 0), (795, 0), (800, 0), (805, 0), (810, 1), (815, 0), (820, 1), (825, 0), (830, 0), (835, 0), (840, 1), (845, 1), (850, 1), (855, 0), (860, 0), (865, 0), (870, 1), (875, 1), (880, 0), (885, 1), (890, 0), (895, 0), (900, 0), (905, 1), (910, 1), (915, 1), (920, 1), (925, 0), (930, 1), (935, 0), (940, 0), (945, 0), (950, 0), (955, 0), (960, 0), (965, 0), (970, 0), (975, 0), (980, 1), (985, 0), (990, 0), (995, 0), (1000, 0), (1005, 1), (1010, 0), (1015, 0), (1020, 1), (1025, 1)]
Va0_2  a0_2  0 PWL (0n 0.0v 4.745n 0.0v 4.755n 1.1v 9.745n 1.1v 9.755n 1.1v 14.745n 1.1v 14.755n 0.0v 19.745n 0.0v 19.755n 1.1v 24.745n 1.1v 24.755n 1.1v 29.745n 1.1v 29.755n 0.0v 34.745n 0.0v 34.755n 0.0v 39.745n 0.0v 39.755n 1.1v 44.745n 1.1v 44.755n 0.0v 49.745n 0.0v 49.755n 0.0v 54.745n 0.0v 54.755n 0.0v 59.745n 0.0v 59.755n 1.1v 64.745n 1.1v 64.755n 1.1v 69.745n 1.1v 69.755n 1.1v 74.745n 1.1v 74.755n 1.1v 79.745n 1.1v 79.755n 1.1v 84.745n 1.1v 84.755n 1.1v 89.745n 1.1v 89.755n 1.1v 94.745n 1.1v 94.755n 1.1v 99.745n 1.1v 99.755n 1.1v 104.745n 1.1v 104.755n 1.1v 109.745n 1.1v 109.755n 1.1v 114.745n 1.1v 114.755n 1.1v 119.745n 1.1v 119.755n 1.1v 124.745n 1.1v 124.755n 1.1v 129.745n 1.1v 129.755n 0.0v 134.745n 0.0v 134.755n 0.0v 139.745n 0.0v 139.755n 1.1v 144.745n 1.1v 144.755n 1.1v 149.745n 1.1v 149.755n 1.1v 154.745n 1.1v 154.755n 0.0v 159.745n 0.0v 159.755n 0.0v 164.745n 0.0v 164.755n 1.1v 169.745n 1.1v 169.755n 0.0v 174.745n 0.0v 174.755n 0.0v 179.745n 0.0v 179.755n 1.1v 184.745n 1.1v 184.755n 0.0v 189.745n 0.0v 189.755n 1.1v 194.745n 1.1v 194.755n 1.1v 199.745n 1.1v 199.755n 0.0v 204.745n 0.0v 204.755n 0.0v 209.745n 0.0v 209.755n 1.1v 214.745n 1.1v 214.755n 0.0v 219.745n 0.0v 219.755n 1.1v 224.745n 1.1v 224.755n 1.1v 229.745n 1.1v 229.755n 1.1v 234.745n 1.1v 234.755n 0.0v 239.745n 0.0v 239.755n 0.0v 244.745n 0.0v 244.755n 0.0v 249.745n 0.0v 249.755n 0.0v 254.745n 0.0v 254.755n 1.1v 259.745n 1.1v 259.755n 1.1v 264.745n 1.1v 264.755n 1.1v 269.745n 1.1v 269.755n 1.1v 274.745n 1.1v 274.755n 1.1v 279.745n 1.1v 279.755n 0.0v 284.745n 0.0v 284.755n 1.1v 289.745n 1.1v 289.755n 1.1v 294.745n 1.1v 294.755n 1.1v 299.745n 1.1v 299.755n 0.0v 304.745n 0.0v 304.755n 0.0v 309.745n 0.0v 309.755n 0.0v 314.745n 0.0v 314.755n 1.1v 319.745n 1.1v 319.755n 1.1v 324.745n 1.1v 324.755n 1.1v 329.745n 1.1v 329.755n 0.0v 334.745n 0.0v 334.755n 1.1v 339.745n 1.1v 339.755n 0.0v 344.745n 0.0v 344.755n 0.0v 349.745n 0.0v 349.755n 0.0v 354.745n 0.0v 354.755n 1.1v 359.745n 1.1v 359.755n 0.0v 364.745n 0.0v 364.755n 0.0v 369.745n 0.0v 369.755n 0.0v 374.745n 0.0v 374.755n 0.0v 379.745n 0.0v 379.755n 0.0v 384.745n 0.0v 384.755n 0.0v 389.745n 0.0v 389.755n 1.1v 394.745n 1.1v 394.755n 1.1v 399.745n 1.1v 399.755n 1.1v 404.745n 1.1v 404.755n 1.1v 409.745n 1.1v 409.755n 0.0v 414.745n 0.0v 414.755n 1.1v 419.745n 1.1v 419.755n 0.0v 424.745n 0.0v 424.755n 1.1v 429.745n 1.1v 429.755n 0.0v 434.745n 0.0v 434.755n 0.0v 439.745n 0.0v 439.755n 0.0v 444.745n 0.0v 444.755n 0.0v 449.745n 0.0v 449.755n 1.1v 454.745n 1.1v 454.755n 1.1v 459.745n 1.1v 459.755n 1.1v 464.745n 1.1v 464.755n 1.1v 469.745n 1.1v 469.755n 1.1v 474.745n 1.1v 474.755n 1.1v 479.745n 1.1v 479.755n 0.0v 484.745n 0.0v 484.755n 0.0v 489.745n 0.0v 489.755n 1.1v 494.745n 1.1v 494.755n 1.1v 499.745n 1.1v 499.755n 1.1v 504.745n 1.1v 504.755n 0.0v 509.745n 0.0v 509.755n 0.0v 514.745n 0.0v 514.755n 0.0v 519.745n 0.0v 519.755n 1.1v 524.745n 1.1v 524.755n 1.1v 529.745n 1.1v 529.755n 1.1v 534.745n 1.1v 534.755n 1.1v 539.745n 1.1v 539.755n 1.1v 544.745n 1.1v 544.755n 1.1v 549.745n 1.1v 549.755n 0.0v 554.745n 0.0v 554.755n 0.0v 559.745n 0.0v 559.755n 1.1v 564.745n 1.1v 564.755n 1.1v 569.745n 1.1v 569.755n 1.1v 574.745n 1.1v 574.755n 1.1v 579.745n 1.1v 579.755n 1.1v 584.745n 1.1v 584.755n 1.1v 589.745n 1.1v 589.755n 0.0v 594.745n 0.0v 594.755n 1.1v 599.745n 1.1v 599.755n 1.1v 604.745n 1.1v 604.755n 0.0v 609.745n 0.0v 609.755n 1.1v 614.745n 1.1v 614.755n 1.1v 619.745n 1.1v 619.755n 1.1v 624.745n 1.1v 624.755n 1.1v 629.745n 1.1v 629.755n 0.0v 634.745n 0.0v 634.755n 0.0v 639.745n 0.0v 639.755n 1.1v 644.745n 1.1v 644.755n 0.0v 649.745n 0.0v 649.755n 1.1v 654.745n 1.1v 654.755n 1.1v 659.745n 1.1v 659.755n 1.1v 664.745n 1.1v 664.755n 1.1v 669.745n 1.1v 669.755n 1.1v 674.745n 1.1v 674.755n 1.1v 679.745n 1.1v 679.755n 1.1v 684.745n 1.1v 684.755n 0.0v 689.745n 0.0v 689.755n 0.0v 694.745n 0.0v 694.755n 1.1v 699.745n 1.1v 699.755n 1.1v 704.745n 1.1v 704.755n 0.0v 709.745n 0.0v 709.755n 1.1v 714.745n 1.1v 714.755n 1.1v 719.745n 1.1v 719.755n 0.0v 724.745n 0.0v 724.755n 1.1v 729.745n 1.1v 729.755n 1.1v 734.745n 1.1v 734.755n 0.0v 739.745n 0.0v 739.755n 1.1v 744.745n 1.1v 744.755n 0.0v 749.745n 0.0v 749.755n 0.0v 754.745n 0.0v 754.755n 1.1v 759.745n 1.1v 759.755n 0.0v 764.745n 0.0v 764.755n 0.0v 769.745n 0.0v 769.755n 0.0v 774.745n 0.0v 774.755n 0.0v 779.745n 0.0v 779.755n 0.0v 784.745n 0.0v 784.755n 0.0v 789.745n 0.0v 789.755n 0.0v 794.745n 0.0v 794.755n 0.0v 799.745n 0.0v 799.755n 0.0v 804.745n 0.0v 804.755n 0.0v 809.745n 0.0v 809.755n 1.1v 814.745n 1.1v 814.755n 0.0v 819.745n 0.0v 819.755n 1.1v 824.745n 1.1v 824.755n 0.0v 829.745n 0.0v 829.755n 0.0v 834.745n 0.0v 834.755n 0.0v 839.745n 0.0v 839.755n 1.1v 844.745n 1.1v 844.755n 1.1v 849.745n 1.1v 849.755n 1.1v 854.745n 1.1v 854.755n 0.0v 859.745n 0.0v 859.755n 0.0v 864.745n 0.0v 864.755n 0.0v 869.745n 0.0v 869.755n 1.1v 874.745n 1.1v 874.755n 1.1v 879.745n 1.1v 879.755n 0.0v 884.745n 0.0v 884.755n 1.1v 889.745n 1.1v 889.755n 0.0v 894.745n 0.0v 894.755n 0.0v 899.745n 0.0v 899.755n 0.0v 904.745n 0.0v 904.755n 1.1v 909.745n 1.1v 909.755n 1.1v 914.745n 1.1v 914.755n 1.1v 919.745n 1.1v 919.755n 1.1v 924.745n 1.1v 924.755n 0.0v 929.745n 0.0v 929.755n 1.1v 934.745n 1.1v 934.755n 0.0v 939.745n 0.0v 939.755n 0.0v 944.745n 0.0v 944.755n 0.0v 949.745n 0.0v 949.755n 0.0v 954.745n 0.0v 954.755n 0.0v 959.745n 0.0v 959.755n 0.0v 964.745n 0.0v 964.755n 0.0v 969.745n 0.0v 969.755n 0.0v 974.745n 0.0v 974.755n 0.0v 979.745n 0.0v 979.755n 1.1v 984.745n 1.1v 984.755n 0.0v 989.745n 0.0v 989.755n 0.0v 994.745n 0.0v 994.755n 0.0v 999.745n 0.0v 999.755n 0.0v 1004.745n 0.0v 1004.755n 1.1v 1009.745n 1.1v 1009.755n 0.0v 1014.745n 0.0v 1014.755n 0.0v 1019.745n 0.0v 1019.755n 1.1v 1024.745n 1.1v 1024.755n 1.1v )
* (time, data): [(0, 0), (5, 1), (10, 1), (15, 0), (20, 1), (25, 1), (30, 0), (35, 0), (40, 1), (45, 0), (50, 0), (55, 0), (60, 1), (65, 1), (70, 1), (75, 1), (80, 1), (85, 1), (90, 1), (95, 1), (100, 1), (105, 1), (110, 1), (115, 1), (120, 1), (125, 1), (130, 0), (135, 0), (140, 1), (145, 1), (150, 1), (155, 0), (160, 0), (165, 1), (170, 0), (175, 0), (180, 1), (185, 0), (190, 1), (195, 1), (200, 0), (205, 0), (210, 1), (215, 0), (220, 1), (225, 1), (230, 1), (235, 0), (240, 0), (245, 0), (250, 0), (255, 1), (260, 1), (265, 1), (270, 1), (275, 1), (280, 0), (285, 1), (290, 1), (295, 1), (300, 0), (305, 0), (310, 0), (315, 1), (320, 1), (325, 1), (330, 0), (335, 1), (340, 0), (345, 0), (350, 0), (355, 1), (360, 0), (365, 0), (370, 0), (375, 0), (380, 0), (385, 0), (390, 1), (395, 1), (400, 1), (405, 1), (410, 0), (415, 1), (420, 0), (425, 1), (430, 0), (435, 0), (440, 0), (445, 0), (450, 1), (455, 1), (460, 1), (465, 1), (470, 1), (475, 1), (480, 0), (485, 0), (490, 1), (495, 1), (500, 1), (505, 0), (510, 0), (515, 0), (520, 1), (525, 1), (530, 1), (535, 1), (540, 1), (545, 1), (550, 0), (555, 0), (560, 1), (565, 1), (570, 1), (575, 1), (580, 1), (585, 1), (590, 0), (595, 1), (600, 1), (605, 0), (610, 1), (615, 1), (620, 1), (625, 1), (630, 0), (635, 0), (640, 1), (645, 0), (650, 1), (655, 1), (660, 1), (665, 1), (670, 1), (675, 1), (680, 1), (685, 0), (690, 0), (695, 1), (700, 1), (705, 0), (710, 1), (715, 1), (720, 0), (725, 1), (730, 1), (735, 0), (740, 1), (745, 0), (750, 0), (755, 1), (760, 0), (765, 0), (770, 0), (775, 0), (780, 0), (785, 0), (790, 0), (795, 0), (800, 0), (805, 0), (810, 1), (815, 0), (820, 1), (825, 0), (830, 0), (835, 0), (840, 1), (845, 1), (850, 1), (855, 0), (860, 0), (865, 0), (870, 1), (875, 1), (880, 0), (885, 1), (890, 0), (895, 0), (900, 0), (905, 1), (910, 1), (915, 1), (920, 1), (925, 0), (930, 1), (935, 0), (940, 0), (945, 0), (950, 0), (955, 0), (960, 0), (965, 0), (970, 0), (975, 0), (980, 1), (985, 0), (990, 0), (995, 0), (1000, 0), (1005, 1), (1010, 0), (1015, 0), (1020, 1), (1025, 1)]
Va0_3  a0_3  0 PWL (0n 0.0v 4.745n 0.0v 4.755n 1.1v 9.745n 1.1v 9.755n 1.1v 14.745n 1.1v 14.755n 0.0v 19.745n 0.0v 19.755n 1.1v 24.745n 1.1v 24.755n 1.1v 29.745n 1.1v 29.755n 0.0v 34.745n 0.0v 34.755n 0.0v 39.745n 0.0v 39.755n 1.1v 44.745n 1.1v 44.755n 0.0v 49.745n 0.0v 49.755n 0.0v 54.745n 0.0v 54.755n 0.0v 59.745n 0.0v 59.755n 1.1v 64.745n 1.1v 64.755n 1.1v 69.745n 1.1v 69.755n 1.1v 74.745n 1.1v 74.755n 1.1v 79.745n 1.1v 79.755n 1.1v 84.745n 1.1v 84.755n 1.1v 89.745n 1.1v 89.755n 1.1v 94.745n 1.1v 94.755n 1.1v 99.745n 1.1v 99.755n 1.1v 104.745n 1.1v 104.755n 1.1v 109.745n 1.1v 109.755n 1.1v 114.745n 1.1v 114.755n 1.1v 119.745n 1.1v 119.755n 1.1v 124.745n 1.1v 124.755n 1.1v 129.745n 1.1v 129.755n 0.0v 134.745n 0.0v 134.755n 0.0v 139.745n 0.0v 139.755n 1.1v 144.745n 1.1v 144.755n 1.1v 149.745n 1.1v 149.755n 1.1v 154.745n 1.1v 154.755n 0.0v 159.745n 0.0v 159.755n 0.0v 164.745n 0.0v 164.755n 1.1v 169.745n 1.1v 169.755n 0.0v 174.745n 0.0v 174.755n 0.0v 179.745n 0.0v 179.755n 1.1v 184.745n 1.1v 184.755n 0.0v 189.745n 0.0v 189.755n 1.1v 194.745n 1.1v 194.755n 1.1v 199.745n 1.1v 199.755n 0.0v 204.745n 0.0v 204.755n 0.0v 209.745n 0.0v 209.755n 1.1v 214.745n 1.1v 214.755n 0.0v 219.745n 0.0v 219.755n 1.1v 224.745n 1.1v 224.755n 1.1v 229.745n 1.1v 229.755n 1.1v 234.745n 1.1v 234.755n 0.0v 239.745n 0.0v 239.755n 0.0v 244.745n 0.0v 244.755n 0.0v 249.745n 0.0v 249.755n 0.0v 254.745n 0.0v 254.755n 1.1v 259.745n 1.1v 259.755n 1.1v 264.745n 1.1v 264.755n 1.1v 269.745n 1.1v 269.755n 1.1v 274.745n 1.1v 274.755n 1.1v 279.745n 1.1v 279.755n 0.0v 284.745n 0.0v 284.755n 1.1v 289.745n 1.1v 289.755n 1.1v 294.745n 1.1v 294.755n 1.1v 299.745n 1.1v 299.755n 0.0v 304.745n 0.0v 304.755n 0.0v 309.745n 0.0v 309.755n 0.0v 314.745n 0.0v 314.755n 1.1v 319.745n 1.1v 319.755n 1.1v 324.745n 1.1v 324.755n 1.1v 329.745n 1.1v 329.755n 0.0v 334.745n 0.0v 334.755n 1.1v 339.745n 1.1v 339.755n 0.0v 344.745n 0.0v 344.755n 0.0v 349.745n 0.0v 349.755n 0.0v 354.745n 0.0v 354.755n 1.1v 359.745n 1.1v 359.755n 0.0v 364.745n 0.0v 364.755n 0.0v 369.745n 0.0v 369.755n 0.0v 374.745n 0.0v 374.755n 0.0v 379.745n 0.0v 379.755n 0.0v 384.745n 0.0v 384.755n 0.0v 389.745n 0.0v 389.755n 1.1v 394.745n 1.1v 394.755n 1.1v 399.745n 1.1v 399.755n 1.1v 404.745n 1.1v 404.755n 1.1v 409.745n 1.1v 409.755n 0.0v 414.745n 0.0v 414.755n 1.1v 419.745n 1.1v 419.755n 0.0v 424.745n 0.0v 424.755n 1.1v 429.745n 1.1v 429.755n 0.0v 434.745n 0.0v 434.755n 0.0v 439.745n 0.0v 439.755n 0.0v 444.745n 0.0v 444.755n 0.0v 449.745n 0.0v 449.755n 1.1v 454.745n 1.1v 454.755n 1.1v 459.745n 1.1v 459.755n 1.1v 464.745n 1.1v 464.755n 1.1v 469.745n 1.1v 469.755n 1.1v 474.745n 1.1v 474.755n 1.1v 479.745n 1.1v 479.755n 0.0v 484.745n 0.0v 484.755n 0.0v 489.745n 0.0v 489.755n 1.1v 494.745n 1.1v 494.755n 1.1v 499.745n 1.1v 499.755n 1.1v 504.745n 1.1v 504.755n 0.0v 509.745n 0.0v 509.755n 0.0v 514.745n 0.0v 514.755n 0.0v 519.745n 0.0v 519.755n 1.1v 524.745n 1.1v 524.755n 1.1v 529.745n 1.1v 529.755n 1.1v 534.745n 1.1v 534.755n 1.1v 539.745n 1.1v 539.755n 1.1v 544.745n 1.1v 544.755n 1.1v 549.745n 1.1v 549.755n 0.0v 554.745n 0.0v 554.755n 0.0v 559.745n 0.0v 559.755n 1.1v 564.745n 1.1v 564.755n 1.1v 569.745n 1.1v 569.755n 1.1v 574.745n 1.1v 574.755n 1.1v 579.745n 1.1v 579.755n 1.1v 584.745n 1.1v 584.755n 1.1v 589.745n 1.1v 589.755n 0.0v 594.745n 0.0v 594.755n 1.1v 599.745n 1.1v 599.755n 1.1v 604.745n 1.1v 604.755n 0.0v 609.745n 0.0v 609.755n 1.1v 614.745n 1.1v 614.755n 1.1v 619.745n 1.1v 619.755n 1.1v 624.745n 1.1v 624.755n 1.1v 629.745n 1.1v 629.755n 0.0v 634.745n 0.0v 634.755n 0.0v 639.745n 0.0v 639.755n 1.1v 644.745n 1.1v 644.755n 0.0v 649.745n 0.0v 649.755n 1.1v 654.745n 1.1v 654.755n 1.1v 659.745n 1.1v 659.755n 1.1v 664.745n 1.1v 664.755n 1.1v 669.745n 1.1v 669.755n 1.1v 674.745n 1.1v 674.755n 1.1v 679.745n 1.1v 679.755n 1.1v 684.745n 1.1v 684.755n 0.0v 689.745n 0.0v 689.755n 0.0v 694.745n 0.0v 694.755n 1.1v 699.745n 1.1v 699.755n 1.1v 704.745n 1.1v 704.755n 0.0v 709.745n 0.0v 709.755n 1.1v 714.745n 1.1v 714.755n 1.1v 719.745n 1.1v 719.755n 0.0v 724.745n 0.0v 724.755n 1.1v 729.745n 1.1v 729.755n 1.1v 734.745n 1.1v 734.755n 0.0v 739.745n 0.0v 739.755n 1.1v 744.745n 1.1v 744.755n 0.0v 749.745n 0.0v 749.755n 0.0v 754.745n 0.0v 754.755n 1.1v 759.745n 1.1v 759.755n 0.0v 764.745n 0.0v 764.755n 0.0v 769.745n 0.0v 769.755n 0.0v 774.745n 0.0v 774.755n 0.0v 779.745n 0.0v 779.755n 0.0v 784.745n 0.0v 784.755n 0.0v 789.745n 0.0v 789.755n 0.0v 794.745n 0.0v 794.755n 0.0v 799.745n 0.0v 799.755n 0.0v 804.745n 0.0v 804.755n 0.0v 809.745n 0.0v 809.755n 1.1v 814.745n 1.1v 814.755n 0.0v 819.745n 0.0v 819.755n 1.1v 824.745n 1.1v 824.755n 0.0v 829.745n 0.0v 829.755n 0.0v 834.745n 0.0v 834.755n 0.0v 839.745n 0.0v 839.755n 1.1v 844.745n 1.1v 844.755n 1.1v 849.745n 1.1v 849.755n 1.1v 854.745n 1.1v 854.755n 0.0v 859.745n 0.0v 859.755n 0.0v 864.745n 0.0v 864.755n 0.0v 869.745n 0.0v 869.755n 1.1v 874.745n 1.1v 874.755n 1.1v 879.745n 1.1v 879.755n 0.0v 884.745n 0.0v 884.755n 1.1v 889.745n 1.1v 889.755n 0.0v 894.745n 0.0v 894.755n 0.0v 899.745n 0.0v 899.755n 0.0v 904.745n 0.0v 904.755n 1.1v 909.745n 1.1v 909.755n 1.1v 914.745n 1.1v 914.755n 1.1v 919.745n 1.1v 919.755n 1.1v 924.745n 1.1v 924.755n 0.0v 929.745n 0.0v 929.755n 1.1v 934.745n 1.1v 934.755n 0.0v 939.745n 0.0v 939.755n 0.0v 944.745n 0.0v 944.755n 0.0v 949.745n 0.0v 949.755n 0.0v 954.745n 0.0v 954.755n 0.0v 959.745n 0.0v 959.755n 0.0v 964.745n 0.0v 964.755n 0.0v 969.745n 0.0v 969.755n 0.0v 974.745n 0.0v 974.755n 0.0v 979.745n 0.0v 979.755n 1.1v 984.745n 1.1v 984.755n 0.0v 989.745n 0.0v 989.755n 0.0v 994.745n 0.0v 994.755n 0.0v 999.745n 0.0v 999.755n 0.0v 1004.745n 0.0v 1004.755n 1.1v 1009.745n 1.1v 1009.755n 0.0v 1014.745n 0.0v 1014.755n 0.0v 1019.745n 0.0v 1019.755n 1.1v 1024.745n 1.1v 1024.755n 1.1v )
* (time, data): [(0, 0), (5, 1), (10, 1), (15, 0), (20, 1), (25, 1), (30, 0), (35, 0), (40, 1), (45, 0), (50, 0), (55, 0), (60, 1), (65, 1), (70, 1), (75, 1), (80, 1), (85, 1), (90, 1), (95, 1), (100, 1), (105, 1), (110, 1), (115, 1), (120, 1), (125, 1), (130, 0), (135, 0), (140, 1), (145, 1), (150, 1), (155, 0), (160, 0), (165, 1), (170, 0), (175, 0), (180, 1), (185, 0), (190, 1), (195, 1), (200, 0), (205, 0), (210, 1), (215, 0), (220, 1), (225, 1), (230, 1), (235, 0), (240, 0), (245, 0), (250, 0), (255, 1), (260, 1), (265, 1), (270, 1), (275, 1), (280, 0), (285, 1), (290, 1), (295, 1), (300, 0), (305, 0), (310, 0), (315, 1), (320, 1), (325, 1), (330, 0), (335, 1), (340, 0), (345, 0), (350, 0), (355, 1), (360, 0), (365, 0), (370, 0), (375, 0), (380, 0), (385, 0), (390, 1), (395, 1), (400, 1), (405, 1), (410, 0), (415, 1), (420, 0), (425, 1), (430, 0), (435, 0), (440, 0), (445, 0), (450, 1), (455, 1), (460, 1), (465, 1), (470, 1), (475, 1), (480, 0), (485, 0), (490, 1), (495, 1), (500, 1), (505, 0), (510, 0), (515, 0), (520, 1), (525, 1), (530, 1), (535, 1), (540, 1), (545, 1), (550, 0), (555, 0), (560, 1), (565, 1), (570, 1), (575, 1), (580, 1), (585, 1), (590, 0), (595, 1), (600, 1), (605, 0), (610, 1), (615, 1), (620, 1), (625, 1), (630, 0), (635, 0), (640, 1), (645, 0), (650, 1), (655, 1), (660, 1), (665, 1), (670, 1), (675, 1), (680, 1), (685, 0), (690, 0), (695, 1), (700, 1), (705, 0), (710, 1), (715, 1), (720, 0), (725, 1), (730, 1), (735, 0), (740, 1), (745, 0), (750, 0), (755, 1), (760, 0), (765, 0), (770, 0), (775, 0), (780, 0), (785, 0), (790, 0), (795, 0), (800, 0), (805, 0), (810, 1), (815, 0), (820, 1), (825, 0), (830, 0), (835, 0), (840, 1), (845, 1), (850, 1), (855, 0), (860, 0), (865, 0), (870, 1), (875, 1), (880, 0), (885, 1), (890, 0), (895, 0), (900, 0), (905, 1), (910, 1), (915, 1), (920, 1), (925, 0), (930, 1), (935, 0), (940, 0), (945, 0), (950, 0), (955, 0), (960, 0), (965, 0), (970, 0), (975, 0), (980, 1), (985, 0), (990, 0), (995, 0), (1000, 0), (1005, 1), (1010, 0), (1015, 0), (1020, 1), (1025, 1)]
Va0_4  a0_4  0 PWL (0n 0.0v 4.745n 0.0v 4.755n 1.1v 9.745n 1.1v 9.755n 1.1v 14.745n 1.1v 14.755n 0.0v 19.745n 0.0v 19.755n 1.1v 24.745n 1.1v 24.755n 1.1v 29.745n 1.1v 29.755n 0.0v 34.745n 0.0v 34.755n 0.0v 39.745n 0.0v 39.755n 1.1v 44.745n 1.1v 44.755n 0.0v 49.745n 0.0v 49.755n 0.0v 54.745n 0.0v 54.755n 0.0v 59.745n 0.0v 59.755n 1.1v 64.745n 1.1v 64.755n 1.1v 69.745n 1.1v 69.755n 1.1v 74.745n 1.1v 74.755n 1.1v 79.745n 1.1v 79.755n 1.1v 84.745n 1.1v 84.755n 1.1v 89.745n 1.1v 89.755n 1.1v 94.745n 1.1v 94.755n 1.1v 99.745n 1.1v 99.755n 1.1v 104.745n 1.1v 104.755n 1.1v 109.745n 1.1v 109.755n 1.1v 114.745n 1.1v 114.755n 1.1v 119.745n 1.1v 119.755n 1.1v 124.745n 1.1v 124.755n 1.1v 129.745n 1.1v 129.755n 0.0v 134.745n 0.0v 134.755n 0.0v 139.745n 0.0v 139.755n 1.1v 144.745n 1.1v 144.755n 1.1v 149.745n 1.1v 149.755n 1.1v 154.745n 1.1v 154.755n 0.0v 159.745n 0.0v 159.755n 0.0v 164.745n 0.0v 164.755n 1.1v 169.745n 1.1v 169.755n 0.0v 174.745n 0.0v 174.755n 0.0v 179.745n 0.0v 179.755n 1.1v 184.745n 1.1v 184.755n 0.0v 189.745n 0.0v 189.755n 1.1v 194.745n 1.1v 194.755n 1.1v 199.745n 1.1v 199.755n 0.0v 204.745n 0.0v 204.755n 0.0v 209.745n 0.0v 209.755n 1.1v 214.745n 1.1v 214.755n 0.0v 219.745n 0.0v 219.755n 1.1v 224.745n 1.1v 224.755n 1.1v 229.745n 1.1v 229.755n 1.1v 234.745n 1.1v 234.755n 0.0v 239.745n 0.0v 239.755n 0.0v 244.745n 0.0v 244.755n 0.0v 249.745n 0.0v 249.755n 0.0v 254.745n 0.0v 254.755n 1.1v 259.745n 1.1v 259.755n 1.1v 264.745n 1.1v 264.755n 1.1v 269.745n 1.1v 269.755n 1.1v 274.745n 1.1v 274.755n 1.1v 279.745n 1.1v 279.755n 0.0v 284.745n 0.0v 284.755n 1.1v 289.745n 1.1v 289.755n 1.1v 294.745n 1.1v 294.755n 1.1v 299.745n 1.1v 299.755n 0.0v 304.745n 0.0v 304.755n 0.0v 309.745n 0.0v 309.755n 0.0v 314.745n 0.0v 314.755n 1.1v 319.745n 1.1v 319.755n 1.1v 324.745n 1.1v 324.755n 1.1v 329.745n 1.1v 329.755n 0.0v 334.745n 0.0v 334.755n 1.1v 339.745n 1.1v 339.755n 0.0v 344.745n 0.0v 344.755n 0.0v 349.745n 0.0v 349.755n 0.0v 354.745n 0.0v 354.755n 1.1v 359.745n 1.1v 359.755n 0.0v 364.745n 0.0v 364.755n 0.0v 369.745n 0.0v 369.755n 0.0v 374.745n 0.0v 374.755n 0.0v 379.745n 0.0v 379.755n 0.0v 384.745n 0.0v 384.755n 0.0v 389.745n 0.0v 389.755n 1.1v 394.745n 1.1v 394.755n 1.1v 399.745n 1.1v 399.755n 1.1v 404.745n 1.1v 404.755n 1.1v 409.745n 1.1v 409.755n 0.0v 414.745n 0.0v 414.755n 1.1v 419.745n 1.1v 419.755n 0.0v 424.745n 0.0v 424.755n 1.1v 429.745n 1.1v 429.755n 0.0v 434.745n 0.0v 434.755n 0.0v 439.745n 0.0v 439.755n 0.0v 444.745n 0.0v 444.755n 0.0v 449.745n 0.0v 449.755n 1.1v 454.745n 1.1v 454.755n 1.1v 459.745n 1.1v 459.755n 1.1v 464.745n 1.1v 464.755n 1.1v 469.745n 1.1v 469.755n 1.1v 474.745n 1.1v 474.755n 1.1v 479.745n 1.1v 479.755n 0.0v 484.745n 0.0v 484.755n 0.0v 489.745n 0.0v 489.755n 1.1v 494.745n 1.1v 494.755n 1.1v 499.745n 1.1v 499.755n 1.1v 504.745n 1.1v 504.755n 0.0v 509.745n 0.0v 509.755n 0.0v 514.745n 0.0v 514.755n 0.0v 519.745n 0.0v 519.755n 1.1v 524.745n 1.1v 524.755n 1.1v 529.745n 1.1v 529.755n 1.1v 534.745n 1.1v 534.755n 1.1v 539.745n 1.1v 539.755n 1.1v 544.745n 1.1v 544.755n 1.1v 549.745n 1.1v 549.755n 0.0v 554.745n 0.0v 554.755n 0.0v 559.745n 0.0v 559.755n 1.1v 564.745n 1.1v 564.755n 1.1v 569.745n 1.1v 569.755n 1.1v 574.745n 1.1v 574.755n 1.1v 579.745n 1.1v 579.755n 1.1v 584.745n 1.1v 584.755n 1.1v 589.745n 1.1v 589.755n 0.0v 594.745n 0.0v 594.755n 1.1v 599.745n 1.1v 599.755n 1.1v 604.745n 1.1v 604.755n 0.0v 609.745n 0.0v 609.755n 1.1v 614.745n 1.1v 614.755n 1.1v 619.745n 1.1v 619.755n 1.1v 624.745n 1.1v 624.755n 1.1v 629.745n 1.1v 629.755n 0.0v 634.745n 0.0v 634.755n 0.0v 639.745n 0.0v 639.755n 1.1v 644.745n 1.1v 644.755n 0.0v 649.745n 0.0v 649.755n 1.1v 654.745n 1.1v 654.755n 1.1v 659.745n 1.1v 659.755n 1.1v 664.745n 1.1v 664.755n 1.1v 669.745n 1.1v 669.755n 1.1v 674.745n 1.1v 674.755n 1.1v 679.745n 1.1v 679.755n 1.1v 684.745n 1.1v 684.755n 0.0v 689.745n 0.0v 689.755n 0.0v 694.745n 0.0v 694.755n 1.1v 699.745n 1.1v 699.755n 1.1v 704.745n 1.1v 704.755n 0.0v 709.745n 0.0v 709.755n 1.1v 714.745n 1.1v 714.755n 1.1v 719.745n 1.1v 719.755n 0.0v 724.745n 0.0v 724.755n 1.1v 729.745n 1.1v 729.755n 1.1v 734.745n 1.1v 734.755n 0.0v 739.745n 0.0v 739.755n 1.1v 744.745n 1.1v 744.755n 0.0v 749.745n 0.0v 749.755n 0.0v 754.745n 0.0v 754.755n 1.1v 759.745n 1.1v 759.755n 0.0v 764.745n 0.0v 764.755n 0.0v 769.745n 0.0v 769.755n 0.0v 774.745n 0.0v 774.755n 0.0v 779.745n 0.0v 779.755n 0.0v 784.745n 0.0v 784.755n 0.0v 789.745n 0.0v 789.755n 0.0v 794.745n 0.0v 794.755n 0.0v 799.745n 0.0v 799.755n 0.0v 804.745n 0.0v 804.755n 0.0v 809.745n 0.0v 809.755n 1.1v 814.745n 1.1v 814.755n 0.0v 819.745n 0.0v 819.755n 1.1v 824.745n 1.1v 824.755n 0.0v 829.745n 0.0v 829.755n 0.0v 834.745n 0.0v 834.755n 0.0v 839.745n 0.0v 839.755n 1.1v 844.745n 1.1v 844.755n 1.1v 849.745n 1.1v 849.755n 1.1v 854.745n 1.1v 854.755n 0.0v 859.745n 0.0v 859.755n 0.0v 864.745n 0.0v 864.755n 0.0v 869.745n 0.0v 869.755n 1.1v 874.745n 1.1v 874.755n 1.1v 879.745n 1.1v 879.755n 0.0v 884.745n 0.0v 884.755n 1.1v 889.745n 1.1v 889.755n 0.0v 894.745n 0.0v 894.755n 0.0v 899.745n 0.0v 899.755n 0.0v 904.745n 0.0v 904.755n 1.1v 909.745n 1.1v 909.755n 1.1v 914.745n 1.1v 914.755n 1.1v 919.745n 1.1v 919.755n 1.1v 924.745n 1.1v 924.755n 0.0v 929.745n 0.0v 929.755n 1.1v 934.745n 1.1v 934.755n 0.0v 939.745n 0.0v 939.755n 0.0v 944.745n 0.0v 944.755n 0.0v 949.745n 0.0v 949.755n 0.0v 954.745n 0.0v 954.755n 0.0v 959.745n 0.0v 959.755n 0.0v 964.745n 0.0v 964.755n 0.0v 969.745n 0.0v 969.755n 0.0v 974.745n 0.0v 974.755n 0.0v 979.745n 0.0v 979.755n 1.1v 984.745n 1.1v 984.755n 0.0v 989.745n 0.0v 989.755n 0.0v 994.745n 0.0v 994.755n 0.0v 999.745n 0.0v 999.755n 0.0v 1004.745n 0.0v 1004.755n 1.1v 1009.745n 1.1v 1009.755n 0.0v 1014.745n 0.0v 1014.755n 0.0v 1019.745n 0.0v 1019.755n 1.1v 1024.745n 1.1v 1024.755n 1.1v )
* (time, data): [(0, 0), (5, 1), (10, 1), (15, 0), (20, 1), (25, 1), (30, 0), (35, 0), (40, 1), (45, 0), (50, 0), (55, 0), (60, 1), (65, 1), (70, 1), (75, 1), (80, 1), (85, 1), (90, 1), (95, 1), (100, 1), (105, 1), (110, 1), (115, 1), (120, 1), (125, 1), (130, 0), (135, 0), (140, 1), (145, 1), (150, 1), (155, 0), (160, 0), (165, 1), (170, 0), (175, 0), (180, 1), (185, 0), (190, 1), (195, 1), (200, 0), (205, 0), (210, 1), (215, 0), (220, 1), (225, 1), (230, 1), (235, 0), (240, 0), (245, 0), (250, 0), (255, 1), (260, 1), (265, 1), (270, 1), (275, 1), (280, 0), (285, 1), (290, 1), (295, 1), (300, 0), (305, 0), (310, 0), (315, 1), (320, 1), (325, 1), (330, 0), (335, 1), (340, 0), (345, 0), (350, 0), (355, 1), (360, 0), (365, 0), (370, 0), (375, 0), (380, 0), (385, 0), (390, 1), (395, 1), (400, 1), (405, 1), (410, 0), (415, 1), (420, 0), (425, 1), (430, 0), (435, 0), (440, 0), (445, 0), (450, 1), (455, 1), (460, 1), (465, 1), (470, 1), (475, 1), (480, 0), (485, 0), (490, 1), (495, 1), (500, 1), (505, 0), (510, 0), (515, 0), (520, 1), (525, 1), (530, 1), (535, 1), (540, 1), (545, 1), (550, 0), (555, 0), (560, 1), (565, 1), (570, 1), (575, 1), (580, 1), (585, 1), (590, 0), (595, 1), (600, 1), (605, 0), (610, 1), (615, 1), (620, 1), (625, 1), (630, 0), (635, 0), (640, 1), (645, 0), (650, 1), (655, 1), (660, 1), (665, 1), (670, 1), (675, 1), (680, 1), (685, 0), (690, 0), (695, 1), (700, 1), (705, 0), (710, 1), (715, 1), (720, 0), (725, 1), (730, 1), (735, 0), (740, 1), (745, 0), (750, 0), (755, 1), (760, 0), (765, 0), (770, 0), (775, 0), (780, 0), (785, 0), (790, 0), (795, 0), (800, 0), (805, 0), (810, 1), (815, 0), (820, 1), (825, 0), (830, 0), (835, 0), (840, 1), (845, 1), (850, 1), (855, 0), (860, 0), (865, 0), (870, 1), (875, 1), (880, 0), (885, 1), (890, 0), (895, 0), (900, 0), (905, 1), (910, 1), (915, 1), (920, 1), (925, 0), (930, 1), (935, 0), (940, 0), (945, 0), (950, 0), (955, 0), (960, 0), (965, 0), (970, 0), (975, 0), (980, 1), (985, 0), (990, 0), (995, 0), (1000, 0), (1005, 1), (1010, 0), (1015, 0), (1020, 1), (1025, 1)]
Va0_5  a0_5  0 PWL (0n 0.0v 4.745n 0.0v 4.755n 1.1v 9.745n 1.1v 9.755n 1.1v 14.745n 1.1v 14.755n 0.0v 19.745n 0.0v 19.755n 1.1v 24.745n 1.1v 24.755n 1.1v 29.745n 1.1v 29.755n 0.0v 34.745n 0.0v 34.755n 0.0v 39.745n 0.0v 39.755n 1.1v 44.745n 1.1v 44.755n 0.0v 49.745n 0.0v 49.755n 0.0v 54.745n 0.0v 54.755n 0.0v 59.745n 0.0v 59.755n 1.1v 64.745n 1.1v 64.755n 1.1v 69.745n 1.1v 69.755n 1.1v 74.745n 1.1v 74.755n 1.1v 79.745n 1.1v 79.755n 1.1v 84.745n 1.1v 84.755n 1.1v 89.745n 1.1v 89.755n 1.1v 94.745n 1.1v 94.755n 1.1v 99.745n 1.1v 99.755n 1.1v 104.745n 1.1v 104.755n 1.1v 109.745n 1.1v 109.755n 1.1v 114.745n 1.1v 114.755n 1.1v 119.745n 1.1v 119.755n 1.1v 124.745n 1.1v 124.755n 1.1v 129.745n 1.1v 129.755n 0.0v 134.745n 0.0v 134.755n 0.0v 139.745n 0.0v 139.755n 1.1v 144.745n 1.1v 144.755n 1.1v 149.745n 1.1v 149.755n 1.1v 154.745n 1.1v 154.755n 0.0v 159.745n 0.0v 159.755n 0.0v 164.745n 0.0v 164.755n 1.1v 169.745n 1.1v 169.755n 0.0v 174.745n 0.0v 174.755n 0.0v 179.745n 0.0v 179.755n 1.1v 184.745n 1.1v 184.755n 0.0v 189.745n 0.0v 189.755n 1.1v 194.745n 1.1v 194.755n 1.1v 199.745n 1.1v 199.755n 0.0v 204.745n 0.0v 204.755n 0.0v 209.745n 0.0v 209.755n 1.1v 214.745n 1.1v 214.755n 0.0v 219.745n 0.0v 219.755n 1.1v 224.745n 1.1v 224.755n 1.1v 229.745n 1.1v 229.755n 1.1v 234.745n 1.1v 234.755n 0.0v 239.745n 0.0v 239.755n 0.0v 244.745n 0.0v 244.755n 0.0v 249.745n 0.0v 249.755n 0.0v 254.745n 0.0v 254.755n 1.1v 259.745n 1.1v 259.755n 1.1v 264.745n 1.1v 264.755n 1.1v 269.745n 1.1v 269.755n 1.1v 274.745n 1.1v 274.755n 1.1v 279.745n 1.1v 279.755n 0.0v 284.745n 0.0v 284.755n 1.1v 289.745n 1.1v 289.755n 1.1v 294.745n 1.1v 294.755n 1.1v 299.745n 1.1v 299.755n 0.0v 304.745n 0.0v 304.755n 0.0v 309.745n 0.0v 309.755n 0.0v 314.745n 0.0v 314.755n 1.1v 319.745n 1.1v 319.755n 1.1v 324.745n 1.1v 324.755n 1.1v 329.745n 1.1v 329.755n 0.0v 334.745n 0.0v 334.755n 1.1v 339.745n 1.1v 339.755n 0.0v 344.745n 0.0v 344.755n 0.0v 349.745n 0.0v 349.755n 0.0v 354.745n 0.0v 354.755n 1.1v 359.745n 1.1v 359.755n 0.0v 364.745n 0.0v 364.755n 0.0v 369.745n 0.0v 369.755n 0.0v 374.745n 0.0v 374.755n 0.0v 379.745n 0.0v 379.755n 0.0v 384.745n 0.0v 384.755n 0.0v 389.745n 0.0v 389.755n 1.1v 394.745n 1.1v 394.755n 1.1v 399.745n 1.1v 399.755n 1.1v 404.745n 1.1v 404.755n 1.1v 409.745n 1.1v 409.755n 0.0v 414.745n 0.0v 414.755n 1.1v 419.745n 1.1v 419.755n 0.0v 424.745n 0.0v 424.755n 1.1v 429.745n 1.1v 429.755n 0.0v 434.745n 0.0v 434.755n 0.0v 439.745n 0.0v 439.755n 0.0v 444.745n 0.0v 444.755n 0.0v 449.745n 0.0v 449.755n 1.1v 454.745n 1.1v 454.755n 1.1v 459.745n 1.1v 459.755n 1.1v 464.745n 1.1v 464.755n 1.1v 469.745n 1.1v 469.755n 1.1v 474.745n 1.1v 474.755n 1.1v 479.745n 1.1v 479.755n 0.0v 484.745n 0.0v 484.755n 0.0v 489.745n 0.0v 489.755n 1.1v 494.745n 1.1v 494.755n 1.1v 499.745n 1.1v 499.755n 1.1v 504.745n 1.1v 504.755n 0.0v 509.745n 0.0v 509.755n 0.0v 514.745n 0.0v 514.755n 0.0v 519.745n 0.0v 519.755n 1.1v 524.745n 1.1v 524.755n 1.1v 529.745n 1.1v 529.755n 1.1v 534.745n 1.1v 534.755n 1.1v 539.745n 1.1v 539.755n 1.1v 544.745n 1.1v 544.755n 1.1v 549.745n 1.1v 549.755n 0.0v 554.745n 0.0v 554.755n 0.0v 559.745n 0.0v 559.755n 1.1v 564.745n 1.1v 564.755n 1.1v 569.745n 1.1v 569.755n 1.1v 574.745n 1.1v 574.755n 1.1v 579.745n 1.1v 579.755n 1.1v 584.745n 1.1v 584.755n 1.1v 589.745n 1.1v 589.755n 0.0v 594.745n 0.0v 594.755n 1.1v 599.745n 1.1v 599.755n 1.1v 604.745n 1.1v 604.755n 0.0v 609.745n 0.0v 609.755n 1.1v 614.745n 1.1v 614.755n 1.1v 619.745n 1.1v 619.755n 1.1v 624.745n 1.1v 624.755n 1.1v 629.745n 1.1v 629.755n 0.0v 634.745n 0.0v 634.755n 0.0v 639.745n 0.0v 639.755n 1.1v 644.745n 1.1v 644.755n 0.0v 649.745n 0.0v 649.755n 1.1v 654.745n 1.1v 654.755n 1.1v 659.745n 1.1v 659.755n 1.1v 664.745n 1.1v 664.755n 1.1v 669.745n 1.1v 669.755n 1.1v 674.745n 1.1v 674.755n 1.1v 679.745n 1.1v 679.755n 1.1v 684.745n 1.1v 684.755n 0.0v 689.745n 0.0v 689.755n 0.0v 694.745n 0.0v 694.755n 1.1v 699.745n 1.1v 699.755n 1.1v 704.745n 1.1v 704.755n 0.0v 709.745n 0.0v 709.755n 1.1v 714.745n 1.1v 714.755n 1.1v 719.745n 1.1v 719.755n 0.0v 724.745n 0.0v 724.755n 1.1v 729.745n 1.1v 729.755n 1.1v 734.745n 1.1v 734.755n 0.0v 739.745n 0.0v 739.755n 1.1v 744.745n 1.1v 744.755n 0.0v 749.745n 0.0v 749.755n 0.0v 754.745n 0.0v 754.755n 1.1v 759.745n 1.1v 759.755n 0.0v 764.745n 0.0v 764.755n 0.0v 769.745n 0.0v 769.755n 0.0v 774.745n 0.0v 774.755n 0.0v 779.745n 0.0v 779.755n 0.0v 784.745n 0.0v 784.755n 0.0v 789.745n 0.0v 789.755n 0.0v 794.745n 0.0v 794.755n 0.0v 799.745n 0.0v 799.755n 0.0v 804.745n 0.0v 804.755n 0.0v 809.745n 0.0v 809.755n 1.1v 814.745n 1.1v 814.755n 0.0v 819.745n 0.0v 819.755n 1.1v 824.745n 1.1v 824.755n 0.0v 829.745n 0.0v 829.755n 0.0v 834.745n 0.0v 834.755n 0.0v 839.745n 0.0v 839.755n 1.1v 844.745n 1.1v 844.755n 1.1v 849.745n 1.1v 849.755n 1.1v 854.745n 1.1v 854.755n 0.0v 859.745n 0.0v 859.755n 0.0v 864.745n 0.0v 864.755n 0.0v 869.745n 0.0v 869.755n 1.1v 874.745n 1.1v 874.755n 1.1v 879.745n 1.1v 879.755n 0.0v 884.745n 0.0v 884.755n 1.1v 889.745n 1.1v 889.755n 0.0v 894.745n 0.0v 894.755n 0.0v 899.745n 0.0v 899.755n 0.0v 904.745n 0.0v 904.755n 1.1v 909.745n 1.1v 909.755n 1.1v 914.745n 1.1v 914.755n 1.1v 919.745n 1.1v 919.755n 1.1v 924.745n 1.1v 924.755n 0.0v 929.745n 0.0v 929.755n 1.1v 934.745n 1.1v 934.755n 0.0v 939.745n 0.0v 939.755n 0.0v 944.745n 0.0v 944.755n 0.0v 949.745n 0.0v 949.755n 0.0v 954.745n 0.0v 954.755n 0.0v 959.745n 0.0v 959.755n 0.0v 964.745n 0.0v 964.755n 0.0v 969.745n 0.0v 969.755n 0.0v 974.745n 0.0v 974.755n 0.0v 979.745n 0.0v 979.755n 1.1v 984.745n 1.1v 984.755n 0.0v 989.745n 0.0v 989.755n 0.0v 994.745n 0.0v 994.755n 0.0v 999.745n 0.0v 999.755n 0.0v 1004.745n 0.0v 1004.755n 1.1v 1009.745n 1.1v 1009.755n 0.0v 1014.745n 0.0v 1014.755n 0.0v 1019.745n 0.0v 1019.755n 1.1v 1024.745n 1.1v 1024.755n 1.1v )
* (time, data): [(0, 0), (5, 1), (10, 1), (15, 0), (20, 1), (25, 1), (30, 0), (35, 0), (40, 1), (45, 0), (50, 0), (55, 0), (60, 1), (65, 1), (70, 1), (75, 1), (80, 1), (85, 1), (90, 1), (95, 1), (100, 1), (105, 1), (110, 1), (115, 1), (120, 1), (125, 1), (130, 0), (135, 0), (140, 1), (145, 1), (150, 1), (155, 0), (160, 0), (165, 1), (170, 0), (175, 0), (180, 1), (185, 0), (190, 1), (195, 1), (200, 0), (205, 0), (210, 1), (215, 0), (220, 1), (225, 1), (230, 1), (235, 0), (240, 0), (245, 0), (250, 0), (255, 1), (260, 1), (265, 1), (270, 1), (275, 1), (280, 0), (285, 1), (290, 1), (295, 1), (300, 0), (305, 0), (310, 0), (315, 1), (320, 1), (325, 1), (330, 0), (335, 1), (340, 0), (345, 0), (350, 0), (355, 1), (360, 0), (365, 0), (370, 0), (375, 0), (380, 0), (385, 0), (390, 1), (395, 1), (400, 1), (405, 1), (410, 0), (415, 1), (420, 0), (425, 1), (430, 0), (435, 0), (440, 0), (445, 0), (450, 1), (455, 1), (460, 1), (465, 1), (470, 1), (475, 1), (480, 0), (485, 0), (490, 1), (495, 1), (500, 1), (505, 0), (510, 0), (515, 0), (520, 1), (525, 1), (530, 1), (535, 1), (540, 1), (545, 1), (550, 0), (555, 0), (560, 1), (565, 1), (570, 1), (575, 1), (580, 1), (585, 1), (590, 0), (595, 1), (600, 1), (605, 0), (610, 1), (615, 1), (620, 1), (625, 1), (630, 0), (635, 0), (640, 1), (645, 0), (650, 1), (655, 1), (660, 1), (665, 1), (670, 1), (675, 1), (680, 1), (685, 0), (690, 0), (695, 1), (700, 1), (705, 0), (710, 1), (715, 1), (720, 0), (725, 1), (730, 1), (735, 0), (740, 1), (745, 0), (750, 0), (755, 1), (760, 0), (765, 0), (770, 0), (775, 0), (780, 0), (785, 0), (790, 0), (795, 0), (800, 0), (805, 0), (810, 1), (815, 0), (820, 1), (825, 0), (830, 0), (835, 0), (840, 1), (845, 1), (850, 1), (855, 0), (860, 0), (865, 0), (870, 1), (875, 1), (880, 0), (885, 1), (890, 0), (895, 0), (900, 0), (905, 1), (910, 1), (915, 1), (920, 1), (925, 0), (930, 1), (935, 0), (940, 0), (945, 0), (950, 0), (955, 0), (960, 0), (965, 0), (970, 0), (975, 0), (980, 1), (985, 0), (990, 0), (995, 0), (1000, 0), (1005, 1), (1010, 0), (1015, 0), (1020, 1), (1025, 1)]
Va0_6  a0_6  0 PWL (0n 0.0v 4.745n 0.0v 4.755n 1.1v 9.745n 1.1v 9.755n 1.1v 14.745n 1.1v 14.755n 0.0v 19.745n 0.0v 19.755n 1.1v 24.745n 1.1v 24.755n 1.1v 29.745n 1.1v 29.755n 0.0v 34.745n 0.0v 34.755n 0.0v 39.745n 0.0v 39.755n 1.1v 44.745n 1.1v 44.755n 0.0v 49.745n 0.0v 49.755n 0.0v 54.745n 0.0v 54.755n 0.0v 59.745n 0.0v 59.755n 1.1v 64.745n 1.1v 64.755n 1.1v 69.745n 1.1v 69.755n 1.1v 74.745n 1.1v 74.755n 1.1v 79.745n 1.1v 79.755n 1.1v 84.745n 1.1v 84.755n 1.1v 89.745n 1.1v 89.755n 1.1v 94.745n 1.1v 94.755n 1.1v 99.745n 1.1v 99.755n 1.1v 104.745n 1.1v 104.755n 1.1v 109.745n 1.1v 109.755n 1.1v 114.745n 1.1v 114.755n 1.1v 119.745n 1.1v 119.755n 1.1v 124.745n 1.1v 124.755n 1.1v 129.745n 1.1v 129.755n 0.0v 134.745n 0.0v 134.755n 0.0v 139.745n 0.0v 139.755n 1.1v 144.745n 1.1v 144.755n 1.1v 149.745n 1.1v 149.755n 1.1v 154.745n 1.1v 154.755n 0.0v 159.745n 0.0v 159.755n 0.0v 164.745n 0.0v 164.755n 1.1v 169.745n 1.1v 169.755n 0.0v 174.745n 0.0v 174.755n 0.0v 179.745n 0.0v 179.755n 1.1v 184.745n 1.1v 184.755n 0.0v 189.745n 0.0v 189.755n 1.1v 194.745n 1.1v 194.755n 1.1v 199.745n 1.1v 199.755n 0.0v 204.745n 0.0v 204.755n 0.0v 209.745n 0.0v 209.755n 1.1v 214.745n 1.1v 214.755n 0.0v 219.745n 0.0v 219.755n 1.1v 224.745n 1.1v 224.755n 1.1v 229.745n 1.1v 229.755n 1.1v 234.745n 1.1v 234.755n 0.0v 239.745n 0.0v 239.755n 0.0v 244.745n 0.0v 244.755n 0.0v 249.745n 0.0v 249.755n 0.0v 254.745n 0.0v 254.755n 1.1v 259.745n 1.1v 259.755n 1.1v 264.745n 1.1v 264.755n 1.1v 269.745n 1.1v 269.755n 1.1v 274.745n 1.1v 274.755n 1.1v 279.745n 1.1v 279.755n 0.0v 284.745n 0.0v 284.755n 1.1v 289.745n 1.1v 289.755n 1.1v 294.745n 1.1v 294.755n 1.1v 299.745n 1.1v 299.755n 0.0v 304.745n 0.0v 304.755n 0.0v 309.745n 0.0v 309.755n 0.0v 314.745n 0.0v 314.755n 1.1v 319.745n 1.1v 319.755n 1.1v 324.745n 1.1v 324.755n 1.1v 329.745n 1.1v 329.755n 0.0v 334.745n 0.0v 334.755n 1.1v 339.745n 1.1v 339.755n 0.0v 344.745n 0.0v 344.755n 0.0v 349.745n 0.0v 349.755n 0.0v 354.745n 0.0v 354.755n 1.1v 359.745n 1.1v 359.755n 0.0v 364.745n 0.0v 364.755n 0.0v 369.745n 0.0v 369.755n 0.0v 374.745n 0.0v 374.755n 0.0v 379.745n 0.0v 379.755n 0.0v 384.745n 0.0v 384.755n 0.0v 389.745n 0.0v 389.755n 1.1v 394.745n 1.1v 394.755n 1.1v 399.745n 1.1v 399.755n 1.1v 404.745n 1.1v 404.755n 1.1v 409.745n 1.1v 409.755n 0.0v 414.745n 0.0v 414.755n 1.1v 419.745n 1.1v 419.755n 0.0v 424.745n 0.0v 424.755n 1.1v 429.745n 1.1v 429.755n 0.0v 434.745n 0.0v 434.755n 0.0v 439.745n 0.0v 439.755n 0.0v 444.745n 0.0v 444.755n 0.0v 449.745n 0.0v 449.755n 1.1v 454.745n 1.1v 454.755n 1.1v 459.745n 1.1v 459.755n 1.1v 464.745n 1.1v 464.755n 1.1v 469.745n 1.1v 469.755n 1.1v 474.745n 1.1v 474.755n 1.1v 479.745n 1.1v 479.755n 0.0v 484.745n 0.0v 484.755n 0.0v 489.745n 0.0v 489.755n 1.1v 494.745n 1.1v 494.755n 1.1v 499.745n 1.1v 499.755n 1.1v 504.745n 1.1v 504.755n 0.0v 509.745n 0.0v 509.755n 0.0v 514.745n 0.0v 514.755n 0.0v 519.745n 0.0v 519.755n 1.1v 524.745n 1.1v 524.755n 1.1v 529.745n 1.1v 529.755n 1.1v 534.745n 1.1v 534.755n 1.1v 539.745n 1.1v 539.755n 1.1v 544.745n 1.1v 544.755n 1.1v 549.745n 1.1v 549.755n 0.0v 554.745n 0.0v 554.755n 0.0v 559.745n 0.0v 559.755n 1.1v 564.745n 1.1v 564.755n 1.1v 569.745n 1.1v 569.755n 1.1v 574.745n 1.1v 574.755n 1.1v 579.745n 1.1v 579.755n 1.1v 584.745n 1.1v 584.755n 1.1v 589.745n 1.1v 589.755n 0.0v 594.745n 0.0v 594.755n 1.1v 599.745n 1.1v 599.755n 1.1v 604.745n 1.1v 604.755n 0.0v 609.745n 0.0v 609.755n 1.1v 614.745n 1.1v 614.755n 1.1v 619.745n 1.1v 619.755n 1.1v 624.745n 1.1v 624.755n 1.1v 629.745n 1.1v 629.755n 0.0v 634.745n 0.0v 634.755n 0.0v 639.745n 0.0v 639.755n 1.1v 644.745n 1.1v 644.755n 0.0v 649.745n 0.0v 649.755n 1.1v 654.745n 1.1v 654.755n 1.1v 659.745n 1.1v 659.755n 1.1v 664.745n 1.1v 664.755n 1.1v 669.745n 1.1v 669.755n 1.1v 674.745n 1.1v 674.755n 1.1v 679.745n 1.1v 679.755n 1.1v 684.745n 1.1v 684.755n 0.0v 689.745n 0.0v 689.755n 0.0v 694.745n 0.0v 694.755n 1.1v 699.745n 1.1v 699.755n 1.1v 704.745n 1.1v 704.755n 0.0v 709.745n 0.0v 709.755n 1.1v 714.745n 1.1v 714.755n 1.1v 719.745n 1.1v 719.755n 0.0v 724.745n 0.0v 724.755n 1.1v 729.745n 1.1v 729.755n 1.1v 734.745n 1.1v 734.755n 0.0v 739.745n 0.0v 739.755n 1.1v 744.745n 1.1v 744.755n 0.0v 749.745n 0.0v 749.755n 0.0v 754.745n 0.0v 754.755n 1.1v 759.745n 1.1v 759.755n 0.0v 764.745n 0.0v 764.755n 0.0v 769.745n 0.0v 769.755n 0.0v 774.745n 0.0v 774.755n 0.0v 779.745n 0.0v 779.755n 0.0v 784.745n 0.0v 784.755n 0.0v 789.745n 0.0v 789.755n 0.0v 794.745n 0.0v 794.755n 0.0v 799.745n 0.0v 799.755n 0.0v 804.745n 0.0v 804.755n 0.0v 809.745n 0.0v 809.755n 1.1v 814.745n 1.1v 814.755n 0.0v 819.745n 0.0v 819.755n 1.1v 824.745n 1.1v 824.755n 0.0v 829.745n 0.0v 829.755n 0.0v 834.745n 0.0v 834.755n 0.0v 839.745n 0.0v 839.755n 1.1v 844.745n 1.1v 844.755n 1.1v 849.745n 1.1v 849.755n 1.1v 854.745n 1.1v 854.755n 0.0v 859.745n 0.0v 859.755n 0.0v 864.745n 0.0v 864.755n 0.0v 869.745n 0.0v 869.755n 1.1v 874.745n 1.1v 874.755n 1.1v 879.745n 1.1v 879.755n 0.0v 884.745n 0.0v 884.755n 1.1v 889.745n 1.1v 889.755n 0.0v 894.745n 0.0v 894.755n 0.0v 899.745n 0.0v 899.755n 0.0v 904.745n 0.0v 904.755n 1.1v 909.745n 1.1v 909.755n 1.1v 914.745n 1.1v 914.755n 1.1v 919.745n 1.1v 919.755n 1.1v 924.745n 1.1v 924.755n 0.0v 929.745n 0.0v 929.755n 1.1v 934.745n 1.1v 934.755n 0.0v 939.745n 0.0v 939.755n 0.0v 944.745n 0.0v 944.755n 0.0v 949.745n 0.0v 949.755n 0.0v 954.745n 0.0v 954.755n 0.0v 959.745n 0.0v 959.755n 0.0v 964.745n 0.0v 964.755n 0.0v 969.745n 0.0v 969.755n 0.0v 974.745n 0.0v 974.755n 0.0v 979.745n 0.0v 979.755n 1.1v 984.745n 1.1v 984.755n 0.0v 989.745n 0.0v 989.755n 0.0v 994.745n 0.0v 994.755n 0.0v 999.745n 0.0v 999.755n 0.0v 1004.745n 0.0v 1004.755n 1.1v 1009.745n 1.1v 1009.755n 0.0v 1014.745n 0.0v 1014.755n 0.0v 1019.745n 0.0v 1019.755n 1.1v 1024.745n 1.1v 1024.755n 1.1v )
* (time, data): [(0, 0), (5, 1), (10, 1), (15, 0), (20, 1), (25, 1), (30, 0), (35, 0), (40, 1), (45, 0), (50, 0), (55, 0), (60, 1), (65, 1), (70, 1), (75, 1), (80, 1), (85, 1), (90, 1), (95, 1), (100, 1), (105, 1), (110, 1), (115, 1), (120, 1), (125, 1), (130, 0), (135, 0), (140, 1), (145, 1), (150, 1), (155, 0), (160, 0), (165, 1), (170, 0), (175, 0), (180, 1), (185, 0), (190, 1), (195, 1), (200, 0), (205, 0), (210, 1), (215, 0), (220, 1), (225, 1), (230, 1), (235, 0), (240, 0), (245, 0), (250, 0), (255, 1), (260, 1), (265, 1), (270, 1), (275, 1), (280, 0), (285, 1), (290, 1), (295, 1), (300, 0), (305, 0), (310, 0), (315, 1), (320, 1), (325, 1), (330, 0), (335, 1), (340, 0), (345, 0), (350, 0), (355, 1), (360, 0), (365, 0), (370, 0), (375, 0), (380, 0), (385, 0), (390, 1), (395, 1), (400, 1), (405, 1), (410, 0), (415, 1), (420, 0), (425, 1), (430, 0), (435, 0), (440, 0), (445, 0), (450, 1), (455, 1), (460, 1), (465, 1), (470, 1), (475, 1), (480, 0), (485, 0), (490, 1), (495, 1), (500, 1), (505, 0), (510, 0), (515, 0), (520, 1), (525, 1), (530, 1), (535, 1), (540, 1), (545, 1), (550, 0), (555, 0), (560, 1), (565, 1), (570, 1), (575, 1), (580, 1), (585, 1), (590, 0), (595, 1), (600, 1), (605, 0), (610, 1), (615, 1), (620, 1), (625, 1), (630, 0), (635, 0), (640, 1), (645, 0), (650, 1), (655, 1), (660, 1), (665, 1), (670, 1), (675, 1), (680, 1), (685, 0), (690, 0), (695, 1), (700, 1), (705, 0), (710, 1), (715, 1), (720, 0), (725, 1), (730, 1), (735, 0), (740, 1), (745, 0), (750, 0), (755, 1), (760, 0), (765, 0), (770, 0), (775, 0), (780, 0), (785, 0), (790, 0), (795, 0), (800, 0), (805, 0), (810, 1), (815, 0), (820, 1), (825, 0), (830, 0), (835, 0), (840, 1), (845, 1), (850, 1), (855, 0), (860, 0), (865, 0), (870, 1), (875, 1), (880, 0), (885, 1), (890, 0), (895, 0), (900, 0), (905, 1), (910, 1), (915, 1), (920, 1), (925, 0), (930, 1), (935, 0), (940, 0), (945, 0), (950, 0), (955, 0), (960, 0), (965, 0), (970, 0), (975, 0), (980, 1), (985, 0), (990, 0), (995, 0), (1000, 0), (1005, 1), (1010, 0), (1015, 0), (1020, 1), (1025, 1)]
Va0_7  a0_7  0 PWL (0n 0.0v 4.745n 0.0v 4.755n 1.1v 9.745n 1.1v 9.755n 1.1v 14.745n 1.1v 14.755n 0.0v 19.745n 0.0v 19.755n 1.1v 24.745n 1.1v 24.755n 1.1v 29.745n 1.1v 29.755n 0.0v 34.745n 0.0v 34.755n 0.0v 39.745n 0.0v 39.755n 1.1v 44.745n 1.1v 44.755n 0.0v 49.745n 0.0v 49.755n 0.0v 54.745n 0.0v 54.755n 0.0v 59.745n 0.0v 59.755n 1.1v 64.745n 1.1v 64.755n 1.1v 69.745n 1.1v 69.755n 1.1v 74.745n 1.1v 74.755n 1.1v 79.745n 1.1v 79.755n 1.1v 84.745n 1.1v 84.755n 1.1v 89.745n 1.1v 89.755n 1.1v 94.745n 1.1v 94.755n 1.1v 99.745n 1.1v 99.755n 1.1v 104.745n 1.1v 104.755n 1.1v 109.745n 1.1v 109.755n 1.1v 114.745n 1.1v 114.755n 1.1v 119.745n 1.1v 119.755n 1.1v 124.745n 1.1v 124.755n 1.1v 129.745n 1.1v 129.755n 0.0v 134.745n 0.0v 134.755n 0.0v 139.745n 0.0v 139.755n 1.1v 144.745n 1.1v 144.755n 1.1v 149.745n 1.1v 149.755n 1.1v 154.745n 1.1v 154.755n 0.0v 159.745n 0.0v 159.755n 0.0v 164.745n 0.0v 164.755n 1.1v 169.745n 1.1v 169.755n 0.0v 174.745n 0.0v 174.755n 0.0v 179.745n 0.0v 179.755n 1.1v 184.745n 1.1v 184.755n 0.0v 189.745n 0.0v 189.755n 1.1v 194.745n 1.1v 194.755n 1.1v 199.745n 1.1v 199.755n 0.0v 204.745n 0.0v 204.755n 0.0v 209.745n 0.0v 209.755n 1.1v 214.745n 1.1v 214.755n 0.0v 219.745n 0.0v 219.755n 1.1v 224.745n 1.1v 224.755n 1.1v 229.745n 1.1v 229.755n 1.1v 234.745n 1.1v 234.755n 0.0v 239.745n 0.0v 239.755n 0.0v 244.745n 0.0v 244.755n 0.0v 249.745n 0.0v 249.755n 0.0v 254.745n 0.0v 254.755n 1.1v 259.745n 1.1v 259.755n 1.1v 264.745n 1.1v 264.755n 1.1v 269.745n 1.1v 269.755n 1.1v 274.745n 1.1v 274.755n 1.1v 279.745n 1.1v 279.755n 0.0v 284.745n 0.0v 284.755n 1.1v 289.745n 1.1v 289.755n 1.1v 294.745n 1.1v 294.755n 1.1v 299.745n 1.1v 299.755n 0.0v 304.745n 0.0v 304.755n 0.0v 309.745n 0.0v 309.755n 0.0v 314.745n 0.0v 314.755n 1.1v 319.745n 1.1v 319.755n 1.1v 324.745n 1.1v 324.755n 1.1v 329.745n 1.1v 329.755n 0.0v 334.745n 0.0v 334.755n 1.1v 339.745n 1.1v 339.755n 0.0v 344.745n 0.0v 344.755n 0.0v 349.745n 0.0v 349.755n 0.0v 354.745n 0.0v 354.755n 1.1v 359.745n 1.1v 359.755n 0.0v 364.745n 0.0v 364.755n 0.0v 369.745n 0.0v 369.755n 0.0v 374.745n 0.0v 374.755n 0.0v 379.745n 0.0v 379.755n 0.0v 384.745n 0.0v 384.755n 0.0v 389.745n 0.0v 389.755n 1.1v 394.745n 1.1v 394.755n 1.1v 399.745n 1.1v 399.755n 1.1v 404.745n 1.1v 404.755n 1.1v 409.745n 1.1v 409.755n 0.0v 414.745n 0.0v 414.755n 1.1v 419.745n 1.1v 419.755n 0.0v 424.745n 0.0v 424.755n 1.1v 429.745n 1.1v 429.755n 0.0v 434.745n 0.0v 434.755n 0.0v 439.745n 0.0v 439.755n 0.0v 444.745n 0.0v 444.755n 0.0v 449.745n 0.0v 449.755n 1.1v 454.745n 1.1v 454.755n 1.1v 459.745n 1.1v 459.755n 1.1v 464.745n 1.1v 464.755n 1.1v 469.745n 1.1v 469.755n 1.1v 474.745n 1.1v 474.755n 1.1v 479.745n 1.1v 479.755n 0.0v 484.745n 0.0v 484.755n 0.0v 489.745n 0.0v 489.755n 1.1v 494.745n 1.1v 494.755n 1.1v 499.745n 1.1v 499.755n 1.1v 504.745n 1.1v 504.755n 0.0v 509.745n 0.0v 509.755n 0.0v 514.745n 0.0v 514.755n 0.0v 519.745n 0.0v 519.755n 1.1v 524.745n 1.1v 524.755n 1.1v 529.745n 1.1v 529.755n 1.1v 534.745n 1.1v 534.755n 1.1v 539.745n 1.1v 539.755n 1.1v 544.745n 1.1v 544.755n 1.1v 549.745n 1.1v 549.755n 0.0v 554.745n 0.0v 554.755n 0.0v 559.745n 0.0v 559.755n 1.1v 564.745n 1.1v 564.755n 1.1v 569.745n 1.1v 569.755n 1.1v 574.745n 1.1v 574.755n 1.1v 579.745n 1.1v 579.755n 1.1v 584.745n 1.1v 584.755n 1.1v 589.745n 1.1v 589.755n 0.0v 594.745n 0.0v 594.755n 1.1v 599.745n 1.1v 599.755n 1.1v 604.745n 1.1v 604.755n 0.0v 609.745n 0.0v 609.755n 1.1v 614.745n 1.1v 614.755n 1.1v 619.745n 1.1v 619.755n 1.1v 624.745n 1.1v 624.755n 1.1v 629.745n 1.1v 629.755n 0.0v 634.745n 0.0v 634.755n 0.0v 639.745n 0.0v 639.755n 1.1v 644.745n 1.1v 644.755n 0.0v 649.745n 0.0v 649.755n 1.1v 654.745n 1.1v 654.755n 1.1v 659.745n 1.1v 659.755n 1.1v 664.745n 1.1v 664.755n 1.1v 669.745n 1.1v 669.755n 1.1v 674.745n 1.1v 674.755n 1.1v 679.745n 1.1v 679.755n 1.1v 684.745n 1.1v 684.755n 0.0v 689.745n 0.0v 689.755n 0.0v 694.745n 0.0v 694.755n 1.1v 699.745n 1.1v 699.755n 1.1v 704.745n 1.1v 704.755n 0.0v 709.745n 0.0v 709.755n 1.1v 714.745n 1.1v 714.755n 1.1v 719.745n 1.1v 719.755n 0.0v 724.745n 0.0v 724.755n 1.1v 729.745n 1.1v 729.755n 1.1v 734.745n 1.1v 734.755n 0.0v 739.745n 0.0v 739.755n 1.1v 744.745n 1.1v 744.755n 0.0v 749.745n 0.0v 749.755n 0.0v 754.745n 0.0v 754.755n 1.1v 759.745n 1.1v 759.755n 0.0v 764.745n 0.0v 764.755n 0.0v 769.745n 0.0v 769.755n 0.0v 774.745n 0.0v 774.755n 0.0v 779.745n 0.0v 779.755n 0.0v 784.745n 0.0v 784.755n 0.0v 789.745n 0.0v 789.755n 0.0v 794.745n 0.0v 794.755n 0.0v 799.745n 0.0v 799.755n 0.0v 804.745n 0.0v 804.755n 0.0v 809.745n 0.0v 809.755n 1.1v 814.745n 1.1v 814.755n 0.0v 819.745n 0.0v 819.755n 1.1v 824.745n 1.1v 824.755n 0.0v 829.745n 0.0v 829.755n 0.0v 834.745n 0.0v 834.755n 0.0v 839.745n 0.0v 839.755n 1.1v 844.745n 1.1v 844.755n 1.1v 849.745n 1.1v 849.755n 1.1v 854.745n 1.1v 854.755n 0.0v 859.745n 0.0v 859.755n 0.0v 864.745n 0.0v 864.755n 0.0v 869.745n 0.0v 869.755n 1.1v 874.745n 1.1v 874.755n 1.1v 879.745n 1.1v 879.755n 0.0v 884.745n 0.0v 884.755n 1.1v 889.745n 1.1v 889.755n 0.0v 894.745n 0.0v 894.755n 0.0v 899.745n 0.0v 899.755n 0.0v 904.745n 0.0v 904.755n 1.1v 909.745n 1.1v 909.755n 1.1v 914.745n 1.1v 914.755n 1.1v 919.745n 1.1v 919.755n 1.1v 924.745n 1.1v 924.755n 0.0v 929.745n 0.0v 929.755n 1.1v 934.745n 1.1v 934.755n 0.0v 939.745n 0.0v 939.755n 0.0v 944.745n 0.0v 944.755n 0.0v 949.745n 0.0v 949.755n 0.0v 954.745n 0.0v 954.755n 0.0v 959.745n 0.0v 959.755n 0.0v 964.745n 0.0v 964.755n 0.0v 969.745n 0.0v 969.755n 0.0v 974.745n 0.0v 974.755n 0.0v 979.745n 0.0v 979.755n 1.1v 984.745n 1.1v 984.755n 0.0v 989.745n 0.0v 989.755n 0.0v 994.745n 0.0v 994.755n 0.0v 999.745n 0.0v 999.755n 0.0v 1004.745n 0.0v 1004.755n 1.1v 1009.745n 1.1v 1009.755n 0.0v 1014.745n 0.0v 1014.755n 0.0v 1019.745n 0.0v 1019.755n 1.1v 1024.745n 1.1v 1024.755n 1.1v )
* (time, data): [(0, 0), (5, 1), (10, 1), (15, 0), (20, 1), (25, 1), (30, 0), (35, 0), (40, 1), (45, 0), (50, 0), (55, 0), (60, 1), (65, 1), (70, 1), (75, 1), (80, 1), (85, 1), (90, 1), (95, 1), (100, 1), (105, 1), (110, 1), (115, 1), (120, 1), (125, 1), (130, 0), (135, 0), (140, 1), (145, 1), (150, 1), (155, 0), (160, 0), (165, 1), (170, 0), (175, 0), (180, 1), (185, 0), (190, 1), (195, 1), (200, 0), (205, 0), (210, 1), (215, 0), (220, 1), (225, 1), (230, 1), (235, 0), (240, 0), (245, 0), (250, 0), (255, 1), (260, 1), (265, 1), (270, 1), (275, 1), (280, 0), (285, 1), (290, 1), (295, 1), (300, 0), (305, 0), (310, 0), (315, 1), (320, 1), (325, 1), (330, 0), (335, 1), (340, 0), (345, 0), (350, 0), (355, 1), (360, 0), (365, 0), (370, 0), (375, 0), (380, 0), (385, 0), (390, 1), (395, 1), (400, 1), (405, 1), (410, 0), (415, 1), (420, 0), (425, 1), (430, 0), (435, 0), (440, 0), (445, 0), (450, 1), (455, 1), (460, 1), (465, 1), (470, 1), (475, 1), (480, 0), (485, 0), (490, 1), (495, 1), (500, 1), (505, 0), (510, 0), (515, 0), (520, 1), (525, 1), (530, 1), (535, 1), (540, 1), (545, 1), (550, 0), (555, 0), (560, 1), (565, 1), (570, 1), (575, 1), (580, 1), (585, 1), (590, 0), (595, 1), (600, 1), (605, 0), (610, 1), (615, 1), (620, 1), (625, 1), (630, 0), (635, 0), (640, 1), (645, 0), (650, 1), (655, 1), (660, 1), (665, 1), (670, 1), (675, 1), (680, 1), (685, 0), (690, 0), (695, 1), (700, 1), (705, 0), (710, 1), (715, 1), (720, 0), (725, 1), (730, 1), (735, 0), (740, 1), (745, 0), (750, 0), (755, 1), (760, 0), (765, 0), (770, 0), (775, 0), (780, 0), (785, 0), (790, 0), (795, 0), (800, 0), (805, 0), (810, 1), (815, 0), (820, 1), (825, 0), (830, 0), (835, 0), (840, 1), (845, 1), (850, 1), (855, 0), (860, 0), (865, 0), (870, 1), (875, 1), (880, 0), (885, 1), (890, 0), (895, 0), (900, 0), (905, 1), (910, 1), (915, 1), (920, 1), (925, 0), (930, 1), (935, 0), (940, 0), (945, 0), (950, 0), (955, 0), (960, 0), (965, 0), (970, 0), (975, 0), (980, 1), (985, 0), (990, 0), (995, 0), (1000, 0), (1005, 1), (1010, 0), (1015, 0), (1020, 1), (1025, 1)]
Va0_8  a0_8  0 PWL (0n 0.0v 4.745n 0.0v 4.755n 1.1v 9.745n 1.1v 9.755n 1.1v 14.745n 1.1v 14.755n 0.0v 19.745n 0.0v 19.755n 1.1v 24.745n 1.1v 24.755n 1.1v 29.745n 1.1v 29.755n 0.0v 34.745n 0.0v 34.755n 0.0v 39.745n 0.0v 39.755n 1.1v 44.745n 1.1v 44.755n 0.0v 49.745n 0.0v 49.755n 0.0v 54.745n 0.0v 54.755n 0.0v 59.745n 0.0v 59.755n 1.1v 64.745n 1.1v 64.755n 1.1v 69.745n 1.1v 69.755n 1.1v 74.745n 1.1v 74.755n 1.1v 79.745n 1.1v 79.755n 1.1v 84.745n 1.1v 84.755n 1.1v 89.745n 1.1v 89.755n 1.1v 94.745n 1.1v 94.755n 1.1v 99.745n 1.1v 99.755n 1.1v 104.745n 1.1v 104.755n 1.1v 109.745n 1.1v 109.755n 1.1v 114.745n 1.1v 114.755n 1.1v 119.745n 1.1v 119.755n 1.1v 124.745n 1.1v 124.755n 1.1v 129.745n 1.1v 129.755n 0.0v 134.745n 0.0v 134.755n 0.0v 139.745n 0.0v 139.755n 1.1v 144.745n 1.1v 144.755n 1.1v 149.745n 1.1v 149.755n 1.1v 154.745n 1.1v 154.755n 0.0v 159.745n 0.0v 159.755n 0.0v 164.745n 0.0v 164.755n 1.1v 169.745n 1.1v 169.755n 0.0v 174.745n 0.0v 174.755n 0.0v 179.745n 0.0v 179.755n 1.1v 184.745n 1.1v 184.755n 0.0v 189.745n 0.0v 189.755n 1.1v 194.745n 1.1v 194.755n 1.1v 199.745n 1.1v 199.755n 0.0v 204.745n 0.0v 204.755n 0.0v 209.745n 0.0v 209.755n 1.1v 214.745n 1.1v 214.755n 0.0v 219.745n 0.0v 219.755n 1.1v 224.745n 1.1v 224.755n 1.1v 229.745n 1.1v 229.755n 1.1v 234.745n 1.1v 234.755n 0.0v 239.745n 0.0v 239.755n 0.0v 244.745n 0.0v 244.755n 0.0v 249.745n 0.0v 249.755n 0.0v 254.745n 0.0v 254.755n 1.1v 259.745n 1.1v 259.755n 1.1v 264.745n 1.1v 264.755n 1.1v 269.745n 1.1v 269.755n 1.1v 274.745n 1.1v 274.755n 1.1v 279.745n 1.1v 279.755n 0.0v 284.745n 0.0v 284.755n 1.1v 289.745n 1.1v 289.755n 1.1v 294.745n 1.1v 294.755n 1.1v 299.745n 1.1v 299.755n 0.0v 304.745n 0.0v 304.755n 0.0v 309.745n 0.0v 309.755n 0.0v 314.745n 0.0v 314.755n 1.1v 319.745n 1.1v 319.755n 1.1v 324.745n 1.1v 324.755n 1.1v 329.745n 1.1v 329.755n 0.0v 334.745n 0.0v 334.755n 1.1v 339.745n 1.1v 339.755n 0.0v 344.745n 0.0v 344.755n 0.0v 349.745n 0.0v 349.755n 0.0v 354.745n 0.0v 354.755n 1.1v 359.745n 1.1v 359.755n 0.0v 364.745n 0.0v 364.755n 0.0v 369.745n 0.0v 369.755n 0.0v 374.745n 0.0v 374.755n 0.0v 379.745n 0.0v 379.755n 0.0v 384.745n 0.0v 384.755n 0.0v 389.745n 0.0v 389.755n 1.1v 394.745n 1.1v 394.755n 1.1v 399.745n 1.1v 399.755n 1.1v 404.745n 1.1v 404.755n 1.1v 409.745n 1.1v 409.755n 0.0v 414.745n 0.0v 414.755n 1.1v 419.745n 1.1v 419.755n 0.0v 424.745n 0.0v 424.755n 1.1v 429.745n 1.1v 429.755n 0.0v 434.745n 0.0v 434.755n 0.0v 439.745n 0.0v 439.755n 0.0v 444.745n 0.0v 444.755n 0.0v 449.745n 0.0v 449.755n 1.1v 454.745n 1.1v 454.755n 1.1v 459.745n 1.1v 459.755n 1.1v 464.745n 1.1v 464.755n 1.1v 469.745n 1.1v 469.755n 1.1v 474.745n 1.1v 474.755n 1.1v 479.745n 1.1v 479.755n 0.0v 484.745n 0.0v 484.755n 0.0v 489.745n 0.0v 489.755n 1.1v 494.745n 1.1v 494.755n 1.1v 499.745n 1.1v 499.755n 1.1v 504.745n 1.1v 504.755n 0.0v 509.745n 0.0v 509.755n 0.0v 514.745n 0.0v 514.755n 0.0v 519.745n 0.0v 519.755n 1.1v 524.745n 1.1v 524.755n 1.1v 529.745n 1.1v 529.755n 1.1v 534.745n 1.1v 534.755n 1.1v 539.745n 1.1v 539.755n 1.1v 544.745n 1.1v 544.755n 1.1v 549.745n 1.1v 549.755n 0.0v 554.745n 0.0v 554.755n 0.0v 559.745n 0.0v 559.755n 1.1v 564.745n 1.1v 564.755n 1.1v 569.745n 1.1v 569.755n 1.1v 574.745n 1.1v 574.755n 1.1v 579.745n 1.1v 579.755n 1.1v 584.745n 1.1v 584.755n 1.1v 589.745n 1.1v 589.755n 0.0v 594.745n 0.0v 594.755n 1.1v 599.745n 1.1v 599.755n 1.1v 604.745n 1.1v 604.755n 0.0v 609.745n 0.0v 609.755n 1.1v 614.745n 1.1v 614.755n 1.1v 619.745n 1.1v 619.755n 1.1v 624.745n 1.1v 624.755n 1.1v 629.745n 1.1v 629.755n 0.0v 634.745n 0.0v 634.755n 0.0v 639.745n 0.0v 639.755n 1.1v 644.745n 1.1v 644.755n 0.0v 649.745n 0.0v 649.755n 1.1v 654.745n 1.1v 654.755n 1.1v 659.745n 1.1v 659.755n 1.1v 664.745n 1.1v 664.755n 1.1v 669.745n 1.1v 669.755n 1.1v 674.745n 1.1v 674.755n 1.1v 679.745n 1.1v 679.755n 1.1v 684.745n 1.1v 684.755n 0.0v 689.745n 0.0v 689.755n 0.0v 694.745n 0.0v 694.755n 1.1v 699.745n 1.1v 699.755n 1.1v 704.745n 1.1v 704.755n 0.0v 709.745n 0.0v 709.755n 1.1v 714.745n 1.1v 714.755n 1.1v 719.745n 1.1v 719.755n 0.0v 724.745n 0.0v 724.755n 1.1v 729.745n 1.1v 729.755n 1.1v 734.745n 1.1v 734.755n 0.0v 739.745n 0.0v 739.755n 1.1v 744.745n 1.1v 744.755n 0.0v 749.745n 0.0v 749.755n 0.0v 754.745n 0.0v 754.755n 1.1v 759.745n 1.1v 759.755n 0.0v 764.745n 0.0v 764.755n 0.0v 769.745n 0.0v 769.755n 0.0v 774.745n 0.0v 774.755n 0.0v 779.745n 0.0v 779.755n 0.0v 784.745n 0.0v 784.755n 0.0v 789.745n 0.0v 789.755n 0.0v 794.745n 0.0v 794.755n 0.0v 799.745n 0.0v 799.755n 0.0v 804.745n 0.0v 804.755n 0.0v 809.745n 0.0v 809.755n 1.1v 814.745n 1.1v 814.755n 0.0v 819.745n 0.0v 819.755n 1.1v 824.745n 1.1v 824.755n 0.0v 829.745n 0.0v 829.755n 0.0v 834.745n 0.0v 834.755n 0.0v 839.745n 0.0v 839.755n 1.1v 844.745n 1.1v 844.755n 1.1v 849.745n 1.1v 849.755n 1.1v 854.745n 1.1v 854.755n 0.0v 859.745n 0.0v 859.755n 0.0v 864.745n 0.0v 864.755n 0.0v 869.745n 0.0v 869.755n 1.1v 874.745n 1.1v 874.755n 1.1v 879.745n 1.1v 879.755n 0.0v 884.745n 0.0v 884.755n 1.1v 889.745n 1.1v 889.755n 0.0v 894.745n 0.0v 894.755n 0.0v 899.745n 0.0v 899.755n 0.0v 904.745n 0.0v 904.755n 1.1v 909.745n 1.1v 909.755n 1.1v 914.745n 1.1v 914.755n 1.1v 919.745n 1.1v 919.755n 1.1v 924.745n 1.1v 924.755n 0.0v 929.745n 0.0v 929.755n 1.1v 934.745n 1.1v 934.755n 0.0v 939.745n 0.0v 939.755n 0.0v 944.745n 0.0v 944.755n 0.0v 949.745n 0.0v 949.755n 0.0v 954.745n 0.0v 954.755n 0.0v 959.745n 0.0v 959.755n 0.0v 964.745n 0.0v 964.755n 0.0v 969.745n 0.0v 969.755n 0.0v 974.745n 0.0v 974.755n 0.0v 979.745n 0.0v 979.755n 1.1v 984.745n 1.1v 984.755n 0.0v 989.745n 0.0v 989.755n 0.0v 994.745n 0.0v 994.755n 0.0v 999.745n 0.0v 999.755n 0.0v 1004.745n 0.0v 1004.755n 1.1v 1009.745n 1.1v 1009.755n 0.0v 1014.745n 0.0v 1014.755n 0.0v 1019.745n 0.0v 1019.755n 1.1v 1024.745n 1.1v 1024.755n 1.1v )
* (time, data): [(0, 0), (5, 1), (10, 1), (15, 0), (20, 1), (25, 1), (30, 0), (35, 0), (40, 1), (45, 0), (50, 0), (55, 0), (60, 1), (65, 1), (70, 1), (75, 1), (80, 1), (85, 1), (90, 1), (95, 1), (100, 1), (105, 1), (110, 1), (115, 1), (120, 1), (125, 1), (130, 0), (135, 0), (140, 1), (145, 1), (150, 1), (155, 0), (160, 0), (165, 1), (170, 0), (175, 0), (180, 1), (185, 0), (190, 1), (195, 1), (200, 0), (205, 0), (210, 1), (215, 0), (220, 1), (225, 1), (230, 1), (235, 0), (240, 0), (245, 0), (250, 0), (255, 1), (260, 1), (265, 1), (270, 1), (275, 1), (280, 0), (285, 1), (290, 1), (295, 1), (300, 0), (305, 0), (310, 0), (315, 1), (320, 1), (325, 1), (330, 0), (335, 1), (340, 0), (345, 0), (350, 0), (355, 1), (360, 0), (365, 0), (370, 0), (375, 0), (380, 0), (385, 0), (390, 1), (395, 1), (400, 1), (405, 1), (410, 0), (415, 1), (420, 0), (425, 1), (430, 0), (435, 0), (440, 0), (445, 0), (450, 1), (455, 1), (460, 1), (465, 1), (470, 1), (475, 1), (480, 0), (485, 0), (490, 1), (495, 1), (500, 1), (505, 0), (510, 0), (515, 0), (520, 1), (525, 1), (530, 1), (535, 1), (540, 1), (545, 1), (550, 0), (555, 0), (560, 1), (565, 1), (570, 1), (575, 1), (580, 1), (585, 1), (590, 0), (595, 1), (600, 1), (605, 0), (610, 1), (615, 1), (620, 1), (625, 1), (630, 0), (635, 0), (640, 1), (645, 0), (650, 1), (655, 1), (660, 1), (665, 1), (670, 1), (675, 1), (680, 1), (685, 0), (690, 0), (695, 1), (700, 1), (705, 0), (710, 1), (715, 1), (720, 0), (725, 1), (730, 1), (735, 0), (740, 1), (745, 0), (750, 0), (755, 1), (760, 0), (765, 0), (770, 0), (775, 0), (780, 0), (785, 0), (790, 0), (795, 0), (800, 0), (805, 0), (810, 1), (815, 0), (820, 1), (825, 0), (830, 0), (835, 0), (840, 1), (845, 1), (850, 1), (855, 0), (860, 0), (865, 0), (870, 1), (875, 1), (880, 0), (885, 1), (890, 0), (895, 0), (900, 0), (905, 1), (910, 1), (915, 1), (920, 1), (925, 0), (930, 1), (935, 0), (940, 0), (945, 0), (950, 0), (955, 0), (960, 0), (965, 0), (970, 0), (975, 0), (980, 1), (985, 0), (990, 0), (995, 0), (1000, 0), (1005, 1), (1010, 0), (1015, 0), (1020, 1), (1025, 1)]
Va0_9  a0_9  0 PWL (0n 0.0v 4.745n 0.0v 4.755n 1.1v 9.745n 1.1v 9.755n 1.1v 14.745n 1.1v 14.755n 0.0v 19.745n 0.0v 19.755n 1.1v 24.745n 1.1v 24.755n 1.1v 29.745n 1.1v 29.755n 0.0v 34.745n 0.0v 34.755n 0.0v 39.745n 0.0v 39.755n 1.1v 44.745n 1.1v 44.755n 0.0v 49.745n 0.0v 49.755n 0.0v 54.745n 0.0v 54.755n 0.0v 59.745n 0.0v 59.755n 1.1v 64.745n 1.1v 64.755n 1.1v 69.745n 1.1v 69.755n 1.1v 74.745n 1.1v 74.755n 1.1v 79.745n 1.1v 79.755n 1.1v 84.745n 1.1v 84.755n 1.1v 89.745n 1.1v 89.755n 1.1v 94.745n 1.1v 94.755n 1.1v 99.745n 1.1v 99.755n 1.1v 104.745n 1.1v 104.755n 1.1v 109.745n 1.1v 109.755n 1.1v 114.745n 1.1v 114.755n 1.1v 119.745n 1.1v 119.755n 1.1v 124.745n 1.1v 124.755n 1.1v 129.745n 1.1v 129.755n 0.0v 134.745n 0.0v 134.755n 0.0v 139.745n 0.0v 139.755n 1.1v 144.745n 1.1v 144.755n 1.1v 149.745n 1.1v 149.755n 1.1v 154.745n 1.1v 154.755n 0.0v 159.745n 0.0v 159.755n 0.0v 164.745n 0.0v 164.755n 1.1v 169.745n 1.1v 169.755n 0.0v 174.745n 0.0v 174.755n 0.0v 179.745n 0.0v 179.755n 1.1v 184.745n 1.1v 184.755n 0.0v 189.745n 0.0v 189.755n 1.1v 194.745n 1.1v 194.755n 1.1v 199.745n 1.1v 199.755n 0.0v 204.745n 0.0v 204.755n 0.0v 209.745n 0.0v 209.755n 1.1v 214.745n 1.1v 214.755n 0.0v 219.745n 0.0v 219.755n 1.1v 224.745n 1.1v 224.755n 1.1v 229.745n 1.1v 229.755n 1.1v 234.745n 1.1v 234.755n 0.0v 239.745n 0.0v 239.755n 0.0v 244.745n 0.0v 244.755n 0.0v 249.745n 0.0v 249.755n 0.0v 254.745n 0.0v 254.755n 1.1v 259.745n 1.1v 259.755n 1.1v 264.745n 1.1v 264.755n 1.1v 269.745n 1.1v 269.755n 1.1v 274.745n 1.1v 274.755n 1.1v 279.745n 1.1v 279.755n 0.0v 284.745n 0.0v 284.755n 1.1v 289.745n 1.1v 289.755n 1.1v 294.745n 1.1v 294.755n 1.1v 299.745n 1.1v 299.755n 0.0v 304.745n 0.0v 304.755n 0.0v 309.745n 0.0v 309.755n 0.0v 314.745n 0.0v 314.755n 1.1v 319.745n 1.1v 319.755n 1.1v 324.745n 1.1v 324.755n 1.1v 329.745n 1.1v 329.755n 0.0v 334.745n 0.0v 334.755n 1.1v 339.745n 1.1v 339.755n 0.0v 344.745n 0.0v 344.755n 0.0v 349.745n 0.0v 349.755n 0.0v 354.745n 0.0v 354.755n 1.1v 359.745n 1.1v 359.755n 0.0v 364.745n 0.0v 364.755n 0.0v 369.745n 0.0v 369.755n 0.0v 374.745n 0.0v 374.755n 0.0v 379.745n 0.0v 379.755n 0.0v 384.745n 0.0v 384.755n 0.0v 389.745n 0.0v 389.755n 1.1v 394.745n 1.1v 394.755n 1.1v 399.745n 1.1v 399.755n 1.1v 404.745n 1.1v 404.755n 1.1v 409.745n 1.1v 409.755n 0.0v 414.745n 0.0v 414.755n 1.1v 419.745n 1.1v 419.755n 0.0v 424.745n 0.0v 424.755n 1.1v 429.745n 1.1v 429.755n 0.0v 434.745n 0.0v 434.755n 0.0v 439.745n 0.0v 439.755n 0.0v 444.745n 0.0v 444.755n 0.0v 449.745n 0.0v 449.755n 1.1v 454.745n 1.1v 454.755n 1.1v 459.745n 1.1v 459.755n 1.1v 464.745n 1.1v 464.755n 1.1v 469.745n 1.1v 469.755n 1.1v 474.745n 1.1v 474.755n 1.1v 479.745n 1.1v 479.755n 0.0v 484.745n 0.0v 484.755n 0.0v 489.745n 0.0v 489.755n 1.1v 494.745n 1.1v 494.755n 1.1v 499.745n 1.1v 499.755n 1.1v 504.745n 1.1v 504.755n 0.0v 509.745n 0.0v 509.755n 0.0v 514.745n 0.0v 514.755n 0.0v 519.745n 0.0v 519.755n 1.1v 524.745n 1.1v 524.755n 1.1v 529.745n 1.1v 529.755n 1.1v 534.745n 1.1v 534.755n 1.1v 539.745n 1.1v 539.755n 1.1v 544.745n 1.1v 544.755n 1.1v 549.745n 1.1v 549.755n 0.0v 554.745n 0.0v 554.755n 0.0v 559.745n 0.0v 559.755n 1.1v 564.745n 1.1v 564.755n 1.1v 569.745n 1.1v 569.755n 1.1v 574.745n 1.1v 574.755n 1.1v 579.745n 1.1v 579.755n 1.1v 584.745n 1.1v 584.755n 1.1v 589.745n 1.1v 589.755n 0.0v 594.745n 0.0v 594.755n 1.1v 599.745n 1.1v 599.755n 1.1v 604.745n 1.1v 604.755n 0.0v 609.745n 0.0v 609.755n 1.1v 614.745n 1.1v 614.755n 1.1v 619.745n 1.1v 619.755n 1.1v 624.745n 1.1v 624.755n 1.1v 629.745n 1.1v 629.755n 0.0v 634.745n 0.0v 634.755n 0.0v 639.745n 0.0v 639.755n 1.1v 644.745n 1.1v 644.755n 0.0v 649.745n 0.0v 649.755n 1.1v 654.745n 1.1v 654.755n 1.1v 659.745n 1.1v 659.755n 1.1v 664.745n 1.1v 664.755n 1.1v 669.745n 1.1v 669.755n 1.1v 674.745n 1.1v 674.755n 1.1v 679.745n 1.1v 679.755n 1.1v 684.745n 1.1v 684.755n 0.0v 689.745n 0.0v 689.755n 0.0v 694.745n 0.0v 694.755n 1.1v 699.745n 1.1v 699.755n 1.1v 704.745n 1.1v 704.755n 0.0v 709.745n 0.0v 709.755n 1.1v 714.745n 1.1v 714.755n 1.1v 719.745n 1.1v 719.755n 0.0v 724.745n 0.0v 724.755n 1.1v 729.745n 1.1v 729.755n 1.1v 734.745n 1.1v 734.755n 0.0v 739.745n 0.0v 739.755n 1.1v 744.745n 1.1v 744.755n 0.0v 749.745n 0.0v 749.755n 0.0v 754.745n 0.0v 754.755n 1.1v 759.745n 1.1v 759.755n 0.0v 764.745n 0.0v 764.755n 0.0v 769.745n 0.0v 769.755n 0.0v 774.745n 0.0v 774.755n 0.0v 779.745n 0.0v 779.755n 0.0v 784.745n 0.0v 784.755n 0.0v 789.745n 0.0v 789.755n 0.0v 794.745n 0.0v 794.755n 0.0v 799.745n 0.0v 799.755n 0.0v 804.745n 0.0v 804.755n 0.0v 809.745n 0.0v 809.755n 1.1v 814.745n 1.1v 814.755n 0.0v 819.745n 0.0v 819.755n 1.1v 824.745n 1.1v 824.755n 0.0v 829.745n 0.0v 829.755n 0.0v 834.745n 0.0v 834.755n 0.0v 839.745n 0.0v 839.755n 1.1v 844.745n 1.1v 844.755n 1.1v 849.745n 1.1v 849.755n 1.1v 854.745n 1.1v 854.755n 0.0v 859.745n 0.0v 859.755n 0.0v 864.745n 0.0v 864.755n 0.0v 869.745n 0.0v 869.755n 1.1v 874.745n 1.1v 874.755n 1.1v 879.745n 1.1v 879.755n 0.0v 884.745n 0.0v 884.755n 1.1v 889.745n 1.1v 889.755n 0.0v 894.745n 0.0v 894.755n 0.0v 899.745n 0.0v 899.755n 0.0v 904.745n 0.0v 904.755n 1.1v 909.745n 1.1v 909.755n 1.1v 914.745n 1.1v 914.755n 1.1v 919.745n 1.1v 919.755n 1.1v 924.745n 1.1v 924.755n 0.0v 929.745n 0.0v 929.755n 1.1v 934.745n 1.1v 934.755n 0.0v 939.745n 0.0v 939.755n 0.0v 944.745n 0.0v 944.755n 0.0v 949.745n 0.0v 949.755n 0.0v 954.745n 0.0v 954.755n 0.0v 959.745n 0.0v 959.755n 0.0v 964.745n 0.0v 964.755n 0.0v 969.745n 0.0v 969.755n 0.0v 974.745n 0.0v 974.755n 0.0v 979.745n 0.0v 979.755n 1.1v 984.745n 1.1v 984.755n 0.0v 989.745n 0.0v 989.755n 0.0v 994.745n 0.0v 994.755n 0.0v 999.745n 0.0v 999.755n 0.0v 1004.745n 0.0v 1004.755n 1.1v 1009.745n 1.1v 1009.755n 0.0v 1014.745n 0.0v 1014.755n 0.0v 1019.745n 0.0v 1019.755n 1.1v 1024.745n 1.1v 1024.755n 1.1v )

 * Generation of control signals
* (time, data): [(0, 1), (5, 0), (10, 0), (15, 0), (20, 0), (25, 1), (30, 0), (35, 1), (40, 0), (45, 0), (50, 0), (55, 0), (60, 0), (65, 0), (70, 0), (75, 0), (80, 1), (85, 1), (90, 0), (95, 1), (100, 0), (105, 1), (110, 0), (115, 1), (120, 1), (125, 0), (130, 0), (135, 0), (140, 0), (145, 1), (150, 0), (155, 0), (160, 0), (165, 0), (170, 0), (175, 1), (180, 0), (185, 0), (190, 0), (195, 0), (200, 0), (205, 1), (210, 0), (215, 0), (220, 0), (225, 0), (230, 0), (235, 0), (240, 0), (245, 0), (250, 0), (255, 0), (260, 1), (265, 0), (270, 1), (275, 0), (280, 0), (285, 0), (290, 1), (295, 0), (300, 0), (305, 1), (310, 1), (315, 0), (320, 0), (325, 1), (330, 0), (335, 0), (340, 0), (345, 1), (350, 1), (355, 0), (360, 0), (365, 0), (370, 0), (375, 1), (380, 0), (385, 1), (390, 0), (395, 0), (400, 0), (405, 0), (410, 0), (415, 0), (420, 0), (425, 0), (430, 0), (435, 1), (440, 1), (445, 1), (450, 0), (455, 0), (460, 0), (465, 0), (470, 0), (475, 1), (480, 0), (485, 1), (490, 0), (495, 0), (500, 0), (505, 0), (510, 0), (515, 0), (520, 0), (525, 1), (530, 0), (535, 0), (540, 0), (545, 1), (550, 0), (555, 0), (560, 0), (565, 0), (570, 1), (575, 0), (580, 0), (585, 0), (590, 0), (595, 0), (600, 0), (605, 0), (610, 0), (615, 1), (620, 0), (625, 1), (630, 0), (635, 0), (640, 0), (645, 0), (650, 0), (655, 0), (660, 0), (665, 1), (670, 0), (675, 0), (680, 0), (685, 0), (690, 0), (695, 0), (700, 1), (705, 0), (710, 0), (715, 0), (720, 0), (725, 0), (730, 1), (735, 0), (740, 0), (745, 0), (750, 1), (755, 0), (760, 0), (765, 0), (770, 0), (775, 0), (780, 0), (785, 0), (790, 0), (795, 1), (800, 1), (805, 0), (810, 0), (815, 0), (820, 0), (825, 0), (830, 0), (835, 0), (840, 0), (845, 0), (850, 1), (855, 0), (860, 0), (865, 0), (870, 0), (875, 0), (880, 0), (885, 0), (890, 0), (895, 1), (900, 1), (905, 0), (910, 0), (915, 0), (920, 0), (925, 0), (930, 0), (935, 0), (940, 0), (945, 1), (950, 1), (955, 0), (960, 1), (965, 0), (970, 1), (975, 0), (980, 0), (985, 0), (990, 1), (995, 0), (1000, 0), (1005, 0), (1010, 0), (1015, 0), (1020, 0), (1025, 1)]
VCSB0 CSB0 0 PWL (0n 1.1v 4.745n 1.1v 4.755n 0.0v 9.745n 0.0v 9.755n 0.0v 14.745n 0.0v 14.755n 0.0v 19.745n 0.0v 19.755n 0.0v 24.745n 0.0v 24.755n 1.1v 29.745n 1.1v 29.755n 0.0v 34.745n 0.0v 34.755n 1.1v 39.745n 1.1v 39.755n 0.0v 44.745n 0.0v 44.755n 0.0v 49.745n 0.0v 49.755n 0.0v 54.745n 0.0v 54.755n 0.0v 59.745n 0.0v 59.755n 0.0v 64.745n 0.0v 64.755n 0.0v 69.745n 0.0v 69.755n 0.0v 74.745n 0.0v 74.755n 0.0v 79.745n 0.0v 79.755n 1.1v 84.745n 1.1v 84.755n 1.1v 89.745n 1.1v 89.755n 0.0v 94.745n 0.0v 94.755n 1.1v 99.745n 1.1v 99.755n 0.0v 104.745n 0.0v 104.755n 1.1v 109.745n 1.1v 109.755n 0.0v 114.745n 0.0v 114.755n 1.1v 119.745n 1.1v 119.755n 1.1v 124.745n 1.1v 124.755n 0.0v 129.745n 0.0v 129.755n 0.0v 134.745n 0.0v 134.755n 0.0v 139.745n 0.0v 139.755n 0.0v 144.745n 0.0v 144.755n 1.1v 149.745n 1.1v 149.755n 0.0v 154.745n 0.0v 154.755n 0.0v 159.745n 0.0v 159.755n 0.0v 164.745n 0.0v 164.755n 0.0v 169.745n 0.0v 169.755n 0.0v 174.745n 0.0v 174.755n 1.1v 179.745n 1.1v 179.755n 0.0v 184.745n 0.0v 184.755n 0.0v 189.745n 0.0v 189.755n 0.0v 194.745n 0.0v 194.755n 0.0v 199.745n 0.0v 199.755n 0.0v 204.745n 0.0v 204.755n 1.1v 209.745n 1.1v 209.755n 0.0v 214.745n 0.0v 214.755n 0.0v 219.745n 0.0v 219.755n 0.0v 224.745n 0.0v 224.755n 0.0v 229.745n 0.0v 229.755n 0.0v 234.745n 0.0v 234.755n 0.0v 239.745n 0.0v 239.755n 0.0v 244.745n 0.0v 244.755n 0.0v 249.745n 0.0v 249.755n 0.0v 254.745n 0.0v 254.755n 0.0v 259.745n 0.0v 259.755n 1.1v 264.745n 1.1v 264.755n 0.0v 269.745n 0.0v 269.755n 1.1v 274.745n 1.1v 274.755n 0.0v 279.745n 0.0v 279.755n 0.0v 284.745n 0.0v 284.755n 0.0v 289.745n 0.0v 289.755n 1.1v 294.745n 1.1v 294.755n 0.0v 299.745n 0.0v 299.755n 0.0v 304.745n 0.0v 304.755n 1.1v 309.745n 1.1v 309.755n 1.1v 314.745n 1.1v 314.755n 0.0v 319.745n 0.0v 319.755n 0.0v 324.745n 0.0v 324.755n 1.1v 329.745n 1.1v 329.755n 0.0v 334.745n 0.0v 334.755n 0.0v 339.745n 0.0v 339.755n 0.0v 344.745n 0.0v 344.755n 1.1v 349.745n 1.1v 349.755n 1.1v 354.745n 1.1v 354.755n 0.0v 359.745n 0.0v 359.755n 0.0v 364.745n 0.0v 364.755n 0.0v 369.745n 0.0v 369.755n 0.0v 374.745n 0.0v 374.755n 1.1v 379.745n 1.1v 379.755n 0.0v 384.745n 0.0v 384.755n 1.1v 389.745n 1.1v 389.755n 0.0v 394.745n 0.0v 394.755n 0.0v 399.745n 0.0v 399.755n 0.0v 404.745n 0.0v 404.755n 0.0v 409.745n 0.0v 409.755n 0.0v 414.745n 0.0v 414.755n 0.0v 419.745n 0.0v 419.755n 0.0v 424.745n 0.0v 424.755n 0.0v 429.745n 0.0v 429.755n 0.0v 434.745n 0.0v 434.755n 1.1v 439.745n 1.1v 439.755n 1.1v 444.745n 1.1v 444.755n 1.1v 449.745n 1.1v 449.755n 0.0v 454.745n 0.0v 454.755n 0.0v 459.745n 0.0v 459.755n 0.0v 464.745n 0.0v 464.755n 0.0v 469.745n 0.0v 469.755n 0.0v 474.745n 0.0v 474.755n 1.1v 479.745n 1.1v 479.755n 0.0v 484.745n 0.0v 484.755n 1.1v 489.745n 1.1v 489.755n 0.0v 494.745n 0.0v 494.755n 0.0v 499.745n 0.0v 499.755n 0.0v 504.745n 0.0v 504.755n 0.0v 509.745n 0.0v 509.755n 0.0v 514.745n 0.0v 514.755n 0.0v 519.745n 0.0v 519.755n 0.0v 524.745n 0.0v 524.755n 1.1v 529.745n 1.1v 529.755n 0.0v 534.745n 0.0v 534.755n 0.0v 539.745n 0.0v 539.755n 0.0v 544.745n 0.0v 544.755n 1.1v 549.745n 1.1v 549.755n 0.0v 554.745n 0.0v 554.755n 0.0v 559.745n 0.0v 559.755n 0.0v 564.745n 0.0v 564.755n 0.0v 569.745n 0.0v 569.755n 1.1v 574.745n 1.1v 574.755n 0.0v 579.745n 0.0v 579.755n 0.0v 584.745n 0.0v 584.755n 0.0v 589.745n 0.0v 589.755n 0.0v 594.745n 0.0v 594.755n 0.0v 599.745n 0.0v 599.755n 0.0v 604.745n 0.0v 604.755n 0.0v 609.745n 0.0v 609.755n 0.0v 614.745n 0.0v 614.755n 1.1v 619.745n 1.1v 619.755n 0.0v 624.745n 0.0v 624.755n 1.1v 629.745n 1.1v 629.755n 0.0v 634.745n 0.0v 634.755n 0.0v 639.745n 0.0v 639.755n 0.0v 644.745n 0.0v 644.755n 0.0v 649.745n 0.0v 649.755n 0.0v 654.745n 0.0v 654.755n 0.0v 659.745n 0.0v 659.755n 0.0v 664.745n 0.0v 664.755n 1.1v 669.745n 1.1v 669.755n 0.0v 674.745n 0.0v 674.755n 0.0v 679.745n 0.0v 679.755n 0.0v 684.745n 0.0v 684.755n 0.0v 689.745n 0.0v 689.755n 0.0v 694.745n 0.0v 694.755n 0.0v 699.745n 0.0v 699.755n 1.1v 704.745n 1.1v 704.755n 0.0v 709.745n 0.0v 709.755n 0.0v 714.745n 0.0v 714.755n 0.0v 719.745n 0.0v 719.755n 0.0v 724.745n 0.0v 724.755n 0.0v 729.745n 0.0v 729.755n 1.1v 734.745n 1.1v 734.755n 0.0v 739.745n 0.0v 739.755n 0.0v 744.745n 0.0v 744.755n 0.0v 749.745n 0.0v 749.755n 1.1v 754.745n 1.1v 754.755n 0.0v 759.745n 0.0v 759.755n 0.0v 764.745n 0.0v 764.755n 0.0v 769.745n 0.0v 769.755n 0.0v 774.745n 0.0v 774.755n 0.0v 779.745n 0.0v 779.755n 0.0v 784.745n 0.0v 784.755n 0.0v 789.745n 0.0v 789.755n 0.0v 794.745n 0.0v 794.755n 1.1v 799.745n 1.1v 799.755n 1.1v 804.745n 1.1v 804.755n 0.0v 809.745n 0.0v 809.755n 0.0v 814.745n 0.0v 814.755n 0.0v 819.745n 0.0v 819.755n 0.0v 824.745n 0.0v 824.755n 0.0v 829.745n 0.0v 829.755n 0.0v 834.745n 0.0v 834.755n 0.0v 839.745n 0.0v 839.755n 0.0v 844.745n 0.0v 844.755n 0.0v 849.745n 0.0v 849.755n 1.1v 854.745n 1.1v 854.755n 0.0v 859.745n 0.0v 859.755n 0.0v 864.745n 0.0v 864.755n 0.0v 869.745n 0.0v 869.755n 0.0v 874.745n 0.0v 874.755n 0.0v 879.745n 0.0v 879.755n 0.0v 884.745n 0.0v 884.755n 0.0v 889.745n 0.0v 889.755n 0.0v 894.745n 0.0v 894.755n 1.1v 899.745n 1.1v 899.755n 1.1v 904.745n 1.1v 904.755n 0.0v 909.745n 0.0v 909.755n 0.0v 914.745n 0.0v 914.755n 0.0v 919.745n 0.0v 919.755n 0.0v 924.745n 0.0v 924.755n 0.0v 929.745n 0.0v 929.755n 0.0v 934.745n 0.0v 934.755n 0.0v 939.745n 0.0v 939.755n 0.0v 944.745n 0.0v 944.755n 1.1v 949.745n 1.1v 949.755n 1.1v 954.745n 1.1v 954.755n 0.0v 959.745n 0.0v 959.755n 1.1v 964.745n 1.1v 964.755n 0.0v 969.745n 0.0v 969.755n 1.1v 974.745n 1.1v 974.755n 0.0v 979.745n 0.0v 979.755n 0.0v 984.745n 0.0v 984.755n 0.0v 989.745n 0.0v 989.755n 1.1v 994.745n 1.1v 994.755n 0.0v 999.745n 0.0v 999.755n 0.0v 1004.745n 0.0v 1004.755n 0.0v 1009.745n 0.0v 1009.755n 0.0v 1014.745n 0.0v 1014.755n 0.0v 1019.745n 0.0v 1019.755n 0.0v 1024.745n 0.0v 1024.755n 1.1v )
* (time, data): [(0, 1), (5, 0), (10, 0), (15, 0), (20, 1), (25, 1), (30, 0), (35, 1), (40, 0), (45, 0), (50, 1), (55, 1), (60, 0), (65, 0), (70, 1), (75, 1), (80, 1), (85, 1), (90, 0), (95, 1), (100, 0), (105, 1), (110, 1), (115, 1), (120, 1), (125, 1), (130, 1), (135, 0), (140, 0), (145, 1), (150, 1), (155, 1), (160, 1), (165, 1), (170, 0), (175, 1), (180, 1), (185, 0), (190, 1), (195, 1), (200, 0), (205, 1), (210, 0), (215, 1), (220, 0), (225, 1), (230, 0), (235, 1), (240, 0), (245, 1), (250, 1), (255, 0), (260, 1), (265, 0), (270, 1), (275, 1), (280, 0), (285, 1), (290, 1), (295, 1), (300, 0), (305, 1), (310, 1), (315, 0), (320, 1), (325, 1), (330, 0), (335, 0), (340, 0), (345, 1), (350, 1), (355, 1), (360, 0), (365, 1), (370, 1), (375, 1), (380, 1), (385, 1), (390, 1), (395, 0), (400, 0), (405, 1), (410, 0), (415, 0), (420, 0), (425, 0), (430, 0), (435, 1), (440, 1), (445, 1), (450, 0), (455, 1), (460, 0), (465, 0), (470, 0), (475, 1), (480, 0), (485, 1), (490, 1), (495, 0), (500, 0), (505, 0), (510, 0), (515, 0), (520, 1), (525, 1), (530, 1), (535, 0), (540, 0), (545, 1), (550, 1), (555, 0), (560, 1), (565, 1), (570, 1), (575, 0), (580, 1), (585, 1), (590, 1), (595, 1), (600, 1), (605, 1), (610, 1), (615, 1), (620, 1), (625, 1), (630, 0), (635, 0), (640, 0), (645, 1), (650, 1), (655, 0), (660, 0), (665, 1), (670, 0), (675, 1), (680, 1), (685, 1), (690, 1), (695, 1), (700, 1), (705, 0), (710, 0), (715, 0), (720, 1), (725, 1), (730, 1), (735, 0), (740, 0), (745, 1), (750, 1), (755, 0), (760, 1), (765, 1), (770, 0), (775, 0), (780, 1), (785, 0), (790, 0), (795, 1), (800, 1), (805, 1), (810, 1), (815, 1), (820, 0), (825, 1), (830, 0), (835, 0), (840, 1), (845, 1), (850, 1), (855, 0), (860, 0), (865, 0), (870, 0), (875, 0), (880, 0), (885, 0), (890, 1), (895, 1), (900, 1), (905, 1), (910, 0), (915, 1), (920, 1), (925, 1), (930, 0), (935, 0), (940, 0), (945, 1), (950, 1), (955, 0), (960, 1), (965, 0), (970, 1), (975, 1), (980, 0), (985, 0), (990, 1), (995, 0), (1000, 0), (1005, 1), (1010, 1), (1015, 1), (1020, 0), (1025, 1)]
VWEB0 WEB0 0 PWL (0n 1.1v 4.745n 1.1v 4.755n 0.0v 9.745n 0.0v 9.755n 0.0v 14.745n 0.0v 14.755n 0.0v 19.745n 0.0v 19.755n 1.1v 24.745n 1.1v 24.755n 1.1v 29.745n 1.1v 29.755n 0.0v 34.745n 0.0v 34.755n 1.1v 39.745n 1.1v 39.755n 0.0v 44.745n 0.0v 44.755n 0.0v 49.745n 0.0v 49.755n 1.1v 54.745n 1.1v 54.755n 1.1v 59.745n 1.1v 59.755n 0.0v 64.745n 0.0v 64.755n 0.0v 69.745n 0.0v 69.755n 1.1v 74.745n 1.1v 74.755n 1.1v 79.745n 1.1v 79.755n 1.1v 84.745n 1.1v 84.755n 1.1v 89.745n 1.1v 89.755n 0.0v 94.745n 0.0v 94.755n 1.1v 99.745n 1.1v 99.755n 0.0v 104.745n 0.0v 104.755n 1.1v 109.745n 1.1v 109.755n 1.1v 114.745n 1.1v 114.755n 1.1v 119.745n 1.1v 119.755n 1.1v 124.745n 1.1v 124.755n 1.1v 129.745n 1.1v 129.755n 1.1v 134.745n 1.1v 134.755n 0.0v 139.745n 0.0v 139.755n 0.0v 144.745n 0.0v 144.755n 1.1v 149.745n 1.1v 149.755n 1.1v 154.745n 1.1v 154.755n 1.1v 159.745n 1.1v 159.755n 1.1v 164.745n 1.1v 164.755n 1.1v 169.745n 1.1v 169.755n 0.0v 174.745n 0.0v 174.755n 1.1v 179.745n 1.1v 179.755n 1.1v 184.745n 1.1v 184.755n 0.0v 189.745n 0.0v 189.755n 1.1v 194.745n 1.1v 194.755n 1.1v 199.745n 1.1v 199.755n 0.0v 204.745n 0.0v 204.755n 1.1v 209.745n 1.1v 209.755n 0.0v 214.745n 0.0v 214.755n 1.1v 219.745n 1.1v 219.755n 0.0v 224.745n 0.0v 224.755n 1.1v 229.745n 1.1v 229.755n 0.0v 234.745n 0.0v 234.755n 1.1v 239.745n 1.1v 239.755n 0.0v 244.745n 0.0v 244.755n 1.1v 249.745n 1.1v 249.755n 1.1v 254.745n 1.1v 254.755n 0.0v 259.745n 0.0v 259.755n 1.1v 264.745n 1.1v 264.755n 0.0v 269.745n 0.0v 269.755n 1.1v 274.745n 1.1v 274.755n 1.1v 279.745n 1.1v 279.755n 0.0v 284.745n 0.0v 284.755n 1.1v 289.745n 1.1v 289.755n 1.1v 294.745n 1.1v 294.755n 1.1v 299.745n 1.1v 299.755n 0.0v 304.745n 0.0v 304.755n 1.1v 309.745n 1.1v 309.755n 1.1v 314.745n 1.1v 314.755n 0.0v 319.745n 0.0v 319.755n 1.1v 324.745n 1.1v 324.755n 1.1v 329.745n 1.1v 329.755n 0.0v 334.745n 0.0v 334.755n 0.0v 339.745n 0.0v 339.755n 0.0v 344.745n 0.0v 344.755n 1.1v 349.745n 1.1v 349.755n 1.1v 354.745n 1.1v 354.755n 1.1v 359.745n 1.1v 359.755n 0.0v 364.745n 0.0v 364.755n 1.1v 369.745n 1.1v 369.755n 1.1v 374.745n 1.1v 374.755n 1.1v 379.745n 1.1v 379.755n 1.1v 384.745n 1.1v 384.755n 1.1v 389.745n 1.1v 389.755n 1.1v 394.745n 1.1v 394.755n 0.0v 399.745n 0.0v 399.755n 0.0v 404.745n 0.0v 404.755n 1.1v 409.745n 1.1v 409.755n 0.0v 414.745n 0.0v 414.755n 0.0v 419.745n 0.0v 419.755n 0.0v 424.745n 0.0v 424.755n 0.0v 429.745n 0.0v 429.755n 0.0v 434.745n 0.0v 434.755n 1.1v 439.745n 1.1v 439.755n 1.1v 444.745n 1.1v 444.755n 1.1v 449.745n 1.1v 449.755n 0.0v 454.745n 0.0v 454.755n 1.1v 459.745n 1.1v 459.755n 0.0v 464.745n 0.0v 464.755n 0.0v 469.745n 0.0v 469.755n 0.0v 474.745n 0.0v 474.755n 1.1v 479.745n 1.1v 479.755n 0.0v 484.745n 0.0v 484.755n 1.1v 489.745n 1.1v 489.755n 1.1v 494.745n 1.1v 494.755n 0.0v 499.745n 0.0v 499.755n 0.0v 504.745n 0.0v 504.755n 0.0v 509.745n 0.0v 509.755n 0.0v 514.745n 0.0v 514.755n 0.0v 519.745n 0.0v 519.755n 1.1v 524.745n 1.1v 524.755n 1.1v 529.745n 1.1v 529.755n 1.1v 534.745n 1.1v 534.755n 0.0v 539.745n 0.0v 539.755n 0.0v 544.745n 0.0v 544.755n 1.1v 549.745n 1.1v 549.755n 1.1v 554.745n 1.1v 554.755n 0.0v 559.745n 0.0v 559.755n 1.1v 564.745n 1.1v 564.755n 1.1v 569.745n 1.1v 569.755n 1.1v 574.745n 1.1v 574.755n 0.0v 579.745n 0.0v 579.755n 1.1v 584.745n 1.1v 584.755n 1.1v 589.745n 1.1v 589.755n 1.1v 594.745n 1.1v 594.755n 1.1v 599.745n 1.1v 599.755n 1.1v 604.745n 1.1v 604.755n 1.1v 609.745n 1.1v 609.755n 1.1v 614.745n 1.1v 614.755n 1.1v 619.745n 1.1v 619.755n 1.1v 624.745n 1.1v 624.755n 1.1v 629.745n 1.1v 629.755n 0.0v 634.745n 0.0v 634.755n 0.0v 639.745n 0.0v 639.755n 0.0v 644.745n 0.0v 644.755n 1.1v 649.745n 1.1v 649.755n 1.1v 654.745n 1.1v 654.755n 0.0v 659.745n 0.0v 659.755n 0.0v 664.745n 0.0v 664.755n 1.1v 669.745n 1.1v 669.755n 0.0v 674.745n 0.0v 674.755n 1.1v 679.745n 1.1v 679.755n 1.1v 684.745n 1.1v 684.755n 1.1v 689.745n 1.1v 689.755n 1.1v 694.745n 1.1v 694.755n 1.1v 699.745n 1.1v 699.755n 1.1v 704.745n 1.1v 704.755n 0.0v 709.745n 0.0v 709.755n 0.0v 714.745n 0.0v 714.755n 0.0v 719.745n 0.0v 719.755n 1.1v 724.745n 1.1v 724.755n 1.1v 729.745n 1.1v 729.755n 1.1v 734.745n 1.1v 734.755n 0.0v 739.745n 0.0v 739.755n 0.0v 744.745n 0.0v 744.755n 1.1v 749.745n 1.1v 749.755n 1.1v 754.745n 1.1v 754.755n 0.0v 759.745n 0.0v 759.755n 1.1v 764.745n 1.1v 764.755n 1.1v 769.745n 1.1v 769.755n 0.0v 774.745n 0.0v 774.755n 0.0v 779.745n 0.0v 779.755n 1.1v 784.745n 1.1v 784.755n 0.0v 789.745n 0.0v 789.755n 0.0v 794.745n 0.0v 794.755n 1.1v 799.745n 1.1v 799.755n 1.1v 804.745n 1.1v 804.755n 1.1v 809.745n 1.1v 809.755n 1.1v 814.745n 1.1v 814.755n 1.1v 819.745n 1.1v 819.755n 0.0v 824.745n 0.0v 824.755n 1.1v 829.745n 1.1v 829.755n 0.0v 834.745n 0.0v 834.755n 0.0v 839.745n 0.0v 839.755n 1.1v 844.745n 1.1v 844.755n 1.1v 849.745n 1.1v 849.755n 1.1v 854.745n 1.1v 854.755n 0.0v 859.745n 0.0v 859.755n 0.0v 864.745n 0.0v 864.755n 0.0v 869.745n 0.0v 869.755n 0.0v 874.745n 0.0v 874.755n 0.0v 879.745n 0.0v 879.755n 0.0v 884.745n 0.0v 884.755n 0.0v 889.745n 0.0v 889.755n 1.1v 894.745n 1.1v 894.755n 1.1v 899.745n 1.1v 899.755n 1.1v 904.745n 1.1v 904.755n 1.1v 909.745n 1.1v 909.755n 0.0v 914.745n 0.0v 914.755n 1.1v 919.745n 1.1v 919.755n 1.1v 924.745n 1.1v 924.755n 1.1v 929.745n 1.1v 929.755n 0.0v 934.745n 0.0v 934.755n 0.0v 939.745n 0.0v 939.755n 0.0v 944.745n 0.0v 944.755n 1.1v 949.745n 1.1v 949.755n 1.1v 954.745n 1.1v 954.755n 0.0v 959.745n 0.0v 959.755n 1.1v 964.745n 1.1v 964.755n 0.0v 969.745n 0.0v 969.755n 1.1v 974.745n 1.1v 974.755n 1.1v 979.745n 1.1v 979.755n 0.0v 984.745n 0.0v 984.755n 0.0v 989.745n 0.0v 989.755n 1.1v 994.745n 1.1v 994.755n 0.0v 999.745n 0.0v 999.755n 0.0v 1004.745n 0.0v 1004.755n 1.1v 1009.745n 1.1v 1009.755n 1.1v 1014.745n 1.1v 1014.755n 1.1v 1019.745n 1.1v 1019.755n 0.0v 1024.745n 0.0v 1024.755n 1.1v )

* Generation of wmask signals
* (time, data): [(0, 0), (5, 1), (10, 1), (15, 1), (20, 1), (25, 1), (30, 1), (35, 1), (40, 0), (45, 1), (50, 1), (55, 1), (60, 1), (65, 0), (70, 0), (75, 0), (80, 0), (85, 0), (90, 1), (95, 1), (100, 1), (105, 1), (110, 1), (115, 1), (120, 1), (125, 1), (130, 1), (135, 1), (140, 0), (145, 0), (150, 0), (155, 0), (160, 0), (165, 0), (170, 0), (175, 0), (180, 0), (185, 1), (190, 1), (195, 1), (200, 1), (205, 1), (210, 1), (215, 1), (220, 0), (225, 0), (230, 1), (235, 1), (240, 1), (245, 1), (250, 1), (255, 1), (260, 1), (265, 1), (270, 1), (275, 1), (280, 1), (285, 1), (290, 1), (295, 1), (300, 1), (305, 1), (310, 1), (315, 1), (320, 1), (325, 1), (330, 1), (335, 1), (340, 1), (345, 1), (350, 1), (355, 1), (360, 0), (365, 0), (370, 0), (375, 0), (380, 0), (385, 0), (390, 0), (395, 1), (400, 0), (405, 0), (410, 1), (415, 0), (420, 1), (425, 0), (430, 0), (435, 0), (440, 0), (445, 0), (450, 0), (455, 0), (460, 0), (465, 1), (470, 1), (475, 1), (480, 1), (485, 1), (490, 1), (495, 1), (500, 1), (505, 1), (510, 1), (515, 1), (520, 1), (525, 1), (530, 1), (535, 0), (540, 1), (545, 1), (550, 1), (555, 1), (560, 1), (565, 1), (570, 1), (575, 1), (580, 1), (585, 1), (590, 1), (595, 1), (600, 1), (605, 1), (610, 1), (615, 1), (620, 1), (625, 1), (630, 0), (635, 1), (640, 0), (645, 0), (650, 0), (655, 1), (660, 1), (665, 1), (670, 1), (675, 1), (680, 1), (685, 1), (690, 1), (695, 1), (700, 1), (705, 1), (710, 1), (715, 1), (720, 1), (725, 1), (730, 1), (735, 1), (740, 0), (745, 0), (750, 0), (755, 1), (760, 1), (765, 1), (770, 1), (775, 0), (780, 0), (785, 1), (790, 1), (795, 1), (800, 1), (805, 1), (810, 1), (815, 1), (820, 1), (825, 1), (830, 0), (835, 1), (840, 1), (845, 1), (850, 1), (855, 1), (860, 1), (865, 1), (870, 0), (875, 1), (880, 1), (885, 1), (890, 1), (895, 1), (900, 1), (905, 1), (910, 1), (915, 1), (920, 1), (925, 1), (930, 1), (935, 1), (940, 1), (945, 1), (950, 1), (955, 1), (960, 1), (965, 0), (970, 0), (975, 0), (980, 0), (985, 1), (990, 1), (995, 1), (1000, 1), (1005, 1), (1010, 1), (1015, 1), (1020, 1), (1025, 1)]
VWMASK0_0  WMASK0_0  0 PWL (0n 0.0v 4.745n 0.0v 4.755n 1.1v 9.745n 1.1v 9.755n 1.1v 14.745n 1.1v 14.755n 1.1v 19.745n 1.1v 19.755n 1.1v 24.745n 1.1v 24.755n 1.1v 29.745n 1.1v 29.755n 1.1v 34.745n 1.1v 34.755n 1.1v 39.745n 1.1v 39.755n 0.0v 44.745n 0.0v 44.755n 1.1v 49.745n 1.1v 49.755n 1.1v 54.745n 1.1v 54.755n 1.1v 59.745n 1.1v 59.755n 1.1v 64.745n 1.1v 64.755n 0.0v 69.745n 0.0v 69.755n 0.0v 74.745n 0.0v 74.755n 0.0v 79.745n 0.0v 79.755n 0.0v 84.745n 0.0v 84.755n 0.0v 89.745n 0.0v 89.755n 1.1v 94.745n 1.1v 94.755n 1.1v 99.745n 1.1v 99.755n 1.1v 104.745n 1.1v 104.755n 1.1v 109.745n 1.1v 109.755n 1.1v 114.745n 1.1v 114.755n 1.1v 119.745n 1.1v 119.755n 1.1v 124.745n 1.1v 124.755n 1.1v 129.745n 1.1v 129.755n 1.1v 134.745n 1.1v 134.755n 1.1v 139.745n 1.1v 139.755n 0.0v 144.745n 0.0v 144.755n 0.0v 149.745n 0.0v 149.755n 0.0v 154.745n 0.0v 154.755n 0.0v 159.745n 0.0v 159.755n 0.0v 164.745n 0.0v 164.755n 0.0v 169.745n 0.0v 169.755n 0.0v 174.745n 0.0v 174.755n 0.0v 179.745n 0.0v 179.755n 0.0v 184.745n 0.0v 184.755n 1.1v 189.745n 1.1v 189.755n 1.1v 194.745n 1.1v 194.755n 1.1v 199.745n 1.1v 199.755n 1.1v 204.745n 1.1v 204.755n 1.1v 209.745n 1.1v 209.755n 1.1v 214.745n 1.1v 214.755n 1.1v 219.745n 1.1v 219.755n 0.0v 224.745n 0.0v 224.755n 0.0v 229.745n 0.0v 229.755n 1.1v 234.745n 1.1v 234.755n 1.1v 239.745n 1.1v 239.755n 1.1v 244.745n 1.1v 244.755n 1.1v 249.745n 1.1v 249.755n 1.1v 254.745n 1.1v 254.755n 1.1v 259.745n 1.1v 259.755n 1.1v 264.745n 1.1v 264.755n 1.1v 269.745n 1.1v 269.755n 1.1v 274.745n 1.1v 274.755n 1.1v 279.745n 1.1v 279.755n 1.1v 284.745n 1.1v 284.755n 1.1v 289.745n 1.1v 289.755n 1.1v 294.745n 1.1v 294.755n 1.1v 299.745n 1.1v 299.755n 1.1v 304.745n 1.1v 304.755n 1.1v 309.745n 1.1v 309.755n 1.1v 314.745n 1.1v 314.755n 1.1v 319.745n 1.1v 319.755n 1.1v 324.745n 1.1v 324.755n 1.1v 329.745n 1.1v 329.755n 1.1v 334.745n 1.1v 334.755n 1.1v 339.745n 1.1v 339.755n 1.1v 344.745n 1.1v 344.755n 1.1v 349.745n 1.1v 349.755n 1.1v 354.745n 1.1v 354.755n 1.1v 359.745n 1.1v 359.755n 0.0v 364.745n 0.0v 364.755n 0.0v 369.745n 0.0v 369.755n 0.0v 374.745n 0.0v 374.755n 0.0v 379.745n 0.0v 379.755n 0.0v 384.745n 0.0v 384.755n 0.0v 389.745n 0.0v 389.755n 0.0v 394.745n 0.0v 394.755n 1.1v 399.745n 1.1v 399.755n 0.0v 404.745n 0.0v 404.755n 0.0v 409.745n 0.0v 409.755n 1.1v 414.745n 1.1v 414.755n 0.0v 419.745n 0.0v 419.755n 1.1v 424.745n 1.1v 424.755n 0.0v 429.745n 0.0v 429.755n 0.0v 434.745n 0.0v 434.755n 0.0v 439.745n 0.0v 439.755n 0.0v 444.745n 0.0v 444.755n 0.0v 449.745n 0.0v 449.755n 0.0v 454.745n 0.0v 454.755n 0.0v 459.745n 0.0v 459.755n 0.0v 464.745n 0.0v 464.755n 1.1v 469.745n 1.1v 469.755n 1.1v 474.745n 1.1v 474.755n 1.1v 479.745n 1.1v 479.755n 1.1v 484.745n 1.1v 484.755n 1.1v 489.745n 1.1v 489.755n 1.1v 494.745n 1.1v 494.755n 1.1v 499.745n 1.1v 499.755n 1.1v 504.745n 1.1v 504.755n 1.1v 509.745n 1.1v 509.755n 1.1v 514.745n 1.1v 514.755n 1.1v 519.745n 1.1v 519.755n 1.1v 524.745n 1.1v 524.755n 1.1v 529.745n 1.1v 529.755n 1.1v 534.745n 1.1v 534.755n 0.0v 539.745n 0.0v 539.755n 1.1v 544.745n 1.1v 544.755n 1.1v 549.745n 1.1v 549.755n 1.1v 554.745n 1.1v 554.755n 1.1v 559.745n 1.1v 559.755n 1.1v 564.745n 1.1v 564.755n 1.1v 569.745n 1.1v 569.755n 1.1v 574.745n 1.1v 574.755n 1.1v 579.745n 1.1v 579.755n 1.1v 584.745n 1.1v 584.755n 1.1v 589.745n 1.1v 589.755n 1.1v 594.745n 1.1v 594.755n 1.1v 599.745n 1.1v 599.755n 1.1v 604.745n 1.1v 604.755n 1.1v 609.745n 1.1v 609.755n 1.1v 614.745n 1.1v 614.755n 1.1v 619.745n 1.1v 619.755n 1.1v 624.745n 1.1v 624.755n 1.1v 629.745n 1.1v 629.755n 0.0v 634.745n 0.0v 634.755n 1.1v 639.745n 1.1v 639.755n 0.0v 644.745n 0.0v 644.755n 0.0v 649.745n 0.0v 649.755n 0.0v 654.745n 0.0v 654.755n 1.1v 659.745n 1.1v 659.755n 1.1v 664.745n 1.1v 664.755n 1.1v 669.745n 1.1v 669.755n 1.1v 674.745n 1.1v 674.755n 1.1v 679.745n 1.1v 679.755n 1.1v 684.745n 1.1v 684.755n 1.1v 689.745n 1.1v 689.755n 1.1v 694.745n 1.1v 694.755n 1.1v 699.745n 1.1v 699.755n 1.1v 704.745n 1.1v 704.755n 1.1v 709.745n 1.1v 709.755n 1.1v 714.745n 1.1v 714.755n 1.1v 719.745n 1.1v 719.755n 1.1v 724.745n 1.1v 724.755n 1.1v 729.745n 1.1v 729.755n 1.1v 734.745n 1.1v 734.755n 1.1v 739.745n 1.1v 739.755n 0.0v 744.745n 0.0v 744.755n 0.0v 749.745n 0.0v 749.755n 0.0v 754.745n 0.0v 754.755n 1.1v 759.745n 1.1v 759.755n 1.1v 764.745n 1.1v 764.755n 1.1v 769.745n 1.1v 769.755n 1.1v 774.745n 1.1v 774.755n 0.0v 779.745n 0.0v 779.755n 0.0v 784.745n 0.0v 784.755n 1.1v 789.745n 1.1v 789.755n 1.1v 794.745n 1.1v 794.755n 1.1v 799.745n 1.1v 799.755n 1.1v 804.745n 1.1v 804.755n 1.1v 809.745n 1.1v 809.755n 1.1v 814.745n 1.1v 814.755n 1.1v 819.745n 1.1v 819.755n 1.1v 824.745n 1.1v 824.755n 1.1v 829.745n 1.1v 829.755n 0.0v 834.745n 0.0v 834.755n 1.1v 839.745n 1.1v 839.755n 1.1v 844.745n 1.1v 844.755n 1.1v 849.745n 1.1v 849.755n 1.1v 854.745n 1.1v 854.755n 1.1v 859.745n 1.1v 859.755n 1.1v 864.745n 1.1v 864.755n 1.1v 869.745n 1.1v 869.755n 0.0v 874.745n 0.0v 874.755n 1.1v 879.745n 1.1v 879.755n 1.1v 884.745n 1.1v 884.755n 1.1v 889.745n 1.1v 889.755n 1.1v 894.745n 1.1v 894.755n 1.1v 899.745n 1.1v 899.755n 1.1v 904.745n 1.1v 904.755n 1.1v 909.745n 1.1v 909.755n 1.1v 914.745n 1.1v 914.755n 1.1v 919.745n 1.1v 919.755n 1.1v 924.745n 1.1v 924.755n 1.1v 929.745n 1.1v 929.755n 1.1v 934.745n 1.1v 934.755n 1.1v 939.745n 1.1v 939.755n 1.1v 944.745n 1.1v 944.755n 1.1v 949.745n 1.1v 949.755n 1.1v 954.745n 1.1v 954.755n 1.1v 959.745n 1.1v 959.755n 1.1v 964.745n 1.1v 964.755n 0.0v 969.745n 0.0v 969.755n 0.0v 974.745n 0.0v 974.755n 0.0v 979.745n 0.0v 979.755n 0.0v 984.745n 0.0v 984.755n 1.1v 989.745n 1.1v 989.755n 1.1v 994.745n 1.1v 994.755n 1.1v 999.745n 1.1v 999.755n 1.1v 1004.745n 1.1v 1004.755n 1.1v 1009.745n 1.1v 1009.755n 1.1v 1014.745n 1.1v 1014.755n 1.1v 1019.745n 1.1v 1019.755n 1.1v 1024.745n 1.1v 1024.755n 1.1v )
* (time, data): [(0, 0), (5, 1), (10, 1), (15, 1), (20, 1), (25, 1), (30, 1), (35, 1), (40, 1), (45, 0), (50, 0), (55, 0), (60, 0), (65, 1), (70, 1), (75, 1), (80, 1), (85, 1), (90, 1), (95, 1), (100, 1), (105, 1), (110, 1), (115, 1), (120, 1), (125, 1), (130, 1), (135, 1), (140, 0), (145, 0), (150, 0), (155, 0), (160, 0), (165, 0), (170, 0), (175, 0), (180, 0), (185, 1), (190, 1), (195, 1), (200, 0), (205, 0), (210, 1), (215, 1), (220, 0), (225, 0), (230, 0), (235, 0), (240, 1), (245, 1), (250, 1), (255, 1), (260, 1), (265, 1), (270, 1), (275, 1), (280, 1), (285, 1), (290, 1), (295, 1), (300, 0), (305, 0), (310, 0), (315, 1), (320, 1), (325, 1), (330, 1), (335, 1), (340, 0), (345, 0), (350, 0), (355, 0), (360, 1), (365, 1), (370, 1), (375, 1), (380, 1), (385, 1), (390, 1), (395, 1), (400, 0), (405, 0), (410, 1), (415, 1), (420, 0), (425, 1), (430, 0), (435, 0), (440, 0), (445, 0), (450, 1), (455, 1), (460, 0), (465, 1), (470, 1), (475, 1), (480, 1), (485, 1), (490, 1), (495, 1), (500, 0), (505, 1), (510, 1), (515, 1), (520, 1), (525, 1), (530, 1), (535, 1), (540, 1), (545, 1), (550, 1), (555, 1), (560, 1), (565, 1), (570, 1), (575, 1), (580, 1), (585, 1), (590, 1), (595, 1), (600, 1), (605, 1), (610, 1), (615, 1), (620, 1), (625, 1), (630, 0), (635, 1), (640, 1), (645, 1), (650, 1), (655, 1), (660, 0), (665, 0), (670, 1), (675, 1), (680, 1), (685, 1), (690, 1), (695, 1), (700, 1), (705, 1), (710, 1), (715, 0), (720, 0), (725, 0), (730, 0), (735, 1), (740, 0), (745, 0), (750, 0), (755, 0), (760, 0), (765, 0), (770, 1), (775, 0), (780, 0), (785, 1), (790, 1), (795, 1), (800, 1), (805, 1), (810, 1), (815, 1), (820, 0), (825, 0), (830, 1), (835, 1), (840, 1), (845, 1), (850, 1), (855, 1), (860, 1), (865, 1), (870, 1), (875, 1), (880, 1), (885, 0), (890, 0), (895, 0), (900, 0), (905, 0), (910, 1), (915, 1), (920, 1), (925, 1), (930, 1), (935, 1), (940, 1), (945, 1), (950, 1), (955, 1), (960, 1), (965, 1), (970, 1), (975, 1), (980, 0), (985, 1), (990, 1), (995, 1), (1000, 1), (1005, 1), (1010, 1), (1015, 1), (1020, 1), (1025, 1)]
VWMASK0_1  WMASK0_1  0 PWL (0n 0.0v 4.745n 0.0v 4.755n 1.1v 9.745n 1.1v 9.755n 1.1v 14.745n 1.1v 14.755n 1.1v 19.745n 1.1v 19.755n 1.1v 24.745n 1.1v 24.755n 1.1v 29.745n 1.1v 29.755n 1.1v 34.745n 1.1v 34.755n 1.1v 39.745n 1.1v 39.755n 1.1v 44.745n 1.1v 44.755n 0.0v 49.745n 0.0v 49.755n 0.0v 54.745n 0.0v 54.755n 0.0v 59.745n 0.0v 59.755n 0.0v 64.745n 0.0v 64.755n 1.1v 69.745n 1.1v 69.755n 1.1v 74.745n 1.1v 74.755n 1.1v 79.745n 1.1v 79.755n 1.1v 84.745n 1.1v 84.755n 1.1v 89.745n 1.1v 89.755n 1.1v 94.745n 1.1v 94.755n 1.1v 99.745n 1.1v 99.755n 1.1v 104.745n 1.1v 104.755n 1.1v 109.745n 1.1v 109.755n 1.1v 114.745n 1.1v 114.755n 1.1v 119.745n 1.1v 119.755n 1.1v 124.745n 1.1v 124.755n 1.1v 129.745n 1.1v 129.755n 1.1v 134.745n 1.1v 134.755n 1.1v 139.745n 1.1v 139.755n 0.0v 144.745n 0.0v 144.755n 0.0v 149.745n 0.0v 149.755n 0.0v 154.745n 0.0v 154.755n 0.0v 159.745n 0.0v 159.755n 0.0v 164.745n 0.0v 164.755n 0.0v 169.745n 0.0v 169.755n 0.0v 174.745n 0.0v 174.755n 0.0v 179.745n 0.0v 179.755n 0.0v 184.745n 0.0v 184.755n 1.1v 189.745n 1.1v 189.755n 1.1v 194.745n 1.1v 194.755n 1.1v 199.745n 1.1v 199.755n 0.0v 204.745n 0.0v 204.755n 0.0v 209.745n 0.0v 209.755n 1.1v 214.745n 1.1v 214.755n 1.1v 219.745n 1.1v 219.755n 0.0v 224.745n 0.0v 224.755n 0.0v 229.745n 0.0v 229.755n 0.0v 234.745n 0.0v 234.755n 0.0v 239.745n 0.0v 239.755n 1.1v 244.745n 1.1v 244.755n 1.1v 249.745n 1.1v 249.755n 1.1v 254.745n 1.1v 254.755n 1.1v 259.745n 1.1v 259.755n 1.1v 264.745n 1.1v 264.755n 1.1v 269.745n 1.1v 269.755n 1.1v 274.745n 1.1v 274.755n 1.1v 279.745n 1.1v 279.755n 1.1v 284.745n 1.1v 284.755n 1.1v 289.745n 1.1v 289.755n 1.1v 294.745n 1.1v 294.755n 1.1v 299.745n 1.1v 299.755n 0.0v 304.745n 0.0v 304.755n 0.0v 309.745n 0.0v 309.755n 0.0v 314.745n 0.0v 314.755n 1.1v 319.745n 1.1v 319.755n 1.1v 324.745n 1.1v 324.755n 1.1v 329.745n 1.1v 329.755n 1.1v 334.745n 1.1v 334.755n 1.1v 339.745n 1.1v 339.755n 0.0v 344.745n 0.0v 344.755n 0.0v 349.745n 0.0v 349.755n 0.0v 354.745n 0.0v 354.755n 0.0v 359.745n 0.0v 359.755n 1.1v 364.745n 1.1v 364.755n 1.1v 369.745n 1.1v 369.755n 1.1v 374.745n 1.1v 374.755n 1.1v 379.745n 1.1v 379.755n 1.1v 384.745n 1.1v 384.755n 1.1v 389.745n 1.1v 389.755n 1.1v 394.745n 1.1v 394.755n 1.1v 399.745n 1.1v 399.755n 0.0v 404.745n 0.0v 404.755n 0.0v 409.745n 0.0v 409.755n 1.1v 414.745n 1.1v 414.755n 1.1v 419.745n 1.1v 419.755n 0.0v 424.745n 0.0v 424.755n 1.1v 429.745n 1.1v 429.755n 0.0v 434.745n 0.0v 434.755n 0.0v 439.745n 0.0v 439.755n 0.0v 444.745n 0.0v 444.755n 0.0v 449.745n 0.0v 449.755n 1.1v 454.745n 1.1v 454.755n 1.1v 459.745n 1.1v 459.755n 0.0v 464.745n 0.0v 464.755n 1.1v 469.745n 1.1v 469.755n 1.1v 474.745n 1.1v 474.755n 1.1v 479.745n 1.1v 479.755n 1.1v 484.745n 1.1v 484.755n 1.1v 489.745n 1.1v 489.755n 1.1v 494.745n 1.1v 494.755n 1.1v 499.745n 1.1v 499.755n 0.0v 504.745n 0.0v 504.755n 1.1v 509.745n 1.1v 509.755n 1.1v 514.745n 1.1v 514.755n 1.1v 519.745n 1.1v 519.755n 1.1v 524.745n 1.1v 524.755n 1.1v 529.745n 1.1v 529.755n 1.1v 534.745n 1.1v 534.755n 1.1v 539.745n 1.1v 539.755n 1.1v 544.745n 1.1v 544.755n 1.1v 549.745n 1.1v 549.755n 1.1v 554.745n 1.1v 554.755n 1.1v 559.745n 1.1v 559.755n 1.1v 564.745n 1.1v 564.755n 1.1v 569.745n 1.1v 569.755n 1.1v 574.745n 1.1v 574.755n 1.1v 579.745n 1.1v 579.755n 1.1v 584.745n 1.1v 584.755n 1.1v 589.745n 1.1v 589.755n 1.1v 594.745n 1.1v 594.755n 1.1v 599.745n 1.1v 599.755n 1.1v 604.745n 1.1v 604.755n 1.1v 609.745n 1.1v 609.755n 1.1v 614.745n 1.1v 614.755n 1.1v 619.745n 1.1v 619.755n 1.1v 624.745n 1.1v 624.755n 1.1v 629.745n 1.1v 629.755n 0.0v 634.745n 0.0v 634.755n 1.1v 639.745n 1.1v 639.755n 1.1v 644.745n 1.1v 644.755n 1.1v 649.745n 1.1v 649.755n 1.1v 654.745n 1.1v 654.755n 1.1v 659.745n 1.1v 659.755n 0.0v 664.745n 0.0v 664.755n 0.0v 669.745n 0.0v 669.755n 1.1v 674.745n 1.1v 674.755n 1.1v 679.745n 1.1v 679.755n 1.1v 684.745n 1.1v 684.755n 1.1v 689.745n 1.1v 689.755n 1.1v 694.745n 1.1v 694.755n 1.1v 699.745n 1.1v 699.755n 1.1v 704.745n 1.1v 704.755n 1.1v 709.745n 1.1v 709.755n 1.1v 714.745n 1.1v 714.755n 0.0v 719.745n 0.0v 719.755n 0.0v 724.745n 0.0v 724.755n 0.0v 729.745n 0.0v 729.755n 0.0v 734.745n 0.0v 734.755n 1.1v 739.745n 1.1v 739.755n 0.0v 744.745n 0.0v 744.755n 0.0v 749.745n 0.0v 749.755n 0.0v 754.745n 0.0v 754.755n 0.0v 759.745n 0.0v 759.755n 0.0v 764.745n 0.0v 764.755n 0.0v 769.745n 0.0v 769.755n 1.1v 774.745n 1.1v 774.755n 0.0v 779.745n 0.0v 779.755n 0.0v 784.745n 0.0v 784.755n 1.1v 789.745n 1.1v 789.755n 1.1v 794.745n 1.1v 794.755n 1.1v 799.745n 1.1v 799.755n 1.1v 804.745n 1.1v 804.755n 1.1v 809.745n 1.1v 809.755n 1.1v 814.745n 1.1v 814.755n 1.1v 819.745n 1.1v 819.755n 0.0v 824.745n 0.0v 824.755n 0.0v 829.745n 0.0v 829.755n 1.1v 834.745n 1.1v 834.755n 1.1v 839.745n 1.1v 839.755n 1.1v 844.745n 1.1v 844.755n 1.1v 849.745n 1.1v 849.755n 1.1v 854.745n 1.1v 854.755n 1.1v 859.745n 1.1v 859.755n 1.1v 864.745n 1.1v 864.755n 1.1v 869.745n 1.1v 869.755n 1.1v 874.745n 1.1v 874.755n 1.1v 879.745n 1.1v 879.755n 1.1v 884.745n 1.1v 884.755n 0.0v 889.745n 0.0v 889.755n 0.0v 894.745n 0.0v 894.755n 0.0v 899.745n 0.0v 899.755n 0.0v 904.745n 0.0v 904.755n 0.0v 909.745n 0.0v 909.755n 1.1v 914.745n 1.1v 914.755n 1.1v 919.745n 1.1v 919.755n 1.1v 924.745n 1.1v 924.755n 1.1v 929.745n 1.1v 929.755n 1.1v 934.745n 1.1v 934.755n 1.1v 939.745n 1.1v 939.755n 1.1v 944.745n 1.1v 944.755n 1.1v 949.745n 1.1v 949.755n 1.1v 954.745n 1.1v 954.755n 1.1v 959.745n 1.1v 959.755n 1.1v 964.745n 1.1v 964.755n 1.1v 969.745n 1.1v 969.755n 1.1v 974.745n 1.1v 974.755n 1.1v 979.745n 1.1v 979.755n 0.0v 984.745n 0.0v 984.755n 1.1v 989.745n 1.1v 989.755n 1.1v 994.745n 1.1v 994.755n 1.1v 999.745n 1.1v 999.755n 1.1v 1004.745n 1.1v 1004.755n 1.1v 1009.745n 1.1v 1009.755n 1.1v 1014.745n 1.1v 1014.755n 1.1v 1019.745n 1.1v 1019.755n 1.1v 1024.745n 1.1v 1024.755n 1.1v )
* (time, data): [(0, 0), (5, 1), (10, 1), (15, 1), (20, 1), (25, 1), (30, 1), (35, 1), (40, 0), (45, 0), (50, 0), (55, 0), (60, 0), (65, 0), (70, 0), (75, 0), (80, 0), (85, 0), (90, 1), (95, 1), (100, 1), (105, 1), (110, 1), (115, 1), (120, 1), (125, 1), (130, 1), (135, 1), (140, 1), (145, 1), (150, 1), (155, 1), (160, 1), (165, 1), (170, 1), (175, 1), (180, 1), (185, 1), (190, 1), (195, 1), (200, 0), (205, 0), (210, 1), (215, 1), (220, 0), (225, 0), (230, 1), (235, 1), (240, 1), (245, 1), (250, 1), (255, 1), (260, 1), (265, 1), (270, 1), (275, 1), (280, 1), (285, 1), (290, 1), (295, 1), (300, 1), (305, 1), (310, 1), (315, 1), (320, 1), (325, 1), (330, 1), (335, 1), (340, 1), (345, 1), (350, 1), (355, 1), (360, 0), (365, 0), (370, 0), (375, 0), (380, 0), (385, 0), (390, 0), (395, 1), (400, 1), (405, 1), (410, 1), (415, 1), (420, 1), (425, 1), (430, 1), (435, 1), (440, 1), (445, 1), (450, 1), (455, 1), (460, 1), (465, 1), (470, 1), (475, 1), (480, 1), (485, 1), (490, 1), (495, 1), (500, 0), (505, 1), (510, 1), (515, 1), (520, 1), (525, 1), (530, 1), (535, 1), (540, 1), (545, 1), (550, 1), (555, 1), (560, 1), (565, 1), (570, 1), (575, 1), (580, 1), (585, 1), (590, 1), (595, 1), (600, 1), (605, 1), (610, 1), (615, 1), (620, 1), (625, 1), (630, 0), (635, 1), (640, 1), (645, 1), (650, 1), (655, 0), (660, 1), (665, 1), (670, 1), (675, 1), (680, 1), (685, 1), (690, 1), (695, 1), (700, 1), (705, 1), (710, 1), (715, 0), (720, 0), (725, 0), (730, 0), (735, 1), (740, 1), (745, 1), (750, 1), (755, 0), (760, 0), (765, 0), (770, 1), (775, 1), (780, 1), (785, 1), (790, 1), (795, 1), (800, 1), (805, 1), (810, 1), (815, 1), (820, 1), (825, 1), (830, 0), (835, 1), (840, 1), (845, 1), (850, 1), (855, 1), (860, 1), (865, 1), (870, 0), (875, 1), (880, 1), (885, 1), (890, 1), (895, 1), (900, 1), (905, 1), (910, 1), (915, 1), (920, 1), (925, 1), (930, 1), (935, 1), (940, 1), (945, 1), (950, 1), (955, 1), (960, 1), (965, 0), (970, 0), (975, 0), (980, 1), (985, 1), (990, 1), (995, 1), (1000, 1), (1005, 1), (1010, 1), (1015, 1), (1020, 1), (1025, 1)]
VWMASK0_2  WMASK0_2  0 PWL (0n 0.0v 4.745n 0.0v 4.755n 1.1v 9.745n 1.1v 9.755n 1.1v 14.745n 1.1v 14.755n 1.1v 19.745n 1.1v 19.755n 1.1v 24.745n 1.1v 24.755n 1.1v 29.745n 1.1v 29.755n 1.1v 34.745n 1.1v 34.755n 1.1v 39.745n 1.1v 39.755n 0.0v 44.745n 0.0v 44.755n 0.0v 49.745n 0.0v 49.755n 0.0v 54.745n 0.0v 54.755n 0.0v 59.745n 0.0v 59.755n 0.0v 64.745n 0.0v 64.755n 0.0v 69.745n 0.0v 69.755n 0.0v 74.745n 0.0v 74.755n 0.0v 79.745n 0.0v 79.755n 0.0v 84.745n 0.0v 84.755n 0.0v 89.745n 0.0v 89.755n 1.1v 94.745n 1.1v 94.755n 1.1v 99.745n 1.1v 99.755n 1.1v 104.745n 1.1v 104.755n 1.1v 109.745n 1.1v 109.755n 1.1v 114.745n 1.1v 114.755n 1.1v 119.745n 1.1v 119.755n 1.1v 124.745n 1.1v 124.755n 1.1v 129.745n 1.1v 129.755n 1.1v 134.745n 1.1v 134.755n 1.1v 139.745n 1.1v 139.755n 1.1v 144.745n 1.1v 144.755n 1.1v 149.745n 1.1v 149.755n 1.1v 154.745n 1.1v 154.755n 1.1v 159.745n 1.1v 159.755n 1.1v 164.745n 1.1v 164.755n 1.1v 169.745n 1.1v 169.755n 1.1v 174.745n 1.1v 174.755n 1.1v 179.745n 1.1v 179.755n 1.1v 184.745n 1.1v 184.755n 1.1v 189.745n 1.1v 189.755n 1.1v 194.745n 1.1v 194.755n 1.1v 199.745n 1.1v 199.755n 0.0v 204.745n 0.0v 204.755n 0.0v 209.745n 0.0v 209.755n 1.1v 214.745n 1.1v 214.755n 1.1v 219.745n 1.1v 219.755n 0.0v 224.745n 0.0v 224.755n 0.0v 229.745n 0.0v 229.755n 1.1v 234.745n 1.1v 234.755n 1.1v 239.745n 1.1v 239.755n 1.1v 244.745n 1.1v 244.755n 1.1v 249.745n 1.1v 249.755n 1.1v 254.745n 1.1v 254.755n 1.1v 259.745n 1.1v 259.755n 1.1v 264.745n 1.1v 264.755n 1.1v 269.745n 1.1v 269.755n 1.1v 274.745n 1.1v 274.755n 1.1v 279.745n 1.1v 279.755n 1.1v 284.745n 1.1v 284.755n 1.1v 289.745n 1.1v 289.755n 1.1v 294.745n 1.1v 294.755n 1.1v 299.745n 1.1v 299.755n 1.1v 304.745n 1.1v 304.755n 1.1v 309.745n 1.1v 309.755n 1.1v 314.745n 1.1v 314.755n 1.1v 319.745n 1.1v 319.755n 1.1v 324.745n 1.1v 324.755n 1.1v 329.745n 1.1v 329.755n 1.1v 334.745n 1.1v 334.755n 1.1v 339.745n 1.1v 339.755n 1.1v 344.745n 1.1v 344.755n 1.1v 349.745n 1.1v 349.755n 1.1v 354.745n 1.1v 354.755n 1.1v 359.745n 1.1v 359.755n 0.0v 364.745n 0.0v 364.755n 0.0v 369.745n 0.0v 369.755n 0.0v 374.745n 0.0v 374.755n 0.0v 379.745n 0.0v 379.755n 0.0v 384.745n 0.0v 384.755n 0.0v 389.745n 0.0v 389.755n 0.0v 394.745n 0.0v 394.755n 1.1v 399.745n 1.1v 399.755n 1.1v 404.745n 1.1v 404.755n 1.1v 409.745n 1.1v 409.755n 1.1v 414.745n 1.1v 414.755n 1.1v 419.745n 1.1v 419.755n 1.1v 424.745n 1.1v 424.755n 1.1v 429.745n 1.1v 429.755n 1.1v 434.745n 1.1v 434.755n 1.1v 439.745n 1.1v 439.755n 1.1v 444.745n 1.1v 444.755n 1.1v 449.745n 1.1v 449.755n 1.1v 454.745n 1.1v 454.755n 1.1v 459.745n 1.1v 459.755n 1.1v 464.745n 1.1v 464.755n 1.1v 469.745n 1.1v 469.755n 1.1v 474.745n 1.1v 474.755n 1.1v 479.745n 1.1v 479.755n 1.1v 484.745n 1.1v 484.755n 1.1v 489.745n 1.1v 489.755n 1.1v 494.745n 1.1v 494.755n 1.1v 499.745n 1.1v 499.755n 0.0v 504.745n 0.0v 504.755n 1.1v 509.745n 1.1v 509.755n 1.1v 514.745n 1.1v 514.755n 1.1v 519.745n 1.1v 519.755n 1.1v 524.745n 1.1v 524.755n 1.1v 529.745n 1.1v 529.755n 1.1v 534.745n 1.1v 534.755n 1.1v 539.745n 1.1v 539.755n 1.1v 544.745n 1.1v 544.755n 1.1v 549.745n 1.1v 549.755n 1.1v 554.745n 1.1v 554.755n 1.1v 559.745n 1.1v 559.755n 1.1v 564.745n 1.1v 564.755n 1.1v 569.745n 1.1v 569.755n 1.1v 574.745n 1.1v 574.755n 1.1v 579.745n 1.1v 579.755n 1.1v 584.745n 1.1v 584.755n 1.1v 589.745n 1.1v 589.755n 1.1v 594.745n 1.1v 594.755n 1.1v 599.745n 1.1v 599.755n 1.1v 604.745n 1.1v 604.755n 1.1v 609.745n 1.1v 609.755n 1.1v 614.745n 1.1v 614.755n 1.1v 619.745n 1.1v 619.755n 1.1v 624.745n 1.1v 624.755n 1.1v 629.745n 1.1v 629.755n 0.0v 634.745n 0.0v 634.755n 1.1v 639.745n 1.1v 639.755n 1.1v 644.745n 1.1v 644.755n 1.1v 649.745n 1.1v 649.755n 1.1v 654.745n 1.1v 654.755n 0.0v 659.745n 0.0v 659.755n 1.1v 664.745n 1.1v 664.755n 1.1v 669.745n 1.1v 669.755n 1.1v 674.745n 1.1v 674.755n 1.1v 679.745n 1.1v 679.755n 1.1v 684.745n 1.1v 684.755n 1.1v 689.745n 1.1v 689.755n 1.1v 694.745n 1.1v 694.755n 1.1v 699.745n 1.1v 699.755n 1.1v 704.745n 1.1v 704.755n 1.1v 709.745n 1.1v 709.755n 1.1v 714.745n 1.1v 714.755n 0.0v 719.745n 0.0v 719.755n 0.0v 724.745n 0.0v 724.755n 0.0v 729.745n 0.0v 729.755n 0.0v 734.745n 0.0v 734.755n 1.1v 739.745n 1.1v 739.755n 1.1v 744.745n 1.1v 744.755n 1.1v 749.745n 1.1v 749.755n 1.1v 754.745n 1.1v 754.755n 0.0v 759.745n 0.0v 759.755n 0.0v 764.745n 0.0v 764.755n 0.0v 769.745n 0.0v 769.755n 1.1v 774.745n 1.1v 774.755n 1.1v 779.745n 1.1v 779.755n 1.1v 784.745n 1.1v 784.755n 1.1v 789.745n 1.1v 789.755n 1.1v 794.745n 1.1v 794.755n 1.1v 799.745n 1.1v 799.755n 1.1v 804.745n 1.1v 804.755n 1.1v 809.745n 1.1v 809.755n 1.1v 814.745n 1.1v 814.755n 1.1v 819.745n 1.1v 819.755n 1.1v 824.745n 1.1v 824.755n 1.1v 829.745n 1.1v 829.755n 0.0v 834.745n 0.0v 834.755n 1.1v 839.745n 1.1v 839.755n 1.1v 844.745n 1.1v 844.755n 1.1v 849.745n 1.1v 849.755n 1.1v 854.745n 1.1v 854.755n 1.1v 859.745n 1.1v 859.755n 1.1v 864.745n 1.1v 864.755n 1.1v 869.745n 1.1v 869.755n 0.0v 874.745n 0.0v 874.755n 1.1v 879.745n 1.1v 879.755n 1.1v 884.745n 1.1v 884.755n 1.1v 889.745n 1.1v 889.755n 1.1v 894.745n 1.1v 894.755n 1.1v 899.745n 1.1v 899.755n 1.1v 904.745n 1.1v 904.755n 1.1v 909.745n 1.1v 909.755n 1.1v 914.745n 1.1v 914.755n 1.1v 919.745n 1.1v 919.755n 1.1v 924.745n 1.1v 924.755n 1.1v 929.745n 1.1v 929.755n 1.1v 934.745n 1.1v 934.755n 1.1v 939.745n 1.1v 939.755n 1.1v 944.745n 1.1v 944.755n 1.1v 949.745n 1.1v 949.755n 1.1v 954.745n 1.1v 954.755n 1.1v 959.745n 1.1v 959.755n 1.1v 964.745n 1.1v 964.755n 0.0v 969.745n 0.0v 969.755n 0.0v 974.745n 0.0v 974.755n 0.0v 979.745n 0.0v 979.755n 1.1v 984.745n 1.1v 984.755n 1.1v 989.745n 1.1v 989.755n 1.1v 994.745n 1.1v 994.755n 1.1v 999.745n 1.1v 999.755n 1.1v 1004.745n 1.1v 1004.755n 1.1v 1009.745n 1.1v 1009.755n 1.1v 1014.745n 1.1v 1014.755n 1.1v 1019.745n 1.1v 1019.755n 1.1v 1024.745n 1.1v 1024.755n 1.1v )
* (time, data): [(0, 0), (5, 1), (10, 1), (15, 1), (20, 1), (25, 1), (30, 1), (35, 1), (40, 1), (45, 0), (50, 0), (55, 0), (60, 1), (65, 0), (70, 0), (75, 0), (80, 0), (85, 0), (90, 0), (95, 0), (100, 1), (105, 1), (110, 1), (115, 1), (120, 1), (125, 1), (130, 1), (135, 1), (140, 0), (145, 0), (150, 0), (155, 0), (160, 0), (165, 0), (170, 1), (175, 1), (180, 1), (185, 1), (190, 1), (195, 1), (200, 1), (205, 1), (210, 0), (215, 0), (220, 0), (225, 0), (230, 0), (235, 0), (240, 1), (245, 1), (250, 1), (255, 1), (260, 1), (265, 1), (270, 1), (275, 1), (280, 1), (285, 1), (290, 1), (295, 1), (300, 1), (305, 1), (310, 1), (315, 1), (320, 1), (325, 1), (330, 1), (335, 1), (340, 1), (345, 1), (350, 1), (355, 1), (360, 0), (365, 0), (370, 0), (375, 0), (380, 0), (385, 0), (390, 0), (395, 1), (400, 0), (405, 0), (410, 1), (415, 0), (420, 1), (425, 1), (430, 0), (435, 0), (440, 0), (445, 0), (450, 0), (455, 0), (460, 1), (465, 1), (470, 1), (475, 1), (480, 1), (485, 1), (490, 1), (495, 0), (500, 1), (505, 1), (510, 1), (515, 1), (520, 1), (525, 1), (530, 1), (535, 0), (540, 1), (545, 1), (550, 1), (555, 1), (560, 1), (565, 1), (570, 1), (575, 1), (580, 1), (585, 1), (590, 1), (595, 1), (600, 1), (605, 1), (610, 1), (615, 1), (620, 1), (625, 1), (630, 1), (635, 1), (640, 1), (645, 1), (650, 1), (655, 0), (660, 0), (665, 0), (670, 0), (675, 0), (680, 0), (685, 0), (690, 0), (695, 0), (700, 0), (705, 1), (710, 1), (715, 1), (720, 1), (725, 1), (730, 1), (735, 1), (740, 1), (745, 1), (750, 1), (755, 1), (760, 1), (765, 1), (770, 1), (775, 0), (780, 0), (785, 1), (790, 1), (795, 1), (800, 1), (805, 1), (810, 1), (815, 1), (820, 0), (825, 0), (830, 0), (835, 1), (840, 1), (845, 1), (850, 1), (855, 1), (860, 1), (865, 1), (870, 1), (875, 1), (880, 1), (885, 1), (890, 1), (895, 1), (900, 1), (905, 1), (910, 1), (915, 1), (920, 1), (925, 1), (930, 1), (935, 1), (940, 1), (945, 1), (950, 1), (955, 1), (960, 1), (965, 1), (970, 1), (975, 1), (980, 0), (985, 1), (990, 1), (995, 1), (1000, 1), (1005, 1), (1010, 1), (1015, 1), (1020, 1), (1025, 1)]
VWMASK0_3  WMASK0_3  0 PWL (0n 0.0v 4.745n 0.0v 4.755n 1.1v 9.745n 1.1v 9.755n 1.1v 14.745n 1.1v 14.755n 1.1v 19.745n 1.1v 19.755n 1.1v 24.745n 1.1v 24.755n 1.1v 29.745n 1.1v 29.755n 1.1v 34.745n 1.1v 34.755n 1.1v 39.745n 1.1v 39.755n 1.1v 44.745n 1.1v 44.755n 0.0v 49.745n 0.0v 49.755n 0.0v 54.745n 0.0v 54.755n 0.0v 59.745n 0.0v 59.755n 1.1v 64.745n 1.1v 64.755n 0.0v 69.745n 0.0v 69.755n 0.0v 74.745n 0.0v 74.755n 0.0v 79.745n 0.0v 79.755n 0.0v 84.745n 0.0v 84.755n 0.0v 89.745n 0.0v 89.755n 0.0v 94.745n 0.0v 94.755n 0.0v 99.745n 0.0v 99.755n 1.1v 104.745n 1.1v 104.755n 1.1v 109.745n 1.1v 109.755n 1.1v 114.745n 1.1v 114.755n 1.1v 119.745n 1.1v 119.755n 1.1v 124.745n 1.1v 124.755n 1.1v 129.745n 1.1v 129.755n 1.1v 134.745n 1.1v 134.755n 1.1v 139.745n 1.1v 139.755n 0.0v 144.745n 0.0v 144.755n 0.0v 149.745n 0.0v 149.755n 0.0v 154.745n 0.0v 154.755n 0.0v 159.745n 0.0v 159.755n 0.0v 164.745n 0.0v 164.755n 0.0v 169.745n 0.0v 169.755n 1.1v 174.745n 1.1v 174.755n 1.1v 179.745n 1.1v 179.755n 1.1v 184.745n 1.1v 184.755n 1.1v 189.745n 1.1v 189.755n 1.1v 194.745n 1.1v 194.755n 1.1v 199.745n 1.1v 199.755n 1.1v 204.745n 1.1v 204.755n 1.1v 209.745n 1.1v 209.755n 0.0v 214.745n 0.0v 214.755n 0.0v 219.745n 0.0v 219.755n 0.0v 224.745n 0.0v 224.755n 0.0v 229.745n 0.0v 229.755n 0.0v 234.745n 0.0v 234.755n 0.0v 239.745n 0.0v 239.755n 1.1v 244.745n 1.1v 244.755n 1.1v 249.745n 1.1v 249.755n 1.1v 254.745n 1.1v 254.755n 1.1v 259.745n 1.1v 259.755n 1.1v 264.745n 1.1v 264.755n 1.1v 269.745n 1.1v 269.755n 1.1v 274.745n 1.1v 274.755n 1.1v 279.745n 1.1v 279.755n 1.1v 284.745n 1.1v 284.755n 1.1v 289.745n 1.1v 289.755n 1.1v 294.745n 1.1v 294.755n 1.1v 299.745n 1.1v 299.755n 1.1v 304.745n 1.1v 304.755n 1.1v 309.745n 1.1v 309.755n 1.1v 314.745n 1.1v 314.755n 1.1v 319.745n 1.1v 319.755n 1.1v 324.745n 1.1v 324.755n 1.1v 329.745n 1.1v 329.755n 1.1v 334.745n 1.1v 334.755n 1.1v 339.745n 1.1v 339.755n 1.1v 344.745n 1.1v 344.755n 1.1v 349.745n 1.1v 349.755n 1.1v 354.745n 1.1v 354.755n 1.1v 359.745n 1.1v 359.755n 0.0v 364.745n 0.0v 364.755n 0.0v 369.745n 0.0v 369.755n 0.0v 374.745n 0.0v 374.755n 0.0v 379.745n 0.0v 379.755n 0.0v 384.745n 0.0v 384.755n 0.0v 389.745n 0.0v 389.755n 0.0v 394.745n 0.0v 394.755n 1.1v 399.745n 1.1v 399.755n 0.0v 404.745n 0.0v 404.755n 0.0v 409.745n 0.0v 409.755n 1.1v 414.745n 1.1v 414.755n 0.0v 419.745n 0.0v 419.755n 1.1v 424.745n 1.1v 424.755n 1.1v 429.745n 1.1v 429.755n 0.0v 434.745n 0.0v 434.755n 0.0v 439.745n 0.0v 439.755n 0.0v 444.745n 0.0v 444.755n 0.0v 449.745n 0.0v 449.755n 0.0v 454.745n 0.0v 454.755n 0.0v 459.745n 0.0v 459.755n 1.1v 464.745n 1.1v 464.755n 1.1v 469.745n 1.1v 469.755n 1.1v 474.745n 1.1v 474.755n 1.1v 479.745n 1.1v 479.755n 1.1v 484.745n 1.1v 484.755n 1.1v 489.745n 1.1v 489.755n 1.1v 494.745n 1.1v 494.755n 0.0v 499.745n 0.0v 499.755n 1.1v 504.745n 1.1v 504.755n 1.1v 509.745n 1.1v 509.755n 1.1v 514.745n 1.1v 514.755n 1.1v 519.745n 1.1v 519.755n 1.1v 524.745n 1.1v 524.755n 1.1v 529.745n 1.1v 529.755n 1.1v 534.745n 1.1v 534.755n 0.0v 539.745n 0.0v 539.755n 1.1v 544.745n 1.1v 544.755n 1.1v 549.745n 1.1v 549.755n 1.1v 554.745n 1.1v 554.755n 1.1v 559.745n 1.1v 559.755n 1.1v 564.745n 1.1v 564.755n 1.1v 569.745n 1.1v 569.755n 1.1v 574.745n 1.1v 574.755n 1.1v 579.745n 1.1v 579.755n 1.1v 584.745n 1.1v 584.755n 1.1v 589.745n 1.1v 589.755n 1.1v 594.745n 1.1v 594.755n 1.1v 599.745n 1.1v 599.755n 1.1v 604.745n 1.1v 604.755n 1.1v 609.745n 1.1v 609.755n 1.1v 614.745n 1.1v 614.755n 1.1v 619.745n 1.1v 619.755n 1.1v 624.745n 1.1v 624.755n 1.1v 629.745n 1.1v 629.755n 1.1v 634.745n 1.1v 634.755n 1.1v 639.745n 1.1v 639.755n 1.1v 644.745n 1.1v 644.755n 1.1v 649.745n 1.1v 649.755n 1.1v 654.745n 1.1v 654.755n 0.0v 659.745n 0.0v 659.755n 0.0v 664.745n 0.0v 664.755n 0.0v 669.745n 0.0v 669.755n 0.0v 674.745n 0.0v 674.755n 0.0v 679.745n 0.0v 679.755n 0.0v 684.745n 0.0v 684.755n 0.0v 689.745n 0.0v 689.755n 0.0v 694.745n 0.0v 694.755n 0.0v 699.745n 0.0v 699.755n 0.0v 704.745n 0.0v 704.755n 1.1v 709.745n 1.1v 709.755n 1.1v 714.745n 1.1v 714.755n 1.1v 719.745n 1.1v 719.755n 1.1v 724.745n 1.1v 724.755n 1.1v 729.745n 1.1v 729.755n 1.1v 734.745n 1.1v 734.755n 1.1v 739.745n 1.1v 739.755n 1.1v 744.745n 1.1v 744.755n 1.1v 749.745n 1.1v 749.755n 1.1v 754.745n 1.1v 754.755n 1.1v 759.745n 1.1v 759.755n 1.1v 764.745n 1.1v 764.755n 1.1v 769.745n 1.1v 769.755n 1.1v 774.745n 1.1v 774.755n 0.0v 779.745n 0.0v 779.755n 0.0v 784.745n 0.0v 784.755n 1.1v 789.745n 1.1v 789.755n 1.1v 794.745n 1.1v 794.755n 1.1v 799.745n 1.1v 799.755n 1.1v 804.745n 1.1v 804.755n 1.1v 809.745n 1.1v 809.755n 1.1v 814.745n 1.1v 814.755n 1.1v 819.745n 1.1v 819.755n 0.0v 824.745n 0.0v 824.755n 0.0v 829.745n 0.0v 829.755n 0.0v 834.745n 0.0v 834.755n 1.1v 839.745n 1.1v 839.755n 1.1v 844.745n 1.1v 844.755n 1.1v 849.745n 1.1v 849.755n 1.1v 854.745n 1.1v 854.755n 1.1v 859.745n 1.1v 859.755n 1.1v 864.745n 1.1v 864.755n 1.1v 869.745n 1.1v 869.755n 1.1v 874.745n 1.1v 874.755n 1.1v 879.745n 1.1v 879.755n 1.1v 884.745n 1.1v 884.755n 1.1v 889.745n 1.1v 889.755n 1.1v 894.745n 1.1v 894.755n 1.1v 899.745n 1.1v 899.755n 1.1v 904.745n 1.1v 904.755n 1.1v 909.745n 1.1v 909.755n 1.1v 914.745n 1.1v 914.755n 1.1v 919.745n 1.1v 919.755n 1.1v 924.745n 1.1v 924.755n 1.1v 929.745n 1.1v 929.755n 1.1v 934.745n 1.1v 934.755n 1.1v 939.745n 1.1v 939.755n 1.1v 944.745n 1.1v 944.755n 1.1v 949.745n 1.1v 949.755n 1.1v 954.745n 1.1v 954.755n 1.1v 959.745n 1.1v 959.755n 1.1v 964.745n 1.1v 964.755n 1.1v 969.745n 1.1v 969.755n 1.1v 974.745n 1.1v 974.755n 1.1v 979.745n 1.1v 979.755n 0.0v 984.745n 0.0v 984.755n 1.1v 989.745n 1.1v 989.755n 1.1v 994.745n 1.1v 994.755n 1.1v 999.745n 1.1v 999.755n 1.1v 1004.745n 1.1v 1004.755n 1.1v 1009.745n 1.1v 1009.755n 1.1v 1014.745n 1.1v 1014.755n 1.1v 1019.745n 1.1v 1019.755n 1.1v 1024.745n 1.1v 1024.755n 1.1v )
* (time, data): [(0, 0), (5, 1), (10, 1), (15, 1), (20, 1), (25, 1), (30, 1), (35, 1), (40, 0), (45, 1), (50, 1), (55, 1), (60, 0), (65, 1), (70, 1), (75, 1), (80, 1), (85, 1), (90, 1), (95, 1), (100, 0), (105, 0), (110, 0), (115, 0), (120, 0), (125, 0), (130, 0), (135, 1), (140, 1), (145, 1), (150, 1), (155, 1), (160, 1), (165, 1), (170, 0), (175, 0), (180, 0), (185, 1), (190, 1), (195, 1), (200, 1), (205, 1), (210, 0), (215, 0), (220, 0), (225, 0), (230, 0), (235, 0), (240, 1), (245, 1), (250, 1), (255, 0), (260, 0), (265, 1), (270, 1), (275, 1), (280, 1), (285, 1), (290, 1), (295, 1), (300, 0), (305, 0), (310, 0), (315, 1), (320, 1), (325, 1), (330, 1), (335, 1), (340, 0), (345, 0), (350, 0), (355, 0), (360, 1), (365, 1), (370, 1), (375, 1), (380, 1), (385, 1), (390, 1), (395, 1), (400, 1), (405, 1), (410, 1), (415, 0), (420, 0), (425, 1), (430, 1), (435, 1), (440, 1), (445, 1), (450, 0), (455, 0), (460, 0), (465, 1), (470, 1), (475, 1), (480, 1), (485, 1), (490, 1), (495, 1), (500, 1), (505, 1), (510, 1), (515, 1), (520, 1), (525, 1), (530, 1), (535, 1), (540, 1), (545, 1), (550, 1), (555, 1), (560, 1), (565, 1), (570, 1), (575, 1), (580, 1), (585, 1), (590, 1), (595, 1), (600, 1), (605, 1), (610, 1), (615, 1), (620, 1), (625, 1), (630, 1), (635, 1), (640, 0), (645, 0), (650, 0), (655, 1), (660, 0), (665, 0), (670, 0), (675, 0), (680, 0), (685, 0), (690, 0), (695, 0), (700, 0), (705, 1), (710, 1), (715, 0), (720, 0), (725, 0), (730, 0), (735, 1), (740, 1), (745, 1), (750, 1), (755, 0), (760, 0), (765, 0), (770, 1), (775, 0), (780, 0), (785, 1), (790, 1), (795, 1), (800, 1), (805, 1), (810, 1), (815, 1), (820, 0), (825, 0), (830, 0), (835, 1), (840, 1), (845, 1), (850, 1), (855, 1), (860, 1), (865, 1), (870, 0), (875, 1), (880, 1), (885, 0), (890, 0), (895, 0), (900, 0), (905, 0), (910, 1), (915, 1), (920, 1), (925, 1), (930, 1), (935, 1), (940, 1), (945, 1), (950, 1), (955, 1), (960, 1), (965, 0), (970, 0), (975, 0), (980, 1), (985, 1), (990, 1), (995, 1), (1000, 1), (1005, 1), (1010, 1), (1015, 1), (1020, 1), (1025, 1)]
VWMASK0_4  WMASK0_4  0 PWL (0n 0.0v 4.745n 0.0v 4.755n 1.1v 9.745n 1.1v 9.755n 1.1v 14.745n 1.1v 14.755n 1.1v 19.745n 1.1v 19.755n 1.1v 24.745n 1.1v 24.755n 1.1v 29.745n 1.1v 29.755n 1.1v 34.745n 1.1v 34.755n 1.1v 39.745n 1.1v 39.755n 0.0v 44.745n 0.0v 44.755n 1.1v 49.745n 1.1v 49.755n 1.1v 54.745n 1.1v 54.755n 1.1v 59.745n 1.1v 59.755n 0.0v 64.745n 0.0v 64.755n 1.1v 69.745n 1.1v 69.755n 1.1v 74.745n 1.1v 74.755n 1.1v 79.745n 1.1v 79.755n 1.1v 84.745n 1.1v 84.755n 1.1v 89.745n 1.1v 89.755n 1.1v 94.745n 1.1v 94.755n 1.1v 99.745n 1.1v 99.755n 0.0v 104.745n 0.0v 104.755n 0.0v 109.745n 0.0v 109.755n 0.0v 114.745n 0.0v 114.755n 0.0v 119.745n 0.0v 119.755n 0.0v 124.745n 0.0v 124.755n 0.0v 129.745n 0.0v 129.755n 0.0v 134.745n 0.0v 134.755n 1.1v 139.745n 1.1v 139.755n 1.1v 144.745n 1.1v 144.755n 1.1v 149.745n 1.1v 149.755n 1.1v 154.745n 1.1v 154.755n 1.1v 159.745n 1.1v 159.755n 1.1v 164.745n 1.1v 164.755n 1.1v 169.745n 1.1v 169.755n 0.0v 174.745n 0.0v 174.755n 0.0v 179.745n 0.0v 179.755n 0.0v 184.745n 0.0v 184.755n 1.1v 189.745n 1.1v 189.755n 1.1v 194.745n 1.1v 194.755n 1.1v 199.745n 1.1v 199.755n 1.1v 204.745n 1.1v 204.755n 1.1v 209.745n 1.1v 209.755n 0.0v 214.745n 0.0v 214.755n 0.0v 219.745n 0.0v 219.755n 0.0v 224.745n 0.0v 224.755n 0.0v 229.745n 0.0v 229.755n 0.0v 234.745n 0.0v 234.755n 0.0v 239.745n 0.0v 239.755n 1.1v 244.745n 1.1v 244.755n 1.1v 249.745n 1.1v 249.755n 1.1v 254.745n 1.1v 254.755n 0.0v 259.745n 0.0v 259.755n 0.0v 264.745n 0.0v 264.755n 1.1v 269.745n 1.1v 269.755n 1.1v 274.745n 1.1v 274.755n 1.1v 279.745n 1.1v 279.755n 1.1v 284.745n 1.1v 284.755n 1.1v 289.745n 1.1v 289.755n 1.1v 294.745n 1.1v 294.755n 1.1v 299.745n 1.1v 299.755n 0.0v 304.745n 0.0v 304.755n 0.0v 309.745n 0.0v 309.755n 0.0v 314.745n 0.0v 314.755n 1.1v 319.745n 1.1v 319.755n 1.1v 324.745n 1.1v 324.755n 1.1v 329.745n 1.1v 329.755n 1.1v 334.745n 1.1v 334.755n 1.1v 339.745n 1.1v 339.755n 0.0v 344.745n 0.0v 344.755n 0.0v 349.745n 0.0v 349.755n 0.0v 354.745n 0.0v 354.755n 0.0v 359.745n 0.0v 359.755n 1.1v 364.745n 1.1v 364.755n 1.1v 369.745n 1.1v 369.755n 1.1v 374.745n 1.1v 374.755n 1.1v 379.745n 1.1v 379.755n 1.1v 384.745n 1.1v 384.755n 1.1v 389.745n 1.1v 389.755n 1.1v 394.745n 1.1v 394.755n 1.1v 399.745n 1.1v 399.755n 1.1v 404.745n 1.1v 404.755n 1.1v 409.745n 1.1v 409.755n 1.1v 414.745n 1.1v 414.755n 0.0v 419.745n 0.0v 419.755n 0.0v 424.745n 0.0v 424.755n 1.1v 429.745n 1.1v 429.755n 1.1v 434.745n 1.1v 434.755n 1.1v 439.745n 1.1v 439.755n 1.1v 444.745n 1.1v 444.755n 1.1v 449.745n 1.1v 449.755n 0.0v 454.745n 0.0v 454.755n 0.0v 459.745n 0.0v 459.755n 0.0v 464.745n 0.0v 464.755n 1.1v 469.745n 1.1v 469.755n 1.1v 474.745n 1.1v 474.755n 1.1v 479.745n 1.1v 479.755n 1.1v 484.745n 1.1v 484.755n 1.1v 489.745n 1.1v 489.755n 1.1v 494.745n 1.1v 494.755n 1.1v 499.745n 1.1v 499.755n 1.1v 504.745n 1.1v 504.755n 1.1v 509.745n 1.1v 509.755n 1.1v 514.745n 1.1v 514.755n 1.1v 519.745n 1.1v 519.755n 1.1v 524.745n 1.1v 524.755n 1.1v 529.745n 1.1v 529.755n 1.1v 534.745n 1.1v 534.755n 1.1v 539.745n 1.1v 539.755n 1.1v 544.745n 1.1v 544.755n 1.1v 549.745n 1.1v 549.755n 1.1v 554.745n 1.1v 554.755n 1.1v 559.745n 1.1v 559.755n 1.1v 564.745n 1.1v 564.755n 1.1v 569.745n 1.1v 569.755n 1.1v 574.745n 1.1v 574.755n 1.1v 579.745n 1.1v 579.755n 1.1v 584.745n 1.1v 584.755n 1.1v 589.745n 1.1v 589.755n 1.1v 594.745n 1.1v 594.755n 1.1v 599.745n 1.1v 599.755n 1.1v 604.745n 1.1v 604.755n 1.1v 609.745n 1.1v 609.755n 1.1v 614.745n 1.1v 614.755n 1.1v 619.745n 1.1v 619.755n 1.1v 624.745n 1.1v 624.755n 1.1v 629.745n 1.1v 629.755n 1.1v 634.745n 1.1v 634.755n 1.1v 639.745n 1.1v 639.755n 0.0v 644.745n 0.0v 644.755n 0.0v 649.745n 0.0v 649.755n 0.0v 654.745n 0.0v 654.755n 1.1v 659.745n 1.1v 659.755n 0.0v 664.745n 0.0v 664.755n 0.0v 669.745n 0.0v 669.755n 0.0v 674.745n 0.0v 674.755n 0.0v 679.745n 0.0v 679.755n 0.0v 684.745n 0.0v 684.755n 0.0v 689.745n 0.0v 689.755n 0.0v 694.745n 0.0v 694.755n 0.0v 699.745n 0.0v 699.755n 0.0v 704.745n 0.0v 704.755n 1.1v 709.745n 1.1v 709.755n 1.1v 714.745n 1.1v 714.755n 0.0v 719.745n 0.0v 719.755n 0.0v 724.745n 0.0v 724.755n 0.0v 729.745n 0.0v 729.755n 0.0v 734.745n 0.0v 734.755n 1.1v 739.745n 1.1v 739.755n 1.1v 744.745n 1.1v 744.755n 1.1v 749.745n 1.1v 749.755n 1.1v 754.745n 1.1v 754.755n 0.0v 759.745n 0.0v 759.755n 0.0v 764.745n 0.0v 764.755n 0.0v 769.745n 0.0v 769.755n 1.1v 774.745n 1.1v 774.755n 0.0v 779.745n 0.0v 779.755n 0.0v 784.745n 0.0v 784.755n 1.1v 789.745n 1.1v 789.755n 1.1v 794.745n 1.1v 794.755n 1.1v 799.745n 1.1v 799.755n 1.1v 804.745n 1.1v 804.755n 1.1v 809.745n 1.1v 809.755n 1.1v 814.745n 1.1v 814.755n 1.1v 819.745n 1.1v 819.755n 0.0v 824.745n 0.0v 824.755n 0.0v 829.745n 0.0v 829.755n 0.0v 834.745n 0.0v 834.755n 1.1v 839.745n 1.1v 839.755n 1.1v 844.745n 1.1v 844.755n 1.1v 849.745n 1.1v 849.755n 1.1v 854.745n 1.1v 854.755n 1.1v 859.745n 1.1v 859.755n 1.1v 864.745n 1.1v 864.755n 1.1v 869.745n 1.1v 869.755n 0.0v 874.745n 0.0v 874.755n 1.1v 879.745n 1.1v 879.755n 1.1v 884.745n 1.1v 884.755n 0.0v 889.745n 0.0v 889.755n 0.0v 894.745n 0.0v 894.755n 0.0v 899.745n 0.0v 899.755n 0.0v 904.745n 0.0v 904.755n 0.0v 909.745n 0.0v 909.755n 1.1v 914.745n 1.1v 914.755n 1.1v 919.745n 1.1v 919.755n 1.1v 924.745n 1.1v 924.755n 1.1v 929.745n 1.1v 929.755n 1.1v 934.745n 1.1v 934.755n 1.1v 939.745n 1.1v 939.755n 1.1v 944.745n 1.1v 944.755n 1.1v 949.745n 1.1v 949.755n 1.1v 954.745n 1.1v 954.755n 1.1v 959.745n 1.1v 959.755n 1.1v 964.745n 1.1v 964.755n 0.0v 969.745n 0.0v 969.755n 0.0v 974.745n 0.0v 974.755n 0.0v 979.745n 0.0v 979.755n 1.1v 984.745n 1.1v 984.755n 1.1v 989.745n 1.1v 989.755n 1.1v 994.745n 1.1v 994.755n 1.1v 999.745n 1.1v 999.755n 1.1v 1004.745n 1.1v 1004.755n 1.1v 1009.745n 1.1v 1009.755n 1.1v 1014.745n 1.1v 1014.755n 1.1v 1019.745n 1.1v 1019.755n 1.1v 1024.745n 1.1v 1024.755n 1.1v )
* (time, data): [(0, 0), (5, 1), (10, 1), (15, 1), (20, 1), (25, 1), (30, 1), (35, 1), (40, 1), (45, 0), (50, 0), (55, 0), (60, 1), (65, 1), (70, 1), (75, 1), (80, 1), (85, 1), (90, 0), (95, 0), (100, 1), (105, 1), (110, 1), (115, 1), (120, 1), (125, 1), (130, 1), (135, 1), (140, 0), (145, 0), (150, 0), (155, 0), (160, 0), (165, 0), (170, 1), (175, 1), (180, 1), (185, 1), (190, 1), (195, 1), (200, 0), (205, 0), (210, 0), (215, 0), (220, 1), (225, 1), (230, 0), (235, 0), (240, 1), (245, 1), (250, 1), (255, 0), (260, 0), (265, 1), (270, 1), (275, 1), (280, 1), (285, 1), (290, 1), (295, 1), (300, 0), (305, 0), (310, 0), (315, 1), (320, 1), (325, 1), (330, 1), (335, 1), (340, 0), (345, 0), (350, 0), (355, 0), (360, 1), (365, 1), (370, 1), (375, 1), (380, 1), (385, 1), (390, 1), (395, 1), (400, 1), (405, 1), (410, 1), (415, 0), (420, 1), (425, 1), (430, 1), (435, 1), (440, 1), (445, 1), (450, 0), (455, 0), (460, 0), (465, 1), (470, 1), (475, 1), (480, 1), (485, 1), (490, 1), (495, 0), (500, 0), (505, 1), (510, 1), (515, 1), (520, 1), (525, 1), (530, 1), (535, 0), (540, 1), (545, 1), (550, 1), (555, 1), (560, 1), (565, 1), (570, 1), (575, 1), (580, 1), (585, 1), (590, 1), (595, 1), (600, 1), (605, 1), (610, 1), (615, 1), (620, 1), (625, 1), (630, 0), (635, 1), (640, 1), (645, 1), (650, 1), (655, 1), (660, 0), (665, 0), (670, 1), (675, 1), (680, 1), (685, 1), (690, 1), (695, 1), (700, 1), (705, 1), (710, 1), (715, 1), (720, 1), (725, 1), (730, 1), (735, 1), (740, 0), (745, 0), (750, 0), (755, 1), (760, 1), (765, 1), (770, 1), (775, 0), (780, 0), (785, 1), (790, 1), (795, 1), (800, 1), (805, 1), (810, 1), (815, 1), (820, 0), (825, 0), (830, 1), (835, 1), (840, 1), (845, 1), (850, 1), (855, 1), (860, 1), (865, 1), (870, 1), (875, 1), (880, 1), (885, 1), (890, 1), (895, 1), (900, 1), (905, 1), (910, 1), (915, 1), (920, 1), (925, 1), (930, 1), (935, 1), (940, 1), (945, 1), (950, 1), (955, 1), (960, 1), (965, 0), (970, 0), (975, 0), (980, 0), (985, 1), (990, 1), (995, 1), (1000, 1), (1005, 1), (1010, 1), (1015, 1), (1020, 1), (1025, 1)]
VWMASK0_5  WMASK0_5  0 PWL (0n 0.0v 4.745n 0.0v 4.755n 1.1v 9.745n 1.1v 9.755n 1.1v 14.745n 1.1v 14.755n 1.1v 19.745n 1.1v 19.755n 1.1v 24.745n 1.1v 24.755n 1.1v 29.745n 1.1v 29.755n 1.1v 34.745n 1.1v 34.755n 1.1v 39.745n 1.1v 39.755n 1.1v 44.745n 1.1v 44.755n 0.0v 49.745n 0.0v 49.755n 0.0v 54.745n 0.0v 54.755n 0.0v 59.745n 0.0v 59.755n 1.1v 64.745n 1.1v 64.755n 1.1v 69.745n 1.1v 69.755n 1.1v 74.745n 1.1v 74.755n 1.1v 79.745n 1.1v 79.755n 1.1v 84.745n 1.1v 84.755n 1.1v 89.745n 1.1v 89.755n 0.0v 94.745n 0.0v 94.755n 0.0v 99.745n 0.0v 99.755n 1.1v 104.745n 1.1v 104.755n 1.1v 109.745n 1.1v 109.755n 1.1v 114.745n 1.1v 114.755n 1.1v 119.745n 1.1v 119.755n 1.1v 124.745n 1.1v 124.755n 1.1v 129.745n 1.1v 129.755n 1.1v 134.745n 1.1v 134.755n 1.1v 139.745n 1.1v 139.755n 0.0v 144.745n 0.0v 144.755n 0.0v 149.745n 0.0v 149.755n 0.0v 154.745n 0.0v 154.755n 0.0v 159.745n 0.0v 159.755n 0.0v 164.745n 0.0v 164.755n 0.0v 169.745n 0.0v 169.755n 1.1v 174.745n 1.1v 174.755n 1.1v 179.745n 1.1v 179.755n 1.1v 184.745n 1.1v 184.755n 1.1v 189.745n 1.1v 189.755n 1.1v 194.745n 1.1v 194.755n 1.1v 199.745n 1.1v 199.755n 0.0v 204.745n 0.0v 204.755n 0.0v 209.745n 0.0v 209.755n 0.0v 214.745n 0.0v 214.755n 0.0v 219.745n 0.0v 219.755n 1.1v 224.745n 1.1v 224.755n 1.1v 229.745n 1.1v 229.755n 0.0v 234.745n 0.0v 234.755n 0.0v 239.745n 0.0v 239.755n 1.1v 244.745n 1.1v 244.755n 1.1v 249.745n 1.1v 249.755n 1.1v 254.745n 1.1v 254.755n 0.0v 259.745n 0.0v 259.755n 0.0v 264.745n 0.0v 264.755n 1.1v 269.745n 1.1v 269.755n 1.1v 274.745n 1.1v 274.755n 1.1v 279.745n 1.1v 279.755n 1.1v 284.745n 1.1v 284.755n 1.1v 289.745n 1.1v 289.755n 1.1v 294.745n 1.1v 294.755n 1.1v 299.745n 1.1v 299.755n 0.0v 304.745n 0.0v 304.755n 0.0v 309.745n 0.0v 309.755n 0.0v 314.745n 0.0v 314.755n 1.1v 319.745n 1.1v 319.755n 1.1v 324.745n 1.1v 324.755n 1.1v 329.745n 1.1v 329.755n 1.1v 334.745n 1.1v 334.755n 1.1v 339.745n 1.1v 339.755n 0.0v 344.745n 0.0v 344.755n 0.0v 349.745n 0.0v 349.755n 0.0v 354.745n 0.0v 354.755n 0.0v 359.745n 0.0v 359.755n 1.1v 364.745n 1.1v 364.755n 1.1v 369.745n 1.1v 369.755n 1.1v 374.745n 1.1v 374.755n 1.1v 379.745n 1.1v 379.755n 1.1v 384.745n 1.1v 384.755n 1.1v 389.745n 1.1v 389.755n 1.1v 394.745n 1.1v 394.755n 1.1v 399.745n 1.1v 399.755n 1.1v 404.745n 1.1v 404.755n 1.1v 409.745n 1.1v 409.755n 1.1v 414.745n 1.1v 414.755n 0.0v 419.745n 0.0v 419.755n 1.1v 424.745n 1.1v 424.755n 1.1v 429.745n 1.1v 429.755n 1.1v 434.745n 1.1v 434.755n 1.1v 439.745n 1.1v 439.755n 1.1v 444.745n 1.1v 444.755n 1.1v 449.745n 1.1v 449.755n 0.0v 454.745n 0.0v 454.755n 0.0v 459.745n 0.0v 459.755n 0.0v 464.745n 0.0v 464.755n 1.1v 469.745n 1.1v 469.755n 1.1v 474.745n 1.1v 474.755n 1.1v 479.745n 1.1v 479.755n 1.1v 484.745n 1.1v 484.755n 1.1v 489.745n 1.1v 489.755n 1.1v 494.745n 1.1v 494.755n 0.0v 499.745n 0.0v 499.755n 0.0v 504.745n 0.0v 504.755n 1.1v 509.745n 1.1v 509.755n 1.1v 514.745n 1.1v 514.755n 1.1v 519.745n 1.1v 519.755n 1.1v 524.745n 1.1v 524.755n 1.1v 529.745n 1.1v 529.755n 1.1v 534.745n 1.1v 534.755n 0.0v 539.745n 0.0v 539.755n 1.1v 544.745n 1.1v 544.755n 1.1v 549.745n 1.1v 549.755n 1.1v 554.745n 1.1v 554.755n 1.1v 559.745n 1.1v 559.755n 1.1v 564.745n 1.1v 564.755n 1.1v 569.745n 1.1v 569.755n 1.1v 574.745n 1.1v 574.755n 1.1v 579.745n 1.1v 579.755n 1.1v 584.745n 1.1v 584.755n 1.1v 589.745n 1.1v 589.755n 1.1v 594.745n 1.1v 594.755n 1.1v 599.745n 1.1v 599.755n 1.1v 604.745n 1.1v 604.755n 1.1v 609.745n 1.1v 609.755n 1.1v 614.745n 1.1v 614.755n 1.1v 619.745n 1.1v 619.755n 1.1v 624.745n 1.1v 624.755n 1.1v 629.745n 1.1v 629.755n 0.0v 634.745n 0.0v 634.755n 1.1v 639.745n 1.1v 639.755n 1.1v 644.745n 1.1v 644.755n 1.1v 649.745n 1.1v 649.755n 1.1v 654.745n 1.1v 654.755n 1.1v 659.745n 1.1v 659.755n 0.0v 664.745n 0.0v 664.755n 0.0v 669.745n 0.0v 669.755n 1.1v 674.745n 1.1v 674.755n 1.1v 679.745n 1.1v 679.755n 1.1v 684.745n 1.1v 684.755n 1.1v 689.745n 1.1v 689.755n 1.1v 694.745n 1.1v 694.755n 1.1v 699.745n 1.1v 699.755n 1.1v 704.745n 1.1v 704.755n 1.1v 709.745n 1.1v 709.755n 1.1v 714.745n 1.1v 714.755n 1.1v 719.745n 1.1v 719.755n 1.1v 724.745n 1.1v 724.755n 1.1v 729.745n 1.1v 729.755n 1.1v 734.745n 1.1v 734.755n 1.1v 739.745n 1.1v 739.755n 0.0v 744.745n 0.0v 744.755n 0.0v 749.745n 0.0v 749.755n 0.0v 754.745n 0.0v 754.755n 1.1v 759.745n 1.1v 759.755n 1.1v 764.745n 1.1v 764.755n 1.1v 769.745n 1.1v 769.755n 1.1v 774.745n 1.1v 774.755n 0.0v 779.745n 0.0v 779.755n 0.0v 784.745n 0.0v 784.755n 1.1v 789.745n 1.1v 789.755n 1.1v 794.745n 1.1v 794.755n 1.1v 799.745n 1.1v 799.755n 1.1v 804.745n 1.1v 804.755n 1.1v 809.745n 1.1v 809.755n 1.1v 814.745n 1.1v 814.755n 1.1v 819.745n 1.1v 819.755n 0.0v 824.745n 0.0v 824.755n 0.0v 829.745n 0.0v 829.755n 1.1v 834.745n 1.1v 834.755n 1.1v 839.745n 1.1v 839.755n 1.1v 844.745n 1.1v 844.755n 1.1v 849.745n 1.1v 849.755n 1.1v 854.745n 1.1v 854.755n 1.1v 859.745n 1.1v 859.755n 1.1v 864.745n 1.1v 864.755n 1.1v 869.745n 1.1v 869.755n 1.1v 874.745n 1.1v 874.755n 1.1v 879.745n 1.1v 879.755n 1.1v 884.745n 1.1v 884.755n 1.1v 889.745n 1.1v 889.755n 1.1v 894.745n 1.1v 894.755n 1.1v 899.745n 1.1v 899.755n 1.1v 904.745n 1.1v 904.755n 1.1v 909.745n 1.1v 909.755n 1.1v 914.745n 1.1v 914.755n 1.1v 919.745n 1.1v 919.755n 1.1v 924.745n 1.1v 924.755n 1.1v 929.745n 1.1v 929.755n 1.1v 934.745n 1.1v 934.755n 1.1v 939.745n 1.1v 939.755n 1.1v 944.745n 1.1v 944.755n 1.1v 949.745n 1.1v 949.755n 1.1v 954.745n 1.1v 954.755n 1.1v 959.745n 1.1v 959.755n 1.1v 964.745n 1.1v 964.755n 0.0v 969.745n 0.0v 969.755n 0.0v 974.745n 0.0v 974.755n 0.0v 979.745n 0.0v 979.755n 0.0v 984.745n 0.0v 984.755n 1.1v 989.745n 1.1v 989.755n 1.1v 994.745n 1.1v 994.755n 1.1v 999.745n 1.1v 999.755n 1.1v 1004.745n 1.1v 1004.755n 1.1v 1009.745n 1.1v 1009.755n 1.1v 1014.745n 1.1v 1014.755n 1.1v 1019.745n 1.1v 1019.755n 1.1v 1024.745n 1.1v 1024.755n 1.1v )
* (time, data): [(0, 0), (5, 1), (10, 1), (15, 1), (20, 1), (25, 1), (30, 1), (35, 1), (40, 0), (45, 0), (50, 0), (55, 0), (60, 1), (65, 0), (70, 0), (75, 0), (80, 0), (85, 0), (90, 1), (95, 1), (100, 1), (105, 1), (110, 1), (115, 1), (120, 1), (125, 1), (130, 1), (135, 1), (140, 1), (145, 1), (150, 1), (155, 1), (160, 1), (165, 1), (170, 0), (175, 0), (180, 0), (185, 1), (190, 1), (195, 1), (200, 0), (205, 0), (210, 1), (215, 1), (220, 1), (225, 1), (230, 0), (235, 0), (240, 1), (245, 1), (250, 1), (255, 0), (260, 0), (265, 0), (270, 0), (275, 0), (280, 1), (285, 1), (290, 1), (295, 1), (300, 1), (305, 1), (310, 1), (315, 1), (320, 1), (325, 1), (330, 1), (335, 1), (340, 0), (345, 0), (350, 0), (355, 0), (360, 1), (365, 1), (370, 1), (375, 1), (380, 1), (385, 1), (390, 1), (395, 1), (400, 1), (405, 1), (410, 1), (415, 1), (420, 1), (425, 1), (430, 1), (435, 1), (440, 1), (445, 1), (450, 1), (455, 1), (460, 0), (465, 1), (470, 1), (475, 1), (480, 1), (485, 1), (490, 1), (495, 1), (500, 0), (505, 1), (510, 1), (515, 1), (520, 1), (525, 1), (530, 1), (535, 1), (540, 1), (545, 1), (550, 1), (555, 1), (560, 1), (565, 1), (570, 1), (575, 1), (580, 1), (585, 1), (590, 1), (595, 1), (600, 1), (605, 1), (610, 1), (615, 1), (620, 1), (625, 1), (630, 0), (635, 1), (640, 0), (645, 0), (650, 0), (655, 0), (660, 0), (665, 0), (670, 0), (675, 0), (680, 0), (685, 0), (690, 0), (695, 0), (700, 0), (705, 1), (710, 1), (715, 0), (720, 0), (725, 0), (730, 0), (735, 1), (740, 1), (745, 1), (750, 1), (755, 0), (760, 0), (765, 0), (770, 1), (775, 0), (780, 0), (785, 1), (790, 1), (795, 1), (800, 1), (805, 1), (810, 1), (815, 1), (820, 0), (825, 0), (830, 0), (835, 1), (840, 1), (845, 1), (850, 1), (855, 1), (860, 1), (865, 1), (870, 0), (875, 1), (880, 1), (885, 0), (890, 0), (895, 0), (900, 0), (905, 0), (910, 1), (915, 1), (920, 1), (925, 1), (930, 1), (935, 1), (940, 1), (945, 1), (950, 1), (955, 1), (960, 1), (965, 1), (970, 1), (975, 1), (980, 0), (985, 1), (990, 1), (995, 1), (1000, 1), (1005, 1), (1010, 1), (1015, 1), (1020, 1), (1025, 1)]
VWMASK0_6  WMASK0_6  0 PWL (0n 0.0v 4.745n 0.0v 4.755n 1.1v 9.745n 1.1v 9.755n 1.1v 14.745n 1.1v 14.755n 1.1v 19.745n 1.1v 19.755n 1.1v 24.745n 1.1v 24.755n 1.1v 29.745n 1.1v 29.755n 1.1v 34.745n 1.1v 34.755n 1.1v 39.745n 1.1v 39.755n 0.0v 44.745n 0.0v 44.755n 0.0v 49.745n 0.0v 49.755n 0.0v 54.745n 0.0v 54.755n 0.0v 59.745n 0.0v 59.755n 1.1v 64.745n 1.1v 64.755n 0.0v 69.745n 0.0v 69.755n 0.0v 74.745n 0.0v 74.755n 0.0v 79.745n 0.0v 79.755n 0.0v 84.745n 0.0v 84.755n 0.0v 89.745n 0.0v 89.755n 1.1v 94.745n 1.1v 94.755n 1.1v 99.745n 1.1v 99.755n 1.1v 104.745n 1.1v 104.755n 1.1v 109.745n 1.1v 109.755n 1.1v 114.745n 1.1v 114.755n 1.1v 119.745n 1.1v 119.755n 1.1v 124.745n 1.1v 124.755n 1.1v 129.745n 1.1v 129.755n 1.1v 134.745n 1.1v 134.755n 1.1v 139.745n 1.1v 139.755n 1.1v 144.745n 1.1v 144.755n 1.1v 149.745n 1.1v 149.755n 1.1v 154.745n 1.1v 154.755n 1.1v 159.745n 1.1v 159.755n 1.1v 164.745n 1.1v 164.755n 1.1v 169.745n 1.1v 169.755n 0.0v 174.745n 0.0v 174.755n 0.0v 179.745n 0.0v 179.755n 0.0v 184.745n 0.0v 184.755n 1.1v 189.745n 1.1v 189.755n 1.1v 194.745n 1.1v 194.755n 1.1v 199.745n 1.1v 199.755n 0.0v 204.745n 0.0v 204.755n 0.0v 209.745n 0.0v 209.755n 1.1v 214.745n 1.1v 214.755n 1.1v 219.745n 1.1v 219.755n 1.1v 224.745n 1.1v 224.755n 1.1v 229.745n 1.1v 229.755n 0.0v 234.745n 0.0v 234.755n 0.0v 239.745n 0.0v 239.755n 1.1v 244.745n 1.1v 244.755n 1.1v 249.745n 1.1v 249.755n 1.1v 254.745n 1.1v 254.755n 0.0v 259.745n 0.0v 259.755n 0.0v 264.745n 0.0v 264.755n 0.0v 269.745n 0.0v 269.755n 0.0v 274.745n 0.0v 274.755n 0.0v 279.745n 0.0v 279.755n 1.1v 284.745n 1.1v 284.755n 1.1v 289.745n 1.1v 289.755n 1.1v 294.745n 1.1v 294.755n 1.1v 299.745n 1.1v 299.755n 1.1v 304.745n 1.1v 304.755n 1.1v 309.745n 1.1v 309.755n 1.1v 314.745n 1.1v 314.755n 1.1v 319.745n 1.1v 319.755n 1.1v 324.745n 1.1v 324.755n 1.1v 329.745n 1.1v 329.755n 1.1v 334.745n 1.1v 334.755n 1.1v 339.745n 1.1v 339.755n 0.0v 344.745n 0.0v 344.755n 0.0v 349.745n 0.0v 349.755n 0.0v 354.745n 0.0v 354.755n 0.0v 359.745n 0.0v 359.755n 1.1v 364.745n 1.1v 364.755n 1.1v 369.745n 1.1v 369.755n 1.1v 374.745n 1.1v 374.755n 1.1v 379.745n 1.1v 379.755n 1.1v 384.745n 1.1v 384.755n 1.1v 389.745n 1.1v 389.755n 1.1v 394.745n 1.1v 394.755n 1.1v 399.745n 1.1v 399.755n 1.1v 404.745n 1.1v 404.755n 1.1v 409.745n 1.1v 409.755n 1.1v 414.745n 1.1v 414.755n 1.1v 419.745n 1.1v 419.755n 1.1v 424.745n 1.1v 424.755n 1.1v 429.745n 1.1v 429.755n 1.1v 434.745n 1.1v 434.755n 1.1v 439.745n 1.1v 439.755n 1.1v 444.745n 1.1v 444.755n 1.1v 449.745n 1.1v 449.755n 1.1v 454.745n 1.1v 454.755n 1.1v 459.745n 1.1v 459.755n 0.0v 464.745n 0.0v 464.755n 1.1v 469.745n 1.1v 469.755n 1.1v 474.745n 1.1v 474.755n 1.1v 479.745n 1.1v 479.755n 1.1v 484.745n 1.1v 484.755n 1.1v 489.745n 1.1v 489.755n 1.1v 494.745n 1.1v 494.755n 1.1v 499.745n 1.1v 499.755n 0.0v 504.745n 0.0v 504.755n 1.1v 509.745n 1.1v 509.755n 1.1v 514.745n 1.1v 514.755n 1.1v 519.745n 1.1v 519.755n 1.1v 524.745n 1.1v 524.755n 1.1v 529.745n 1.1v 529.755n 1.1v 534.745n 1.1v 534.755n 1.1v 539.745n 1.1v 539.755n 1.1v 544.745n 1.1v 544.755n 1.1v 549.745n 1.1v 549.755n 1.1v 554.745n 1.1v 554.755n 1.1v 559.745n 1.1v 559.755n 1.1v 564.745n 1.1v 564.755n 1.1v 569.745n 1.1v 569.755n 1.1v 574.745n 1.1v 574.755n 1.1v 579.745n 1.1v 579.755n 1.1v 584.745n 1.1v 584.755n 1.1v 589.745n 1.1v 589.755n 1.1v 594.745n 1.1v 594.755n 1.1v 599.745n 1.1v 599.755n 1.1v 604.745n 1.1v 604.755n 1.1v 609.745n 1.1v 609.755n 1.1v 614.745n 1.1v 614.755n 1.1v 619.745n 1.1v 619.755n 1.1v 624.745n 1.1v 624.755n 1.1v 629.745n 1.1v 629.755n 0.0v 634.745n 0.0v 634.755n 1.1v 639.745n 1.1v 639.755n 0.0v 644.745n 0.0v 644.755n 0.0v 649.745n 0.0v 649.755n 0.0v 654.745n 0.0v 654.755n 0.0v 659.745n 0.0v 659.755n 0.0v 664.745n 0.0v 664.755n 0.0v 669.745n 0.0v 669.755n 0.0v 674.745n 0.0v 674.755n 0.0v 679.745n 0.0v 679.755n 0.0v 684.745n 0.0v 684.755n 0.0v 689.745n 0.0v 689.755n 0.0v 694.745n 0.0v 694.755n 0.0v 699.745n 0.0v 699.755n 0.0v 704.745n 0.0v 704.755n 1.1v 709.745n 1.1v 709.755n 1.1v 714.745n 1.1v 714.755n 0.0v 719.745n 0.0v 719.755n 0.0v 724.745n 0.0v 724.755n 0.0v 729.745n 0.0v 729.755n 0.0v 734.745n 0.0v 734.755n 1.1v 739.745n 1.1v 739.755n 1.1v 744.745n 1.1v 744.755n 1.1v 749.745n 1.1v 749.755n 1.1v 754.745n 1.1v 754.755n 0.0v 759.745n 0.0v 759.755n 0.0v 764.745n 0.0v 764.755n 0.0v 769.745n 0.0v 769.755n 1.1v 774.745n 1.1v 774.755n 0.0v 779.745n 0.0v 779.755n 0.0v 784.745n 0.0v 784.755n 1.1v 789.745n 1.1v 789.755n 1.1v 794.745n 1.1v 794.755n 1.1v 799.745n 1.1v 799.755n 1.1v 804.745n 1.1v 804.755n 1.1v 809.745n 1.1v 809.755n 1.1v 814.745n 1.1v 814.755n 1.1v 819.745n 1.1v 819.755n 0.0v 824.745n 0.0v 824.755n 0.0v 829.745n 0.0v 829.755n 0.0v 834.745n 0.0v 834.755n 1.1v 839.745n 1.1v 839.755n 1.1v 844.745n 1.1v 844.755n 1.1v 849.745n 1.1v 849.755n 1.1v 854.745n 1.1v 854.755n 1.1v 859.745n 1.1v 859.755n 1.1v 864.745n 1.1v 864.755n 1.1v 869.745n 1.1v 869.755n 0.0v 874.745n 0.0v 874.755n 1.1v 879.745n 1.1v 879.755n 1.1v 884.745n 1.1v 884.755n 0.0v 889.745n 0.0v 889.755n 0.0v 894.745n 0.0v 894.755n 0.0v 899.745n 0.0v 899.755n 0.0v 904.745n 0.0v 904.755n 0.0v 909.745n 0.0v 909.755n 1.1v 914.745n 1.1v 914.755n 1.1v 919.745n 1.1v 919.755n 1.1v 924.745n 1.1v 924.755n 1.1v 929.745n 1.1v 929.755n 1.1v 934.745n 1.1v 934.755n 1.1v 939.745n 1.1v 939.755n 1.1v 944.745n 1.1v 944.755n 1.1v 949.745n 1.1v 949.755n 1.1v 954.745n 1.1v 954.755n 1.1v 959.745n 1.1v 959.755n 1.1v 964.745n 1.1v 964.755n 1.1v 969.745n 1.1v 969.755n 1.1v 974.745n 1.1v 974.755n 1.1v 979.745n 1.1v 979.755n 0.0v 984.745n 0.0v 984.755n 1.1v 989.745n 1.1v 989.755n 1.1v 994.745n 1.1v 994.755n 1.1v 999.745n 1.1v 999.755n 1.1v 1004.745n 1.1v 1004.755n 1.1v 1009.745n 1.1v 1009.755n 1.1v 1014.745n 1.1v 1014.755n 1.1v 1019.745n 1.1v 1019.755n 1.1v 1024.745n 1.1v 1024.755n 1.1v )
* (time, data): [(0, 0), (5, 1), (10, 1), (15, 1), (20, 1), (25, 1), (30, 1), (35, 1), (40, 1), (45, 0), (50, 0), (55, 0), (60, 1), (65, 1), (70, 1), (75, 1), (80, 1), (85, 1), (90, 1), (95, 1), (100, 0), (105, 0), (110, 0), (115, 0), (120, 0), (125, 0), (130, 0), (135, 1), (140, 0), (145, 0), (150, 0), (155, 0), (160, 0), (165, 0), (170, 0), (175, 0), (180, 0), (185, 1), (190, 1), (195, 1), (200, 0), (205, 0), (210, 0), (215, 0), (220, 1), (225, 1), (230, 0), (235, 0), (240, 1), (245, 1), (250, 1), (255, 0), (260, 0), (265, 1), (270, 1), (275, 1), (280, 1), (285, 1), (290, 1), (295, 1), (300, 1), (305, 1), (310, 1), (315, 1), (320, 1), (325, 1), (330, 1), (335, 1), (340, 0), (345, 0), (350, 0), (355, 0), (360, 0), (365, 0), (370, 0), (375, 0), (380, 0), (385, 0), (390, 0), (395, 1), (400, 1), (405, 1), (410, 1), (415, 0), (420, 0), (425, 1), (430, 1), (435, 1), (440, 1), (445, 1), (450, 1), (455, 1), (460, 1), (465, 1), (470, 1), (475, 1), (480, 1), (485, 1), (490, 1), (495, 1), (500, 0), (505, 1), (510, 1), (515, 1), (520, 1), (525, 1), (530, 1), (535, 1), (540, 1), (545, 1), (550, 1), (555, 1), (560, 1), (565, 1), (570, 1), (575, 1), (580, 1), (585, 1), (590, 1), (595, 1), (600, 1), (605, 1), (610, 1), (615, 1), (620, 1), (625, 1), (630, 0), (635, 1), (640, 0), (645, 0), (650, 0), (655, 0), (660, 0), (665, 0), (670, 1), (675, 1), (680, 1), (685, 1), (690, 1), (695, 1), (700, 1), (705, 1), (710, 1), (715, 0), (720, 0), (725, 0), (730, 0), (735, 1), (740, 1), (745, 1), (750, 1), (755, 0), (760, 0), (765, 0), (770, 1), (775, 1), (780, 1), (785, 1), (790, 1), (795, 1), (800, 1), (805, 1), (810, 1), (815, 1), (820, 0), (825, 0), (830, 1), (835, 1), (840, 1), (845, 1), (850, 1), (855, 1), (860, 1), (865, 1), (870, 1), (875, 1), (880, 1), (885, 1), (890, 1), (895, 1), (900, 1), (905, 1), (910, 1), (915, 1), (920, 1), (925, 1), (930, 1), (935, 1), (940, 1), (945, 1), (950, 1), (955, 1), (960, 1), (965, 0), (970, 0), (975, 0), (980, 1), (985, 1), (990, 1), (995, 1), (1000, 1), (1005, 1), (1010, 1), (1015, 1), (1020, 1), (1025, 1)]
VWMASK0_7  WMASK0_7  0 PWL (0n 0.0v 4.745n 0.0v 4.755n 1.1v 9.745n 1.1v 9.755n 1.1v 14.745n 1.1v 14.755n 1.1v 19.745n 1.1v 19.755n 1.1v 24.745n 1.1v 24.755n 1.1v 29.745n 1.1v 29.755n 1.1v 34.745n 1.1v 34.755n 1.1v 39.745n 1.1v 39.755n 1.1v 44.745n 1.1v 44.755n 0.0v 49.745n 0.0v 49.755n 0.0v 54.745n 0.0v 54.755n 0.0v 59.745n 0.0v 59.755n 1.1v 64.745n 1.1v 64.755n 1.1v 69.745n 1.1v 69.755n 1.1v 74.745n 1.1v 74.755n 1.1v 79.745n 1.1v 79.755n 1.1v 84.745n 1.1v 84.755n 1.1v 89.745n 1.1v 89.755n 1.1v 94.745n 1.1v 94.755n 1.1v 99.745n 1.1v 99.755n 0.0v 104.745n 0.0v 104.755n 0.0v 109.745n 0.0v 109.755n 0.0v 114.745n 0.0v 114.755n 0.0v 119.745n 0.0v 119.755n 0.0v 124.745n 0.0v 124.755n 0.0v 129.745n 0.0v 129.755n 0.0v 134.745n 0.0v 134.755n 1.1v 139.745n 1.1v 139.755n 0.0v 144.745n 0.0v 144.755n 0.0v 149.745n 0.0v 149.755n 0.0v 154.745n 0.0v 154.755n 0.0v 159.745n 0.0v 159.755n 0.0v 164.745n 0.0v 164.755n 0.0v 169.745n 0.0v 169.755n 0.0v 174.745n 0.0v 174.755n 0.0v 179.745n 0.0v 179.755n 0.0v 184.745n 0.0v 184.755n 1.1v 189.745n 1.1v 189.755n 1.1v 194.745n 1.1v 194.755n 1.1v 199.745n 1.1v 199.755n 0.0v 204.745n 0.0v 204.755n 0.0v 209.745n 0.0v 209.755n 0.0v 214.745n 0.0v 214.755n 0.0v 219.745n 0.0v 219.755n 1.1v 224.745n 1.1v 224.755n 1.1v 229.745n 1.1v 229.755n 0.0v 234.745n 0.0v 234.755n 0.0v 239.745n 0.0v 239.755n 1.1v 244.745n 1.1v 244.755n 1.1v 249.745n 1.1v 249.755n 1.1v 254.745n 1.1v 254.755n 0.0v 259.745n 0.0v 259.755n 0.0v 264.745n 0.0v 264.755n 1.1v 269.745n 1.1v 269.755n 1.1v 274.745n 1.1v 274.755n 1.1v 279.745n 1.1v 279.755n 1.1v 284.745n 1.1v 284.755n 1.1v 289.745n 1.1v 289.755n 1.1v 294.745n 1.1v 294.755n 1.1v 299.745n 1.1v 299.755n 1.1v 304.745n 1.1v 304.755n 1.1v 309.745n 1.1v 309.755n 1.1v 314.745n 1.1v 314.755n 1.1v 319.745n 1.1v 319.755n 1.1v 324.745n 1.1v 324.755n 1.1v 329.745n 1.1v 329.755n 1.1v 334.745n 1.1v 334.755n 1.1v 339.745n 1.1v 339.755n 0.0v 344.745n 0.0v 344.755n 0.0v 349.745n 0.0v 349.755n 0.0v 354.745n 0.0v 354.755n 0.0v 359.745n 0.0v 359.755n 0.0v 364.745n 0.0v 364.755n 0.0v 369.745n 0.0v 369.755n 0.0v 374.745n 0.0v 374.755n 0.0v 379.745n 0.0v 379.755n 0.0v 384.745n 0.0v 384.755n 0.0v 389.745n 0.0v 389.755n 0.0v 394.745n 0.0v 394.755n 1.1v 399.745n 1.1v 399.755n 1.1v 404.745n 1.1v 404.755n 1.1v 409.745n 1.1v 409.755n 1.1v 414.745n 1.1v 414.755n 0.0v 419.745n 0.0v 419.755n 0.0v 424.745n 0.0v 424.755n 1.1v 429.745n 1.1v 429.755n 1.1v 434.745n 1.1v 434.755n 1.1v 439.745n 1.1v 439.755n 1.1v 444.745n 1.1v 444.755n 1.1v 449.745n 1.1v 449.755n 1.1v 454.745n 1.1v 454.755n 1.1v 459.745n 1.1v 459.755n 1.1v 464.745n 1.1v 464.755n 1.1v 469.745n 1.1v 469.755n 1.1v 474.745n 1.1v 474.755n 1.1v 479.745n 1.1v 479.755n 1.1v 484.745n 1.1v 484.755n 1.1v 489.745n 1.1v 489.755n 1.1v 494.745n 1.1v 494.755n 1.1v 499.745n 1.1v 499.755n 0.0v 504.745n 0.0v 504.755n 1.1v 509.745n 1.1v 509.755n 1.1v 514.745n 1.1v 514.755n 1.1v 519.745n 1.1v 519.755n 1.1v 524.745n 1.1v 524.755n 1.1v 529.745n 1.1v 529.755n 1.1v 534.745n 1.1v 534.755n 1.1v 539.745n 1.1v 539.755n 1.1v 544.745n 1.1v 544.755n 1.1v 549.745n 1.1v 549.755n 1.1v 554.745n 1.1v 554.755n 1.1v 559.745n 1.1v 559.755n 1.1v 564.745n 1.1v 564.755n 1.1v 569.745n 1.1v 569.755n 1.1v 574.745n 1.1v 574.755n 1.1v 579.745n 1.1v 579.755n 1.1v 584.745n 1.1v 584.755n 1.1v 589.745n 1.1v 589.755n 1.1v 594.745n 1.1v 594.755n 1.1v 599.745n 1.1v 599.755n 1.1v 604.745n 1.1v 604.755n 1.1v 609.745n 1.1v 609.755n 1.1v 614.745n 1.1v 614.755n 1.1v 619.745n 1.1v 619.755n 1.1v 624.745n 1.1v 624.755n 1.1v 629.745n 1.1v 629.755n 0.0v 634.745n 0.0v 634.755n 1.1v 639.745n 1.1v 639.755n 0.0v 644.745n 0.0v 644.755n 0.0v 649.745n 0.0v 649.755n 0.0v 654.745n 0.0v 654.755n 0.0v 659.745n 0.0v 659.755n 0.0v 664.745n 0.0v 664.755n 0.0v 669.745n 0.0v 669.755n 1.1v 674.745n 1.1v 674.755n 1.1v 679.745n 1.1v 679.755n 1.1v 684.745n 1.1v 684.755n 1.1v 689.745n 1.1v 689.755n 1.1v 694.745n 1.1v 694.755n 1.1v 699.745n 1.1v 699.755n 1.1v 704.745n 1.1v 704.755n 1.1v 709.745n 1.1v 709.755n 1.1v 714.745n 1.1v 714.755n 0.0v 719.745n 0.0v 719.755n 0.0v 724.745n 0.0v 724.755n 0.0v 729.745n 0.0v 729.755n 0.0v 734.745n 0.0v 734.755n 1.1v 739.745n 1.1v 739.755n 1.1v 744.745n 1.1v 744.755n 1.1v 749.745n 1.1v 749.755n 1.1v 754.745n 1.1v 754.755n 0.0v 759.745n 0.0v 759.755n 0.0v 764.745n 0.0v 764.755n 0.0v 769.745n 0.0v 769.755n 1.1v 774.745n 1.1v 774.755n 1.1v 779.745n 1.1v 779.755n 1.1v 784.745n 1.1v 784.755n 1.1v 789.745n 1.1v 789.755n 1.1v 794.745n 1.1v 794.755n 1.1v 799.745n 1.1v 799.755n 1.1v 804.745n 1.1v 804.755n 1.1v 809.745n 1.1v 809.755n 1.1v 814.745n 1.1v 814.755n 1.1v 819.745n 1.1v 819.755n 0.0v 824.745n 0.0v 824.755n 0.0v 829.745n 0.0v 829.755n 1.1v 834.745n 1.1v 834.755n 1.1v 839.745n 1.1v 839.755n 1.1v 844.745n 1.1v 844.755n 1.1v 849.745n 1.1v 849.755n 1.1v 854.745n 1.1v 854.755n 1.1v 859.745n 1.1v 859.755n 1.1v 864.745n 1.1v 864.755n 1.1v 869.745n 1.1v 869.755n 1.1v 874.745n 1.1v 874.755n 1.1v 879.745n 1.1v 879.755n 1.1v 884.745n 1.1v 884.755n 1.1v 889.745n 1.1v 889.755n 1.1v 894.745n 1.1v 894.755n 1.1v 899.745n 1.1v 899.755n 1.1v 904.745n 1.1v 904.755n 1.1v 909.745n 1.1v 909.755n 1.1v 914.745n 1.1v 914.755n 1.1v 919.745n 1.1v 919.755n 1.1v 924.745n 1.1v 924.755n 1.1v 929.745n 1.1v 929.755n 1.1v 934.745n 1.1v 934.755n 1.1v 939.745n 1.1v 939.755n 1.1v 944.745n 1.1v 944.755n 1.1v 949.745n 1.1v 949.755n 1.1v 954.745n 1.1v 954.755n 1.1v 959.745n 1.1v 959.755n 1.1v 964.745n 1.1v 964.755n 0.0v 969.745n 0.0v 969.755n 0.0v 974.745n 0.0v 974.755n 0.0v 979.745n 0.0v 979.755n 1.1v 984.745n 1.1v 984.755n 1.1v 989.745n 1.1v 989.755n 1.1v 994.745n 1.1v 994.755n 1.1v 999.745n 1.1v 999.755n 1.1v 1004.745n 1.1v 1004.755n 1.1v 1009.745n 1.1v 1009.755n 1.1v 1014.745n 1.1v 1014.755n 1.1v 1019.745n 1.1v 1019.755n 1.1v 1024.745n 1.1v 1024.755n 1.1v )
* PULSE: period=5
Vclk0 clk0 0 PULSE (0 1.1 4.995n 0.01n 0.01n 2.49n 5n)

 * Generation of dout measurements
* CHECK dout0_0 vdout0_0ck4 = 0 time = 25
* CHECK dout0_1 vdout0_1ck4 = 0 time = 25
* CHECK dout0_2 vdout0_2ck4 = 1.1 time = 25
* CHECK dout0_3 vdout0_3ck4 = 0 time = 25
* CHECK dout0_4 vdout0_4ck4 = 1.1 time = 25
* CHECK dout0_5 vdout0_5ck4 = 0 time = 25
* CHECK dout0_6 vdout0_6ck4 = 0 time = 25
* CHECK dout0_7 vdout0_7ck4 = 0 time = 25
* CHECK dout0_8 vdout0_8ck4 = 0 time = 25
* CHECK dout0_9 vdout0_9ck4 = 0 time = 25
* CHECK dout0_10 vdout0_10ck4 = 0 time = 25
* CHECK dout0_11 vdout0_11ck4 = 1.1 time = 25
* CHECK dout0_12 vdout0_12ck4 = 0 time = 25
* CHECK dout0_13 vdout0_13ck4 = 1.1 time = 25
* CHECK dout0_14 vdout0_14ck4 = 0 time = 25
* CHECK dout0_15 vdout0_15ck4 = 1.1 time = 25
* CHECK dout0_16 vdout0_16ck4 = 0 time = 25
* CHECK dout0_17 vdout0_17ck4 = 1.1 time = 25
* CHECK dout0_18 vdout0_18ck4 = 1.1 time = 25
* CHECK dout0_19 vdout0_19ck4 = 0 time = 25
* CHECK dout0_20 vdout0_20ck4 = 1.1 time = 25
* CHECK dout0_21 vdout0_21ck4 = 0 time = 25
* CHECK dout0_22 vdout0_22ck4 = 0 time = 25
* CHECK dout0_23 vdout0_23ck4 = 0 time = 25
* CHECK dout0_24 vdout0_24ck4 = 1.1 time = 25
* CHECK dout0_25 vdout0_25ck4 = 1.1 time = 25
* CHECK dout0_26 vdout0_26ck4 = 0 time = 25
* CHECK dout0_27 vdout0_27ck4 = 1.1 time = 25
* CHECK dout0_28 vdout0_28ck4 = 0 time = 25
* CHECK dout0_29 vdout0_29ck4 = 1.1 time = 25
* CHECK dout0_30 vdout0_30ck4 = 1.1 time = 25
* CHECK dout0_31 vdout0_31ck4 = 1.1 time = 25
* CHECK dout0_32 vdout0_32ck4 = 0 time = 25
* CHECK dout0_33 vdout0_33ck4 = 0 time = 25
* CHECK dout0_34 vdout0_34ck4 = 1.1 time = 25
* CHECK dout0_35 vdout0_35ck4 = 1.1 time = 25
* CHECK dout0_36 vdout0_36ck4 = 0 time = 25
* CHECK dout0_37 vdout0_37ck4 = 1.1 time = 25
* CHECK dout0_38 vdout0_38ck4 = 0 time = 25
* CHECK dout0_39 vdout0_39ck4 = 0 time = 25
* CHECK dout0_40 vdout0_40ck4 = 0 time = 25
* CHECK dout0_41 vdout0_41ck4 = 1.1 time = 25
* CHECK dout0_42 vdout0_42ck4 = 0 time = 25
* CHECK dout0_43 vdout0_43ck4 = 1.1 time = 25
* CHECK dout0_44 vdout0_44ck4 = 0 time = 25
* CHECK dout0_45 vdout0_45ck4 = 0 time = 25
* CHECK dout0_46 vdout0_46ck4 = 1.1 time = 25
* CHECK dout0_47 vdout0_47ck4 = 0 time = 25
* CHECK dout0_48 vdout0_48ck4 = 1.1 time = 25
* CHECK dout0_49 vdout0_49ck4 = 0 time = 25
* CHECK dout0_50 vdout0_50ck4 = 0 time = 25
* CHECK dout0_51 vdout0_51ck4 = 0 time = 25
* CHECK dout0_52 vdout0_52ck4 = 0 time = 25
* CHECK dout0_53 vdout0_53ck4 = 1.1 time = 25
* CHECK dout0_54 vdout0_54ck4 = 0 time = 25
* CHECK dout0_55 vdout0_55ck4 = 1.1 time = 25
* CHECK dout0_56 vdout0_56ck4 = 1.1 time = 25
* CHECK dout0_57 vdout0_57ck4 = 0 time = 25
* CHECK dout0_58 vdout0_58ck4 = 0 time = 25
* CHECK dout0_59 vdout0_59ck4 = 0 time = 25
* CHECK dout0_60 vdout0_60ck4 = 1.1 time = 25
* CHECK dout0_61 vdout0_61ck4 = 0 time = 25
* CHECK dout0_62 vdout0_62ck4 = 1.1 time = 25
* CHECK dout0_63 vdout0_63ck4 = 0 time = 25
* CHECK dout0_0 vdout0_0ck10 = 1.1 time = 55
* CHECK dout0_1 vdout0_1ck10 = 0 time = 55
* CHECK dout0_2 vdout0_2ck10 = 0 time = 55
* CHECK dout0_3 vdout0_3ck10 = 1.1 time = 55
* CHECK dout0_4 vdout0_4ck10 = 0 time = 55
* CHECK dout0_5 vdout0_5ck10 = 0 time = 55
* CHECK dout0_6 vdout0_6ck10 = 1.1 time = 55
* CHECK dout0_7 vdout0_7ck10 = 1.1 time = 55
* CHECK dout0_8 vdout0_8ck10 = 0 time = 55
* CHECK dout0_9 vdout0_9ck10 = 1.1 time = 55
* CHECK dout0_10 vdout0_10ck10 = 1.1 time = 55
* CHECK dout0_11 vdout0_11ck10 = 1.1 time = 55
* CHECK dout0_12 vdout0_12ck10 = 0 time = 55
* CHECK dout0_13 vdout0_13ck10 = 1.1 time = 55
* CHECK dout0_14 vdout0_14ck10 = 1.1 time = 55
* CHECK dout0_15 vdout0_15ck10 = 0 time = 55
* CHECK dout0_16 vdout0_16ck10 = 1.1 time = 55
* CHECK dout0_17 vdout0_17ck10 = 0 time = 55
* CHECK dout0_18 vdout0_18ck10 = 0 time = 55
* CHECK dout0_19 vdout0_19ck10 = 0 time = 55
* CHECK dout0_20 vdout0_20ck10 = 1.1 time = 55
* CHECK dout0_21 vdout0_21ck10 = 0 time = 55
* CHECK dout0_22 vdout0_22ck10 = 1.1 time = 55
* CHECK dout0_23 vdout0_23ck10 = 1.1 time = 55
* CHECK dout0_24 vdout0_24ck10 = 0 time = 55
* CHECK dout0_25 vdout0_25ck10 = 0 time = 55
* CHECK dout0_26 vdout0_26ck10 = 1.1 time = 55
* CHECK dout0_27 vdout0_27ck10 = 0 time = 55
* CHECK dout0_28 vdout0_28ck10 = 1.1 time = 55
* CHECK dout0_29 vdout0_29ck10 = 1.1 time = 55
* CHECK dout0_30 vdout0_30ck10 = 0 time = 55
* CHECK dout0_31 vdout0_31ck10 = 0 time = 55
* CHECK dout0_32 vdout0_32ck10 = 0 time = 55
* CHECK dout0_33 vdout0_33ck10 = 1.1 time = 55
* CHECK dout0_34 vdout0_34ck10 = 1.1 time = 55
* CHECK dout0_35 vdout0_35ck10 = 1.1 time = 55
* CHECK dout0_36 vdout0_36ck10 = 0 time = 55
* CHECK dout0_37 vdout0_37ck10 = 1.1 time = 55
* CHECK dout0_38 vdout0_38ck10 = 1.1 time = 55
* CHECK dout0_39 vdout0_39ck10 = 0 time = 55
* CHECK dout0_40 vdout0_40ck10 = 1.1 time = 55
* CHECK dout0_41 vdout0_41ck10 = 0 time = 55
* CHECK dout0_42 vdout0_42ck10 = 1.1 time = 55
* CHECK dout0_43 vdout0_43ck10 = 1.1 time = 55
* CHECK dout0_44 vdout0_44ck10 = 1.1 time = 55
* CHECK dout0_45 vdout0_45ck10 = 0 time = 55
* CHECK dout0_46 vdout0_46ck10 = 0 time = 55
* CHECK dout0_47 vdout0_47ck10 = 0 time = 55
* CHECK dout0_48 vdout0_48ck10 = 1.1 time = 55
* CHECK dout0_49 vdout0_49ck10 = 0 time = 55
* CHECK dout0_50 vdout0_50ck10 = 0 time = 55
* CHECK dout0_51 vdout0_51ck10 = 1.1 time = 55
* CHECK dout0_52 vdout0_52ck10 = 1.1 time = 55
* CHECK dout0_53 vdout0_53ck10 = 0 time = 55
* CHECK dout0_54 vdout0_54ck10 = 0 time = 55
* CHECK dout0_55 vdout0_55ck10 = 0 time = 55
* CHECK dout0_56 vdout0_56ck10 = 0 time = 55
* CHECK dout0_57 vdout0_57ck10 = 0 time = 55
* CHECK dout0_58 vdout0_58ck10 = 0 time = 55
* CHECK dout0_59 vdout0_59ck10 = 1.1 time = 55
* CHECK dout0_60 vdout0_60ck10 = 1.1 time = 55
* CHECK dout0_61 vdout0_61ck10 = 1.1 time = 55
* CHECK dout0_62 vdout0_62ck10 = 1.1 time = 55
* CHECK dout0_63 vdout0_63ck10 = 0 time = 55
* CHECK dout0_0 vdout0_0ck11 = 1.1 time = 60
* CHECK dout0_1 vdout0_1ck11 = 0 time = 60
* CHECK dout0_2 vdout0_2ck11 = 0 time = 60
* CHECK dout0_3 vdout0_3ck11 = 1.1 time = 60
* CHECK dout0_4 vdout0_4ck11 = 0 time = 60
* CHECK dout0_5 vdout0_5ck11 = 0 time = 60
* CHECK dout0_6 vdout0_6ck11 = 1.1 time = 60
* CHECK dout0_7 vdout0_7ck11 = 1.1 time = 60
* CHECK dout0_8 vdout0_8ck11 = 0 time = 60
* CHECK dout0_9 vdout0_9ck11 = 1.1 time = 60
* CHECK dout0_10 vdout0_10ck11 = 1.1 time = 60
* CHECK dout0_11 vdout0_11ck11 = 1.1 time = 60
* CHECK dout0_12 vdout0_12ck11 = 0 time = 60
* CHECK dout0_13 vdout0_13ck11 = 1.1 time = 60
* CHECK dout0_14 vdout0_14ck11 = 1.1 time = 60
* CHECK dout0_15 vdout0_15ck11 = 0 time = 60
* CHECK dout0_16 vdout0_16ck11 = 1.1 time = 60
* CHECK dout0_17 vdout0_17ck11 = 0 time = 60
* CHECK dout0_18 vdout0_18ck11 = 0 time = 60
* CHECK dout0_19 vdout0_19ck11 = 0 time = 60
* CHECK dout0_20 vdout0_20ck11 = 1.1 time = 60
* CHECK dout0_21 vdout0_21ck11 = 0 time = 60
* CHECK dout0_22 vdout0_22ck11 = 1.1 time = 60
* CHECK dout0_23 vdout0_23ck11 = 1.1 time = 60
* CHECK dout0_24 vdout0_24ck11 = 0 time = 60
* CHECK dout0_25 vdout0_25ck11 = 0 time = 60
* CHECK dout0_26 vdout0_26ck11 = 1.1 time = 60
* CHECK dout0_27 vdout0_27ck11 = 0 time = 60
* CHECK dout0_28 vdout0_28ck11 = 1.1 time = 60
* CHECK dout0_29 vdout0_29ck11 = 1.1 time = 60
* CHECK dout0_30 vdout0_30ck11 = 0 time = 60
* CHECK dout0_31 vdout0_31ck11 = 0 time = 60
* CHECK dout0_32 vdout0_32ck11 = 0 time = 60
* CHECK dout0_33 vdout0_33ck11 = 1.1 time = 60
* CHECK dout0_34 vdout0_34ck11 = 1.1 time = 60
* CHECK dout0_35 vdout0_35ck11 = 1.1 time = 60
* CHECK dout0_36 vdout0_36ck11 = 0 time = 60
* CHECK dout0_37 vdout0_37ck11 = 1.1 time = 60
* CHECK dout0_38 vdout0_38ck11 = 1.1 time = 60
* CHECK dout0_39 vdout0_39ck11 = 0 time = 60
* CHECK dout0_40 vdout0_40ck11 = 1.1 time = 60
* CHECK dout0_41 vdout0_41ck11 = 0 time = 60
* CHECK dout0_42 vdout0_42ck11 = 1.1 time = 60
* CHECK dout0_43 vdout0_43ck11 = 1.1 time = 60
* CHECK dout0_44 vdout0_44ck11 = 1.1 time = 60
* CHECK dout0_45 vdout0_45ck11 = 0 time = 60
* CHECK dout0_46 vdout0_46ck11 = 0 time = 60
* CHECK dout0_47 vdout0_47ck11 = 0 time = 60
* CHECK dout0_48 vdout0_48ck11 = 1.1 time = 60
* CHECK dout0_49 vdout0_49ck11 = 0 time = 60
* CHECK dout0_50 vdout0_50ck11 = 0 time = 60
* CHECK dout0_51 vdout0_51ck11 = 1.1 time = 60
* CHECK dout0_52 vdout0_52ck11 = 1.1 time = 60
* CHECK dout0_53 vdout0_53ck11 = 0 time = 60
* CHECK dout0_54 vdout0_54ck11 = 0 time = 60
* CHECK dout0_55 vdout0_55ck11 = 0 time = 60
* CHECK dout0_56 vdout0_56ck11 = 0 time = 60
* CHECK dout0_57 vdout0_57ck11 = 0 time = 60
* CHECK dout0_58 vdout0_58ck11 = 0 time = 60
* CHECK dout0_59 vdout0_59ck11 = 1.1 time = 60
* CHECK dout0_60 vdout0_60ck11 = 1.1 time = 60
* CHECK dout0_61 vdout0_61ck11 = 1.1 time = 60
* CHECK dout0_62 vdout0_62ck11 = 1.1 time = 60
* CHECK dout0_63 vdout0_63ck11 = 0 time = 60
* CHECK dout0_0 vdout0_0ck14 = 1.1 time = 75
* CHECK dout0_1 vdout0_1ck14 = 0 time = 75
* CHECK dout0_2 vdout0_2ck14 = 1.1 time = 75
* CHECK dout0_3 vdout0_3ck14 = 0 time = 75
* CHECK dout0_4 vdout0_4ck14 = 0 time = 75
* CHECK dout0_5 vdout0_5ck14 = 0 time = 75
* CHECK dout0_6 vdout0_6ck14 = 1.1 time = 75
* CHECK dout0_7 vdout0_7ck14 = 1.1 time = 75
* CHECK dout0_8 vdout0_8ck14 = 1.1 time = 75
* CHECK dout0_9 vdout0_9ck14 = 1.1 time = 75
* CHECK dout0_10 vdout0_10ck14 = 0 time = 75
* CHECK dout0_11 vdout0_11ck14 = 0 time = 75
* CHECK dout0_12 vdout0_12ck14 = 0 time = 75
* CHECK dout0_13 vdout0_13ck14 = 1.1 time = 75
* CHECK dout0_14 vdout0_14ck14 = 1.1 time = 75
* CHECK dout0_15 vdout0_15ck14 = 1.1 time = 75
* CHECK dout0_16 vdout0_16ck14 = 0 time = 75
* CHECK dout0_17 vdout0_17ck14 = 1.1 time = 75
* CHECK dout0_18 vdout0_18ck14 = 1.1 time = 75
* CHECK dout0_19 vdout0_19ck14 = 0 time = 75
* CHECK dout0_20 vdout0_20ck14 = 1.1 time = 75
* CHECK dout0_21 vdout0_21ck14 = 0 time = 75
* CHECK dout0_22 vdout0_22ck14 = 0 time = 75
* CHECK dout0_23 vdout0_23ck14 = 0 time = 75
* CHECK dout0_24 vdout0_24ck14 = 1.1 time = 75
* CHECK dout0_25 vdout0_25ck14 = 1.1 time = 75
* CHECK dout0_26 vdout0_26ck14 = 0 time = 75
* CHECK dout0_27 vdout0_27ck14 = 0 time = 75
* CHECK dout0_28 vdout0_28ck14 = 1.1 time = 75
* CHECK dout0_29 vdout0_29ck14 = 0 time = 75
* CHECK dout0_30 vdout0_30ck14 = 1.1 time = 75
* CHECK dout0_31 vdout0_31ck14 = 1.1 time = 75
* CHECK dout0_32 vdout0_32ck14 = 0 time = 75
* CHECK dout0_33 vdout0_33ck14 = 1.1 time = 75
* CHECK dout0_34 vdout0_34ck14 = 0 time = 75
* CHECK dout0_35 vdout0_35ck14 = 1.1 time = 75
* CHECK dout0_36 vdout0_36ck14 = 1.1 time = 75
* CHECK dout0_37 vdout0_37ck14 = 0 time = 75
* CHECK dout0_38 vdout0_38ck14 = 1.1 time = 75
* CHECK dout0_39 vdout0_39ck14 = 1.1 time = 75
* CHECK dout0_40 vdout0_40ck14 = 0 time = 75
* CHECK dout0_41 vdout0_41ck14 = 0 time = 75
* CHECK dout0_42 vdout0_42ck14 = 0 time = 75
* CHECK dout0_43 vdout0_43ck14 = 0 time = 75
* CHECK dout0_44 vdout0_44ck14 = 0 time = 75
* CHECK dout0_45 vdout0_45ck14 = 1.1 time = 75
* CHECK dout0_46 vdout0_46ck14 = 1.1 time = 75
* CHECK dout0_47 vdout0_47ck14 = 0 time = 75
* CHECK dout0_48 vdout0_48ck14 = 1.1 time = 75
* CHECK dout0_49 vdout0_49ck14 = 0 time = 75
* CHECK dout0_50 vdout0_50ck14 = 1.1 time = 75
* CHECK dout0_51 vdout0_51ck14 = 0 time = 75
* CHECK dout0_52 vdout0_52ck14 = 0 time = 75
* CHECK dout0_53 vdout0_53ck14 = 0 time = 75
* CHECK dout0_54 vdout0_54ck14 = 0 time = 75
* CHECK dout0_55 vdout0_55ck14 = 1.1 time = 75
* CHECK dout0_56 vdout0_56ck14 = 0 time = 75
* CHECK dout0_57 vdout0_57ck14 = 1.1 time = 75
* CHECK dout0_58 vdout0_58ck14 = 0 time = 75
* CHECK dout0_59 vdout0_59ck14 = 1.1 time = 75
* CHECK dout0_60 vdout0_60ck14 = 0 time = 75
* CHECK dout0_61 vdout0_61ck14 = 0 time = 75
* CHECK dout0_62 vdout0_62ck14 = 1.1 time = 75
* CHECK dout0_63 vdout0_63ck14 = 0 time = 75
* CHECK dout0_0 vdout0_0ck15 = 1.1 time = 80
* CHECK dout0_1 vdout0_1ck15 = 0 time = 80
* CHECK dout0_2 vdout0_2ck15 = 1.1 time = 80
* CHECK dout0_3 vdout0_3ck15 = 0 time = 80
* CHECK dout0_4 vdout0_4ck15 = 0 time = 80
* CHECK dout0_5 vdout0_5ck15 = 0 time = 80
* CHECK dout0_6 vdout0_6ck15 = 1.1 time = 80
* CHECK dout0_7 vdout0_7ck15 = 1.1 time = 80
* CHECK dout0_8 vdout0_8ck15 = 1.1 time = 80
* CHECK dout0_9 vdout0_9ck15 = 1.1 time = 80
* CHECK dout0_10 vdout0_10ck15 = 0 time = 80
* CHECK dout0_11 vdout0_11ck15 = 0 time = 80
* CHECK dout0_12 vdout0_12ck15 = 0 time = 80
* CHECK dout0_13 vdout0_13ck15 = 1.1 time = 80
* CHECK dout0_14 vdout0_14ck15 = 1.1 time = 80
* CHECK dout0_15 vdout0_15ck15 = 1.1 time = 80
* CHECK dout0_16 vdout0_16ck15 = 0 time = 80
* CHECK dout0_17 vdout0_17ck15 = 1.1 time = 80
* CHECK dout0_18 vdout0_18ck15 = 1.1 time = 80
* CHECK dout0_19 vdout0_19ck15 = 0 time = 80
* CHECK dout0_20 vdout0_20ck15 = 1.1 time = 80
* CHECK dout0_21 vdout0_21ck15 = 0 time = 80
* CHECK dout0_22 vdout0_22ck15 = 0 time = 80
* CHECK dout0_23 vdout0_23ck15 = 0 time = 80
* CHECK dout0_24 vdout0_24ck15 = 1.1 time = 80
* CHECK dout0_25 vdout0_25ck15 = 1.1 time = 80
* CHECK dout0_26 vdout0_26ck15 = 0 time = 80
* CHECK dout0_27 vdout0_27ck15 = 0 time = 80
* CHECK dout0_28 vdout0_28ck15 = 1.1 time = 80
* CHECK dout0_29 vdout0_29ck15 = 0 time = 80
* CHECK dout0_30 vdout0_30ck15 = 1.1 time = 80
* CHECK dout0_31 vdout0_31ck15 = 1.1 time = 80
* CHECK dout0_32 vdout0_32ck15 = 0 time = 80
* CHECK dout0_33 vdout0_33ck15 = 1.1 time = 80
* CHECK dout0_34 vdout0_34ck15 = 0 time = 80
* CHECK dout0_35 vdout0_35ck15 = 1.1 time = 80
* CHECK dout0_36 vdout0_36ck15 = 1.1 time = 80
* CHECK dout0_37 vdout0_37ck15 = 0 time = 80
* CHECK dout0_38 vdout0_38ck15 = 1.1 time = 80
* CHECK dout0_39 vdout0_39ck15 = 1.1 time = 80
* CHECK dout0_40 vdout0_40ck15 = 0 time = 80
* CHECK dout0_41 vdout0_41ck15 = 0 time = 80
* CHECK dout0_42 vdout0_42ck15 = 0 time = 80
* CHECK dout0_43 vdout0_43ck15 = 0 time = 80
* CHECK dout0_44 vdout0_44ck15 = 0 time = 80
* CHECK dout0_45 vdout0_45ck15 = 1.1 time = 80
* CHECK dout0_46 vdout0_46ck15 = 1.1 time = 80
* CHECK dout0_47 vdout0_47ck15 = 0 time = 80
* CHECK dout0_48 vdout0_48ck15 = 1.1 time = 80
* CHECK dout0_49 vdout0_49ck15 = 0 time = 80
* CHECK dout0_50 vdout0_50ck15 = 1.1 time = 80
* CHECK dout0_51 vdout0_51ck15 = 0 time = 80
* CHECK dout0_52 vdout0_52ck15 = 0 time = 80
* CHECK dout0_53 vdout0_53ck15 = 0 time = 80
* CHECK dout0_54 vdout0_54ck15 = 0 time = 80
* CHECK dout0_55 vdout0_55ck15 = 1.1 time = 80
* CHECK dout0_56 vdout0_56ck15 = 0 time = 80
* CHECK dout0_57 vdout0_57ck15 = 1.1 time = 80
* CHECK dout0_58 vdout0_58ck15 = 0 time = 80
* CHECK dout0_59 vdout0_59ck15 = 1.1 time = 80
* CHECK dout0_60 vdout0_60ck15 = 0 time = 80
* CHECK dout0_61 vdout0_61ck15 = 0 time = 80
* CHECK dout0_62 vdout0_62ck15 = 1.1 time = 80
* CHECK dout0_63 vdout0_63ck15 = 0 time = 80
* CHECK dout0_0 vdout0_0ck22 = 1.1 time = 115
* CHECK dout0_1 vdout0_1ck22 = 0 time = 115
* CHECK dout0_2 vdout0_2ck22 = 1.1 time = 115
* CHECK dout0_3 vdout0_3ck22 = 1.1 time = 115
* CHECK dout0_4 vdout0_4ck22 = 0 time = 115
* CHECK dout0_5 vdout0_5ck22 = 0 time = 115
* CHECK dout0_6 vdout0_6ck22 = 1.1 time = 115
* CHECK dout0_7 vdout0_7ck22 = 0 time = 115
* CHECK dout0_8 vdout0_8ck22 = 0 time = 115
* CHECK dout0_9 vdout0_9ck22 = 0 time = 115
* CHECK dout0_10 vdout0_10ck22 = 0 time = 115
* CHECK dout0_11 vdout0_11ck22 = 0 time = 115
* CHECK dout0_12 vdout0_12ck22 = 1.1 time = 115
* CHECK dout0_13 vdout0_13ck22 = 0 time = 115
* CHECK dout0_14 vdout0_14ck22 = 0 time = 115
* CHECK dout0_15 vdout0_15ck22 = 1.1 time = 115
* CHECK dout0_16 vdout0_16ck22 = 0 time = 115
* CHECK dout0_17 vdout0_17ck22 = 0 time = 115
* CHECK dout0_18 vdout0_18ck22 = 0 time = 115
* CHECK dout0_19 vdout0_19ck22 = 0 time = 115
* CHECK dout0_20 vdout0_20ck22 = 1.1 time = 115
* CHECK dout0_21 vdout0_21ck22 = 1.1 time = 115
* CHECK dout0_22 vdout0_22ck22 = 0 time = 115
* CHECK dout0_23 vdout0_23ck22 = 1.1 time = 115
* CHECK dout0_24 vdout0_24ck22 = 1.1 time = 115
* CHECK dout0_25 vdout0_25ck22 = 1.1 time = 115
* CHECK dout0_26 vdout0_26ck22 = 0 time = 115
* CHECK dout0_27 vdout0_27ck22 = 1.1 time = 115
* CHECK dout0_28 vdout0_28ck22 = 1.1 time = 115
* CHECK dout0_29 vdout0_29ck22 = 0 time = 115
* CHECK dout0_30 vdout0_30ck22 = 1.1 time = 115
* CHECK dout0_31 vdout0_31ck22 = 1.1 time = 115
* CHECK dout0_32 vdout0_32ck22 = 1.1 time = 115
* CHECK dout0_33 vdout0_33ck22 = 0 time = 115
* CHECK dout0_34 vdout0_34ck22 = 0 time = 115
* CHECK dout0_35 vdout0_35ck22 = 1.1 time = 115
* CHECK dout0_36 vdout0_36ck22 = 0 time = 115
* CHECK dout0_37 vdout0_37ck22 = 1.1 time = 115
* CHECK dout0_38 vdout0_38ck22 = 1.1 time = 115
* CHECK dout0_39 vdout0_39ck22 = 1.1 time = 115
* CHECK dout0_40 vdout0_40ck22 = 0 time = 115
* CHECK dout0_41 vdout0_41ck22 = 1.1 time = 115
* CHECK dout0_42 vdout0_42ck22 = 0 time = 115
* CHECK dout0_43 vdout0_43ck22 = 1.1 time = 115
* CHECK dout0_44 vdout0_44ck22 = 0 time = 115
* CHECK dout0_45 vdout0_45ck22 = 0 time = 115
* CHECK dout0_46 vdout0_46ck22 = 0 time = 115
* CHECK dout0_47 vdout0_47ck22 = 1.1 time = 115
* CHECK dout0_48 vdout0_48ck22 = 1.1 time = 115
* CHECK dout0_49 vdout0_49ck22 = 0 time = 115
* CHECK dout0_50 vdout0_50ck22 = 1.1 time = 115
* CHECK dout0_51 vdout0_51ck22 = 0 time = 115
* CHECK dout0_52 vdout0_52ck22 = 0 time = 115
* CHECK dout0_53 vdout0_53ck22 = 1.1 time = 115
* CHECK dout0_54 vdout0_54ck22 = 1.1 time = 115
* CHECK dout0_55 vdout0_55ck22 = 1.1 time = 115
* CHECK dout0_56 vdout0_56ck22 = 0 time = 115
* CHECK dout0_57 vdout0_57ck22 = 1.1 time = 115
* CHECK dout0_58 vdout0_58ck22 = 1.1 time = 115
* CHECK dout0_59 vdout0_59ck22 = 1.1 time = 115
* CHECK dout0_60 vdout0_60ck22 = 1.1 time = 115
* CHECK dout0_61 vdout0_61ck22 = 0 time = 115
* CHECK dout0_62 vdout0_62ck22 = 0 time = 115
* CHECK dout0_63 vdout0_63ck22 = 0 time = 115
* CHECK dout0_0 vdout0_0ck25 = 1.1 time = 130
* CHECK dout0_1 vdout0_1ck25 = 0 time = 130
* CHECK dout0_2 vdout0_2ck25 = 1.1 time = 130
* CHECK dout0_3 vdout0_3ck25 = 1.1 time = 130
* CHECK dout0_4 vdout0_4ck25 = 0 time = 130
* CHECK dout0_5 vdout0_5ck25 = 0 time = 130
* CHECK dout0_6 vdout0_6ck25 = 1.1 time = 130
* CHECK dout0_7 vdout0_7ck25 = 0 time = 130
* CHECK dout0_8 vdout0_8ck25 = 0 time = 130
* CHECK dout0_9 vdout0_9ck25 = 0 time = 130
* CHECK dout0_10 vdout0_10ck25 = 0 time = 130
* CHECK dout0_11 vdout0_11ck25 = 0 time = 130
* CHECK dout0_12 vdout0_12ck25 = 1.1 time = 130
* CHECK dout0_13 vdout0_13ck25 = 0 time = 130
* CHECK dout0_14 vdout0_14ck25 = 0 time = 130
* CHECK dout0_15 vdout0_15ck25 = 1.1 time = 130
* CHECK dout0_16 vdout0_16ck25 = 0 time = 130
* CHECK dout0_17 vdout0_17ck25 = 0 time = 130
* CHECK dout0_18 vdout0_18ck25 = 0 time = 130
* CHECK dout0_19 vdout0_19ck25 = 0 time = 130
* CHECK dout0_20 vdout0_20ck25 = 1.1 time = 130
* CHECK dout0_21 vdout0_21ck25 = 1.1 time = 130
* CHECK dout0_22 vdout0_22ck25 = 0 time = 130
* CHECK dout0_23 vdout0_23ck25 = 1.1 time = 130
* CHECK dout0_24 vdout0_24ck25 = 1.1 time = 130
* CHECK dout0_25 vdout0_25ck25 = 1.1 time = 130
* CHECK dout0_26 vdout0_26ck25 = 0 time = 130
* CHECK dout0_27 vdout0_27ck25 = 1.1 time = 130
* CHECK dout0_28 vdout0_28ck25 = 1.1 time = 130
* CHECK dout0_29 vdout0_29ck25 = 0 time = 130
* CHECK dout0_30 vdout0_30ck25 = 1.1 time = 130
* CHECK dout0_31 vdout0_31ck25 = 1.1 time = 130
* CHECK dout0_32 vdout0_32ck25 = 1.1 time = 130
* CHECK dout0_33 vdout0_33ck25 = 0 time = 130
* CHECK dout0_34 vdout0_34ck25 = 0 time = 130
* CHECK dout0_35 vdout0_35ck25 = 1.1 time = 130
* CHECK dout0_36 vdout0_36ck25 = 0 time = 130
* CHECK dout0_37 vdout0_37ck25 = 1.1 time = 130
* CHECK dout0_38 vdout0_38ck25 = 1.1 time = 130
* CHECK dout0_39 vdout0_39ck25 = 1.1 time = 130
* CHECK dout0_40 vdout0_40ck25 = 0 time = 130
* CHECK dout0_41 vdout0_41ck25 = 1.1 time = 130
* CHECK dout0_42 vdout0_42ck25 = 0 time = 130
* CHECK dout0_43 vdout0_43ck25 = 1.1 time = 130
* CHECK dout0_44 vdout0_44ck25 = 0 time = 130
* CHECK dout0_45 vdout0_45ck25 = 0 time = 130
* CHECK dout0_46 vdout0_46ck25 = 0 time = 130
* CHECK dout0_47 vdout0_47ck25 = 1.1 time = 130
* CHECK dout0_48 vdout0_48ck25 = 1.1 time = 130
* CHECK dout0_49 vdout0_49ck25 = 0 time = 130
* CHECK dout0_50 vdout0_50ck25 = 1.1 time = 130
* CHECK dout0_51 vdout0_51ck25 = 0 time = 130
* CHECK dout0_52 vdout0_52ck25 = 0 time = 130
* CHECK dout0_53 vdout0_53ck25 = 1.1 time = 130
* CHECK dout0_54 vdout0_54ck25 = 1.1 time = 130
* CHECK dout0_55 vdout0_55ck25 = 1.1 time = 130
* CHECK dout0_56 vdout0_56ck25 = 0 time = 130
* CHECK dout0_57 vdout0_57ck25 = 1.1 time = 130
* CHECK dout0_58 vdout0_58ck25 = 1.1 time = 130
* CHECK dout0_59 vdout0_59ck25 = 1.1 time = 130
* CHECK dout0_60 vdout0_60ck25 = 1.1 time = 130
* CHECK dout0_61 vdout0_61ck25 = 0 time = 130
* CHECK dout0_62 vdout0_62ck25 = 0 time = 130
* CHECK dout0_63 vdout0_63ck25 = 0 time = 130
* CHECK dout0_0 vdout0_0ck26 = 1.1 time = 135
* CHECK dout0_1 vdout0_1ck26 = 0 time = 135
* CHECK dout0_2 vdout0_2ck26 = 0 time = 135
* CHECK dout0_3 vdout0_3ck26 = 1.1 time = 135
* CHECK dout0_4 vdout0_4ck26 = 0 time = 135
* CHECK dout0_5 vdout0_5ck26 = 0 time = 135
* CHECK dout0_6 vdout0_6ck26 = 1.1 time = 135
* CHECK dout0_7 vdout0_7ck26 = 1.1 time = 135
* CHECK dout0_8 vdout0_8ck26 = 0 time = 135
* CHECK dout0_9 vdout0_9ck26 = 1.1 time = 135
* CHECK dout0_10 vdout0_10ck26 = 1.1 time = 135
* CHECK dout0_11 vdout0_11ck26 = 1.1 time = 135
* CHECK dout0_12 vdout0_12ck26 = 0 time = 135
* CHECK dout0_13 vdout0_13ck26 = 1.1 time = 135
* CHECK dout0_14 vdout0_14ck26 = 1.1 time = 135
* CHECK dout0_15 vdout0_15ck26 = 0 time = 135
* CHECK dout0_16 vdout0_16ck26 = 1.1 time = 135
* CHECK dout0_17 vdout0_17ck26 = 0 time = 135
* CHECK dout0_18 vdout0_18ck26 = 0 time = 135
* CHECK dout0_19 vdout0_19ck26 = 0 time = 135
* CHECK dout0_20 vdout0_20ck26 = 1.1 time = 135
* CHECK dout0_21 vdout0_21ck26 = 0 time = 135
* CHECK dout0_22 vdout0_22ck26 = 1.1 time = 135
* CHECK dout0_23 vdout0_23ck26 = 1.1 time = 135
* CHECK dout0_24 vdout0_24ck26 = 0 time = 135
* CHECK dout0_25 vdout0_25ck26 = 0 time = 135
* CHECK dout0_26 vdout0_26ck26 = 1.1 time = 135
* CHECK dout0_27 vdout0_27ck26 = 0 time = 135
* CHECK dout0_28 vdout0_28ck26 = 1.1 time = 135
* CHECK dout0_29 vdout0_29ck26 = 1.1 time = 135
* CHECK dout0_30 vdout0_30ck26 = 0 time = 135
* CHECK dout0_31 vdout0_31ck26 = 0 time = 135
* CHECK dout0_32 vdout0_32ck26 = 0 time = 135
* CHECK dout0_33 vdout0_33ck26 = 1.1 time = 135
* CHECK dout0_34 vdout0_34ck26 = 1.1 time = 135
* CHECK dout0_35 vdout0_35ck26 = 1.1 time = 135
* CHECK dout0_36 vdout0_36ck26 = 0 time = 135
* CHECK dout0_37 vdout0_37ck26 = 1.1 time = 135
* CHECK dout0_38 vdout0_38ck26 = 1.1 time = 135
* CHECK dout0_39 vdout0_39ck26 = 0 time = 135
* CHECK dout0_40 vdout0_40ck26 = 1.1 time = 135
* CHECK dout0_41 vdout0_41ck26 = 0 time = 135
* CHECK dout0_42 vdout0_42ck26 = 1.1 time = 135
* CHECK dout0_43 vdout0_43ck26 = 1.1 time = 135
* CHECK dout0_44 vdout0_44ck26 = 1.1 time = 135
* CHECK dout0_45 vdout0_45ck26 = 0 time = 135
* CHECK dout0_46 vdout0_46ck26 = 0 time = 135
* CHECK dout0_47 vdout0_47ck26 = 0 time = 135
* CHECK dout0_48 vdout0_48ck26 = 1.1 time = 135
* CHECK dout0_49 vdout0_49ck26 = 0 time = 135
* CHECK dout0_50 vdout0_50ck26 = 0 time = 135
* CHECK dout0_51 vdout0_51ck26 = 1.1 time = 135
* CHECK dout0_52 vdout0_52ck26 = 1.1 time = 135
* CHECK dout0_53 vdout0_53ck26 = 0 time = 135
* CHECK dout0_54 vdout0_54ck26 = 0 time = 135
* CHECK dout0_55 vdout0_55ck26 = 0 time = 135
* CHECK dout0_56 vdout0_56ck26 = 0 time = 135
* CHECK dout0_57 vdout0_57ck26 = 0 time = 135
* CHECK dout0_58 vdout0_58ck26 = 0 time = 135
* CHECK dout0_59 vdout0_59ck26 = 1.1 time = 135
* CHECK dout0_60 vdout0_60ck26 = 1.1 time = 135
* CHECK dout0_61 vdout0_61ck26 = 1.1 time = 135
* CHECK dout0_62 vdout0_62ck26 = 1.1 time = 135
* CHECK dout0_63 vdout0_63ck26 = 0 time = 135
* CHECK dout0_0 vdout0_0ck30 = 1.1 time = 155
* CHECK dout0_1 vdout0_1ck30 = 0 time = 155
* CHECK dout0_2 vdout0_2ck30 = 1.1 time = 155
* CHECK dout0_3 vdout0_3ck30 = 1.1 time = 155
* CHECK dout0_4 vdout0_4ck30 = 0 time = 155
* CHECK dout0_5 vdout0_5ck30 = 0 time = 155
* CHECK dout0_6 vdout0_6ck30 = 1.1 time = 155
* CHECK dout0_7 vdout0_7ck30 = 0 time = 155
* CHECK dout0_8 vdout0_8ck30 = 0 time = 155
* CHECK dout0_9 vdout0_9ck30 = 0 time = 155
* CHECK dout0_10 vdout0_10ck30 = 0 time = 155
* CHECK dout0_11 vdout0_11ck30 = 0 time = 155
* CHECK dout0_12 vdout0_12ck30 = 1.1 time = 155
* CHECK dout0_13 vdout0_13ck30 = 0 time = 155
* CHECK dout0_14 vdout0_14ck30 = 0 time = 155
* CHECK dout0_15 vdout0_15ck30 = 1.1 time = 155
* CHECK dout0_16 vdout0_16ck30 = 0 time = 155
* CHECK dout0_17 vdout0_17ck30 = 1.1 time = 155
* CHECK dout0_18 vdout0_18ck30 = 0 time = 155
* CHECK dout0_19 vdout0_19ck30 = 0 time = 155
* CHECK dout0_20 vdout0_20ck30 = 1.1 time = 155
* CHECK dout0_21 vdout0_21ck30 = 1.1 time = 155
* CHECK dout0_22 vdout0_22ck30 = 0 time = 155
* CHECK dout0_23 vdout0_23ck30 = 1.1 time = 155
* CHECK dout0_24 vdout0_24ck30 = 1.1 time = 155
* CHECK dout0_25 vdout0_25ck30 = 1.1 time = 155
* CHECK dout0_26 vdout0_26ck30 = 0 time = 155
* CHECK dout0_27 vdout0_27ck30 = 1.1 time = 155
* CHECK dout0_28 vdout0_28ck30 = 1.1 time = 155
* CHECK dout0_29 vdout0_29ck30 = 0 time = 155
* CHECK dout0_30 vdout0_30ck30 = 1.1 time = 155
* CHECK dout0_31 vdout0_31ck30 = 1.1 time = 155
* CHECK dout0_32 vdout0_32ck30 = 1.1 time = 155
* CHECK dout0_33 vdout0_33ck30 = 0 time = 155
* CHECK dout0_34 vdout0_34ck30 = 1.1 time = 155
* CHECK dout0_35 vdout0_35ck30 = 0 time = 155
* CHECK dout0_36 vdout0_36ck30 = 1.1 time = 155
* CHECK dout0_37 vdout0_37ck30 = 0 time = 155
* CHECK dout0_38 vdout0_38ck30 = 0 time = 155
* CHECK dout0_39 vdout0_39ck30 = 1.1 time = 155
* CHECK dout0_40 vdout0_40ck30 = 0 time = 155
* CHECK dout0_41 vdout0_41ck30 = 1.1 time = 155
* CHECK dout0_42 vdout0_42ck30 = 0 time = 155
* CHECK dout0_43 vdout0_43ck30 = 1.1 time = 155
* CHECK dout0_44 vdout0_44ck30 = 0 time = 155
* CHECK dout0_45 vdout0_45ck30 = 0 time = 155
* CHECK dout0_46 vdout0_46ck30 = 0 time = 155
* CHECK dout0_47 vdout0_47ck30 = 1.1 time = 155
* CHECK dout0_48 vdout0_48ck30 = 0 time = 155
* CHECK dout0_49 vdout0_49ck30 = 0 time = 155
* CHECK dout0_50 vdout0_50ck30 = 0 time = 155
* CHECK dout0_51 vdout0_51ck30 = 0 time = 155
* CHECK dout0_52 vdout0_52ck30 = 1.1 time = 155
* CHECK dout0_53 vdout0_53ck30 = 1.1 time = 155
* CHECK dout0_54 vdout0_54ck30 = 0 time = 155
* CHECK dout0_55 vdout0_55ck30 = 0 time = 155
* CHECK dout0_56 vdout0_56ck30 = 0 time = 155
* CHECK dout0_57 vdout0_57ck30 = 1.1 time = 155
* CHECK dout0_58 vdout0_58ck30 = 1.1 time = 155
* CHECK dout0_59 vdout0_59ck30 = 1.1 time = 155
* CHECK dout0_60 vdout0_60ck30 = 1.1 time = 155
* CHECK dout0_61 vdout0_61ck30 = 0 time = 155
* CHECK dout0_62 vdout0_62ck30 = 0 time = 155
* CHECK dout0_63 vdout0_63ck30 = 0 time = 155
* CHECK dout0_0 vdout0_0ck31 = 0 time = 160
* CHECK dout0_1 vdout0_1ck31 = 1.1 time = 160
* CHECK dout0_2 vdout0_2ck31 = 1.1 time = 160
* CHECK dout0_3 vdout0_3ck31 = 0 time = 160
* CHECK dout0_4 vdout0_4ck31 = 0 time = 160
* CHECK dout0_5 vdout0_5ck31 = 0 time = 160
* CHECK dout0_6 vdout0_6ck31 = 1.1 time = 160
* CHECK dout0_7 vdout0_7ck31 = 0 time = 160
* CHECK dout0_8 vdout0_8ck31 = 1.1 time = 160
* CHECK dout0_9 vdout0_9ck31 = 1.1 time = 160
* CHECK dout0_10 vdout0_10ck31 = 0 time = 160
* CHECK dout0_11 vdout0_11ck31 = 1.1 time = 160
* CHECK dout0_12 vdout0_12ck31 = 0 time = 160
* CHECK dout0_13 vdout0_13ck31 = 1.1 time = 160
* CHECK dout0_14 vdout0_14ck31 = 0 time = 160
* CHECK dout0_15 vdout0_15ck31 = 1.1 time = 160
* CHECK dout0_16 vdout0_16ck31 = 0 time = 160
* CHECK dout0_17 vdout0_17ck31 = 0 time = 160
* CHECK dout0_18 vdout0_18ck31 = 0 time = 160
* CHECK dout0_19 vdout0_19ck31 = 0 time = 160
* CHECK dout0_20 vdout0_20ck31 = 0 time = 160
* CHECK dout0_21 vdout0_21ck31 = 1.1 time = 160
* CHECK dout0_22 vdout0_22ck31 = 1.1 time = 160
* CHECK dout0_23 vdout0_23ck31 = 0 time = 160
* CHECK dout0_24 vdout0_24ck31 = 1.1 time = 160
* CHECK dout0_25 vdout0_25ck31 = 0 time = 160
* CHECK dout0_26 vdout0_26ck31 = 0 time = 160
* CHECK dout0_27 vdout0_27ck31 = 1.1 time = 160
* CHECK dout0_28 vdout0_28ck31 = 0 time = 160
* CHECK dout0_29 vdout0_29ck31 = 1.1 time = 160
* CHECK dout0_30 vdout0_30ck31 = 0 time = 160
* CHECK dout0_31 vdout0_31ck31 = 0 time = 160
* CHECK dout0_32 vdout0_32ck31 = 0 time = 160
* CHECK dout0_33 vdout0_33ck31 = 0 time = 160
* CHECK dout0_34 vdout0_34ck31 = 0 time = 160
* CHECK dout0_35 vdout0_35ck31 = 1.1 time = 160
* CHECK dout0_36 vdout0_36ck31 = 1.1 time = 160
* CHECK dout0_37 vdout0_37ck31 = 1.1 time = 160
* CHECK dout0_38 vdout0_38ck31 = 0 time = 160
* CHECK dout0_39 vdout0_39ck31 = 0 time = 160
* CHECK dout0_40 vdout0_40ck31 = 1.1 time = 160
* CHECK dout0_41 vdout0_41ck31 = 1.1 time = 160
* CHECK dout0_42 vdout0_42ck31 = 0 time = 160
* CHECK dout0_43 vdout0_43ck31 = 1.1 time = 160
* CHECK dout0_44 vdout0_44ck31 = 0 time = 160
* CHECK dout0_45 vdout0_45ck31 = 0 time = 160
* CHECK dout0_46 vdout0_46ck31 = 1.1 time = 160
* CHECK dout0_47 vdout0_47ck31 = 0 time = 160
* CHECK dout0_48 vdout0_48ck31 = 0 time = 160
* CHECK dout0_49 vdout0_49ck31 = 1.1 time = 160
* CHECK dout0_50 vdout0_50ck31 = 1.1 time = 160
* CHECK dout0_51 vdout0_51ck31 = 1.1 time = 160
* CHECK dout0_52 vdout0_52ck31 = 0 time = 160
* CHECK dout0_53 vdout0_53ck31 = 0 time = 160
* CHECK dout0_54 vdout0_54ck31 = 0 time = 160
* CHECK dout0_55 vdout0_55ck31 = 0 time = 160
* CHECK dout0_56 vdout0_56ck31 = 1.1 time = 160
* CHECK dout0_57 vdout0_57ck31 = 1.1 time = 160
* CHECK dout0_58 vdout0_58ck31 = 1.1 time = 160
* CHECK dout0_59 vdout0_59ck31 = 0 time = 160
* CHECK dout0_60 vdout0_60ck31 = 0 time = 160
* CHECK dout0_61 vdout0_61ck31 = 0 time = 160
* CHECK dout0_62 vdout0_62ck31 = 1.1 time = 160
* CHECK dout0_63 vdout0_63ck31 = 1.1 time = 160
* CHECK dout0_0 vdout0_0ck32 = 0 time = 165
* CHECK dout0_1 vdout0_1ck32 = 1.1 time = 165
* CHECK dout0_2 vdout0_2ck32 = 1.1 time = 165
* CHECK dout0_3 vdout0_3ck32 = 0 time = 165
* CHECK dout0_4 vdout0_4ck32 = 0 time = 165
* CHECK dout0_5 vdout0_5ck32 = 0 time = 165
* CHECK dout0_6 vdout0_6ck32 = 1.1 time = 165
* CHECK dout0_7 vdout0_7ck32 = 0 time = 165
* CHECK dout0_8 vdout0_8ck32 = 1.1 time = 165
* CHECK dout0_9 vdout0_9ck32 = 1.1 time = 165
* CHECK dout0_10 vdout0_10ck32 = 0 time = 165
* CHECK dout0_11 vdout0_11ck32 = 1.1 time = 165
* CHECK dout0_12 vdout0_12ck32 = 0 time = 165
* CHECK dout0_13 vdout0_13ck32 = 1.1 time = 165
* CHECK dout0_14 vdout0_14ck32 = 0 time = 165
* CHECK dout0_15 vdout0_15ck32 = 1.1 time = 165
* CHECK dout0_16 vdout0_16ck32 = 0 time = 165
* CHECK dout0_17 vdout0_17ck32 = 0 time = 165
* CHECK dout0_18 vdout0_18ck32 = 0 time = 165
* CHECK dout0_19 vdout0_19ck32 = 0 time = 165
* CHECK dout0_20 vdout0_20ck32 = 0 time = 165
* CHECK dout0_21 vdout0_21ck32 = 1.1 time = 165
* CHECK dout0_22 vdout0_22ck32 = 1.1 time = 165
* CHECK dout0_23 vdout0_23ck32 = 0 time = 165
* CHECK dout0_24 vdout0_24ck32 = 1.1 time = 165
* CHECK dout0_25 vdout0_25ck32 = 0 time = 165
* CHECK dout0_26 vdout0_26ck32 = 0 time = 165
* CHECK dout0_27 vdout0_27ck32 = 1.1 time = 165
* CHECK dout0_28 vdout0_28ck32 = 0 time = 165
* CHECK dout0_29 vdout0_29ck32 = 1.1 time = 165
* CHECK dout0_30 vdout0_30ck32 = 0 time = 165
* CHECK dout0_31 vdout0_31ck32 = 0 time = 165
* CHECK dout0_32 vdout0_32ck32 = 0 time = 165
* CHECK dout0_33 vdout0_33ck32 = 0 time = 165
* CHECK dout0_34 vdout0_34ck32 = 0 time = 165
* CHECK dout0_35 vdout0_35ck32 = 1.1 time = 165
* CHECK dout0_36 vdout0_36ck32 = 1.1 time = 165
* CHECK dout0_37 vdout0_37ck32 = 1.1 time = 165
* CHECK dout0_38 vdout0_38ck32 = 0 time = 165
* CHECK dout0_39 vdout0_39ck32 = 0 time = 165
* CHECK dout0_40 vdout0_40ck32 = 1.1 time = 165
* CHECK dout0_41 vdout0_41ck32 = 1.1 time = 165
* CHECK dout0_42 vdout0_42ck32 = 0 time = 165
* CHECK dout0_43 vdout0_43ck32 = 1.1 time = 165
* CHECK dout0_44 vdout0_44ck32 = 0 time = 165
* CHECK dout0_45 vdout0_45ck32 = 0 time = 165
* CHECK dout0_46 vdout0_46ck32 = 1.1 time = 165
* CHECK dout0_47 vdout0_47ck32 = 0 time = 165
* CHECK dout0_48 vdout0_48ck32 = 0 time = 165
* CHECK dout0_49 vdout0_49ck32 = 1.1 time = 165
* CHECK dout0_50 vdout0_50ck32 = 1.1 time = 165
* CHECK dout0_51 vdout0_51ck32 = 1.1 time = 165
* CHECK dout0_52 vdout0_52ck32 = 0 time = 165
* CHECK dout0_53 vdout0_53ck32 = 0 time = 165
* CHECK dout0_54 vdout0_54ck32 = 0 time = 165
* CHECK dout0_55 vdout0_55ck32 = 0 time = 165
* CHECK dout0_56 vdout0_56ck32 = 1.1 time = 165
* CHECK dout0_57 vdout0_57ck32 = 1.1 time = 165
* CHECK dout0_58 vdout0_58ck32 = 1.1 time = 165
* CHECK dout0_59 vdout0_59ck32 = 0 time = 165
* CHECK dout0_60 vdout0_60ck32 = 0 time = 165
* CHECK dout0_61 vdout0_61ck32 = 0 time = 165
* CHECK dout0_62 vdout0_62ck32 = 1.1 time = 165
* CHECK dout0_63 vdout0_63ck32 = 1.1 time = 165
* CHECK dout0_0 vdout0_0ck33 = 1.1 time = 170
* CHECK dout0_1 vdout0_1ck33 = 0 time = 170
* CHECK dout0_2 vdout0_2ck33 = 1.1 time = 170
* CHECK dout0_3 vdout0_3ck33 = 1.1 time = 170
* CHECK dout0_4 vdout0_4ck33 = 0 time = 170
* CHECK dout0_5 vdout0_5ck33 = 0 time = 170
* CHECK dout0_6 vdout0_6ck33 = 1.1 time = 170
* CHECK dout0_7 vdout0_7ck33 = 0 time = 170
* CHECK dout0_8 vdout0_8ck33 = 0 time = 170
* CHECK dout0_9 vdout0_9ck33 = 0 time = 170
* CHECK dout0_10 vdout0_10ck33 = 0 time = 170
* CHECK dout0_11 vdout0_11ck33 = 0 time = 170
* CHECK dout0_12 vdout0_12ck33 = 1.1 time = 170
* CHECK dout0_13 vdout0_13ck33 = 0 time = 170
* CHECK dout0_14 vdout0_14ck33 = 0 time = 170
* CHECK dout0_15 vdout0_15ck33 = 1.1 time = 170
* CHECK dout0_16 vdout0_16ck33 = 0 time = 170
* CHECK dout0_17 vdout0_17ck33 = 1.1 time = 170
* CHECK dout0_18 vdout0_18ck33 = 0 time = 170
* CHECK dout0_19 vdout0_19ck33 = 0 time = 170
* CHECK dout0_20 vdout0_20ck33 = 1.1 time = 170
* CHECK dout0_21 vdout0_21ck33 = 1.1 time = 170
* CHECK dout0_22 vdout0_22ck33 = 0 time = 170
* CHECK dout0_23 vdout0_23ck33 = 1.1 time = 170
* CHECK dout0_24 vdout0_24ck33 = 1.1 time = 170
* CHECK dout0_25 vdout0_25ck33 = 1.1 time = 170
* CHECK dout0_26 vdout0_26ck33 = 0 time = 170
* CHECK dout0_27 vdout0_27ck33 = 1.1 time = 170
* CHECK dout0_28 vdout0_28ck33 = 1.1 time = 170
* CHECK dout0_29 vdout0_29ck33 = 0 time = 170
* CHECK dout0_30 vdout0_30ck33 = 1.1 time = 170
* CHECK dout0_31 vdout0_31ck33 = 1.1 time = 170
* CHECK dout0_32 vdout0_32ck33 = 1.1 time = 170
* CHECK dout0_33 vdout0_33ck33 = 0 time = 170
* CHECK dout0_34 vdout0_34ck33 = 1.1 time = 170
* CHECK dout0_35 vdout0_35ck33 = 0 time = 170
* CHECK dout0_36 vdout0_36ck33 = 1.1 time = 170
* CHECK dout0_37 vdout0_37ck33 = 0 time = 170
* CHECK dout0_38 vdout0_38ck33 = 0 time = 170
* CHECK dout0_39 vdout0_39ck33 = 1.1 time = 170
* CHECK dout0_40 vdout0_40ck33 = 0 time = 170
* CHECK dout0_41 vdout0_41ck33 = 1.1 time = 170
* CHECK dout0_42 vdout0_42ck33 = 0 time = 170
* CHECK dout0_43 vdout0_43ck33 = 1.1 time = 170
* CHECK dout0_44 vdout0_44ck33 = 0 time = 170
* CHECK dout0_45 vdout0_45ck33 = 0 time = 170
* CHECK dout0_46 vdout0_46ck33 = 0 time = 170
* CHECK dout0_47 vdout0_47ck33 = 1.1 time = 170
* CHECK dout0_48 vdout0_48ck33 = 0 time = 170
* CHECK dout0_49 vdout0_49ck33 = 0 time = 170
* CHECK dout0_50 vdout0_50ck33 = 0 time = 170
* CHECK dout0_51 vdout0_51ck33 = 0 time = 170
* CHECK dout0_52 vdout0_52ck33 = 1.1 time = 170
* CHECK dout0_53 vdout0_53ck33 = 1.1 time = 170
* CHECK dout0_54 vdout0_54ck33 = 0 time = 170
* CHECK dout0_55 vdout0_55ck33 = 0 time = 170
* CHECK dout0_56 vdout0_56ck33 = 0 time = 170
* CHECK dout0_57 vdout0_57ck33 = 1.1 time = 170
* CHECK dout0_58 vdout0_58ck33 = 1.1 time = 170
* CHECK dout0_59 vdout0_59ck33 = 1.1 time = 170
* CHECK dout0_60 vdout0_60ck33 = 1.1 time = 170
* CHECK dout0_61 vdout0_61ck33 = 0 time = 170
* CHECK dout0_62 vdout0_62ck33 = 0 time = 170
* CHECK dout0_63 vdout0_63ck33 = 0 time = 170
* CHECK dout0_0 vdout0_0ck36 = 1.1 time = 185
* CHECK dout0_1 vdout0_1ck36 = 0 time = 185
* CHECK dout0_2 vdout0_2ck36 = 1.1 time = 185
* CHECK dout0_3 vdout0_3ck36 = 1.1 time = 185
* CHECK dout0_4 vdout0_4ck36 = 0 time = 185
* CHECK dout0_5 vdout0_5ck36 = 0 time = 185
* CHECK dout0_6 vdout0_6ck36 = 1.1 time = 185
* CHECK dout0_7 vdout0_7ck36 = 0 time = 185
* CHECK dout0_8 vdout0_8ck36 = 0 time = 185
* CHECK dout0_9 vdout0_9ck36 = 0 time = 185
* CHECK dout0_10 vdout0_10ck36 = 0 time = 185
* CHECK dout0_11 vdout0_11ck36 = 0 time = 185
* CHECK dout0_12 vdout0_12ck36 = 1.1 time = 185
* CHECK dout0_13 vdout0_13ck36 = 0 time = 185
* CHECK dout0_14 vdout0_14ck36 = 0 time = 185
* CHECK dout0_15 vdout0_15ck36 = 1.1 time = 185
* CHECK dout0_16 vdout0_16ck36 = 0 time = 185
* CHECK dout0_17 vdout0_17ck36 = 1.1 time = 185
* CHECK dout0_18 vdout0_18ck36 = 0 time = 185
* CHECK dout0_19 vdout0_19ck36 = 0 time = 185
* CHECK dout0_20 vdout0_20ck36 = 1.1 time = 185
* CHECK dout0_21 vdout0_21ck36 = 1.1 time = 185
* CHECK dout0_22 vdout0_22ck36 = 0 time = 185
* CHECK dout0_23 vdout0_23ck36 = 1.1 time = 185
* CHECK dout0_24 vdout0_24ck36 = 1.1 time = 185
* CHECK dout0_25 vdout0_25ck36 = 1.1 time = 185
* CHECK dout0_26 vdout0_26ck36 = 0 time = 185
* CHECK dout0_27 vdout0_27ck36 = 1.1 time = 185
* CHECK dout0_28 vdout0_28ck36 = 1.1 time = 185
* CHECK dout0_29 vdout0_29ck36 = 0 time = 185
* CHECK dout0_30 vdout0_30ck36 = 1.1 time = 185
* CHECK dout0_31 vdout0_31ck36 = 1.1 time = 185
* CHECK dout0_32 vdout0_32ck36 = 1.1 time = 185
* CHECK dout0_33 vdout0_33ck36 = 0 time = 185
* CHECK dout0_34 vdout0_34ck36 = 1.1 time = 185
* CHECK dout0_35 vdout0_35ck36 = 0 time = 185
* CHECK dout0_36 vdout0_36ck36 = 1.1 time = 185
* CHECK dout0_37 vdout0_37ck36 = 0 time = 185
* CHECK dout0_38 vdout0_38ck36 = 0 time = 185
* CHECK dout0_39 vdout0_39ck36 = 1.1 time = 185
* CHECK dout0_40 vdout0_40ck36 = 0 time = 185
* CHECK dout0_41 vdout0_41ck36 = 1.1 time = 185
* CHECK dout0_42 vdout0_42ck36 = 0 time = 185
* CHECK dout0_43 vdout0_43ck36 = 1.1 time = 185
* CHECK dout0_44 vdout0_44ck36 = 0 time = 185
* CHECK dout0_45 vdout0_45ck36 = 0 time = 185
* CHECK dout0_46 vdout0_46ck36 = 0 time = 185
* CHECK dout0_47 vdout0_47ck36 = 1.1 time = 185
* CHECK dout0_48 vdout0_48ck36 = 0 time = 185
* CHECK dout0_49 vdout0_49ck36 = 0 time = 185
* CHECK dout0_50 vdout0_50ck36 = 0 time = 185
* CHECK dout0_51 vdout0_51ck36 = 0 time = 185
* CHECK dout0_52 vdout0_52ck36 = 1.1 time = 185
* CHECK dout0_53 vdout0_53ck36 = 1.1 time = 185
* CHECK dout0_54 vdout0_54ck36 = 0 time = 185
* CHECK dout0_55 vdout0_55ck36 = 0 time = 185
* CHECK dout0_56 vdout0_56ck36 = 0 time = 185
* CHECK dout0_57 vdout0_57ck36 = 1.1 time = 185
* CHECK dout0_58 vdout0_58ck36 = 1.1 time = 185
* CHECK dout0_59 vdout0_59ck36 = 1.1 time = 185
* CHECK dout0_60 vdout0_60ck36 = 1.1 time = 185
* CHECK dout0_61 vdout0_61ck36 = 0 time = 185
* CHECK dout0_62 vdout0_62ck36 = 0 time = 185
* CHECK dout0_63 vdout0_63ck36 = 0 time = 185
* CHECK dout0_0 vdout0_0ck38 = 1.1 time = 195
* CHECK dout0_1 vdout0_1ck38 = 0 time = 195
* CHECK dout0_2 vdout0_2ck38 = 1.1 time = 195
* CHECK dout0_3 vdout0_3ck38 = 1.1 time = 195
* CHECK dout0_4 vdout0_4ck38 = 0 time = 195
* CHECK dout0_5 vdout0_5ck38 = 0 time = 195
* CHECK dout0_6 vdout0_6ck38 = 1.1 time = 195
* CHECK dout0_7 vdout0_7ck38 = 0 time = 195
* CHECK dout0_8 vdout0_8ck38 = 0 time = 195
* CHECK dout0_9 vdout0_9ck38 = 0 time = 195
* CHECK dout0_10 vdout0_10ck38 = 0 time = 195
* CHECK dout0_11 vdout0_11ck38 = 0 time = 195
* CHECK dout0_12 vdout0_12ck38 = 1.1 time = 195
* CHECK dout0_13 vdout0_13ck38 = 0 time = 195
* CHECK dout0_14 vdout0_14ck38 = 0 time = 195
* CHECK dout0_15 vdout0_15ck38 = 1.1 time = 195
* CHECK dout0_16 vdout0_16ck38 = 0 time = 195
* CHECK dout0_17 vdout0_17ck38 = 1.1 time = 195
* CHECK dout0_18 vdout0_18ck38 = 0 time = 195
* CHECK dout0_19 vdout0_19ck38 = 0 time = 195
* CHECK dout0_20 vdout0_20ck38 = 1.1 time = 195
* CHECK dout0_21 vdout0_21ck38 = 1.1 time = 195
* CHECK dout0_22 vdout0_22ck38 = 0 time = 195
* CHECK dout0_23 vdout0_23ck38 = 1.1 time = 195
* CHECK dout0_24 vdout0_24ck38 = 1.1 time = 195
* CHECK dout0_25 vdout0_25ck38 = 1.1 time = 195
* CHECK dout0_26 vdout0_26ck38 = 0 time = 195
* CHECK dout0_27 vdout0_27ck38 = 1.1 time = 195
* CHECK dout0_28 vdout0_28ck38 = 1.1 time = 195
* CHECK dout0_29 vdout0_29ck38 = 0 time = 195
* CHECK dout0_30 vdout0_30ck38 = 1.1 time = 195
* CHECK dout0_31 vdout0_31ck38 = 1.1 time = 195
* CHECK dout0_32 vdout0_32ck38 = 1.1 time = 195
* CHECK dout0_33 vdout0_33ck38 = 0 time = 195
* CHECK dout0_34 vdout0_34ck38 = 1.1 time = 195
* CHECK dout0_35 vdout0_35ck38 = 0 time = 195
* CHECK dout0_36 vdout0_36ck38 = 1.1 time = 195
* CHECK dout0_37 vdout0_37ck38 = 0 time = 195
* CHECK dout0_38 vdout0_38ck38 = 0 time = 195
* CHECK dout0_39 vdout0_39ck38 = 1.1 time = 195
* CHECK dout0_40 vdout0_40ck38 = 0 time = 195
* CHECK dout0_41 vdout0_41ck38 = 1.1 time = 195
* CHECK dout0_42 vdout0_42ck38 = 0 time = 195
* CHECK dout0_43 vdout0_43ck38 = 1.1 time = 195
* CHECK dout0_44 vdout0_44ck38 = 0 time = 195
* CHECK dout0_45 vdout0_45ck38 = 0 time = 195
* CHECK dout0_46 vdout0_46ck38 = 0 time = 195
* CHECK dout0_47 vdout0_47ck38 = 1.1 time = 195
* CHECK dout0_48 vdout0_48ck38 = 0 time = 195
* CHECK dout0_49 vdout0_49ck38 = 0 time = 195
* CHECK dout0_50 vdout0_50ck38 = 0 time = 195
* CHECK dout0_51 vdout0_51ck38 = 0 time = 195
* CHECK dout0_52 vdout0_52ck38 = 1.1 time = 195
* CHECK dout0_53 vdout0_53ck38 = 1.1 time = 195
* CHECK dout0_54 vdout0_54ck38 = 0 time = 195
* CHECK dout0_55 vdout0_55ck38 = 0 time = 195
* CHECK dout0_56 vdout0_56ck38 = 0 time = 195
* CHECK dout0_57 vdout0_57ck38 = 1.1 time = 195
* CHECK dout0_58 vdout0_58ck38 = 1.1 time = 195
* CHECK dout0_59 vdout0_59ck38 = 1.1 time = 195
* CHECK dout0_60 vdout0_60ck38 = 1.1 time = 195
* CHECK dout0_61 vdout0_61ck38 = 0 time = 195
* CHECK dout0_62 vdout0_62ck38 = 0 time = 195
* CHECK dout0_63 vdout0_63ck38 = 0 time = 195
* CHECK dout0_0 vdout0_0ck39 = 1.1 time = 200
* CHECK dout0_1 vdout0_1ck39 = 0 time = 200
* CHECK dout0_2 vdout0_2ck39 = 1.1 time = 200
* CHECK dout0_3 vdout0_3ck39 = 1.1 time = 200
* CHECK dout0_4 vdout0_4ck39 = 0 time = 200
* CHECK dout0_5 vdout0_5ck39 = 0 time = 200
* CHECK dout0_6 vdout0_6ck39 = 1.1 time = 200
* CHECK dout0_7 vdout0_7ck39 = 0 time = 200
* CHECK dout0_8 vdout0_8ck39 = 0 time = 200
* CHECK dout0_9 vdout0_9ck39 = 0 time = 200
* CHECK dout0_10 vdout0_10ck39 = 0 time = 200
* CHECK dout0_11 vdout0_11ck39 = 0 time = 200
* CHECK dout0_12 vdout0_12ck39 = 1.1 time = 200
* CHECK dout0_13 vdout0_13ck39 = 0 time = 200
* CHECK dout0_14 vdout0_14ck39 = 0 time = 200
* CHECK dout0_15 vdout0_15ck39 = 1.1 time = 200
* CHECK dout0_16 vdout0_16ck39 = 0 time = 200
* CHECK dout0_17 vdout0_17ck39 = 1.1 time = 200
* CHECK dout0_18 vdout0_18ck39 = 0 time = 200
* CHECK dout0_19 vdout0_19ck39 = 0 time = 200
* CHECK dout0_20 vdout0_20ck39 = 1.1 time = 200
* CHECK dout0_21 vdout0_21ck39 = 1.1 time = 200
* CHECK dout0_22 vdout0_22ck39 = 0 time = 200
* CHECK dout0_23 vdout0_23ck39 = 1.1 time = 200
* CHECK dout0_24 vdout0_24ck39 = 1.1 time = 200
* CHECK dout0_25 vdout0_25ck39 = 1.1 time = 200
* CHECK dout0_26 vdout0_26ck39 = 0 time = 200
* CHECK dout0_27 vdout0_27ck39 = 1.1 time = 200
* CHECK dout0_28 vdout0_28ck39 = 1.1 time = 200
* CHECK dout0_29 vdout0_29ck39 = 0 time = 200
* CHECK dout0_30 vdout0_30ck39 = 1.1 time = 200
* CHECK dout0_31 vdout0_31ck39 = 1.1 time = 200
* CHECK dout0_32 vdout0_32ck39 = 1.1 time = 200
* CHECK dout0_33 vdout0_33ck39 = 0 time = 200
* CHECK dout0_34 vdout0_34ck39 = 1.1 time = 200
* CHECK dout0_35 vdout0_35ck39 = 0 time = 200
* CHECK dout0_36 vdout0_36ck39 = 1.1 time = 200
* CHECK dout0_37 vdout0_37ck39 = 0 time = 200
* CHECK dout0_38 vdout0_38ck39 = 0 time = 200
* CHECK dout0_39 vdout0_39ck39 = 1.1 time = 200
* CHECK dout0_40 vdout0_40ck39 = 0 time = 200
* CHECK dout0_41 vdout0_41ck39 = 1.1 time = 200
* CHECK dout0_42 vdout0_42ck39 = 0 time = 200
* CHECK dout0_43 vdout0_43ck39 = 1.1 time = 200
* CHECK dout0_44 vdout0_44ck39 = 0 time = 200
* CHECK dout0_45 vdout0_45ck39 = 0 time = 200
* CHECK dout0_46 vdout0_46ck39 = 0 time = 200
* CHECK dout0_47 vdout0_47ck39 = 1.1 time = 200
* CHECK dout0_48 vdout0_48ck39 = 0 time = 200
* CHECK dout0_49 vdout0_49ck39 = 0 time = 200
* CHECK dout0_50 vdout0_50ck39 = 0 time = 200
* CHECK dout0_51 vdout0_51ck39 = 0 time = 200
* CHECK dout0_52 vdout0_52ck39 = 1.1 time = 200
* CHECK dout0_53 vdout0_53ck39 = 1.1 time = 200
* CHECK dout0_54 vdout0_54ck39 = 0 time = 200
* CHECK dout0_55 vdout0_55ck39 = 0 time = 200
* CHECK dout0_56 vdout0_56ck39 = 0 time = 200
* CHECK dout0_57 vdout0_57ck39 = 1.1 time = 200
* CHECK dout0_58 vdout0_58ck39 = 1.1 time = 200
* CHECK dout0_59 vdout0_59ck39 = 1.1 time = 200
* CHECK dout0_60 vdout0_60ck39 = 1.1 time = 200
* CHECK dout0_61 vdout0_61ck39 = 0 time = 200
* CHECK dout0_62 vdout0_62ck39 = 0 time = 200
* CHECK dout0_63 vdout0_63ck39 = 0 time = 200
* CHECK dout0_0 vdout0_0ck43 = 1.1 time = 220
* CHECK dout0_1 vdout0_1ck43 = 0 time = 220
* CHECK dout0_2 vdout0_2ck43 = 0 time = 220
* CHECK dout0_3 vdout0_3ck43 = 0 time = 220
* CHECK dout0_4 vdout0_4ck43 = 0 time = 220
* CHECK dout0_5 vdout0_5ck43 = 1.1 time = 220
* CHECK dout0_6 vdout0_6ck43 = 1.1 time = 220
* CHECK dout0_7 vdout0_7ck43 = 0 time = 220
* CHECK dout0_8 vdout0_8ck43 = 0 time = 220
* CHECK dout0_9 vdout0_9ck43 = 1.1 time = 220
* CHECK dout0_10 vdout0_10ck43 = 1.1 time = 220
* CHECK dout0_11 vdout0_11ck43 = 0 time = 220
* CHECK dout0_12 vdout0_12ck43 = 0 time = 220
* CHECK dout0_13 vdout0_13ck43 = 1.1 time = 220
* CHECK dout0_14 vdout0_14ck43 = 1.1 time = 220
* CHECK dout0_15 vdout0_15ck43 = 0 time = 220
* CHECK dout0_16 vdout0_16ck43 = 0 time = 220
* CHECK dout0_17 vdout0_17ck43 = 0 time = 220
* CHECK dout0_18 vdout0_18ck43 = 1.1 time = 220
* CHECK dout0_19 vdout0_19ck43 = 0 time = 220
* CHECK dout0_20 vdout0_20ck43 = 1.1 time = 220
* CHECK dout0_21 vdout0_21ck43 = 0 time = 220
* CHECK dout0_22 vdout0_22ck43 = 0 time = 220
* CHECK dout0_23 vdout0_23ck43 = 1.1 time = 220
* CHECK dout0_24 vdout0_24ck43 = 0 time = 220
* CHECK dout0_25 vdout0_25ck43 = 1.1 time = 220
* CHECK dout0_26 vdout0_26ck43 = 1.1 time = 220
* CHECK dout0_27 vdout0_27ck43 = 1.1 time = 220
* CHECK dout0_28 vdout0_28ck43 = 1.1 time = 220
* CHECK dout0_29 vdout0_29ck43 = 1.1 time = 220
* CHECK dout0_30 vdout0_30ck43 = 1.1 time = 220
* CHECK dout0_31 vdout0_31ck43 = 1.1 time = 220
* CHECK dout0_32 vdout0_32ck43 = 1.1 time = 220
* CHECK dout0_33 vdout0_33ck43 = 0 time = 220
* CHECK dout0_34 vdout0_34ck43 = 1.1 time = 220
* CHECK dout0_35 vdout0_35ck43 = 0 time = 220
* CHECK dout0_36 vdout0_36ck43 = 0 time = 220
* CHECK dout0_37 vdout0_37ck43 = 0 time = 220
* CHECK dout0_38 vdout0_38ck43 = 1.1 time = 220
* CHECK dout0_39 vdout0_39ck43 = 1.1 time = 220
* CHECK dout0_40 vdout0_40ck43 = 1.1 time = 220
* CHECK dout0_41 vdout0_41ck43 = 0 time = 220
* CHECK dout0_42 vdout0_42ck43 = 1.1 time = 220
* CHECK dout0_43 vdout0_43ck43 = 1.1 time = 220
* CHECK dout0_44 vdout0_44ck43 = 0 time = 220
* CHECK dout0_45 vdout0_45ck43 = 0 time = 220
* CHECK dout0_46 vdout0_46ck43 = 1.1 time = 220
* CHECK dout0_47 vdout0_47ck43 = 0 time = 220
* CHECK dout0_48 vdout0_48ck43 = 1.1 time = 220
* CHECK dout0_49 vdout0_49ck43 = 1.1 time = 220
* CHECK dout0_50 vdout0_50ck43 = 1.1 time = 220
* CHECK dout0_51 vdout0_51ck43 = 1.1 time = 220
* CHECK dout0_52 vdout0_52ck43 = 0 time = 220
* CHECK dout0_53 vdout0_53ck43 = 0 time = 220
* CHECK dout0_54 vdout0_54ck43 = 1.1 time = 220
* CHECK dout0_55 vdout0_55ck43 = 1.1 time = 220
* CHECK dout0_56 vdout0_56ck43 = 1.1 time = 220
* CHECK dout0_57 vdout0_57ck43 = 1.1 time = 220
* CHECK dout0_58 vdout0_58ck43 = 1.1 time = 220
* CHECK dout0_59 vdout0_59ck43 = 0 time = 220
* CHECK dout0_60 vdout0_60ck43 = 0 time = 220
* CHECK dout0_61 vdout0_61ck43 = 1.1 time = 220
* CHECK dout0_62 vdout0_62ck43 = 1.1 time = 220
* CHECK dout0_63 vdout0_63ck43 = 1.1 time = 220
* CHECK dout0_0 vdout0_0ck45 = 0 time = 230
* CHECK dout0_1 vdout0_1ck45 = 0 time = 230
* CHECK dout0_2 vdout0_2ck45 = 1.1 time = 230
* CHECK dout0_3 vdout0_3ck45 = 0 time = 230
* CHECK dout0_4 vdout0_4ck45 = 0 time = 230
* CHECK dout0_5 vdout0_5ck45 = 1.1 time = 230
* CHECK dout0_6 vdout0_6ck45 = 0 time = 230
* CHECK dout0_7 vdout0_7ck45 = 0 time = 230
* CHECK dout0_8 vdout0_8ck45 = 0 time = 230
* CHECK dout0_9 vdout0_9ck45 = 1.1 time = 230
* CHECK dout0_10 vdout0_10ck45 = 1.1 time = 230
* CHECK dout0_11 vdout0_11ck45 = 0 time = 230
* CHECK dout0_12 vdout0_12ck45 = 1.1 time = 230
* CHECK dout0_13 vdout0_13ck45 = 0 time = 230
* CHECK dout0_14 vdout0_14ck45 = 1.1 time = 230
* CHECK dout0_15 vdout0_15ck45 = 1.1 time = 230
* CHECK dout0_16 vdout0_16ck45 = 1.1 time = 230
* CHECK dout0_17 vdout0_17ck45 = 1.1 time = 230
* CHECK dout0_18 vdout0_18ck45 = 1.1 time = 230
* CHECK dout0_19 vdout0_19ck45 = 1.1 time = 230
* CHECK dout0_20 vdout0_20ck45 = 1.1 time = 230
* CHECK dout0_21 vdout0_21ck45 = 1.1 time = 230
* CHECK dout0_22 vdout0_22ck45 = 0 time = 230
* CHECK dout0_23 vdout0_23ck45 = 0 time = 230
* CHECK dout0_24 vdout0_24ck45 = 1.1 time = 230
* CHECK dout0_25 vdout0_25ck45 = 1.1 time = 230
* CHECK dout0_26 vdout0_26ck45 = 0 time = 230
* CHECK dout0_27 vdout0_27ck45 = 1.1 time = 230
* CHECK dout0_28 vdout0_28ck45 = 1.1 time = 230
* CHECK dout0_29 vdout0_29ck45 = 0 time = 230
* CHECK dout0_30 vdout0_30ck45 = 1.1 time = 230
* CHECK dout0_31 vdout0_31ck45 = 1.1 time = 230
* CHECK dout0_32 vdout0_32ck45 = 1.1 time = 230
* CHECK dout0_33 vdout0_33ck45 = 0 time = 230
* CHECK dout0_34 vdout0_34ck45 = 1.1 time = 230
* CHECK dout0_35 vdout0_35ck45 = 0 time = 230
* CHECK dout0_36 vdout0_36ck45 = 1.1 time = 230
* CHECK dout0_37 vdout0_37ck45 = 0 time = 230
* CHECK dout0_38 vdout0_38ck45 = 0 time = 230
* CHECK dout0_39 vdout0_39ck45 = 1.1 time = 230
* CHECK dout0_40 vdout0_40ck45 = 1.1 time = 230
* CHECK dout0_41 vdout0_41ck45 = 1.1 time = 230
* CHECK dout0_42 vdout0_42ck45 = 0 time = 230
* CHECK dout0_43 vdout0_43ck45 = 0 time = 230
* CHECK dout0_44 vdout0_44ck45 = 0 time = 230
* CHECK dout0_45 vdout0_45ck45 = 0 time = 230
* CHECK dout0_46 vdout0_46ck45 = 0 time = 230
* CHECK dout0_47 vdout0_47ck45 = 0 time = 230
* CHECK dout0_48 vdout0_48ck45 = 1.1 time = 230
* CHECK dout0_49 vdout0_49ck45 = 0 time = 230
* CHECK dout0_50 vdout0_50ck45 = 1.1 time = 230
* CHECK dout0_51 vdout0_51ck45 = 1.1 time = 230
* CHECK dout0_52 vdout0_52ck45 = 0 time = 230
* CHECK dout0_53 vdout0_53ck45 = 1.1 time = 230
* CHECK dout0_54 vdout0_54ck45 = 0 time = 230
* CHECK dout0_55 vdout0_55ck45 = 0 time = 230
* CHECK dout0_56 vdout0_56ck45 = 0 time = 230
* CHECK dout0_57 vdout0_57ck45 = 1.1 time = 230
* CHECK dout0_58 vdout0_58ck45 = 1.1 time = 230
* CHECK dout0_59 vdout0_59ck45 = 0 time = 230
* CHECK dout0_60 vdout0_60ck45 = 0 time = 230
* CHECK dout0_61 vdout0_61ck45 = 1.1 time = 230
* CHECK dout0_62 vdout0_62ck45 = 1.1 time = 230
* CHECK dout0_63 vdout0_63ck45 = 1.1 time = 230
* CHECK dout0_0 vdout0_0ck47 = 1.1 time = 240
* CHECK dout0_1 vdout0_1ck47 = 0 time = 240
* CHECK dout0_2 vdout0_2ck47 = 0 time = 240
* CHECK dout0_3 vdout0_3ck47 = 0 time = 240
* CHECK dout0_4 vdout0_4ck47 = 0 time = 240
* CHECK dout0_5 vdout0_5ck47 = 1.1 time = 240
* CHECK dout0_6 vdout0_6ck47 = 1.1 time = 240
* CHECK dout0_7 vdout0_7ck47 = 0 time = 240
* CHECK dout0_8 vdout0_8ck47 = 0 time = 240
* CHECK dout0_9 vdout0_9ck47 = 1.1 time = 240
* CHECK dout0_10 vdout0_10ck47 = 1.1 time = 240
* CHECK dout0_11 vdout0_11ck47 = 0 time = 240
* CHECK dout0_12 vdout0_12ck47 = 0 time = 240
* CHECK dout0_13 vdout0_13ck47 = 1.1 time = 240
* CHECK dout0_14 vdout0_14ck47 = 1.1 time = 240
* CHECK dout0_15 vdout0_15ck47 = 0 time = 240
* CHECK dout0_16 vdout0_16ck47 = 0 time = 240
* CHECK dout0_17 vdout0_17ck47 = 0 time = 240
* CHECK dout0_18 vdout0_18ck47 = 1.1 time = 240
* CHECK dout0_19 vdout0_19ck47 = 0 time = 240
* CHECK dout0_20 vdout0_20ck47 = 1.1 time = 240
* CHECK dout0_21 vdout0_21ck47 = 0 time = 240
* CHECK dout0_22 vdout0_22ck47 = 0 time = 240
* CHECK dout0_23 vdout0_23ck47 = 1.1 time = 240
* CHECK dout0_24 vdout0_24ck47 = 0 time = 240
* CHECK dout0_25 vdout0_25ck47 = 1.1 time = 240
* CHECK dout0_26 vdout0_26ck47 = 1.1 time = 240
* CHECK dout0_27 vdout0_27ck47 = 1.1 time = 240
* CHECK dout0_28 vdout0_28ck47 = 1.1 time = 240
* CHECK dout0_29 vdout0_29ck47 = 1.1 time = 240
* CHECK dout0_30 vdout0_30ck47 = 1.1 time = 240
* CHECK dout0_31 vdout0_31ck47 = 1.1 time = 240
* CHECK dout0_32 vdout0_32ck47 = 1.1 time = 240
* CHECK dout0_33 vdout0_33ck47 = 0 time = 240
* CHECK dout0_34 vdout0_34ck47 = 1.1 time = 240
* CHECK dout0_35 vdout0_35ck47 = 0 time = 240
* CHECK dout0_36 vdout0_36ck47 = 0 time = 240
* CHECK dout0_37 vdout0_37ck47 = 0 time = 240
* CHECK dout0_38 vdout0_38ck47 = 1.1 time = 240
* CHECK dout0_39 vdout0_39ck47 = 1.1 time = 240
* CHECK dout0_40 vdout0_40ck47 = 1.1 time = 240
* CHECK dout0_41 vdout0_41ck47 = 0 time = 240
* CHECK dout0_42 vdout0_42ck47 = 1.1 time = 240
* CHECK dout0_43 vdout0_43ck47 = 1.1 time = 240
* CHECK dout0_44 vdout0_44ck47 = 0 time = 240
* CHECK dout0_45 vdout0_45ck47 = 0 time = 240
* CHECK dout0_46 vdout0_46ck47 = 1.1 time = 240
* CHECK dout0_47 vdout0_47ck47 = 0 time = 240
* CHECK dout0_48 vdout0_48ck47 = 1.1 time = 240
* CHECK dout0_49 vdout0_49ck47 = 1.1 time = 240
* CHECK dout0_50 vdout0_50ck47 = 1.1 time = 240
* CHECK dout0_51 vdout0_51ck47 = 1.1 time = 240
* CHECK dout0_52 vdout0_52ck47 = 0 time = 240
* CHECK dout0_53 vdout0_53ck47 = 0 time = 240
* CHECK dout0_54 vdout0_54ck47 = 1.1 time = 240
* CHECK dout0_55 vdout0_55ck47 = 1.1 time = 240
* CHECK dout0_56 vdout0_56ck47 = 1.1 time = 240
* CHECK dout0_57 vdout0_57ck47 = 1.1 time = 240
* CHECK dout0_58 vdout0_58ck47 = 1.1 time = 240
* CHECK dout0_59 vdout0_59ck47 = 0 time = 240
* CHECK dout0_60 vdout0_60ck47 = 0 time = 240
* CHECK dout0_61 vdout0_61ck47 = 1.1 time = 240
* CHECK dout0_62 vdout0_62ck47 = 1.1 time = 240
* CHECK dout0_63 vdout0_63ck47 = 1.1 time = 240
* CHECK dout0_0 vdout0_0ck49 = 1.1 time = 250
* CHECK dout0_1 vdout0_1ck49 = 0 time = 250
* CHECK dout0_2 vdout0_2ck49 = 0 time = 250
* CHECK dout0_3 vdout0_3ck49 = 0 time = 250
* CHECK dout0_4 vdout0_4ck49 = 0 time = 250
* CHECK dout0_5 vdout0_5ck49 = 0 time = 250
* CHECK dout0_6 vdout0_6ck49 = 1.1 time = 250
* CHECK dout0_7 vdout0_7ck49 = 1.1 time = 250
* CHECK dout0_8 vdout0_8ck49 = 1.1 time = 250
* CHECK dout0_9 vdout0_9ck49 = 1.1 time = 250
* CHECK dout0_10 vdout0_10ck49 = 1.1 time = 250
* CHECK dout0_11 vdout0_11ck49 = 1.1 time = 250
* CHECK dout0_12 vdout0_12ck49 = 0 time = 250
* CHECK dout0_13 vdout0_13ck49 = 1.1 time = 250
* CHECK dout0_14 vdout0_14ck49 = 0 time = 250
* CHECK dout0_15 vdout0_15ck49 = 1.1 time = 250
* CHECK dout0_16 vdout0_16ck49 = 1.1 time = 250
* CHECK dout0_17 vdout0_17ck49 = 0 time = 250
* CHECK dout0_18 vdout0_18ck49 = 0 time = 250
* CHECK dout0_19 vdout0_19ck49 = 0 time = 250
* CHECK dout0_20 vdout0_20ck49 = 0 time = 250
* CHECK dout0_21 vdout0_21ck49 = 0 time = 250
* CHECK dout0_22 vdout0_22ck49 = 1.1 time = 250
* CHECK dout0_23 vdout0_23ck49 = 1.1 time = 250
* CHECK dout0_24 vdout0_24ck49 = 1.1 time = 250
* CHECK dout0_25 vdout0_25ck49 = 1.1 time = 250
* CHECK dout0_26 vdout0_26ck49 = 1.1 time = 250
* CHECK dout0_27 vdout0_27ck49 = 1.1 time = 250
* CHECK dout0_28 vdout0_28ck49 = 0 time = 250
* CHECK dout0_29 vdout0_29ck49 = 1.1 time = 250
* CHECK dout0_30 vdout0_30ck49 = 1.1 time = 250
* CHECK dout0_31 vdout0_31ck49 = 0 time = 250
* CHECK dout0_32 vdout0_32ck49 = 1.1 time = 250
* CHECK dout0_33 vdout0_33ck49 = 1.1 time = 250
* CHECK dout0_34 vdout0_34ck49 = 0 time = 250
* CHECK dout0_35 vdout0_35ck49 = 1.1 time = 250
* CHECK dout0_36 vdout0_36ck49 = 0 time = 250
* CHECK dout0_37 vdout0_37ck49 = 1.1 time = 250
* CHECK dout0_38 vdout0_38ck49 = 1.1 time = 250
* CHECK dout0_39 vdout0_39ck49 = 0 time = 250
* CHECK dout0_40 vdout0_40ck49 = 1.1 time = 250
* CHECK dout0_41 vdout0_41ck49 = 0 time = 250
* CHECK dout0_42 vdout0_42ck49 = 0 time = 250
* CHECK dout0_43 vdout0_43ck49 = 0 time = 250
* CHECK dout0_44 vdout0_44ck49 = 1.1 time = 250
* CHECK dout0_45 vdout0_45ck49 = 1.1 time = 250
* CHECK dout0_46 vdout0_46ck49 = 0 time = 250
* CHECK dout0_47 vdout0_47ck49 = 1.1 time = 250
* CHECK dout0_48 vdout0_48ck49 = 1.1 time = 250
* CHECK dout0_49 vdout0_49ck49 = 0 time = 250
* CHECK dout0_50 vdout0_50ck49 = 0 time = 250
* CHECK dout0_51 vdout0_51ck49 = 1.1 time = 250
* CHECK dout0_52 vdout0_52ck49 = 1.1 time = 250
* CHECK dout0_53 vdout0_53ck49 = 1.1 time = 250
* CHECK dout0_54 vdout0_54ck49 = 0 time = 250
* CHECK dout0_55 vdout0_55ck49 = 0 time = 250
* CHECK dout0_56 vdout0_56ck49 = 1.1 time = 250
* CHECK dout0_57 vdout0_57ck49 = 0 time = 250
* CHECK dout0_58 vdout0_58ck49 = 1.1 time = 250
* CHECK dout0_59 vdout0_59ck49 = 0 time = 250
* CHECK dout0_60 vdout0_60ck49 = 0 time = 250
* CHECK dout0_61 vdout0_61ck49 = 1.1 time = 250
* CHECK dout0_62 vdout0_62ck49 = 0 time = 250
* CHECK dout0_63 vdout0_63ck49 = 0 time = 250
* CHECK dout0_0 vdout0_0ck50 = 1.1 time = 255
* CHECK dout0_1 vdout0_1ck50 = 0 time = 255
* CHECK dout0_2 vdout0_2ck50 = 0 time = 255
* CHECK dout0_3 vdout0_3ck50 = 0 time = 255
* CHECK dout0_4 vdout0_4ck50 = 0 time = 255
* CHECK dout0_5 vdout0_5ck50 = 0 time = 255
* CHECK dout0_6 vdout0_6ck50 = 1.1 time = 255
* CHECK dout0_7 vdout0_7ck50 = 1.1 time = 255
* CHECK dout0_8 vdout0_8ck50 = 1.1 time = 255
* CHECK dout0_9 vdout0_9ck50 = 1.1 time = 255
* CHECK dout0_10 vdout0_10ck50 = 1.1 time = 255
* CHECK dout0_11 vdout0_11ck50 = 1.1 time = 255
* CHECK dout0_12 vdout0_12ck50 = 0 time = 255
* CHECK dout0_13 vdout0_13ck50 = 1.1 time = 255
* CHECK dout0_14 vdout0_14ck50 = 0 time = 255
* CHECK dout0_15 vdout0_15ck50 = 1.1 time = 255
* CHECK dout0_16 vdout0_16ck50 = 1.1 time = 255
* CHECK dout0_17 vdout0_17ck50 = 0 time = 255
* CHECK dout0_18 vdout0_18ck50 = 0 time = 255
* CHECK dout0_19 vdout0_19ck50 = 0 time = 255
* CHECK dout0_20 vdout0_20ck50 = 0 time = 255
* CHECK dout0_21 vdout0_21ck50 = 0 time = 255
* CHECK dout0_22 vdout0_22ck50 = 1.1 time = 255
* CHECK dout0_23 vdout0_23ck50 = 1.1 time = 255
* CHECK dout0_24 vdout0_24ck50 = 1.1 time = 255
* CHECK dout0_25 vdout0_25ck50 = 1.1 time = 255
* CHECK dout0_26 vdout0_26ck50 = 1.1 time = 255
* CHECK dout0_27 vdout0_27ck50 = 1.1 time = 255
* CHECK dout0_28 vdout0_28ck50 = 0 time = 255
* CHECK dout0_29 vdout0_29ck50 = 1.1 time = 255
* CHECK dout0_30 vdout0_30ck50 = 1.1 time = 255
* CHECK dout0_31 vdout0_31ck50 = 0 time = 255
* CHECK dout0_32 vdout0_32ck50 = 1.1 time = 255
* CHECK dout0_33 vdout0_33ck50 = 1.1 time = 255
* CHECK dout0_34 vdout0_34ck50 = 0 time = 255
* CHECK dout0_35 vdout0_35ck50 = 1.1 time = 255
* CHECK dout0_36 vdout0_36ck50 = 0 time = 255
* CHECK dout0_37 vdout0_37ck50 = 1.1 time = 255
* CHECK dout0_38 vdout0_38ck50 = 1.1 time = 255
* CHECK dout0_39 vdout0_39ck50 = 0 time = 255
* CHECK dout0_40 vdout0_40ck50 = 1.1 time = 255
* CHECK dout0_41 vdout0_41ck50 = 0 time = 255
* CHECK dout0_42 vdout0_42ck50 = 0 time = 255
* CHECK dout0_43 vdout0_43ck50 = 0 time = 255
* CHECK dout0_44 vdout0_44ck50 = 1.1 time = 255
* CHECK dout0_45 vdout0_45ck50 = 1.1 time = 255
* CHECK dout0_46 vdout0_46ck50 = 0 time = 255
* CHECK dout0_47 vdout0_47ck50 = 1.1 time = 255
* CHECK dout0_48 vdout0_48ck50 = 1.1 time = 255
* CHECK dout0_49 vdout0_49ck50 = 0 time = 255
* CHECK dout0_50 vdout0_50ck50 = 0 time = 255
* CHECK dout0_51 vdout0_51ck50 = 1.1 time = 255
* CHECK dout0_52 vdout0_52ck50 = 1.1 time = 255
* CHECK dout0_53 vdout0_53ck50 = 1.1 time = 255
* CHECK dout0_54 vdout0_54ck50 = 0 time = 255
* CHECK dout0_55 vdout0_55ck50 = 0 time = 255
* CHECK dout0_56 vdout0_56ck50 = 1.1 time = 255
* CHECK dout0_57 vdout0_57ck50 = 0 time = 255
* CHECK dout0_58 vdout0_58ck50 = 1.1 time = 255
* CHECK dout0_59 vdout0_59ck50 = 0 time = 255
* CHECK dout0_60 vdout0_60ck50 = 0 time = 255
* CHECK dout0_61 vdout0_61ck50 = 1.1 time = 255
* CHECK dout0_62 vdout0_62ck50 = 0 time = 255
* CHECK dout0_63 vdout0_63ck50 = 0 time = 255
* CHECK dout0_0 vdout0_0ck55 = 1.1 time = 280
* CHECK dout0_1 vdout0_1ck55 = 0 time = 280
* CHECK dout0_2 vdout0_2ck55 = 1.1 time = 280
* CHECK dout0_3 vdout0_3ck55 = 1.1 time = 280
* CHECK dout0_4 vdout0_4ck55 = 1.1 time = 280
* CHECK dout0_5 vdout0_5ck55 = 1.1 time = 280
* CHECK dout0_6 vdout0_6ck55 = 0 time = 280
* CHECK dout0_7 vdout0_7ck55 = 0 time = 280
* CHECK dout0_8 vdout0_8ck55 = 1.1 time = 280
* CHECK dout0_9 vdout0_9ck55 = 0 time = 280
* CHECK dout0_10 vdout0_10ck55 = 0 time = 280
* CHECK dout0_11 vdout0_11ck55 = 1.1 time = 280
* CHECK dout0_12 vdout0_12ck55 = 1.1 time = 280
* CHECK dout0_13 vdout0_13ck55 = 0 time = 280
* CHECK dout0_14 vdout0_14ck55 = 0 time = 280
* CHECK dout0_15 vdout0_15ck55 = 1.1 time = 280
* CHECK dout0_16 vdout0_16ck55 = 0 time = 280
* CHECK dout0_17 vdout0_17ck55 = 0 time = 280
* CHECK dout0_18 vdout0_18ck55 = 0 time = 280
* CHECK dout0_19 vdout0_19ck55 = 1.1 time = 280
* CHECK dout0_20 vdout0_20ck55 = 0 time = 280
* CHECK dout0_21 vdout0_21ck55 = 0 time = 280
* CHECK dout0_22 vdout0_22ck55 = 0 time = 280
* CHECK dout0_23 vdout0_23ck55 = 0 time = 280
* CHECK dout0_24 vdout0_24ck55 = 1.1 time = 280
* CHECK dout0_25 vdout0_25ck55 = 0 time = 280
* CHECK dout0_26 vdout0_26ck55 = 0 time = 280
* CHECK dout0_27 vdout0_27ck55 = 1.1 time = 280
* CHECK dout0_28 vdout0_28ck55 = 0 time = 280
* CHECK dout0_29 vdout0_29ck55 = 0 time = 280
* CHECK dout0_30 vdout0_30ck55 = 0 time = 280
* CHECK dout0_31 vdout0_31ck55 = 0 time = 280
* CHECK dout0_32 vdout0_32ck55 = 0 time = 280
* CHECK dout0_33 vdout0_33ck55 = 0 time = 280
* CHECK dout0_34 vdout0_34ck55 = 0 time = 280
* CHECK dout0_35 vdout0_35ck55 = 1.1 time = 280
* CHECK dout0_36 vdout0_36ck55 = 0 time = 280
* CHECK dout0_37 vdout0_37ck55 = 1.1 time = 280
* CHECK dout0_38 vdout0_38ck55 = 1.1 time = 280
* CHECK dout0_39 vdout0_39ck55 = 1.1 time = 280
* CHECK dout0_40 vdout0_40ck55 = 0 time = 280
* CHECK dout0_41 vdout0_41ck55 = 0 time = 280
* CHECK dout0_42 vdout0_42ck55 = 0 time = 280
* CHECK dout0_43 vdout0_43ck55 = 0 time = 280
* CHECK dout0_44 vdout0_44ck55 = 0 time = 280
* CHECK dout0_45 vdout0_45ck55 = 1.1 time = 280
* CHECK dout0_46 vdout0_46ck55 = 0 time = 280
* CHECK dout0_47 vdout0_47ck55 = 1.1 time = 280
* CHECK dout0_48 vdout0_48ck55 = 1.1 time = 280
* CHECK dout0_49 vdout0_49ck55 = 0 time = 280
* CHECK dout0_50 vdout0_50ck55 = 1.1 time = 280
* CHECK dout0_51 vdout0_51ck55 = 1.1 time = 280
* CHECK dout0_52 vdout0_52ck55 = 0 time = 280
* CHECK dout0_53 vdout0_53ck55 = 1.1 time = 280
* CHECK dout0_54 vdout0_54ck55 = 0 time = 280
* CHECK dout0_55 vdout0_55ck55 = 0 time = 280
* CHECK dout0_56 vdout0_56ck55 = 1.1 time = 280
* CHECK dout0_57 vdout0_57ck55 = 0 time = 280
* CHECK dout0_58 vdout0_58ck55 = 0 time = 280
* CHECK dout0_59 vdout0_59ck55 = 1.1 time = 280
* CHECK dout0_60 vdout0_60ck55 = 1.1 time = 280
* CHECK dout0_61 vdout0_61ck55 = 0 time = 280
* CHECK dout0_62 vdout0_62ck55 = 1.1 time = 280
* CHECK dout0_63 vdout0_63ck55 = 0 time = 280
* CHECK dout0_0 vdout0_0ck57 = 1.1 time = 290
* CHECK dout0_1 vdout0_1ck57 = 0 time = 290
* CHECK dout0_2 vdout0_2ck57 = 1.1 time = 290
* CHECK dout0_3 vdout0_3ck57 = 1.1 time = 290
* CHECK dout0_4 vdout0_4ck57 = 1.1 time = 290
* CHECK dout0_5 vdout0_5ck57 = 1.1 time = 290
* CHECK dout0_6 vdout0_6ck57 = 0 time = 290
* CHECK dout0_7 vdout0_7ck57 = 0 time = 290
* CHECK dout0_8 vdout0_8ck57 = 1.1 time = 290
* CHECK dout0_9 vdout0_9ck57 = 0 time = 290
* CHECK dout0_10 vdout0_10ck57 = 0 time = 290
* CHECK dout0_11 vdout0_11ck57 = 1.1 time = 290
* CHECK dout0_12 vdout0_12ck57 = 1.1 time = 290
* CHECK dout0_13 vdout0_13ck57 = 0 time = 290
* CHECK dout0_14 vdout0_14ck57 = 0 time = 290
* CHECK dout0_15 vdout0_15ck57 = 1.1 time = 290
* CHECK dout0_16 vdout0_16ck57 = 0 time = 290
* CHECK dout0_17 vdout0_17ck57 = 0 time = 290
* CHECK dout0_18 vdout0_18ck57 = 0 time = 290
* CHECK dout0_19 vdout0_19ck57 = 1.1 time = 290
* CHECK dout0_20 vdout0_20ck57 = 0 time = 290
* CHECK dout0_21 vdout0_21ck57 = 0 time = 290
* CHECK dout0_22 vdout0_22ck57 = 0 time = 290
* CHECK dout0_23 vdout0_23ck57 = 0 time = 290
* CHECK dout0_24 vdout0_24ck57 = 1.1 time = 290
* CHECK dout0_25 vdout0_25ck57 = 0 time = 290
* CHECK dout0_26 vdout0_26ck57 = 0 time = 290
* CHECK dout0_27 vdout0_27ck57 = 1.1 time = 290
* CHECK dout0_28 vdout0_28ck57 = 0 time = 290
* CHECK dout0_29 vdout0_29ck57 = 0 time = 290
* CHECK dout0_30 vdout0_30ck57 = 0 time = 290
* CHECK dout0_31 vdout0_31ck57 = 0 time = 290
* CHECK dout0_32 vdout0_32ck57 = 0 time = 290
* CHECK dout0_33 vdout0_33ck57 = 0 time = 290
* CHECK dout0_34 vdout0_34ck57 = 0 time = 290
* CHECK dout0_35 vdout0_35ck57 = 1.1 time = 290
* CHECK dout0_36 vdout0_36ck57 = 0 time = 290
* CHECK dout0_37 vdout0_37ck57 = 1.1 time = 290
* CHECK dout0_38 vdout0_38ck57 = 1.1 time = 290
* CHECK dout0_39 vdout0_39ck57 = 1.1 time = 290
* CHECK dout0_40 vdout0_40ck57 = 0 time = 290
* CHECK dout0_41 vdout0_41ck57 = 0 time = 290
* CHECK dout0_42 vdout0_42ck57 = 0 time = 290
* CHECK dout0_43 vdout0_43ck57 = 0 time = 290
* CHECK dout0_44 vdout0_44ck57 = 0 time = 290
* CHECK dout0_45 vdout0_45ck57 = 1.1 time = 290
* CHECK dout0_46 vdout0_46ck57 = 0 time = 290
* CHECK dout0_47 vdout0_47ck57 = 1.1 time = 290
* CHECK dout0_48 vdout0_48ck57 = 1.1 time = 290
* CHECK dout0_49 vdout0_49ck57 = 0 time = 290
* CHECK dout0_50 vdout0_50ck57 = 1.1 time = 290
* CHECK dout0_51 vdout0_51ck57 = 1.1 time = 290
* CHECK dout0_52 vdout0_52ck57 = 0 time = 290
* CHECK dout0_53 vdout0_53ck57 = 1.1 time = 290
* CHECK dout0_54 vdout0_54ck57 = 0 time = 290
* CHECK dout0_55 vdout0_55ck57 = 0 time = 290
* CHECK dout0_56 vdout0_56ck57 = 1.1 time = 290
* CHECK dout0_57 vdout0_57ck57 = 0 time = 290
* CHECK dout0_58 vdout0_58ck57 = 0 time = 290
* CHECK dout0_59 vdout0_59ck57 = 1.1 time = 290
* CHECK dout0_60 vdout0_60ck57 = 1.1 time = 290
* CHECK dout0_61 vdout0_61ck57 = 0 time = 290
* CHECK dout0_62 vdout0_62ck57 = 1.1 time = 290
* CHECK dout0_63 vdout0_63ck57 = 0 time = 290
* CHECK dout0_0 vdout0_0ck59 = 1.1 time = 300
* CHECK dout0_1 vdout0_1ck59 = 0 time = 300
* CHECK dout0_2 vdout0_2ck59 = 1.1 time = 300
* CHECK dout0_3 vdout0_3ck59 = 1.1 time = 300
* CHECK dout0_4 vdout0_4ck59 = 1.1 time = 300
* CHECK dout0_5 vdout0_5ck59 = 1.1 time = 300
* CHECK dout0_6 vdout0_6ck59 = 0 time = 300
* CHECK dout0_7 vdout0_7ck59 = 0 time = 300
* CHECK dout0_8 vdout0_8ck59 = 1.1 time = 300
* CHECK dout0_9 vdout0_9ck59 = 0 time = 300
* CHECK dout0_10 vdout0_10ck59 = 0 time = 300
* CHECK dout0_11 vdout0_11ck59 = 1.1 time = 300
* CHECK dout0_12 vdout0_12ck59 = 1.1 time = 300
* CHECK dout0_13 vdout0_13ck59 = 0 time = 300
* CHECK dout0_14 vdout0_14ck59 = 0 time = 300
* CHECK dout0_15 vdout0_15ck59 = 1.1 time = 300
* CHECK dout0_16 vdout0_16ck59 = 0 time = 300
* CHECK dout0_17 vdout0_17ck59 = 0 time = 300
* CHECK dout0_18 vdout0_18ck59 = 0 time = 300
* CHECK dout0_19 vdout0_19ck59 = 1.1 time = 300
* CHECK dout0_20 vdout0_20ck59 = 0 time = 300
* CHECK dout0_21 vdout0_21ck59 = 0 time = 300
* CHECK dout0_22 vdout0_22ck59 = 0 time = 300
* CHECK dout0_23 vdout0_23ck59 = 0 time = 300
* CHECK dout0_24 vdout0_24ck59 = 1.1 time = 300
* CHECK dout0_25 vdout0_25ck59 = 0 time = 300
* CHECK dout0_26 vdout0_26ck59 = 0 time = 300
* CHECK dout0_27 vdout0_27ck59 = 1.1 time = 300
* CHECK dout0_28 vdout0_28ck59 = 0 time = 300
* CHECK dout0_29 vdout0_29ck59 = 0 time = 300
* CHECK dout0_30 vdout0_30ck59 = 0 time = 300
* CHECK dout0_31 vdout0_31ck59 = 0 time = 300
* CHECK dout0_32 vdout0_32ck59 = 0 time = 300
* CHECK dout0_33 vdout0_33ck59 = 0 time = 300
* CHECK dout0_34 vdout0_34ck59 = 0 time = 300
* CHECK dout0_35 vdout0_35ck59 = 1.1 time = 300
* CHECK dout0_36 vdout0_36ck59 = 0 time = 300
* CHECK dout0_37 vdout0_37ck59 = 1.1 time = 300
* CHECK dout0_38 vdout0_38ck59 = 1.1 time = 300
* CHECK dout0_39 vdout0_39ck59 = 1.1 time = 300
* CHECK dout0_40 vdout0_40ck59 = 0 time = 300
* CHECK dout0_41 vdout0_41ck59 = 0 time = 300
* CHECK dout0_42 vdout0_42ck59 = 0 time = 300
* CHECK dout0_43 vdout0_43ck59 = 0 time = 300
* CHECK dout0_44 vdout0_44ck59 = 0 time = 300
* CHECK dout0_45 vdout0_45ck59 = 1.1 time = 300
* CHECK dout0_46 vdout0_46ck59 = 0 time = 300
* CHECK dout0_47 vdout0_47ck59 = 1.1 time = 300
* CHECK dout0_48 vdout0_48ck59 = 1.1 time = 300
* CHECK dout0_49 vdout0_49ck59 = 0 time = 300
* CHECK dout0_50 vdout0_50ck59 = 1.1 time = 300
* CHECK dout0_51 vdout0_51ck59 = 1.1 time = 300
* CHECK dout0_52 vdout0_52ck59 = 0 time = 300
* CHECK dout0_53 vdout0_53ck59 = 1.1 time = 300
* CHECK dout0_54 vdout0_54ck59 = 0 time = 300
* CHECK dout0_55 vdout0_55ck59 = 0 time = 300
* CHECK dout0_56 vdout0_56ck59 = 1.1 time = 300
* CHECK dout0_57 vdout0_57ck59 = 0 time = 300
* CHECK dout0_58 vdout0_58ck59 = 0 time = 300
* CHECK dout0_59 vdout0_59ck59 = 1.1 time = 300
* CHECK dout0_60 vdout0_60ck59 = 1.1 time = 300
* CHECK dout0_61 vdout0_61ck59 = 0 time = 300
* CHECK dout0_62 vdout0_62ck59 = 1.1 time = 300
* CHECK dout0_63 vdout0_63ck59 = 0 time = 300
* CHECK dout0_0 vdout0_0ck64 = 1.1 time = 325
* CHECK dout0_1 vdout0_1ck64 = 0 time = 325
* CHECK dout0_2 vdout0_2ck64 = 0 time = 325
* CHECK dout0_3 vdout0_3ck64 = 0 time = 325
* CHECK dout0_4 vdout0_4ck64 = 1.1 time = 325
* CHECK dout0_5 vdout0_5ck64 = 0 time = 325
* CHECK dout0_6 vdout0_6ck64 = 1.1 time = 325
* CHECK dout0_7 vdout0_7ck64 = 1.1 time = 325
* CHECK dout0_8 vdout0_8ck64 = 1.1 time = 325
* CHECK dout0_9 vdout0_9ck64 = 1.1 time = 325
* CHECK dout0_10 vdout0_10ck64 = 0 time = 325
* CHECK dout0_11 vdout0_11ck64 = 0 time = 325
* CHECK dout0_12 vdout0_12ck64 = 0 time = 325
* CHECK dout0_13 vdout0_13ck64 = 0 time = 325
* CHECK dout0_14 vdout0_14ck64 = 1.1 time = 325
* CHECK dout0_15 vdout0_15ck64 = 0 time = 325
* CHECK dout0_16 vdout0_16ck64 = 0 time = 325
* CHECK dout0_17 vdout0_17ck64 = 1.1 time = 325
* CHECK dout0_18 vdout0_18ck64 = 0 time = 325
* CHECK dout0_19 vdout0_19ck64 = 1.1 time = 325
* CHECK dout0_20 vdout0_20ck64 = 1.1 time = 325
* CHECK dout0_21 vdout0_21ck64 = 1.1 time = 325
* CHECK dout0_22 vdout0_22ck64 = 1.1 time = 325
* CHECK dout0_23 vdout0_23ck64 = 0 time = 325
* CHECK dout0_24 vdout0_24ck64 = 1.1 time = 325
* CHECK dout0_25 vdout0_25ck64 = 0 time = 325
* CHECK dout0_26 vdout0_26ck64 = 1.1 time = 325
* CHECK dout0_27 vdout0_27ck64 = 0 time = 325
* CHECK dout0_28 vdout0_28ck64 = 0 time = 325
* CHECK dout0_29 vdout0_29ck64 = 0 time = 325
* CHECK dout0_30 vdout0_30ck64 = 1.1 time = 325
* CHECK dout0_31 vdout0_31ck64 = 0 time = 325
* CHECK dout0_32 vdout0_32ck64 = 1.1 time = 325
* CHECK dout0_33 vdout0_33ck64 = 1.1 time = 325
* CHECK dout0_34 vdout0_34ck64 = 1.1 time = 325
* CHECK dout0_35 vdout0_35ck64 = 1.1 time = 325
* CHECK dout0_36 vdout0_36ck64 = 0 time = 325
* CHECK dout0_37 vdout0_37ck64 = 1.1 time = 325
* CHECK dout0_38 vdout0_38ck64 = 1.1 time = 325
* CHECK dout0_39 vdout0_39ck64 = 1.1 time = 325
* CHECK dout0_40 vdout0_40ck64 = 0 time = 325
* CHECK dout0_41 vdout0_41ck64 = 1.1 time = 325
* CHECK dout0_42 vdout0_42ck64 = 1.1 time = 325
* CHECK dout0_43 vdout0_43ck64 = 0 time = 325
* CHECK dout0_44 vdout0_44ck64 = 1.1 time = 325
* CHECK dout0_45 vdout0_45ck64 = 1.1 time = 325
* CHECK dout0_46 vdout0_46ck64 = 1.1 time = 325
* CHECK dout0_47 vdout0_47ck64 = 0 time = 325
* CHECK dout0_48 vdout0_48ck64 = 0 time = 325
* CHECK dout0_49 vdout0_49ck64 = 1.1 time = 325
* CHECK dout0_50 vdout0_50ck64 = 1.1 time = 325
* CHECK dout0_51 vdout0_51ck64 = 1.1 time = 325
* CHECK dout0_52 vdout0_52ck64 = 0 time = 325
* CHECK dout0_53 vdout0_53ck64 = 0 time = 325
* CHECK dout0_54 vdout0_54ck64 = 1.1 time = 325
* CHECK dout0_55 vdout0_55ck64 = 1.1 time = 325
* CHECK dout0_56 vdout0_56ck64 = 1.1 time = 325
* CHECK dout0_57 vdout0_57ck64 = 0 time = 325
* CHECK dout0_58 vdout0_58ck64 = 0 time = 325
* CHECK dout0_59 vdout0_59ck64 = 1.1 time = 325
* CHECK dout0_60 vdout0_60ck64 = 1.1 time = 325
* CHECK dout0_61 vdout0_61ck64 = 1.1 time = 325
* CHECK dout0_62 vdout0_62ck64 = 1.1 time = 325
* CHECK dout0_63 vdout0_63ck64 = 1.1 time = 325
* CHECK dout0_0 vdout0_0ck71 = 1.1 time = 360
* CHECK dout0_1 vdout0_1ck71 = 0 time = 360
* CHECK dout0_2 vdout0_2ck71 = 0 time = 360
* CHECK dout0_3 vdout0_3ck71 = 0 time = 360
* CHECK dout0_4 vdout0_4ck71 = 1.1 time = 360
* CHECK dout0_5 vdout0_5ck71 = 0 time = 360
* CHECK dout0_6 vdout0_6ck71 = 1.1 time = 360
* CHECK dout0_7 vdout0_7ck71 = 1.1 time = 360
* CHECK dout0_8 vdout0_8ck71 = 1.1 time = 360
* CHECK dout0_9 vdout0_9ck71 = 1.1 time = 360
* CHECK dout0_10 vdout0_10ck71 = 0 time = 360
* CHECK dout0_11 vdout0_11ck71 = 0 time = 360
* CHECK dout0_12 vdout0_12ck71 = 0 time = 360
* CHECK dout0_13 vdout0_13ck71 = 0 time = 360
* CHECK dout0_14 vdout0_14ck71 = 1.1 time = 360
* CHECK dout0_15 vdout0_15ck71 = 0 time = 360
* CHECK dout0_16 vdout0_16ck71 = 0 time = 360
* CHECK dout0_17 vdout0_17ck71 = 1.1 time = 360
* CHECK dout0_18 vdout0_18ck71 = 0 time = 360
* CHECK dout0_19 vdout0_19ck71 = 1.1 time = 360
* CHECK dout0_20 vdout0_20ck71 = 1.1 time = 360
* CHECK dout0_21 vdout0_21ck71 = 1.1 time = 360
* CHECK dout0_22 vdout0_22ck71 = 1.1 time = 360
* CHECK dout0_23 vdout0_23ck71 = 0 time = 360
* CHECK dout0_24 vdout0_24ck71 = 1.1 time = 360
* CHECK dout0_25 vdout0_25ck71 = 0 time = 360
* CHECK dout0_26 vdout0_26ck71 = 1.1 time = 360
* CHECK dout0_27 vdout0_27ck71 = 0 time = 360
* CHECK dout0_28 vdout0_28ck71 = 0 time = 360
* CHECK dout0_29 vdout0_29ck71 = 0 time = 360
* CHECK dout0_30 vdout0_30ck71 = 1.1 time = 360
* CHECK dout0_31 vdout0_31ck71 = 0 time = 360
* CHECK dout0_32 vdout0_32ck71 = 1.1 time = 360
* CHECK dout0_33 vdout0_33ck71 = 1.1 time = 360
* CHECK dout0_34 vdout0_34ck71 = 1.1 time = 360
* CHECK dout0_35 vdout0_35ck71 = 1.1 time = 360
* CHECK dout0_36 vdout0_36ck71 = 0 time = 360
* CHECK dout0_37 vdout0_37ck71 = 1.1 time = 360
* CHECK dout0_38 vdout0_38ck71 = 1.1 time = 360
* CHECK dout0_39 vdout0_39ck71 = 1.1 time = 360
* CHECK dout0_40 vdout0_40ck71 = 0 time = 360
* CHECK dout0_41 vdout0_41ck71 = 1.1 time = 360
* CHECK dout0_42 vdout0_42ck71 = 1.1 time = 360
* CHECK dout0_43 vdout0_43ck71 = 0 time = 360
* CHECK dout0_44 vdout0_44ck71 = 1.1 time = 360
* CHECK dout0_45 vdout0_45ck71 = 1.1 time = 360
* CHECK dout0_46 vdout0_46ck71 = 1.1 time = 360
* CHECK dout0_47 vdout0_47ck71 = 0 time = 360
* CHECK dout0_48 vdout0_48ck71 = 0 time = 360
* CHECK dout0_49 vdout0_49ck71 = 1.1 time = 360
* CHECK dout0_50 vdout0_50ck71 = 1.1 time = 360
* CHECK dout0_51 vdout0_51ck71 = 1.1 time = 360
* CHECK dout0_52 vdout0_52ck71 = 0 time = 360
* CHECK dout0_53 vdout0_53ck71 = 0 time = 360
* CHECK dout0_54 vdout0_54ck71 = 1.1 time = 360
* CHECK dout0_55 vdout0_55ck71 = 1.1 time = 360
* CHECK dout0_56 vdout0_56ck71 = 1.1 time = 360
* CHECK dout0_57 vdout0_57ck71 = 0 time = 360
* CHECK dout0_58 vdout0_58ck71 = 0 time = 360
* CHECK dout0_59 vdout0_59ck71 = 1.1 time = 360
* CHECK dout0_60 vdout0_60ck71 = 1.1 time = 360
* CHECK dout0_61 vdout0_61ck71 = 1.1 time = 360
* CHECK dout0_62 vdout0_62ck71 = 1.1 time = 360
* CHECK dout0_63 vdout0_63ck71 = 1.1 time = 360
* CHECK dout0_0 vdout0_0ck73 = 0 time = 370
* CHECK dout0_1 vdout0_1ck73 = 1.1 time = 370
* CHECK dout0_2 vdout0_2ck73 = 1.1 time = 370
* CHECK dout0_3 vdout0_3ck73 = 0 time = 370
* CHECK dout0_4 vdout0_4ck73 = 1.1 time = 370
* CHECK dout0_5 vdout0_5ck73 = 0 time = 370
* CHECK dout0_6 vdout0_6ck73 = 0 time = 370
* CHECK dout0_7 vdout0_7ck73 = 0 time = 370
* CHECK dout0_8 vdout0_8ck73 = 1.1 time = 370
* CHECK dout0_9 vdout0_9ck73 = 1.1 time = 370
* CHECK dout0_10 vdout0_10ck73 = 0 time = 370
* CHECK dout0_11 vdout0_11ck73 = 1.1 time = 370
* CHECK dout0_12 vdout0_12ck73 = 0 time = 370
* CHECK dout0_13 vdout0_13ck73 = 1.1 time = 370
* CHECK dout0_14 vdout0_14ck73 = 0 time = 370
* CHECK dout0_15 vdout0_15ck73 = 1.1 time = 370
* CHECK dout0_16 vdout0_16ck73 = 1.1 time = 370
* CHECK dout0_17 vdout0_17ck73 = 1.1 time = 370
* CHECK dout0_18 vdout0_18ck73 = 1.1 time = 370
* CHECK dout0_19 vdout0_19ck73 = 1.1 time = 370
* CHECK dout0_20 vdout0_20ck73 = 1.1 time = 370
* CHECK dout0_21 vdout0_21ck73 = 1.1 time = 370
* CHECK dout0_22 vdout0_22ck73 = 1.1 time = 370
* CHECK dout0_23 vdout0_23ck73 = 1.1 time = 370
* CHECK dout0_24 vdout0_24ck73 = 0 time = 370
* CHECK dout0_25 vdout0_25ck73 = 0 time = 370
* CHECK dout0_26 vdout0_26ck73 = 1.1 time = 370
* CHECK dout0_27 vdout0_27ck73 = 1.1 time = 370
* CHECK dout0_28 vdout0_28ck73 = 1.1 time = 370
* CHECK dout0_29 vdout0_29ck73 = 1.1 time = 370
* CHECK dout0_30 vdout0_30ck73 = 1.1 time = 370
* CHECK dout0_31 vdout0_31ck73 = 0 time = 370
* CHECK dout0_32 vdout0_32ck73 = 0 time = 370
* CHECK dout0_33 vdout0_33ck73 = 0 time = 370
* CHECK dout0_34 vdout0_34ck73 = 0 time = 370
* CHECK dout0_35 vdout0_35ck73 = 1.1 time = 370
* CHECK dout0_36 vdout0_36ck73 = 1.1 time = 370
* CHECK dout0_37 vdout0_37ck73 = 1.1 time = 370
* CHECK dout0_38 vdout0_38ck73 = 0 time = 370
* CHECK dout0_39 vdout0_39ck73 = 0 time = 370
* CHECK dout0_40 vdout0_40ck73 = 0 time = 370
* CHECK dout0_41 vdout0_41ck73 = 0 time = 370
* CHECK dout0_42 vdout0_42ck73 = 1.1 time = 370
* CHECK dout0_43 vdout0_43ck73 = 0 time = 370
* CHECK dout0_44 vdout0_44ck73 = 1.1 time = 370
* CHECK dout0_45 vdout0_45ck73 = 1.1 time = 370
* CHECK dout0_46 vdout0_46ck73 = 0 time = 370
* CHECK dout0_47 vdout0_47ck73 = 1.1 time = 370
* CHECK dout0_48 vdout0_48ck73 = 0 time = 370
* CHECK dout0_49 vdout0_49ck73 = 1.1 time = 370
* CHECK dout0_50 vdout0_50ck73 = 0 time = 370
* CHECK dout0_51 vdout0_51ck73 = 0 time = 370
* CHECK dout0_52 vdout0_52ck73 = 1.1 time = 370
* CHECK dout0_53 vdout0_53ck73 = 0 time = 370
* CHECK dout0_54 vdout0_54ck73 = 0 time = 370
* CHECK dout0_55 vdout0_55ck73 = 1.1 time = 370
* CHECK dout0_56 vdout0_56ck73 = 1.1 time = 370
* CHECK dout0_57 vdout0_57ck73 = 0 time = 370
* CHECK dout0_58 vdout0_58ck73 = 1.1 time = 370
* CHECK dout0_59 vdout0_59ck73 = 1.1 time = 370
* CHECK dout0_60 vdout0_60ck73 = 0 time = 370
* CHECK dout0_61 vdout0_61ck73 = 1.1 time = 370
* CHECK dout0_62 vdout0_62ck73 = 0 time = 370
* CHECK dout0_63 vdout0_63ck73 = 1.1 time = 370
* CHECK dout0_0 vdout0_0ck74 = 0 time = 375
* CHECK dout0_1 vdout0_1ck74 = 1.1 time = 375
* CHECK dout0_2 vdout0_2ck74 = 1.1 time = 375
* CHECK dout0_3 vdout0_3ck74 = 0 time = 375
* CHECK dout0_4 vdout0_4ck74 = 1.1 time = 375
* CHECK dout0_5 vdout0_5ck74 = 0 time = 375
* CHECK dout0_6 vdout0_6ck74 = 0 time = 375
* CHECK dout0_7 vdout0_7ck74 = 0 time = 375
* CHECK dout0_8 vdout0_8ck74 = 1.1 time = 375
* CHECK dout0_9 vdout0_9ck74 = 1.1 time = 375
* CHECK dout0_10 vdout0_10ck74 = 0 time = 375
* CHECK dout0_11 vdout0_11ck74 = 1.1 time = 375
* CHECK dout0_12 vdout0_12ck74 = 0 time = 375
* CHECK dout0_13 vdout0_13ck74 = 1.1 time = 375
* CHECK dout0_14 vdout0_14ck74 = 0 time = 375
* CHECK dout0_15 vdout0_15ck74 = 1.1 time = 375
* CHECK dout0_16 vdout0_16ck74 = 1.1 time = 375
* CHECK dout0_17 vdout0_17ck74 = 1.1 time = 375
* CHECK dout0_18 vdout0_18ck74 = 1.1 time = 375
* CHECK dout0_19 vdout0_19ck74 = 1.1 time = 375
* CHECK dout0_20 vdout0_20ck74 = 1.1 time = 375
* CHECK dout0_21 vdout0_21ck74 = 1.1 time = 375
* CHECK dout0_22 vdout0_22ck74 = 1.1 time = 375
* CHECK dout0_23 vdout0_23ck74 = 1.1 time = 375
* CHECK dout0_24 vdout0_24ck74 = 0 time = 375
* CHECK dout0_25 vdout0_25ck74 = 0 time = 375
* CHECK dout0_26 vdout0_26ck74 = 1.1 time = 375
* CHECK dout0_27 vdout0_27ck74 = 1.1 time = 375
* CHECK dout0_28 vdout0_28ck74 = 1.1 time = 375
* CHECK dout0_29 vdout0_29ck74 = 1.1 time = 375
* CHECK dout0_30 vdout0_30ck74 = 1.1 time = 375
* CHECK dout0_31 vdout0_31ck74 = 0 time = 375
* CHECK dout0_32 vdout0_32ck74 = 0 time = 375
* CHECK dout0_33 vdout0_33ck74 = 0 time = 375
* CHECK dout0_34 vdout0_34ck74 = 0 time = 375
* CHECK dout0_35 vdout0_35ck74 = 1.1 time = 375
* CHECK dout0_36 vdout0_36ck74 = 1.1 time = 375
* CHECK dout0_37 vdout0_37ck74 = 1.1 time = 375
* CHECK dout0_38 vdout0_38ck74 = 0 time = 375
* CHECK dout0_39 vdout0_39ck74 = 0 time = 375
* CHECK dout0_40 vdout0_40ck74 = 0 time = 375
* CHECK dout0_41 vdout0_41ck74 = 0 time = 375
* CHECK dout0_42 vdout0_42ck74 = 1.1 time = 375
* CHECK dout0_43 vdout0_43ck74 = 0 time = 375
* CHECK dout0_44 vdout0_44ck74 = 1.1 time = 375
* CHECK dout0_45 vdout0_45ck74 = 1.1 time = 375
* CHECK dout0_46 vdout0_46ck74 = 0 time = 375
* CHECK dout0_47 vdout0_47ck74 = 1.1 time = 375
* CHECK dout0_48 vdout0_48ck74 = 0 time = 375
* CHECK dout0_49 vdout0_49ck74 = 1.1 time = 375
* CHECK dout0_50 vdout0_50ck74 = 0 time = 375
* CHECK dout0_51 vdout0_51ck74 = 0 time = 375
* CHECK dout0_52 vdout0_52ck74 = 1.1 time = 375
* CHECK dout0_53 vdout0_53ck74 = 0 time = 375
* CHECK dout0_54 vdout0_54ck74 = 0 time = 375
* CHECK dout0_55 vdout0_55ck74 = 1.1 time = 375
* CHECK dout0_56 vdout0_56ck74 = 1.1 time = 375
* CHECK dout0_57 vdout0_57ck74 = 0 time = 375
* CHECK dout0_58 vdout0_58ck74 = 1.1 time = 375
* CHECK dout0_59 vdout0_59ck74 = 1.1 time = 375
* CHECK dout0_60 vdout0_60ck74 = 0 time = 375
* CHECK dout0_61 vdout0_61ck74 = 1.1 time = 375
* CHECK dout0_62 vdout0_62ck74 = 0 time = 375
* CHECK dout0_63 vdout0_63ck74 = 1.1 time = 375
* CHECK dout0_0 vdout0_0ck76 = 0 time = 385
* CHECK dout0_1 vdout0_1ck76 = 1.1 time = 385
* CHECK dout0_2 vdout0_2ck76 = 1.1 time = 385
* CHECK dout0_3 vdout0_3ck76 = 0 time = 385
* CHECK dout0_4 vdout0_4ck76 = 1.1 time = 385
* CHECK dout0_5 vdout0_5ck76 = 0 time = 385
* CHECK dout0_6 vdout0_6ck76 = 0 time = 385
* CHECK dout0_7 vdout0_7ck76 = 0 time = 385
* CHECK dout0_8 vdout0_8ck76 = 1.1 time = 385
* CHECK dout0_9 vdout0_9ck76 = 1.1 time = 385
* CHECK dout0_10 vdout0_10ck76 = 0 time = 385
* CHECK dout0_11 vdout0_11ck76 = 1.1 time = 385
* CHECK dout0_12 vdout0_12ck76 = 0 time = 385
* CHECK dout0_13 vdout0_13ck76 = 1.1 time = 385
* CHECK dout0_14 vdout0_14ck76 = 0 time = 385
* CHECK dout0_15 vdout0_15ck76 = 1.1 time = 385
* CHECK dout0_16 vdout0_16ck76 = 1.1 time = 385
* CHECK dout0_17 vdout0_17ck76 = 1.1 time = 385
* CHECK dout0_18 vdout0_18ck76 = 1.1 time = 385
* CHECK dout0_19 vdout0_19ck76 = 1.1 time = 385
* CHECK dout0_20 vdout0_20ck76 = 1.1 time = 385
* CHECK dout0_21 vdout0_21ck76 = 1.1 time = 385
* CHECK dout0_22 vdout0_22ck76 = 1.1 time = 385
* CHECK dout0_23 vdout0_23ck76 = 1.1 time = 385
* CHECK dout0_24 vdout0_24ck76 = 0 time = 385
* CHECK dout0_25 vdout0_25ck76 = 0 time = 385
* CHECK dout0_26 vdout0_26ck76 = 1.1 time = 385
* CHECK dout0_27 vdout0_27ck76 = 1.1 time = 385
* CHECK dout0_28 vdout0_28ck76 = 1.1 time = 385
* CHECK dout0_29 vdout0_29ck76 = 1.1 time = 385
* CHECK dout0_30 vdout0_30ck76 = 1.1 time = 385
* CHECK dout0_31 vdout0_31ck76 = 0 time = 385
* CHECK dout0_32 vdout0_32ck76 = 0 time = 385
* CHECK dout0_33 vdout0_33ck76 = 0 time = 385
* CHECK dout0_34 vdout0_34ck76 = 0 time = 385
* CHECK dout0_35 vdout0_35ck76 = 1.1 time = 385
* CHECK dout0_36 vdout0_36ck76 = 1.1 time = 385
* CHECK dout0_37 vdout0_37ck76 = 1.1 time = 385
* CHECK dout0_38 vdout0_38ck76 = 0 time = 385
* CHECK dout0_39 vdout0_39ck76 = 0 time = 385
* CHECK dout0_40 vdout0_40ck76 = 0 time = 385
* CHECK dout0_41 vdout0_41ck76 = 0 time = 385
* CHECK dout0_42 vdout0_42ck76 = 1.1 time = 385
* CHECK dout0_43 vdout0_43ck76 = 0 time = 385
* CHECK dout0_44 vdout0_44ck76 = 1.1 time = 385
* CHECK dout0_45 vdout0_45ck76 = 1.1 time = 385
* CHECK dout0_46 vdout0_46ck76 = 0 time = 385
* CHECK dout0_47 vdout0_47ck76 = 1.1 time = 385
* CHECK dout0_48 vdout0_48ck76 = 0 time = 385
* CHECK dout0_49 vdout0_49ck76 = 1.1 time = 385
* CHECK dout0_50 vdout0_50ck76 = 0 time = 385
* CHECK dout0_51 vdout0_51ck76 = 0 time = 385
* CHECK dout0_52 vdout0_52ck76 = 1.1 time = 385
* CHECK dout0_53 vdout0_53ck76 = 0 time = 385
* CHECK dout0_54 vdout0_54ck76 = 0 time = 385
* CHECK dout0_55 vdout0_55ck76 = 1.1 time = 385
* CHECK dout0_56 vdout0_56ck76 = 1.1 time = 385
* CHECK dout0_57 vdout0_57ck76 = 0 time = 385
* CHECK dout0_58 vdout0_58ck76 = 1.1 time = 385
* CHECK dout0_59 vdout0_59ck76 = 1.1 time = 385
* CHECK dout0_60 vdout0_60ck76 = 0 time = 385
* CHECK dout0_61 vdout0_61ck76 = 1.1 time = 385
* CHECK dout0_62 vdout0_62ck76 = 0 time = 385
* CHECK dout0_63 vdout0_63ck76 = 1.1 time = 385
* CHECK dout0_0 vdout0_0ck78 = 0 time = 395
* CHECK dout0_1 vdout0_1ck78 = 0 time = 395
* CHECK dout0_2 vdout0_2ck78 = 1.1 time = 395
* CHECK dout0_3 vdout0_3ck78 = 1.1 time = 395
* CHECK dout0_4 vdout0_4ck78 = 1.1 time = 395
* CHECK dout0_5 vdout0_5ck78 = 0 time = 395
* CHECK dout0_6 vdout0_6ck78 = 1.1 time = 395
* CHECK dout0_7 vdout0_7ck78 = 1.1 time = 395
* CHECK dout0_8 vdout0_8ck78 = 1.1 time = 395
* CHECK dout0_9 vdout0_9ck78 = 1.1 time = 395
* CHECK dout0_10 vdout0_10ck78 = 1.1 time = 395
* CHECK dout0_11 vdout0_11ck78 = 0 time = 395
* CHECK dout0_12 vdout0_12ck78 = 1.1 time = 395
* CHECK dout0_13 vdout0_13ck78 = 1.1 time = 395
* CHECK dout0_14 vdout0_14ck78 = 1.1 time = 395
* CHECK dout0_15 vdout0_15ck78 = 1.1 time = 395
* CHECK dout0_16 vdout0_16ck78 = 0 time = 395
* CHECK dout0_17 vdout0_17ck78 = 0 time = 395
* CHECK dout0_18 vdout0_18ck78 = 1.1 time = 395
* CHECK dout0_19 vdout0_19ck78 = 0 time = 395
* CHECK dout0_20 vdout0_20ck78 = 0 time = 395
* CHECK dout0_21 vdout0_21ck78 = 1.1 time = 395
* CHECK dout0_22 vdout0_22ck78 = 0 time = 395
* CHECK dout0_23 vdout0_23ck78 = 1.1 time = 395
* CHECK dout0_24 vdout0_24ck78 = 0 time = 395
* CHECK dout0_25 vdout0_25ck78 = 0 time = 395
* CHECK dout0_26 vdout0_26ck78 = 1.1 time = 395
* CHECK dout0_27 vdout0_27ck78 = 1.1 time = 395
* CHECK dout0_28 vdout0_28ck78 = 0 time = 395
* CHECK dout0_29 vdout0_29ck78 = 0 time = 395
* CHECK dout0_30 vdout0_30ck78 = 0 time = 395
* CHECK dout0_31 vdout0_31ck78 = 1.1 time = 395
* CHECK dout0_32 vdout0_32ck78 = 1.1 time = 395
* CHECK dout0_33 vdout0_33ck78 = 0 time = 395
* CHECK dout0_34 vdout0_34ck78 = 0 time = 395
* CHECK dout0_35 vdout0_35ck78 = 0 time = 395
* CHECK dout0_36 vdout0_36ck78 = 1.1 time = 395
* CHECK dout0_37 vdout0_37ck78 = 1.1 time = 395
* CHECK dout0_38 vdout0_38ck78 = 0 time = 395
* CHECK dout0_39 vdout0_39ck78 = 1.1 time = 395
* CHECK dout0_40 vdout0_40ck78 = 0 time = 395
* CHECK dout0_41 vdout0_41ck78 = 0 time = 395
* CHECK dout0_42 vdout0_42ck78 = 0 time = 395
* CHECK dout0_43 vdout0_43ck78 = 0 time = 395
* CHECK dout0_44 vdout0_44ck78 = 1.1 time = 395
* CHECK dout0_45 vdout0_45ck78 = 0 time = 395
* CHECK dout0_46 vdout0_46ck78 = 1.1 time = 395
* CHECK dout0_47 vdout0_47ck78 = 0 time = 395
* CHECK dout0_48 vdout0_48ck78 = 0 time = 395
* CHECK dout0_49 vdout0_49ck78 = 1.1 time = 395
* CHECK dout0_50 vdout0_50ck78 = 1.1 time = 395
* CHECK dout0_51 vdout0_51ck78 = 0 time = 395
* CHECK dout0_52 vdout0_52ck78 = 1.1 time = 395
* CHECK dout0_53 vdout0_53ck78 = 0 time = 395
* CHECK dout0_54 vdout0_54ck78 = 1.1 time = 395
* CHECK dout0_55 vdout0_55ck78 = 0 time = 395
* CHECK dout0_56 vdout0_56ck78 = 0 time = 395
* CHECK dout0_57 vdout0_57ck78 = 0 time = 395
* CHECK dout0_58 vdout0_58ck78 = 1.1 time = 395
* CHECK dout0_59 vdout0_59ck78 = 1.1 time = 395
* CHECK dout0_60 vdout0_60ck78 = 1.1 time = 395
* CHECK dout0_61 vdout0_61ck78 = 1.1 time = 395
* CHECK dout0_62 vdout0_62ck78 = 0 time = 395
* CHECK dout0_63 vdout0_63ck78 = 1.1 time = 395
* CHECK dout0_0 vdout0_0ck81 = 0 time = 410
* CHECK dout0_1 vdout0_1ck81 = 0 time = 410
* CHECK dout0_2 vdout0_2ck81 = 1.1 time = 410
* CHECK dout0_3 vdout0_3ck81 = 1.1 time = 410
* CHECK dout0_4 vdout0_4ck81 = 1.1 time = 410
* CHECK dout0_5 vdout0_5ck81 = 1.1 time = 410
* CHECK dout0_6 vdout0_6ck81 = 0 time = 410
* CHECK dout0_7 vdout0_7ck81 = 1.1 time = 410
* CHECK dout0_8 vdout0_8ck81 = 1.1 time = 410
* CHECK dout0_9 vdout0_9ck81 = 0 time = 410
* CHECK dout0_10 vdout0_10ck81 = 1.1 time = 410
* CHECK dout0_11 vdout0_11ck81 = 1.1 time = 410
* CHECK dout0_12 vdout0_12ck81 = 0 time = 410
* CHECK dout0_13 vdout0_13ck81 = 0 time = 410
* CHECK dout0_14 vdout0_14ck81 = 0 time = 410
* CHECK dout0_15 vdout0_15ck81 = 0 time = 410
* CHECK dout0_16 vdout0_16ck81 = 1.1 time = 410
* CHECK dout0_17 vdout0_17ck81 = 0 time = 410
* CHECK dout0_18 vdout0_18ck81 = 1.1 time = 410
* CHECK dout0_19 vdout0_19ck81 = 1.1 time = 410
* CHECK dout0_20 vdout0_20ck81 = 1.1 time = 410
* CHECK dout0_21 vdout0_21ck81 = 1.1 time = 410
* CHECK dout0_22 vdout0_22ck81 = 1.1 time = 410
* CHECK dout0_23 vdout0_23ck81 = 0 time = 410
* CHECK dout0_24 vdout0_24ck81 = 0 time = 410
* CHECK dout0_25 vdout0_25ck81 = 0 time = 410
* CHECK dout0_26 vdout0_26ck81 = 1.1 time = 410
* CHECK dout0_27 vdout0_27ck81 = 0 time = 410
* CHECK dout0_28 vdout0_28ck81 = 1.1 time = 410
* CHECK dout0_29 vdout0_29ck81 = 0 time = 410
* CHECK dout0_30 vdout0_30ck81 = 0 time = 410
* CHECK dout0_31 vdout0_31ck81 = 1.1 time = 410
* CHECK dout0_32 vdout0_32ck81 = 0 time = 410
* CHECK dout0_33 vdout0_33ck81 = 0 time = 410
* CHECK dout0_34 vdout0_34ck81 = 0 time = 410
* CHECK dout0_35 vdout0_35ck81 = 0 time = 410
* CHECK dout0_36 vdout0_36ck81 = 0 time = 410
* CHECK dout0_37 vdout0_37ck81 = 1.1 time = 410
* CHECK dout0_38 vdout0_38ck81 = 1.1 time = 410
* CHECK dout0_39 vdout0_39ck81 = 1.1 time = 410
* CHECK dout0_40 vdout0_40ck81 = 1.1 time = 410
* CHECK dout0_41 vdout0_41ck81 = 0 time = 410
* CHECK dout0_42 vdout0_42ck81 = 0 time = 410
* CHECK dout0_43 vdout0_43ck81 = 1.1 time = 410
* CHECK dout0_44 vdout0_44ck81 = 0 time = 410
* CHECK dout0_45 vdout0_45ck81 = 0 time = 410
* CHECK dout0_46 vdout0_46ck81 = 0 time = 410
* CHECK dout0_47 vdout0_47ck81 = 1.1 time = 410
* CHECK dout0_48 vdout0_48ck81 = 1.1 time = 410
* CHECK dout0_49 vdout0_49ck81 = 1.1 time = 410
* CHECK dout0_50 vdout0_50ck81 = 1.1 time = 410
* CHECK dout0_51 vdout0_51ck81 = 0 time = 410
* CHECK dout0_52 vdout0_52ck81 = 1.1 time = 410
* CHECK dout0_53 vdout0_53ck81 = 0 time = 410
* CHECK dout0_54 vdout0_54ck81 = 0 time = 410
* CHECK dout0_55 vdout0_55ck81 = 0 time = 410
* CHECK dout0_56 vdout0_56ck81 = 0 time = 410
* CHECK dout0_57 vdout0_57ck81 = 1.1 time = 410
* CHECK dout0_58 vdout0_58ck81 = 1.1 time = 410
* CHECK dout0_59 vdout0_59ck81 = 0 time = 410
* CHECK dout0_60 vdout0_60ck81 = 0 time = 410
* CHECK dout0_61 vdout0_61ck81 = 1.1 time = 410
* CHECK dout0_62 vdout0_62ck81 = 1.1 time = 410
* CHECK dout0_63 vdout0_63ck81 = 0 time = 410
* CHECK dout0_0 vdout0_0ck91 = 0 time = 460
* CHECK dout0_1 vdout0_1ck91 = 0 time = 460
* CHECK dout0_2 vdout0_2ck91 = 1.1 time = 460
* CHECK dout0_3 vdout0_3ck91 = 1.1 time = 460
* CHECK dout0_4 vdout0_4ck91 = 1.1 time = 460
* CHECK dout0_5 vdout0_5ck91 = 0 time = 460
* CHECK dout0_6 vdout0_6ck91 = 1.1 time = 460
* CHECK dout0_7 vdout0_7ck91 = 1.1 time = 460
* CHECK dout0_8 vdout0_8ck91 = 0 time = 460
* CHECK dout0_9 vdout0_9ck91 = 1.1 time = 460
* CHECK dout0_10 vdout0_10ck91 = 0 time = 460
* CHECK dout0_11 vdout0_11ck91 = 0 time = 460
* CHECK dout0_12 vdout0_12ck91 = 1.1 time = 460
* CHECK dout0_13 vdout0_13ck91 = 1.1 time = 460
* CHECK dout0_14 vdout0_14ck91 = 1.1 time = 460
* CHECK dout0_15 vdout0_15ck91 = 1.1 time = 460
* CHECK dout0_16 vdout0_16ck91 = 1.1 time = 460
* CHECK dout0_17 vdout0_17ck91 = 0 time = 460
* CHECK dout0_18 vdout0_18ck91 = 1.1 time = 460
* CHECK dout0_19 vdout0_19ck91 = 0 time = 460
* CHECK dout0_20 vdout0_20ck91 = 1.1 time = 460
* CHECK dout0_21 vdout0_21ck91 = 0 time = 460
* CHECK dout0_22 vdout0_22ck91 = 1.1 time = 460
* CHECK dout0_23 vdout0_23ck91 = 1.1 time = 460
* CHECK dout0_24 vdout0_24ck91 = 1.1 time = 460
* CHECK dout0_25 vdout0_25ck91 = 1.1 time = 460
* CHECK dout0_26 vdout0_26ck91 = 1.1 time = 460
* CHECK dout0_27 vdout0_27ck91 = 1.1 time = 460
* CHECK dout0_28 vdout0_28ck91 = 0 time = 460
* CHECK dout0_29 vdout0_29ck91 = 1.1 time = 460
* CHECK dout0_30 vdout0_30ck91 = 1.1 time = 460
* CHECK dout0_31 vdout0_31ck91 = 0 time = 460
* CHECK dout0_32 vdout0_32ck91 = 0 time = 460
* CHECK dout0_33 vdout0_33ck91 = 1.1 time = 460
* CHECK dout0_34 vdout0_34ck91 = 1.1 time = 460
* CHECK dout0_35 vdout0_35ck91 = 1.1 time = 460
* CHECK dout0_36 vdout0_36ck91 = 0 time = 460
* CHECK dout0_37 vdout0_37ck91 = 0 time = 460
* CHECK dout0_38 vdout0_38ck91 = 0 time = 460
* CHECK dout0_39 vdout0_39ck91 = 0 time = 460
* CHECK dout0_40 vdout0_40ck91 = 1.1 time = 460
* CHECK dout0_41 vdout0_41ck91 = 0 time = 460
* CHECK dout0_42 vdout0_42ck91 = 1.1 time = 460
* CHECK dout0_43 vdout0_43ck91 = 1.1 time = 460
* CHECK dout0_44 vdout0_44ck91 = 0 time = 460
* CHECK dout0_45 vdout0_45ck91 = 1.1 time = 460
* CHECK dout0_46 vdout0_46ck91 = 0 time = 460
* CHECK dout0_47 vdout0_47ck91 = 0 time = 460
* CHECK dout0_48 vdout0_48ck91 = 1.1 time = 460
* CHECK dout0_49 vdout0_49ck91 = 0 time = 460
* CHECK dout0_50 vdout0_50ck91 = 1.1 time = 460
* CHECK dout0_51 vdout0_51ck91 = 0 time = 460
* CHECK dout0_52 vdout0_52ck91 = 1.1 time = 460
* CHECK dout0_53 vdout0_53ck91 = 0 time = 460
* CHECK dout0_54 vdout0_54ck91 = 1.1 time = 460
* CHECK dout0_55 vdout0_55ck91 = 1.1 time = 460
* CHECK dout0_56 vdout0_56ck91 = 0 time = 460
* CHECK dout0_57 vdout0_57ck91 = 1.1 time = 460
* CHECK dout0_58 vdout0_58ck91 = 0 time = 460
* CHECK dout0_59 vdout0_59ck91 = 1.1 time = 460
* CHECK dout0_60 vdout0_60ck91 = 1.1 time = 460
* CHECK dout0_61 vdout0_61ck91 = 1.1 time = 460
* CHECK dout0_62 vdout0_62ck91 = 1.1 time = 460
* CHECK dout0_63 vdout0_63ck91 = 1.1 time = 460
* CHECK dout0_0 vdout0_0ck98 = 0 time = 495
* CHECK dout0_1 vdout0_1ck98 = 1.1 time = 495
* CHECK dout0_2 vdout0_2ck98 = 1.1 time = 495
* CHECK dout0_3 vdout0_3ck98 = 1.1 time = 495
* CHECK dout0_4 vdout0_4ck98 = 0 time = 495
* CHECK dout0_5 vdout0_5ck98 = 1.1 time = 495
* CHECK dout0_6 vdout0_6ck98 = 1.1 time = 495
* CHECK dout0_7 vdout0_7ck98 = 1.1 time = 495
* CHECK dout0_8 vdout0_8ck98 = 0 time = 495
* CHECK dout0_9 vdout0_9ck98 = 0 time = 495
* CHECK dout0_10 vdout0_10ck98 = 0 time = 495
* CHECK dout0_11 vdout0_11ck98 = 0 time = 495
* CHECK dout0_12 vdout0_12ck98 = 0 time = 495
* CHECK dout0_13 vdout0_13ck98 = 1.1 time = 495
* CHECK dout0_14 vdout0_14ck98 = 0 time = 495
* CHECK dout0_15 vdout0_15ck98 = 0 time = 495
* CHECK dout0_16 vdout0_16ck98 = 0 time = 495
* CHECK dout0_17 vdout0_17ck98 = 0 time = 495
* CHECK dout0_18 vdout0_18ck98 = 1.1 time = 495
* CHECK dout0_19 vdout0_19ck98 = 0 time = 495
* CHECK dout0_20 vdout0_20ck98 = 1.1 time = 495
* CHECK dout0_21 vdout0_21ck98 = 1.1 time = 495
* CHECK dout0_22 vdout0_22ck98 = 1.1 time = 495
* CHECK dout0_23 vdout0_23ck98 = 0 time = 495
* CHECK dout0_24 vdout0_24ck98 = 1.1 time = 495
* CHECK dout0_25 vdout0_25ck98 = 1.1 time = 495
* CHECK dout0_26 vdout0_26ck98 = 1.1 time = 495
* CHECK dout0_27 vdout0_27ck98 = 0 time = 495
* CHECK dout0_28 vdout0_28ck98 = 0 time = 495
* CHECK dout0_29 vdout0_29ck98 = 1.1 time = 495
* CHECK dout0_30 vdout0_30ck98 = 0 time = 495
* CHECK dout0_31 vdout0_31ck98 = 1.1 time = 495
* CHECK dout0_32 vdout0_32ck98 = 0 time = 495
* CHECK dout0_33 vdout0_33ck98 = 1.1 time = 495
* CHECK dout0_34 vdout0_34ck98 = 0 time = 495
* CHECK dout0_35 vdout0_35ck98 = 0 time = 495
* CHECK dout0_36 vdout0_36ck98 = 1.1 time = 495
* CHECK dout0_37 vdout0_37ck98 = 0 time = 495
* CHECK dout0_38 vdout0_38ck98 = 0 time = 495
* CHECK dout0_39 vdout0_39ck98 = 1.1 time = 495
* CHECK dout0_40 vdout0_40ck98 = 0 time = 495
* CHECK dout0_41 vdout0_41ck98 = 1.1 time = 495
* CHECK dout0_42 vdout0_42ck98 = 0 time = 495
* CHECK dout0_43 vdout0_43ck98 = 1.1 time = 495
* CHECK dout0_44 vdout0_44ck98 = 1.1 time = 495
* CHECK dout0_45 vdout0_45ck98 = 0 time = 495
* CHECK dout0_46 vdout0_46ck98 = 0 time = 495
* CHECK dout0_47 vdout0_47ck98 = 0 time = 495
* CHECK dout0_48 vdout0_48ck98 = 1.1 time = 495
* CHECK dout0_49 vdout0_49ck98 = 0 time = 495
* CHECK dout0_50 vdout0_50ck98 = 1.1 time = 495
* CHECK dout0_51 vdout0_51ck98 = 0 time = 495
* CHECK dout0_52 vdout0_52ck98 = 0 time = 495
* CHECK dout0_53 vdout0_53ck98 = 1.1 time = 495
* CHECK dout0_54 vdout0_54ck98 = 1.1 time = 495
* CHECK dout0_55 vdout0_55ck98 = 1.1 time = 495
* CHECK dout0_56 vdout0_56ck98 = 1.1 time = 495
* CHECK dout0_57 vdout0_57ck98 = 0 time = 495
* CHECK dout0_58 vdout0_58ck98 = 1.1 time = 495
* CHECK dout0_59 vdout0_59ck98 = 1.1 time = 495
* CHECK dout0_60 vdout0_60ck98 = 1.1 time = 495
* CHECK dout0_61 vdout0_61ck98 = 1.1 time = 495
* CHECK dout0_62 vdout0_62ck98 = 1.1 time = 495
* CHECK dout0_63 vdout0_63ck98 = 0 time = 495
* CHECK dout0_0 vdout0_0ck104 = 0 time = 525
* CHECK dout0_1 vdout0_1ck104 = 1.1 time = 525
* CHECK dout0_2 vdout0_2ck104 = 1.1 time = 525
* CHECK dout0_3 vdout0_3ck104 = 1.1 time = 525
* CHECK dout0_4 vdout0_4ck104 = 0 time = 525
* CHECK dout0_5 vdout0_5ck104 = 1.1 time = 525
* CHECK dout0_6 vdout0_6ck104 = 1.1 time = 525
* CHECK dout0_7 vdout0_7ck104 = 1.1 time = 525
* CHECK dout0_8 vdout0_8ck104 = 0 time = 525
* CHECK dout0_9 vdout0_9ck104 = 0 time = 525
* CHECK dout0_10 vdout0_10ck104 = 0 time = 525
* CHECK dout0_11 vdout0_11ck104 = 0 time = 525
* CHECK dout0_12 vdout0_12ck104 = 0 time = 525
* CHECK dout0_13 vdout0_13ck104 = 1.1 time = 525
* CHECK dout0_14 vdout0_14ck104 = 0 time = 525
* CHECK dout0_15 vdout0_15ck104 = 0 time = 525
* CHECK dout0_16 vdout0_16ck104 = 0 time = 525
* CHECK dout0_17 vdout0_17ck104 = 0 time = 525
* CHECK dout0_18 vdout0_18ck104 = 1.1 time = 525
* CHECK dout0_19 vdout0_19ck104 = 0 time = 525
* CHECK dout0_20 vdout0_20ck104 = 1.1 time = 525
* CHECK dout0_21 vdout0_21ck104 = 1.1 time = 525
* CHECK dout0_22 vdout0_22ck104 = 1.1 time = 525
* CHECK dout0_23 vdout0_23ck104 = 0 time = 525
* CHECK dout0_24 vdout0_24ck104 = 1.1 time = 525
* CHECK dout0_25 vdout0_25ck104 = 1.1 time = 525
* CHECK dout0_26 vdout0_26ck104 = 1.1 time = 525
* CHECK dout0_27 vdout0_27ck104 = 0 time = 525
* CHECK dout0_28 vdout0_28ck104 = 0 time = 525
* CHECK dout0_29 vdout0_29ck104 = 1.1 time = 525
* CHECK dout0_30 vdout0_30ck104 = 0 time = 525
* CHECK dout0_31 vdout0_31ck104 = 1.1 time = 525
* CHECK dout0_32 vdout0_32ck104 = 0 time = 525
* CHECK dout0_33 vdout0_33ck104 = 1.1 time = 525
* CHECK dout0_34 vdout0_34ck104 = 0 time = 525
* CHECK dout0_35 vdout0_35ck104 = 0 time = 525
* CHECK dout0_36 vdout0_36ck104 = 1.1 time = 525
* CHECK dout0_37 vdout0_37ck104 = 0 time = 525
* CHECK dout0_38 vdout0_38ck104 = 0 time = 525
* CHECK dout0_39 vdout0_39ck104 = 1.1 time = 525
* CHECK dout0_40 vdout0_40ck104 = 0 time = 525
* CHECK dout0_41 vdout0_41ck104 = 1.1 time = 525
* CHECK dout0_42 vdout0_42ck104 = 0 time = 525
* CHECK dout0_43 vdout0_43ck104 = 1.1 time = 525
* CHECK dout0_44 vdout0_44ck104 = 1.1 time = 525
* CHECK dout0_45 vdout0_45ck104 = 0 time = 525
* CHECK dout0_46 vdout0_46ck104 = 0 time = 525
* CHECK dout0_47 vdout0_47ck104 = 0 time = 525
* CHECK dout0_48 vdout0_48ck104 = 1.1 time = 525
* CHECK dout0_49 vdout0_49ck104 = 0 time = 525
* CHECK dout0_50 vdout0_50ck104 = 1.1 time = 525
* CHECK dout0_51 vdout0_51ck104 = 0 time = 525
* CHECK dout0_52 vdout0_52ck104 = 0 time = 525
* CHECK dout0_53 vdout0_53ck104 = 1.1 time = 525
* CHECK dout0_54 vdout0_54ck104 = 1.1 time = 525
* CHECK dout0_55 vdout0_55ck104 = 1.1 time = 525
* CHECK dout0_56 vdout0_56ck104 = 1.1 time = 525
* CHECK dout0_57 vdout0_57ck104 = 0 time = 525
* CHECK dout0_58 vdout0_58ck104 = 1.1 time = 525
* CHECK dout0_59 vdout0_59ck104 = 1.1 time = 525
* CHECK dout0_60 vdout0_60ck104 = 1.1 time = 525
* CHECK dout0_61 vdout0_61ck104 = 1.1 time = 525
* CHECK dout0_62 vdout0_62ck104 = 1.1 time = 525
* CHECK dout0_63 vdout0_63ck104 = 0 time = 525
* CHECK dout0_0 vdout0_0ck106 = 0 time = 535
* CHECK dout0_1 vdout0_1ck106 = 1.1 time = 535
* CHECK dout0_2 vdout0_2ck106 = 1.1 time = 535
* CHECK dout0_3 vdout0_3ck106 = 1.1 time = 535
* CHECK dout0_4 vdout0_4ck106 = 0 time = 535
* CHECK dout0_5 vdout0_5ck106 = 1.1 time = 535
* CHECK dout0_6 vdout0_6ck106 = 1.1 time = 535
* CHECK dout0_7 vdout0_7ck106 = 1.1 time = 535
* CHECK dout0_8 vdout0_8ck106 = 0 time = 535
* CHECK dout0_9 vdout0_9ck106 = 0 time = 535
* CHECK dout0_10 vdout0_10ck106 = 0 time = 535
* CHECK dout0_11 vdout0_11ck106 = 0 time = 535
* CHECK dout0_12 vdout0_12ck106 = 0 time = 535
* CHECK dout0_13 vdout0_13ck106 = 1.1 time = 535
* CHECK dout0_14 vdout0_14ck106 = 0 time = 535
* CHECK dout0_15 vdout0_15ck106 = 0 time = 535
* CHECK dout0_16 vdout0_16ck106 = 0 time = 535
* CHECK dout0_17 vdout0_17ck106 = 0 time = 535
* CHECK dout0_18 vdout0_18ck106 = 1.1 time = 535
* CHECK dout0_19 vdout0_19ck106 = 0 time = 535
* CHECK dout0_20 vdout0_20ck106 = 1.1 time = 535
* CHECK dout0_21 vdout0_21ck106 = 1.1 time = 535
* CHECK dout0_22 vdout0_22ck106 = 1.1 time = 535
* CHECK dout0_23 vdout0_23ck106 = 0 time = 535
* CHECK dout0_24 vdout0_24ck106 = 1.1 time = 535
* CHECK dout0_25 vdout0_25ck106 = 1.1 time = 535
* CHECK dout0_26 vdout0_26ck106 = 1.1 time = 535
* CHECK dout0_27 vdout0_27ck106 = 0 time = 535
* CHECK dout0_28 vdout0_28ck106 = 0 time = 535
* CHECK dout0_29 vdout0_29ck106 = 1.1 time = 535
* CHECK dout0_30 vdout0_30ck106 = 0 time = 535
* CHECK dout0_31 vdout0_31ck106 = 1.1 time = 535
* CHECK dout0_32 vdout0_32ck106 = 0 time = 535
* CHECK dout0_33 vdout0_33ck106 = 1.1 time = 535
* CHECK dout0_34 vdout0_34ck106 = 0 time = 535
* CHECK dout0_35 vdout0_35ck106 = 0 time = 535
* CHECK dout0_36 vdout0_36ck106 = 1.1 time = 535
* CHECK dout0_37 vdout0_37ck106 = 0 time = 535
* CHECK dout0_38 vdout0_38ck106 = 0 time = 535
* CHECK dout0_39 vdout0_39ck106 = 1.1 time = 535
* CHECK dout0_40 vdout0_40ck106 = 0 time = 535
* CHECK dout0_41 vdout0_41ck106 = 1.1 time = 535
* CHECK dout0_42 vdout0_42ck106 = 0 time = 535
* CHECK dout0_43 vdout0_43ck106 = 1.1 time = 535
* CHECK dout0_44 vdout0_44ck106 = 1.1 time = 535
* CHECK dout0_45 vdout0_45ck106 = 0 time = 535
* CHECK dout0_46 vdout0_46ck106 = 0 time = 535
* CHECK dout0_47 vdout0_47ck106 = 0 time = 535
* CHECK dout0_48 vdout0_48ck106 = 1.1 time = 535
* CHECK dout0_49 vdout0_49ck106 = 0 time = 535
* CHECK dout0_50 vdout0_50ck106 = 1.1 time = 535
* CHECK dout0_51 vdout0_51ck106 = 0 time = 535
* CHECK dout0_52 vdout0_52ck106 = 0 time = 535
* CHECK dout0_53 vdout0_53ck106 = 1.1 time = 535
* CHECK dout0_54 vdout0_54ck106 = 1.1 time = 535
* CHECK dout0_55 vdout0_55ck106 = 1.1 time = 535
* CHECK dout0_56 vdout0_56ck106 = 1.1 time = 535
* CHECK dout0_57 vdout0_57ck106 = 0 time = 535
* CHECK dout0_58 vdout0_58ck106 = 1.1 time = 535
* CHECK dout0_59 vdout0_59ck106 = 1.1 time = 535
* CHECK dout0_60 vdout0_60ck106 = 1.1 time = 535
* CHECK dout0_61 vdout0_61ck106 = 1.1 time = 535
* CHECK dout0_62 vdout0_62ck106 = 1.1 time = 535
* CHECK dout0_63 vdout0_63ck106 = 0 time = 535
* CHECK dout0_0 vdout0_0ck110 = 1.1 time = 555
* CHECK dout0_1 vdout0_1ck110 = 0 time = 555
* CHECK dout0_2 vdout0_2ck110 = 1.1 time = 555
* CHECK dout0_3 vdout0_3ck110 = 0 time = 555
* CHECK dout0_4 vdout0_4ck110 = 1.1 time = 555
* CHECK dout0_5 vdout0_5ck110 = 1.1 time = 555
* CHECK dout0_6 vdout0_6ck110 = 1.1 time = 555
* CHECK dout0_7 vdout0_7ck110 = 1.1 time = 555
* CHECK dout0_8 vdout0_8ck110 = 0 time = 555
* CHECK dout0_9 vdout0_9ck110 = 0 time = 555
* CHECK dout0_10 vdout0_10ck110 = 0 time = 555
* CHECK dout0_11 vdout0_11ck110 = 1.1 time = 555
* CHECK dout0_12 vdout0_12ck110 = 1.1 time = 555
* CHECK dout0_13 vdout0_13ck110 = 1.1 time = 555
* CHECK dout0_14 vdout0_14ck110 = 0 time = 555
* CHECK dout0_15 vdout0_15ck110 = 1.1 time = 555
* CHECK dout0_16 vdout0_16ck110 = 0 time = 555
* CHECK dout0_17 vdout0_17ck110 = 1.1 time = 555
* CHECK dout0_18 vdout0_18ck110 = 0 time = 555
* CHECK dout0_19 vdout0_19ck110 = 0 time = 555
* CHECK dout0_20 vdout0_20ck110 = 1.1 time = 555
* CHECK dout0_21 vdout0_21ck110 = 0 time = 555
* CHECK dout0_22 vdout0_22ck110 = 0 time = 555
* CHECK dout0_23 vdout0_23ck110 = 0 time = 555
* CHECK dout0_24 vdout0_24ck110 = 1.1 time = 555
* CHECK dout0_25 vdout0_25ck110 = 1.1 time = 555
* CHECK dout0_26 vdout0_26ck110 = 1.1 time = 555
* CHECK dout0_27 vdout0_27ck110 = 0 time = 555
* CHECK dout0_28 vdout0_28ck110 = 1.1 time = 555
* CHECK dout0_29 vdout0_29ck110 = 0 time = 555
* CHECK dout0_30 vdout0_30ck110 = 1.1 time = 555
* CHECK dout0_31 vdout0_31ck110 = 1.1 time = 555
* CHECK dout0_32 vdout0_32ck110 = 1.1 time = 555
* CHECK dout0_33 vdout0_33ck110 = 0 time = 555
* CHECK dout0_34 vdout0_34ck110 = 0 time = 555
* CHECK dout0_35 vdout0_35ck110 = 0 time = 555
* CHECK dout0_36 vdout0_36ck110 = 1.1 time = 555
* CHECK dout0_37 vdout0_37ck110 = 1.1 time = 555
* CHECK dout0_38 vdout0_38ck110 = 1.1 time = 555
* CHECK dout0_39 vdout0_39ck110 = 0 time = 555
* CHECK dout0_40 vdout0_40ck110 = 1.1 time = 555
* CHECK dout0_41 vdout0_41ck110 = 1.1 time = 555
* CHECK dout0_42 vdout0_42ck110 = 0 time = 555
* CHECK dout0_43 vdout0_43ck110 = 0 time = 555
* CHECK dout0_44 vdout0_44ck110 = 1.1 time = 555
* CHECK dout0_45 vdout0_45ck110 = 1.1 time = 555
* CHECK dout0_46 vdout0_46ck110 = 1.1 time = 555
* CHECK dout0_47 vdout0_47ck110 = 0 time = 555
* CHECK dout0_48 vdout0_48ck110 = 1.1 time = 555
* CHECK dout0_49 vdout0_49ck110 = 0 time = 555
* CHECK dout0_50 vdout0_50ck110 = 1.1 time = 555
* CHECK dout0_51 vdout0_51ck110 = 0 time = 555
* CHECK dout0_52 vdout0_52ck110 = 0 time = 555
* CHECK dout0_53 vdout0_53ck110 = 0 time = 555
* CHECK dout0_54 vdout0_54ck110 = 1.1 time = 555
* CHECK dout0_55 vdout0_55ck110 = 1.1 time = 555
* CHECK dout0_56 vdout0_56ck110 = 0 time = 555
* CHECK dout0_57 vdout0_57ck110 = 0 time = 555
* CHECK dout0_58 vdout0_58ck110 = 1.1 time = 555
* CHECK dout0_59 vdout0_59ck110 = 1.1 time = 555
* CHECK dout0_60 vdout0_60ck110 = 0 time = 555
* CHECK dout0_61 vdout0_61ck110 = 1.1 time = 555
* CHECK dout0_62 vdout0_62ck110 = 0 time = 555
* CHECK dout0_63 vdout0_63ck110 = 1.1 time = 555
* CHECK dout0_0 vdout0_0ck112 = 0 time = 565
* CHECK dout0_1 vdout0_1ck112 = 0 time = 565
* CHECK dout0_2 vdout0_2ck112 = 0 time = 565
* CHECK dout0_3 vdout0_3ck112 = 0 time = 565
* CHECK dout0_4 vdout0_4ck112 = 1.1 time = 565
* CHECK dout0_5 vdout0_5ck112 = 0 time = 565
* CHECK dout0_6 vdout0_6ck112 = 1.1 time = 565
* CHECK dout0_7 vdout0_7ck112 = 1.1 time = 565
* CHECK dout0_8 vdout0_8ck112 = 1.1 time = 565
* CHECK dout0_9 vdout0_9ck112 = 1.1 time = 565
* CHECK dout0_10 vdout0_10ck112 = 1.1 time = 565
* CHECK dout0_11 vdout0_11ck112 = 1.1 time = 565
* CHECK dout0_12 vdout0_12ck112 = 0 time = 565
* CHECK dout0_13 vdout0_13ck112 = 0 time = 565
* CHECK dout0_14 vdout0_14ck112 = 1.1 time = 565
* CHECK dout0_15 vdout0_15ck112 = 0 time = 565
* CHECK dout0_16 vdout0_16ck112 = 1.1 time = 565
* CHECK dout0_17 vdout0_17ck112 = 0 time = 565
* CHECK dout0_18 vdout0_18ck112 = 1.1 time = 565
* CHECK dout0_19 vdout0_19ck112 = 0 time = 565
* CHECK dout0_20 vdout0_20ck112 = 0 time = 565
* CHECK dout0_21 vdout0_21ck112 = 1.1 time = 565
* CHECK dout0_22 vdout0_22ck112 = 1.1 time = 565
* CHECK dout0_23 vdout0_23ck112 = 0 time = 565
* CHECK dout0_24 vdout0_24ck112 = 0 time = 565
* CHECK dout0_25 vdout0_25ck112 = 1.1 time = 565
* CHECK dout0_26 vdout0_26ck112 = 0 time = 565
* CHECK dout0_27 vdout0_27ck112 = 0 time = 565
* CHECK dout0_28 vdout0_28ck112 = 0 time = 565
* CHECK dout0_29 vdout0_29ck112 = 1.1 time = 565
* CHECK dout0_30 vdout0_30ck112 = 0 time = 565
* CHECK dout0_31 vdout0_31ck112 = 1.1 time = 565
* CHECK dout0_32 vdout0_32ck112 = 0 time = 565
* CHECK dout0_33 vdout0_33ck112 = 1.1 time = 565
* CHECK dout0_34 vdout0_34ck112 = 1.1 time = 565
* CHECK dout0_35 vdout0_35ck112 = 1.1 time = 565
* CHECK dout0_36 vdout0_36ck112 = 0 time = 565
* CHECK dout0_37 vdout0_37ck112 = 1.1 time = 565
* CHECK dout0_38 vdout0_38ck112 = 0 time = 565
* CHECK dout0_39 vdout0_39ck112 = 1.1 time = 565
* CHECK dout0_40 vdout0_40ck112 = 0 time = 565
* CHECK dout0_41 vdout0_41ck112 = 0 time = 565
* CHECK dout0_42 vdout0_42ck112 = 0 time = 565
* CHECK dout0_43 vdout0_43ck112 = 1.1 time = 565
* CHECK dout0_44 vdout0_44ck112 = 0 time = 565
* CHECK dout0_45 vdout0_45ck112 = 1.1 time = 565
* CHECK dout0_46 vdout0_46ck112 = 0 time = 565
* CHECK dout0_47 vdout0_47ck112 = 0 time = 565
* CHECK dout0_48 vdout0_48ck112 = 0 time = 565
* CHECK dout0_49 vdout0_49ck112 = 1.1 time = 565
* CHECK dout0_50 vdout0_50ck112 = 0 time = 565
* CHECK dout0_51 vdout0_51ck112 = 1.1 time = 565
* CHECK dout0_52 vdout0_52ck112 = 0 time = 565
* CHECK dout0_53 vdout0_53ck112 = 0 time = 565
* CHECK dout0_54 vdout0_54ck112 = 1.1 time = 565
* CHECK dout0_55 vdout0_55ck112 = 0 time = 565
* CHECK dout0_56 vdout0_56ck112 = 0 time = 565
* CHECK dout0_57 vdout0_57ck112 = 1.1 time = 565
* CHECK dout0_58 vdout0_58ck112 = 1.1 time = 565
* CHECK dout0_59 vdout0_59ck112 = 1.1 time = 565
* CHECK dout0_60 vdout0_60ck112 = 1.1 time = 565
* CHECK dout0_61 vdout0_61ck112 = 1.1 time = 565
* CHECK dout0_62 vdout0_62ck112 = 0 time = 565
* CHECK dout0_63 vdout0_63ck112 = 0 time = 565
* CHECK dout0_0 vdout0_0ck113 = 1.1 time = 570
* CHECK dout0_1 vdout0_1ck113 = 1.1 time = 570
* CHECK dout0_2 vdout0_2ck113 = 0 time = 570
* CHECK dout0_3 vdout0_3ck113 = 0 time = 570
* CHECK dout0_4 vdout0_4ck113 = 1.1 time = 570
* CHECK dout0_5 vdout0_5ck113 = 1.1 time = 570
* CHECK dout0_6 vdout0_6ck113 = 1.1 time = 570
* CHECK dout0_7 vdout0_7ck113 = 0 time = 570
* CHECK dout0_8 vdout0_8ck113 = 1.1 time = 570
* CHECK dout0_9 vdout0_9ck113 = 1.1 time = 570
* CHECK dout0_10 vdout0_10ck113 = 1.1 time = 570
* CHECK dout0_11 vdout0_11ck113 = 1.1 time = 570
* CHECK dout0_12 vdout0_12ck113 = 0 time = 570
* CHECK dout0_13 vdout0_13ck113 = 1.1 time = 570
* CHECK dout0_14 vdout0_14ck113 = 1.1 time = 570
* CHECK dout0_15 vdout0_15ck113 = 0 time = 570
* CHECK dout0_16 vdout0_16ck113 = 1.1 time = 570
* CHECK dout0_17 vdout0_17ck113 = 0 time = 570
* CHECK dout0_18 vdout0_18ck113 = 0 time = 570
* CHECK dout0_19 vdout0_19ck113 = 1.1 time = 570
* CHECK dout0_20 vdout0_20ck113 = 1.1 time = 570
* CHECK dout0_21 vdout0_21ck113 = 1.1 time = 570
* CHECK dout0_22 vdout0_22ck113 = 0 time = 570
* CHECK dout0_23 vdout0_23ck113 = 0 time = 570
* CHECK dout0_24 vdout0_24ck113 = 1.1 time = 570
* CHECK dout0_25 vdout0_25ck113 = 0 time = 570
* CHECK dout0_26 vdout0_26ck113 = 0 time = 570
* CHECK dout0_27 vdout0_27ck113 = 1.1 time = 570
* CHECK dout0_28 vdout0_28ck113 = 0 time = 570
* CHECK dout0_29 vdout0_29ck113 = 0 time = 570
* CHECK dout0_30 vdout0_30ck113 = 0 time = 570
* CHECK dout0_31 vdout0_31ck113 = 1.1 time = 570
* CHECK dout0_32 vdout0_32ck113 = 1.1 time = 570
* CHECK dout0_33 vdout0_33ck113 = 0 time = 570
* CHECK dout0_34 vdout0_34ck113 = 1.1 time = 570
* CHECK dout0_35 vdout0_35ck113 = 1.1 time = 570
* CHECK dout0_36 vdout0_36ck113 = 1.1 time = 570
* CHECK dout0_37 vdout0_37ck113 = 0 time = 570
* CHECK dout0_38 vdout0_38ck113 = 0 time = 570
* CHECK dout0_39 vdout0_39ck113 = 0 time = 570
* CHECK dout0_40 vdout0_40ck113 = 1.1 time = 570
* CHECK dout0_41 vdout0_41ck113 = 1.1 time = 570
* CHECK dout0_42 vdout0_42ck113 = 1.1 time = 570
* CHECK dout0_43 vdout0_43ck113 = 1.1 time = 570
* CHECK dout0_44 vdout0_44ck113 = 0 time = 570
* CHECK dout0_45 vdout0_45ck113 = 0 time = 570
* CHECK dout0_46 vdout0_46ck113 = 1.1 time = 570
* CHECK dout0_47 vdout0_47ck113 = 0 time = 570
* CHECK dout0_48 vdout0_48ck113 = 0 time = 570
* CHECK dout0_49 vdout0_49ck113 = 1.1 time = 570
* CHECK dout0_50 vdout0_50ck113 = 1.1 time = 570
* CHECK dout0_51 vdout0_51ck113 = 0 time = 570
* CHECK dout0_52 vdout0_52ck113 = 1.1 time = 570
* CHECK dout0_53 vdout0_53ck113 = 1.1 time = 570
* CHECK dout0_54 vdout0_54ck113 = 0 time = 570
* CHECK dout0_55 vdout0_55ck113 = 0 time = 570
* CHECK dout0_56 vdout0_56ck113 = 0 time = 570
* CHECK dout0_57 vdout0_57ck113 = 0 time = 570
* CHECK dout0_58 vdout0_58ck113 = 0 time = 570
* CHECK dout0_59 vdout0_59ck113 = 0 time = 570
* CHECK dout0_60 vdout0_60ck113 = 0 time = 570
* CHECK dout0_61 vdout0_61ck113 = 1.1 time = 570
* CHECK dout0_62 vdout0_62ck113 = 1.1 time = 570
* CHECK dout0_63 vdout0_63ck113 = 0 time = 570
* CHECK dout0_0 vdout0_0ck116 = 1.1 time = 585
* CHECK dout0_1 vdout0_1ck116 = 0 time = 585
* CHECK dout0_2 vdout0_2ck116 = 1.1 time = 585
* CHECK dout0_3 vdout0_3ck116 = 1.1 time = 585
* CHECK dout0_4 vdout0_4ck116 = 0 time = 585
* CHECK dout0_5 vdout0_5ck116 = 0 time = 585
* CHECK dout0_6 vdout0_6ck116 = 1.1 time = 585
* CHECK dout0_7 vdout0_7ck116 = 1.1 time = 585
* CHECK dout0_8 vdout0_8ck116 = 0 time = 585
* CHECK dout0_9 vdout0_9ck116 = 0 time = 585
* CHECK dout0_10 vdout0_10ck116 = 1.1 time = 585
* CHECK dout0_11 vdout0_11ck116 = 0 time = 585
* CHECK dout0_12 vdout0_12ck116 = 1.1 time = 585
* CHECK dout0_13 vdout0_13ck116 = 0 time = 585
* CHECK dout0_14 vdout0_14ck116 = 1.1 time = 585
* CHECK dout0_15 vdout0_15ck116 = 0 time = 585
* CHECK dout0_16 vdout0_16ck116 = 0 time = 585
* CHECK dout0_17 vdout0_17ck116 = 1.1 time = 585
* CHECK dout0_18 vdout0_18ck116 = 1.1 time = 585
* CHECK dout0_19 vdout0_19ck116 = 1.1 time = 585
* CHECK dout0_20 vdout0_20ck116 = 0 time = 585
* CHECK dout0_21 vdout0_21ck116 = 0 time = 585
* CHECK dout0_22 vdout0_22ck116 = 0 time = 585
* CHECK dout0_23 vdout0_23ck116 = 1.1 time = 585
* CHECK dout0_24 vdout0_24ck116 = 0 time = 585
* CHECK dout0_25 vdout0_25ck116 = 0 time = 585
* CHECK dout0_26 vdout0_26ck116 = 1.1 time = 585
* CHECK dout0_27 vdout0_27ck116 = 1.1 time = 585
* CHECK dout0_28 vdout0_28ck116 = 1.1 time = 585
* CHECK dout0_29 vdout0_29ck116 = 1.1 time = 585
* CHECK dout0_30 vdout0_30ck116 = 0 time = 585
* CHECK dout0_31 vdout0_31ck116 = 1.1 time = 585
* CHECK dout0_32 vdout0_32ck116 = 1.1 time = 585
* CHECK dout0_33 vdout0_33ck116 = 1.1 time = 585
* CHECK dout0_34 vdout0_34ck116 = 1.1 time = 585
* CHECK dout0_35 vdout0_35ck116 = 1.1 time = 585
* CHECK dout0_36 vdout0_36ck116 = 0 time = 585
* CHECK dout0_37 vdout0_37ck116 = 1.1 time = 585
* CHECK dout0_38 vdout0_38ck116 = 1.1 time = 585
* CHECK dout0_39 vdout0_39ck116 = 1.1 time = 585
* CHECK dout0_40 vdout0_40ck116 = 1.1 time = 585
* CHECK dout0_41 vdout0_41ck116 = 0 time = 585
* CHECK dout0_42 vdout0_42ck116 = 0 time = 585
* CHECK dout0_43 vdout0_43ck116 = 0 time = 585
* CHECK dout0_44 vdout0_44ck116 = 1.1 time = 585
* CHECK dout0_45 vdout0_45ck116 = 1.1 time = 585
* CHECK dout0_46 vdout0_46ck116 = 0 time = 585
* CHECK dout0_47 vdout0_47ck116 = 0 time = 585
* CHECK dout0_48 vdout0_48ck116 = 0 time = 585
* CHECK dout0_49 vdout0_49ck116 = 1.1 time = 585
* CHECK dout0_50 vdout0_50ck116 = 1.1 time = 585
* CHECK dout0_51 vdout0_51ck116 = 1.1 time = 585
* CHECK dout0_52 vdout0_52ck116 = 1.1 time = 585
* CHECK dout0_53 vdout0_53ck116 = 1.1 time = 585
* CHECK dout0_54 vdout0_54ck116 = 1.1 time = 585
* CHECK dout0_55 vdout0_55ck116 = 1.1 time = 585
* CHECK dout0_56 vdout0_56ck116 = 0 time = 585
* CHECK dout0_57 vdout0_57ck116 = 1.1 time = 585
* CHECK dout0_58 vdout0_58ck116 = 0 time = 585
* CHECK dout0_59 vdout0_59ck116 = 0 time = 585
* CHECK dout0_60 vdout0_60ck116 = 0 time = 585
* CHECK dout0_61 vdout0_61ck116 = 1.1 time = 585
* CHECK dout0_62 vdout0_62ck116 = 0 time = 585
* CHECK dout0_63 vdout0_63ck116 = 1.1 time = 585
* CHECK dout0_0 vdout0_0ck117 = 1.1 time = 590
* CHECK dout0_1 vdout0_1ck117 = 1.1 time = 590
* CHECK dout0_2 vdout0_2ck117 = 0 time = 590
* CHECK dout0_3 vdout0_3ck117 = 0 time = 590
* CHECK dout0_4 vdout0_4ck117 = 1.1 time = 590
* CHECK dout0_5 vdout0_5ck117 = 1.1 time = 590
* CHECK dout0_6 vdout0_6ck117 = 1.1 time = 590
* CHECK dout0_7 vdout0_7ck117 = 0 time = 590
* CHECK dout0_8 vdout0_8ck117 = 1.1 time = 590
* CHECK dout0_9 vdout0_9ck117 = 1.1 time = 590
* CHECK dout0_10 vdout0_10ck117 = 1.1 time = 590
* CHECK dout0_11 vdout0_11ck117 = 1.1 time = 590
* CHECK dout0_12 vdout0_12ck117 = 0 time = 590
* CHECK dout0_13 vdout0_13ck117 = 1.1 time = 590
* CHECK dout0_14 vdout0_14ck117 = 1.1 time = 590
* CHECK dout0_15 vdout0_15ck117 = 0 time = 590
* CHECK dout0_16 vdout0_16ck117 = 1.1 time = 590
* CHECK dout0_17 vdout0_17ck117 = 0 time = 590
* CHECK dout0_18 vdout0_18ck117 = 0 time = 590
* CHECK dout0_19 vdout0_19ck117 = 1.1 time = 590
* CHECK dout0_20 vdout0_20ck117 = 1.1 time = 590
* CHECK dout0_21 vdout0_21ck117 = 1.1 time = 590
* CHECK dout0_22 vdout0_22ck117 = 0 time = 590
* CHECK dout0_23 vdout0_23ck117 = 0 time = 590
* CHECK dout0_24 vdout0_24ck117 = 1.1 time = 590
* CHECK dout0_25 vdout0_25ck117 = 0 time = 590
* CHECK dout0_26 vdout0_26ck117 = 0 time = 590
* CHECK dout0_27 vdout0_27ck117 = 1.1 time = 590
* CHECK dout0_28 vdout0_28ck117 = 0 time = 590
* CHECK dout0_29 vdout0_29ck117 = 0 time = 590
* CHECK dout0_30 vdout0_30ck117 = 0 time = 590
* CHECK dout0_31 vdout0_31ck117 = 1.1 time = 590
* CHECK dout0_32 vdout0_32ck117 = 1.1 time = 590
* CHECK dout0_33 vdout0_33ck117 = 0 time = 590
* CHECK dout0_34 vdout0_34ck117 = 1.1 time = 590
* CHECK dout0_35 vdout0_35ck117 = 1.1 time = 590
* CHECK dout0_36 vdout0_36ck117 = 1.1 time = 590
* CHECK dout0_37 vdout0_37ck117 = 0 time = 590
* CHECK dout0_38 vdout0_38ck117 = 0 time = 590
* CHECK dout0_39 vdout0_39ck117 = 0 time = 590
* CHECK dout0_40 vdout0_40ck117 = 1.1 time = 590
* CHECK dout0_41 vdout0_41ck117 = 1.1 time = 590
* CHECK dout0_42 vdout0_42ck117 = 1.1 time = 590
* CHECK dout0_43 vdout0_43ck117 = 1.1 time = 590
* CHECK dout0_44 vdout0_44ck117 = 0 time = 590
* CHECK dout0_45 vdout0_45ck117 = 0 time = 590
* CHECK dout0_46 vdout0_46ck117 = 1.1 time = 590
* CHECK dout0_47 vdout0_47ck117 = 0 time = 590
* CHECK dout0_48 vdout0_48ck117 = 0 time = 590
* CHECK dout0_49 vdout0_49ck117 = 1.1 time = 590
* CHECK dout0_50 vdout0_50ck117 = 1.1 time = 590
* CHECK dout0_51 vdout0_51ck117 = 0 time = 590
* CHECK dout0_52 vdout0_52ck117 = 1.1 time = 590
* CHECK dout0_53 vdout0_53ck117 = 1.1 time = 590
* CHECK dout0_54 vdout0_54ck117 = 0 time = 590
* CHECK dout0_55 vdout0_55ck117 = 0 time = 590
* CHECK dout0_56 vdout0_56ck117 = 0 time = 590
* CHECK dout0_57 vdout0_57ck117 = 0 time = 590
* CHECK dout0_58 vdout0_58ck117 = 0 time = 590
* CHECK dout0_59 vdout0_59ck117 = 0 time = 590
* CHECK dout0_60 vdout0_60ck117 = 0 time = 590
* CHECK dout0_61 vdout0_61ck117 = 1.1 time = 590
* CHECK dout0_62 vdout0_62ck117 = 1.1 time = 590
* CHECK dout0_63 vdout0_63ck117 = 0 time = 590
* CHECK dout0_0 vdout0_0ck118 = 1.1 time = 595
* CHECK dout0_1 vdout0_1ck118 = 1.1 time = 595
* CHECK dout0_2 vdout0_2ck118 = 1.1 time = 595
* CHECK dout0_3 vdout0_3ck118 = 1.1 time = 595
* CHECK dout0_4 vdout0_4ck118 = 0 time = 595
* CHECK dout0_5 vdout0_5ck118 = 0 time = 595
* CHECK dout0_6 vdout0_6ck118 = 0 time = 595
* CHECK dout0_7 vdout0_7ck118 = 0 time = 595
* CHECK dout0_8 vdout0_8ck118 = 1.1 time = 595
* CHECK dout0_9 vdout0_9ck118 = 0 time = 595
* CHECK dout0_10 vdout0_10ck118 = 0 time = 595
* CHECK dout0_11 vdout0_11ck118 = 0 time = 595
* CHECK dout0_12 vdout0_12ck118 = 1.1 time = 595
* CHECK dout0_13 vdout0_13ck118 = 0 time = 595
* CHECK dout0_14 vdout0_14ck118 = 1.1 time = 595
* CHECK dout0_15 vdout0_15ck118 = 0 time = 595
* CHECK dout0_16 vdout0_16ck118 = 0 time = 595
* CHECK dout0_17 vdout0_17ck118 = 1.1 time = 595
* CHECK dout0_18 vdout0_18ck118 = 1.1 time = 595
* CHECK dout0_19 vdout0_19ck118 = 0 time = 595
* CHECK dout0_20 vdout0_20ck118 = 0 time = 595
* CHECK dout0_21 vdout0_21ck118 = 1.1 time = 595
* CHECK dout0_22 vdout0_22ck118 = 1.1 time = 595
* CHECK dout0_23 vdout0_23ck118 = 0 time = 595
* CHECK dout0_24 vdout0_24ck118 = 1.1 time = 595
* CHECK dout0_25 vdout0_25ck118 = 0 time = 595
* CHECK dout0_26 vdout0_26ck118 = 1.1 time = 595
* CHECK dout0_27 vdout0_27ck118 = 0 time = 595
* CHECK dout0_28 vdout0_28ck118 = 1.1 time = 595
* CHECK dout0_29 vdout0_29ck118 = 1.1 time = 595
* CHECK dout0_30 vdout0_30ck118 = 1.1 time = 595
* CHECK dout0_31 vdout0_31ck118 = 1.1 time = 595
* CHECK dout0_32 vdout0_32ck118 = 1.1 time = 595
* CHECK dout0_33 vdout0_33ck118 = 0 time = 595
* CHECK dout0_34 vdout0_34ck118 = 0 time = 595
* CHECK dout0_35 vdout0_35ck118 = 1.1 time = 595
* CHECK dout0_36 vdout0_36ck118 = 0 time = 595
* CHECK dout0_37 vdout0_37ck118 = 1.1 time = 595
* CHECK dout0_38 vdout0_38ck118 = 1.1 time = 595
* CHECK dout0_39 vdout0_39ck118 = 0 time = 595
* CHECK dout0_40 vdout0_40ck118 = 0 time = 595
* CHECK dout0_41 vdout0_41ck118 = 1.1 time = 595
* CHECK dout0_42 vdout0_42ck118 = 0 time = 595
* CHECK dout0_43 vdout0_43ck118 = 0 time = 595
* CHECK dout0_44 vdout0_44ck118 = 1.1 time = 595
* CHECK dout0_45 vdout0_45ck118 = 1.1 time = 595
* CHECK dout0_46 vdout0_46ck118 = 1.1 time = 595
* CHECK dout0_47 vdout0_47ck118 = 1.1 time = 595
* CHECK dout0_48 vdout0_48ck118 = 1.1 time = 595
* CHECK dout0_49 vdout0_49ck118 = 0 time = 595
* CHECK dout0_50 vdout0_50ck118 = 1.1 time = 595
* CHECK dout0_51 vdout0_51ck118 = 0 time = 595
* CHECK dout0_52 vdout0_52ck118 = 1.1 time = 595
* CHECK dout0_53 vdout0_53ck118 = 1.1 time = 595
* CHECK dout0_54 vdout0_54ck118 = 0 time = 595
* CHECK dout0_55 vdout0_55ck118 = 0 time = 595
* CHECK dout0_56 vdout0_56ck118 = 0 time = 595
* CHECK dout0_57 vdout0_57ck118 = 0 time = 595
* CHECK dout0_58 vdout0_58ck118 = 1.1 time = 595
* CHECK dout0_59 vdout0_59ck118 = 1.1 time = 595
* CHECK dout0_60 vdout0_60ck118 = 0 time = 595
* CHECK dout0_61 vdout0_61ck118 = 0 time = 595
* CHECK dout0_62 vdout0_62ck118 = 1.1 time = 595
* CHECK dout0_63 vdout0_63ck118 = 0 time = 595
* CHECK dout0_0 vdout0_0ck119 = 1.1 time = 600
* CHECK dout0_1 vdout0_1ck119 = 0 time = 600
* CHECK dout0_2 vdout0_2ck119 = 1.1 time = 600
* CHECK dout0_3 vdout0_3ck119 = 1.1 time = 600
* CHECK dout0_4 vdout0_4ck119 = 0 time = 600
* CHECK dout0_5 vdout0_5ck119 = 0 time = 600
* CHECK dout0_6 vdout0_6ck119 = 1.1 time = 600
* CHECK dout0_7 vdout0_7ck119 = 1.1 time = 600
* CHECK dout0_8 vdout0_8ck119 = 0 time = 600
* CHECK dout0_9 vdout0_9ck119 = 0 time = 600
* CHECK dout0_10 vdout0_10ck119 = 1.1 time = 600
* CHECK dout0_11 vdout0_11ck119 = 0 time = 600
* CHECK dout0_12 vdout0_12ck119 = 1.1 time = 600
* CHECK dout0_13 vdout0_13ck119 = 0 time = 600
* CHECK dout0_14 vdout0_14ck119 = 1.1 time = 600
* CHECK dout0_15 vdout0_15ck119 = 0 time = 600
* CHECK dout0_16 vdout0_16ck119 = 0 time = 600
* CHECK dout0_17 vdout0_17ck119 = 1.1 time = 600
* CHECK dout0_18 vdout0_18ck119 = 1.1 time = 600
* CHECK dout0_19 vdout0_19ck119 = 1.1 time = 600
* CHECK dout0_20 vdout0_20ck119 = 0 time = 600
* CHECK dout0_21 vdout0_21ck119 = 0 time = 600
* CHECK dout0_22 vdout0_22ck119 = 0 time = 600
* CHECK dout0_23 vdout0_23ck119 = 1.1 time = 600
* CHECK dout0_24 vdout0_24ck119 = 0 time = 600
* CHECK dout0_25 vdout0_25ck119 = 0 time = 600
* CHECK dout0_26 vdout0_26ck119 = 1.1 time = 600
* CHECK dout0_27 vdout0_27ck119 = 1.1 time = 600
* CHECK dout0_28 vdout0_28ck119 = 1.1 time = 600
* CHECK dout0_29 vdout0_29ck119 = 1.1 time = 600
* CHECK dout0_30 vdout0_30ck119 = 0 time = 600
* CHECK dout0_31 vdout0_31ck119 = 1.1 time = 600
* CHECK dout0_32 vdout0_32ck119 = 1.1 time = 600
* CHECK dout0_33 vdout0_33ck119 = 1.1 time = 600
* CHECK dout0_34 vdout0_34ck119 = 1.1 time = 600
* CHECK dout0_35 vdout0_35ck119 = 1.1 time = 600
* CHECK dout0_36 vdout0_36ck119 = 0 time = 600
* CHECK dout0_37 vdout0_37ck119 = 1.1 time = 600
* CHECK dout0_38 vdout0_38ck119 = 1.1 time = 600
* CHECK dout0_39 vdout0_39ck119 = 1.1 time = 600
* CHECK dout0_40 vdout0_40ck119 = 1.1 time = 600
* CHECK dout0_41 vdout0_41ck119 = 0 time = 600
* CHECK dout0_42 vdout0_42ck119 = 0 time = 600
* CHECK dout0_43 vdout0_43ck119 = 0 time = 600
* CHECK dout0_44 vdout0_44ck119 = 1.1 time = 600
* CHECK dout0_45 vdout0_45ck119 = 1.1 time = 600
* CHECK dout0_46 vdout0_46ck119 = 0 time = 600
* CHECK dout0_47 vdout0_47ck119 = 0 time = 600
* CHECK dout0_48 vdout0_48ck119 = 0 time = 600
* CHECK dout0_49 vdout0_49ck119 = 1.1 time = 600
* CHECK dout0_50 vdout0_50ck119 = 1.1 time = 600
* CHECK dout0_51 vdout0_51ck119 = 1.1 time = 600
* CHECK dout0_52 vdout0_52ck119 = 1.1 time = 600
* CHECK dout0_53 vdout0_53ck119 = 1.1 time = 600
* CHECK dout0_54 vdout0_54ck119 = 1.1 time = 600
* CHECK dout0_55 vdout0_55ck119 = 1.1 time = 600
* CHECK dout0_56 vdout0_56ck119 = 0 time = 600
* CHECK dout0_57 vdout0_57ck119 = 1.1 time = 600
* CHECK dout0_58 vdout0_58ck119 = 0 time = 600
* CHECK dout0_59 vdout0_59ck119 = 0 time = 600
* CHECK dout0_60 vdout0_60ck119 = 0 time = 600
* CHECK dout0_61 vdout0_61ck119 = 1.1 time = 600
* CHECK dout0_62 vdout0_62ck119 = 0 time = 600
* CHECK dout0_63 vdout0_63ck119 = 1.1 time = 600
* CHECK dout0_0 vdout0_0ck120 = 1.1 time = 605
* CHECK dout0_1 vdout0_1ck120 = 1.1 time = 605
* CHECK dout0_2 vdout0_2ck120 = 0 time = 605
* CHECK dout0_3 vdout0_3ck120 = 0 time = 605
* CHECK dout0_4 vdout0_4ck120 = 1.1 time = 605
* CHECK dout0_5 vdout0_5ck120 = 1.1 time = 605
* CHECK dout0_6 vdout0_6ck120 = 1.1 time = 605
* CHECK dout0_7 vdout0_7ck120 = 0 time = 605
* CHECK dout0_8 vdout0_8ck120 = 1.1 time = 605
* CHECK dout0_9 vdout0_9ck120 = 1.1 time = 605
* CHECK dout0_10 vdout0_10ck120 = 1.1 time = 605
* CHECK dout0_11 vdout0_11ck120 = 1.1 time = 605
* CHECK dout0_12 vdout0_12ck120 = 0 time = 605
* CHECK dout0_13 vdout0_13ck120 = 1.1 time = 605
* CHECK dout0_14 vdout0_14ck120 = 1.1 time = 605
* CHECK dout0_15 vdout0_15ck120 = 0 time = 605
* CHECK dout0_16 vdout0_16ck120 = 1.1 time = 605
* CHECK dout0_17 vdout0_17ck120 = 0 time = 605
* CHECK dout0_18 vdout0_18ck120 = 0 time = 605
* CHECK dout0_19 vdout0_19ck120 = 1.1 time = 605
* CHECK dout0_20 vdout0_20ck120 = 1.1 time = 605
* CHECK dout0_21 vdout0_21ck120 = 1.1 time = 605
* CHECK dout0_22 vdout0_22ck120 = 0 time = 605
* CHECK dout0_23 vdout0_23ck120 = 0 time = 605
* CHECK dout0_24 vdout0_24ck120 = 1.1 time = 605
* CHECK dout0_25 vdout0_25ck120 = 0 time = 605
* CHECK dout0_26 vdout0_26ck120 = 0 time = 605
* CHECK dout0_27 vdout0_27ck120 = 1.1 time = 605
* CHECK dout0_28 vdout0_28ck120 = 0 time = 605
* CHECK dout0_29 vdout0_29ck120 = 0 time = 605
* CHECK dout0_30 vdout0_30ck120 = 0 time = 605
* CHECK dout0_31 vdout0_31ck120 = 1.1 time = 605
* CHECK dout0_32 vdout0_32ck120 = 1.1 time = 605
* CHECK dout0_33 vdout0_33ck120 = 0 time = 605
* CHECK dout0_34 vdout0_34ck120 = 1.1 time = 605
* CHECK dout0_35 vdout0_35ck120 = 1.1 time = 605
* CHECK dout0_36 vdout0_36ck120 = 1.1 time = 605
* CHECK dout0_37 vdout0_37ck120 = 0 time = 605
* CHECK dout0_38 vdout0_38ck120 = 0 time = 605
* CHECK dout0_39 vdout0_39ck120 = 0 time = 605
* CHECK dout0_40 vdout0_40ck120 = 1.1 time = 605
* CHECK dout0_41 vdout0_41ck120 = 1.1 time = 605
* CHECK dout0_42 vdout0_42ck120 = 1.1 time = 605
* CHECK dout0_43 vdout0_43ck120 = 1.1 time = 605
* CHECK dout0_44 vdout0_44ck120 = 0 time = 605
* CHECK dout0_45 vdout0_45ck120 = 0 time = 605
* CHECK dout0_46 vdout0_46ck120 = 1.1 time = 605
* CHECK dout0_47 vdout0_47ck120 = 0 time = 605
* CHECK dout0_48 vdout0_48ck120 = 0 time = 605
* CHECK dout0_49 vdout0_49ck120 = 1.1 time = 605
* CHECK dout0_50 vdout0_50ck120 = 1.1 time = 605
* CHECK dout0_51 vdout0_51ck120 = 0 time = 605
* CHECK dout0_52 vdout0_52ck120 = 1.1 time = 605
* CHECK dout0_53 vdout0_53ck120 = 1.1 time = 605
* CHECK dout0_54 vdout0_54ck120 = 0 time = 605
* CHECK dout0_55 vdout0_55ck120 = 0 time = 605
* CHECK dout0_56 vdout0_56ck120 = 0 time = 605
* CHECK dout0_57 vdout0_57ck120 = 0 time = 605
* CHECK dout0_58 vdout0_58ck120 = 0 time = 605
* CHECK dout0_59 vdout0_59ck120 = 0 time = 605
* CHECK dout0_60 vdout0_60ck120 = 0 time = 605
* CHECK dout0_61 vdout0_61ck120 = 1.1 time = 605
* CHECK dout0_62 vdout0_62ck120 = 1.1 time = 605
* CHECK dout0_63 vdout0_63ck120 = 0 time = 605
* CHECK dout0_0 vdout0_0ck121 = 1.1 time = 610
* CHECK dout0_1 vdout0_1ck121 = 1.1 time = 610
* CHECK dout0_2 vdout0_2ck121 = 1.1 time = 610
* CHECK dout0_3 vdout0_3ck121 = 1.1 time = 610
* CHECK dout0_4 vdout0_4ck121 = 0 time = 610
* CHECK dout0_5 vdout0_5ck121 = 0 time = 610
* CHECK dout0_6 vdout0_6ck121 = 0 time = 610
* CHECK dout0_7 vdout0_7ck121 = 0 time = 610
* CHECK dout0_8 vdout0_8ck121 = 1.1 time = 610
* CHECK dout0_9 vdout0_9ck121 = 0 time = 610
* CHECK dout0_10 vdout0_10ck121 = 0 time = 610
* CHECK dout0_11 vdout0_11ck121 = 0 time = 610
* CHECK dout0_12 vdout0_12ck121 = 1.1 time = 610
* CHECK dout0_13 vdout0_13ck121 = 0 time = 610
* CHECK dout0_14 vdout0_14ck121 = 1.1 time = 610
* CHECK dout0_15 vdout0_15ck121 = 0 time = 610
* CHECK dout0_16 vdout0_16ck121 = 0 time = 610
* CHECK dout0_17 vdout0_17ck121 = 1.1 time = 610
* CHECK dout0_18 vdout0_18ck121 = 1.1 time = 610
* CHECK dout0_19 vdout0_19ck121 = 0 time = 610
* CHECK dout0_20 vdout0_20ck121 = 0 time = 610
* CHECK dout0_21 vdout0_21ck121 = 1.1 time = 610
* CHECK dout0_22 vdout0_22ck121 = 1.1 time = 610
* CHECK dout0_23 vdout0_23ck121 = 0 time = 610
* CHECK dout0_24 vdout0_24ck121 = 1.1 time = 610
* CHECK dout0_25 vdout0_25ck121 = 0 time = 610
* CHECK dout0_26 vdout0_26ck121 = 1.1 time = 610
* CHECK dout0_27 vdout0_27ck121 = 0 time = 610
* CHECK dout0_28 vdout0_28ck121 = 1.1 time = 610
* CHECK dout0_29 vdout0_29ck121 = 1.1 time = 610
* CHECK dout0_30 vdout0_30ck121 = 1.1 time = 610
* CHECK dout0_31 vdout0_31ck121 = 1.1 time = 610
* CHECK dout0_32 vdout0_32ck121 = 1.1 time = 610
* CHECK dout0_33 vdout0_33ck121 = 0 time = 610
* CHECK dout0_34 vdout0_34ck121 = 0 time = 610
* CHECK dout0_35 vdout0_35ck121 = 1.1 time = 610
* CHECK dout0_36 vdout0_36ck121 = 0 time = 610
* CHECK dout0_37 vdout0_37ck121 = 1.1 time = 610
* CHECK dout0_38 vdout0_38ck121 = 1.1 time = 610
* CHECK dout0_39 vdout0_39ck121 = 0 time = 610
* CHECK dout0_40 vdout0_40ck121 = 0 time = 610
* CHECK dout0_41 vdout0_41ck121 = 1.1 time = 610
* CHECK dout0_42 vdout0_42ck121 = 0 time = 610
* CHECK dout0_43 vdout0_43ck121 = 0 time = 610
* CHECK dout0_44 vdout0_44ck121 = 1.1 time = 610
* CHECK dout0_45 vdout0_45ck121 = 1.1 time = 610
* CHECK dout0_46 vdout0_46ck121 = 1.1 time = 610
* CHECK dout0_47 vdout0_47ck121 = 1.1 time = 610
* CHECK dout0_48 vdout0_48ck121 = 1.1 time = 610
* CHECK dout0_49 vdout0_49ck121 = 0 time = 610
* CHECK dout0_50 vdout0_50ck121 = 1.1 time = 610
* CHECK dout0_51 vdout0_51ck121 = 0 time = 610
* CHECK dout0_52 vdout0_52ck121 = 1.1 time = 610
* CHECK dout0_53 vdout0_53ck121 = 1.1 time = 610
* CHECK dout0_54 vdout0_54ck121 = 0 time = 610
* CHECK dout0_55 vdout0_55ck121 = 0 time = 610
* CHECK dout0_56 vdout0_56ck121 = 0 time = 610
* CHECK dout0_57 vdout0_57ck121 = 0 time = 610
* CHECK dout0_58 vdout0_58ck121 = 1.1 time = 610
* CHECK dout0_59 vdout0_59ck121 = 1.1 time = 610
* CHECK dout0_60 vdout0_60ck121 = 0 time = 610
* CHECK dout0_61 vdout0_61ck121 = 0 time = 610
* CHECK dout0_62 vdout0_62ck121 = 1.1 time = 610
* CHECK dout0_63 vdout0_63ck121 = 0 time = 610
* CHECK dout0_0 vdout0_0ck122 = 1.1 time = 615
* CHECK dout0_1 vdout0_1ck122 = 0 time = 615
* CHECK dout0_2 vdout0_2ck122 = 1.1 time = 615
* CHECK dout0_3 vdout0_3ck122 = 1.1 time = 615
* CHECK dout0_4 vdout0_4ck122 = 0 time = 615
* CHECK dout0_5 vdout0_5ck122 = 0 time = 615
* CHECK dout0_6 vdout0_6ck122 = 1.1 time = 615
* CHECK dout0_7 vdout0_7ck122 = 1.1 time = 615
* CHECK dout0_8 vdout0_8ck122 = 0 time = 615
* CHECK dout0_9 vdout0_9ck122 = 0 time = 615
* CHECK dout0_10 vdout0_10ck122 = 1.1 time = 615
* CHECK dout0_11 vdout0_11ck122 = 0 time = 615
* CHECK dout0_12 vdout0_12ck122 = 1.1 time = 615
* CHECK dout0_13 vdout0_13ck122 = 0 time = 615
* CHECK dout0_14 vdout0_14ck122 = 1.1 time = 615
* CHECK dout0_15 vdout0_15ck122 = 0 time = 615
* CHECK dout0_16 vdout0_16ck122 = 0 time = 615
* CHECK dout0_17 vdout0_17ck122 = 1.1 time = 615
* CHECK dout0_18 vdout0_18ck122 = 1.1 time = 615
* CHECK dout0_19 vdout0_19ck122 = 1.1 time = 615
* CHECK dout0_20 vdout0_20ck122 = 0 time = 615
* CHECK dout0_21 vdout0_21ck122 = 0 time = 615
* CHECK dout0_22 vdout0_22ck122 = 0 time = 615
* CHECK dout0_23 vdout0_23ck122 = 1.1 time = 615
* CHECK dout0_24 vdout0_24ck122 = 0 time = 615
* CHECK dout0_25 vdout0_25ck122 = 0 time = 615
* CHECK dout0_26 vdout0_26ck122 = 1.1 time = 615
* CHECK dout0_27 vdout0_27ck122 = 1.1 time = 615
* CHECK dout0_28 vdout0_28ck122 = 1.1 time = 615
* CHECK dout0_29 vdout0_29ck122 = 1.1 time = 615
* CHECK dout0_30 vdout0_30ck122 = 0 time = 615
* CHECK dout0_31 vdout0_31ck122 = 1.1 time = 615
* CHECK dout0_32 vdout0_32ck122 = 1.1 time = 615
* CHECK dout0_33 vdout0_33ck122 = 1.1 time = 615
* CHECK dout0_34 vdout0_34ck122 = 1.1 time = 615
* CHECK dout0_35 vdout0_35ck122 = 1.1 time = 615
* CHECK dout0_36 vdout0_36ck122 = 0 time = 615
* CHECK dout0_37 vdout0_37ck122 = 1.1 time = 615
* CHECK dout0_38 vdout0_38ck122 = 1.1 time = 615
* CHECK dout0_39 vdout0_39ck122 = 1.1 time = 615
* CHECK dout0_40 vdout0_40ck122 = 1.1 time = 615
* CHECK dout0_41 vdout0_41ck122 = 0 time = 615
* CHECK dout0_42 vdout0_42ck122 = 0 time = 615
* CHECK dout0_43 vdout0_43ck122 = 0 time = 615
* CHECK dout0_44 vdout0_44ck122 = 1.1 time = 615
* CHECK dout0_45 vdout0_45ck122 = 1.1 time = 615
* CHECK dout0_46 vdout0_46ck122 = 0 time = 615
* CHECK dout0_47 vdout0_47ck122 = 0 time = 615
* CHECK dout0_48 vdout0_48ck122 = 0 time = 615
* CHECK dout0_49 vdout0_49ck122 = 1.1 time = 615
* CHECK dout0_50 vdout0_50ck122 = 1.1 time = 615
* CHECK dout0_51 vdout0_51ck122 = 1.1 time = 615
* CHECK dout0_52 vdout0_52ck122 = 1.1 time = 615
* CHECK dout0_53 vdout0_53ck122 = 1.1 time = 615
* CHECK dout0_54 vdout0_54ck122 = 1.1 time = 615
* CHECK dout0_55 vdout0_55ck122 = 1.1 time = 615
* CHECK dout0_56 vdout0_56ck122 = 0 time = 615
* CHECK dout0_57 vdout0_57ck122 = 1.1 time = 615
* CHECK dout0_58 vdout0_58ck122 = 0 time = 615
* CHECK dout0_59 vdout0_59ck122 = 0 time = 615
* CHECK dout0_60 vdout0_60ck122 = 0 time = 615
* CHECK dout0_61 vdout0_61ck122 = 1.1 time = 615
* CHECK dout0_62 vdout0_62ck122 = 0 time = 615
* CHECK dout0_63 vdout0_63ck122 = 1.1 time = 615
* CHECK dout0_0 vdout0_0ck124 = 1.1 time = 625
* CHECK dout0_1 vdout0_1ck124 = 0 time = 625
* CHECK dout0_2 vdout0_2ck124 = 1.1 time = 625
* CHECK dout0_3 vdout0_3ck124 = 1.1 time = 625
* CHECK dout0_4 vdout0_4ck124 = 0 time = 625
* CHECK dout0_5 vdout0_5ck124 = 0 time = 625
* CHECK dout0_6 vdout0_6ck124 = 1.1 time = 625
* CHECK dout0_7 vdout0_7ck124 = 1.1 time = 625
* CHECK dout0_8 vdout0_8ck124 = 0 time = 625
* CHECK dout0_9 vdout0_9ck124 = 0 time = 625
* CHECK dout0_10 vdout0_10ck124 = 1.1 time = 625
* CHECK dout0_11 vdout0_11ck124 = 0 time = 625
* CHECK dout0_12 vdout0_12ck124 = 1.1 time = 625
* CHECK dout0_13 vdout0_13ck124 = 0 time = 625
* CHECK dout0_14 vdout0_14ck124 = 1.1 time = 625
* CHECK dout0_15 vdout0_15ck124 = 0 time = 625
* CHECK dout0_16 vdout0_16ck124 = 0 time = 625
* CHECK dout0_17 vdout0_17ck124 = 1.1 time = 625
* CHECK dout0_18 vdout0_18ck124 = 1.1 time = 625
* CHECK dout0_19 vdout0_19ck124 = 1.1 time = 625
* CHECK dout0_20 vdout0_20ck124 = 0 time = 625
* CHECK dout0_21 vdout0_21ck124 = 0 time = 625
* CHECK dout0_22 vdout0_22ck124 = 0 time = 625
* CHECK dout0_23 vdout0_23ck124 = 1.1 time = 625
* CHECK dout0_24 vdout0_24ck124 = 0 time = 625
* CHECK dout0_25 vdout0_25ck124 = 0 time = 625
* CHECK dout0_26 vdout0_26ck124 = 1.1 time = 625
* CHECK dout0_27 vdout0_27ck124 = 1.1 time = 625
* CHECK dout0_28 vdout0_28ck124 = 1.1 time = 625
* CHECK dout0_29 vdout0_29ck124 = 1.1 time = 625
* CHECK dout0_30 vdout0_30ck124 = 0 time = 625
* CHECK dout0_31 vdout0_31ck124 = 1.1 time = 625
* CHECK dout0_32 vdout0_32ck124 = 1.1 time = 625
* CHECK dout0_33 vdout0_33ck124 = 1.1 time = 625
* CHECK dout0_34 vdout0_34ck124 = 1.1 time = 625
* CHECK dout0_35 vdout0_35ck124 = 1.1 time = 625
* CHECK dout0_36 vdout0_36ck124 = 0 time = 625
* CHECK dout0_37 vdout0_37ck124 = 1.1 time = 625
* CHECK dout0_38 vdout0_38ck124 = 1.1 time = 625
* CHECK dout0_39 vdout0_39ck124 = 1.1 time = 625
* CHECK dout0_40 vdout0_40ck124 = 1.1 time = 625
* CHECK dout0_41 vdout0_41ck124 = 0 time = 625
* CHECK dout0_42 vdout0_42ck124 = 0 time = 625
* CHECK dout0_43 vdout0_43ck124 = 0 time = 625
* CHECK dout0_44 vdout0_44ck124 = 1.1 time = 625
* CHECK dout0_45 vdout0_45ck124 = 1.1 time = 625
* CHECK dout0_46 vdout0_46ck124 = 0 time = 625
* CHECK dout0_47 vdout0_47ck124 = 0 time = 625
* CHECK dout0_48 vdout0_48ck124 = 0 time = 625
* CHECK dout0_49 vdout0_49ck124 = 1.1 time = 625
* CHECK dout0_50 vdout0_50ck124 = 1.1 time = 625
* CHECK dout0_51 vdout0_51ck124 = 1.1 time = 625
* CHECK dout0_52 vdout0_52ck124 = 1.1 time = 625
* CHECK dout0_53 vdout0_53ck124 = 1.1 time = 625
* CHECK dout0_54 vdout0_54ck124 = 1.1 time = 625
* CHECK dout0_55 vdout0_55ck124 = 1.1 time = 625
* CHECK dout0_56 vdout0_56ck124 = 0 time = 625
* CHECK dout0_57 vdout0_57ck124 = 1.1 time = 625
* CHECK dout0_58 vdout0_58ck124 = 0 time = 625
* CHECK dout0_59 vdout0_59ck124 = 0 time = 625
* CHECK dout0_60 vdout0_60ck124 = 0 time = 625
* CHECK dout0_61 vdout0_61ck124 = 1.1 time = 625
* CHECK dout0_62 vdout0_62ck124 = 0 time = 625
* CHECK dout0_63 vdout0_63ck124 = 1.1 time = 625
* CHECK dout0_0 vdout0_0ck129 = 0 time = 650
* CHECK dout0_1 vdout0_1ck129 = 0 time = 650
* CHECK dout0_2 vdout0_2ck129 = 0 time = 650
* CHECK dout0_3 vdout0_3ck129 = 1.1 time = 650
* CHECK dout0_4 vdout0_4ck129 = 0 time = 650
* CHECK dout0_5 vdout0_5ck129 = 1.1 time = 650
* CHECK dout0_6 vdout0_6ck129 = 0 time = 650
* CHECK dout0_7 vdout0_7ck129 = 1.1 time = 650
* CHECK dout0_8 vdout0_8ck129 = 0 time = 650
* CHECK dout0_9 vdout0_9ck129 = 0 time = 650
* CHECK dout0_10 vdout0_10ck129 = 1.1 time = 650
* CHECK dout0_11 vdout0_11ck129 = 1.1 time = 650
* CHECK dout0_12 vdout0_12ck129 = 1.1 time = 650
* CHECK dout0_13 vdout0_13ck129 = 0 time = 650
* CHECK dout0_14 vdout0_14ck129 = 1.1 time = 650
* CHECK dout0_15 vdout0_15ck129 = 0 time = 650
* CHECK dout0_16 vdout0_16ck129 = 1.1 time = 650
* CHECK dout0_17 vdout0_17ck129 = 1.1 time = 650
* CHECK dout0_18 vdout0_18ck129 = 0 time = 650
* CHECK dout0_19 vdout0_19ck129 = 0 time = 650
* CHECK dout0_20 vdout0_20ck129 = 1.1 time = 650
* CHECK dout0_21 vdout0_21ck129 = 1.1 time = 650
* CHECK dout0_22 vdout0_22ck129 = 1.1 time = 650
* CHECK dout0_23 vdout0_23ck129 = 1.1 time = 650
* CHECK dout0_24 vdout0_24ck129 = 0 time = 650
* CHECK dout0_25 vdout0_25ck129 = 0 time = 650
* CHECK dout0_26 vdout0_26ck129 = 1.1 time = 650
* CHECK dout0_27 vdout0_27ck129 = 1.1 time = 650
* CHECK dout0_28 vdout0_28ck129 = 1.1 time = 650
* CHECK dout0_29 vdout0_29ck129 = 0 time = 650
* CHECK dout0_30 vdout0_30ck129 = 0 time = 650
* CHECK dout0_31 vdout0_31ck129 = 0 time = 650
* CHECK dout0_32 vdout0_32ck129 = 1.1 time = 650
* CHECK dout0_33 vdout0_33ck129 = 0 time = 650
* CHECK dout0_34 vdout0_34ck129 = 0 time = 650
* CHECK dout0_35 vdout0_35ck129 = 1.1 time = 650
* CHECK dout0_36 vdout0_36ck129 = 1.1 time = 650
* CHECK dout0_37 vdout0_37ck129 = 1.1 time = 650
* CHECK dout0_38 vdout0_38ck129 = 1.1 time = 650
* CHECK dout0_39 vdout0_39ck129 = 1.1 time = 650
* CHECK dout0_40 vdout0_40ck129 = 0 time = 650
* CHECK dout0_41 vdout0_41ck129 = 1.1 time = 650
* CHECK dout0_42 vdout0_42ck129 = 0 time = 650
* CHECK dout0_43 vdout0_43ck129 = 0 time = 650
* CHECK dout0_44 vdout0_44ck129 = 0 time = 650
* CHECK dout0_45 vdout0_45ck129 = 0 time = 650
* CHECK dout0_46 vdout0_46ck129 = 1.1 time = 650
* CHECK dout0_47 vdout0_47ck129 = 0 time = 650
* CHECK dout0_48 vdout0_48ck129 = 1.1 time = 650
* CHECK dout0_49 vdout0_49ck129 = 0 time = 650
* CHECK dout0_50 vdout0_50ck129 = 0 time = 650
* CHECK dout0_51 vdout0_51ck129 = 1.1 time = 650
* CHECK dout0_52 vdout0_52ck129 = 0 time = 650
* CHECK dout0_53 vdout0_53ck129 = 1.1 time = 650
* CHECK dout0_54 vdout0_54ck129 = 0 time = 650
* CHECK dout0_55 vdout0_55ck129 = 1.1 time = 650
* CHECK dout0_56 vdout0_56ck129 = 0 time = 650
* CHECK dout0_57 vdout0_57ck129 = 1.1 time = 650
* CHECK dout0_58 vdout0_58ck129 = 0 time = 650
* CHECK dout0_59 vdout0_59ck129 = 1.1 time = 650
* CHECK dout0_60 vdout0_60ck129 = 0 time = 650
* CHECK dout0_61 vdout0_61ck129 = 0 time = 650
* CHECK dout0_62 vdout0_62ck129 = 1.1 time = 650
* CHECK dout0_63 vdout0_63ck129 = 0 time = 650
* CHECK dout0_0 vdout0_0ck130 = 1.1 time = 655
* CHECK dout0_1 vdout0_1ck130 = 0 time = 655
* CHECK dout0_2 vdout0_2ck130 = 1.1 time = 655
* CHECK dout0_3 vdout0_3ck130 = 1.1 time = 655
* CHECK dout0_4 vdout0_4ck130 = 0 time = 655
* CHECK dout0_5 vdout0_5ck130 = 0 time = 655
* CHECK dout0_6 vdout0_6ck130 = 1.1 time = 655
* CHECK dout0_7 vdout0_7ck130 = 1.1 time = 655
* CHECK dout0_8 vdout0_8ck130 = 0 time = 655
* CHECK dout0_9 vdout0_9ck130 = 0 time = 655
* CHECK dout0_10 vdout0_10ck130 = 1.1 time = 655
* CHECK dout0_11 vdout0_11ck130 = 0 time = 655
* CHECK dout0_12 vdout0_12ck130 = 0 time = 655
* CHECK dout0_13 vdout0_13ck130 = 1.1 time = 655
* CHECK dout0_14 vdout0_14ck130 = 0 time = 655
* CHECK dout0_15 vdout0_15ck130 = 1.1 time = 655
* CHECK dout0_16 vdout0_16ck130 = 1.1 time = 655
* CHECK dout0_17 vdout0_17ck130 = 1.1 time = 655
* CHECK dout0_18 vdout0_18ck130 = 0 time = 655
* CHECK dout0_19 vdout0_19ck130 = 0 time = 655
* CHECK dout0_20 vdout0_20ck130 = 1.1 time = 655
* CHECK dout0_21 vdout0_21ck130 = 0 time = 655
* CHECK dout0_22 vdout0_22ck130 = 0 time = 655
* CHECK dout0_23 vdout0_23ck130 = 1.1 time = 655
* CHECK dout0_24 vdout0_24ck130 = 1.1 time = 655
* CHECK dout0_25 vdout0_25ck130 = 1.1 time = 655
* CHECK dout0_26 vdout0_26ck130 = 1.1 time = 655
* CHECK dout0_27 vdout0_27ck130 = 1.1 time = 655
* CHECK dout0_28 vdout0_28ck130 = 1.1 time = 655
* CHECK dout0_29 vdout0_29ck130 = 1.1 time = 655
* CHECK dout0_30 vdout0_30ck130 = 0 time = 655
* CHECK dout0_31 vdout0_31ck130 = 1.1 time = 655
* CHECK dout0_32 vdout0_32ck130 = 1.1 time = 655
* CHECK dout0_33 vdout0_33ck130 = 1.1 time = 655
* CHECK dout0_34 vdout0_34ck130 = 1.1 time = 655
* CHECK dout0_35 vdout0_35ck130 = 1.1 time = 655
* CHECK dout0_36 vdout0_36ck130 = 0 time = 655
* CHECK dout0_37 vdout0_37ck130 = 1.1 time = 655
* CHECK dout0_38 vdout0_38ck130 = 1.1 time = 655
* CHECK dout0_39 vdout0_39ck130 = 1.1 time = 655
* CHECK dout0_40 vdout0_40ck130 = 1.1 time = 655
* CHECK dout0_41 vdout0_41ck130 = 0 time = 655
* CHECK dout0_42 vdout0_42ck130 = 0 time = 655
* CHECK dout0_43 vdout0_43ck130 = 0 time = 655
* CHECK dout0_44 vdout0_44ck130 = 0 time = 655
* CHECK dout0_45 vdout0_45ck130 = 1.1 time = 655
* CHECK dout0_46 vdout0_46ck130 = 1.1 time = 655
* CHECK dout0_47 vdout0_47ck130 = 1.1 time = 655
* CHECK dout0_48 vdout0_48ck130 = 0 time = 655
* CHECK dout0_49 vdout0_49ck130 = 1.1 time = 655
* CHECK dout0_50 vdout0_50ck130 = 1.1 time = 655
* CHECK dout0_51 vdout0_51ck130 = 1.1 time = 655
* CHECK dout0_52 vdout0_52ck130 = 1.1 time = 655
* CHECK dout0_53 vdout0_53ck130 = 1.1 time = 655
* CHECK dout0_54 vdout0_54ck130 = 1.1 time = 655
* CHECK dout0_55 vdout0_55ck130 = 1.1 time = 655
* CHECK dout0_56 vdout0_56ck130 = 0 time = 655
* CHECK dout0_57 vdout0_57ck130 = 1.1 time = 655
* CHECK dout0_58 vdout0_58ck130 = 0 time = 655
* CHECK dout0_59 vdout0_59ck130 = 0 time = 655
* CHECK dout0_60 vdout0_60ck130 = 0 time = 655
* CHECK dout0_61 vdout0_61ck130 = 1.1 time = 655
* CHECK dout0_62 vdout0_62ck130 = 0 time = 655
* CHECK dout0_63 vdout0_63ck130 = 1.1 time = 655
* CHECK dout0_0 vdout0_0ck135 = 0 time = 680
* CHECK dout0_1 vdout0_1ck135 = 0 time = 680
* CHECK dout0_2 vdout0_2ck135 = 0 time = 680
* CHECK dout0_3 vdout0_3ck135 = 1.1 time = 680
* CHECK dout0_4 vdout0_4ck135 = 1.1 time = 680
* CHECK dout0_5 vdout0_5ck135 = 1.1 time = 680
* CHECK dout0_6 vdout0_6ck135 = 1.1 time = 680
* CHECK dout0_7 vdout0_7ck135 = 1.1 time = 680
* CHECK dout0_8 vdout0_8ck135 = 0 time = 680
* CHECK dout0_9 vdout0_9ck135 = 1.1 time = 680
* CHECK dout0_10 vdout0_10ck135 = 0 time = 680
* CHECK dout0_11 vdout0_11ck135 = 0 time = 680
* CHECK dout0_12 vdout0_12ck135 = 1.1 time = 680
* CHECK dout0_13 vdout0_13ck135 = 0 time = 680
* CHECK dout0_14 vdout0_14ck135 = 0 time = 680
* CHECK dout0_15 vdout0_15ck135 = 0 time = 680
* CHECK dout0_16 vdout0_16ck135 = 1.1 time = 680
* CHECK dout0_17 vdout0_17ck135 = 1.1 time = 680
* CHECK dout0_18 vdout0_18ck135 = 1.1 time = 680
* CHECK dout0_19 vdout0_19ck135 = 1.1 time = 680
* CHECK dout0_20 vdout0_20ck135 = 1.1 time = 680
* CHECK dout0_21 vdout0_21ck135 = 1.1 time = 680
* CHECK dout0_22 vdout0_22ck135 = 1.1 time = 680
* CHECK dout0_23 vdout0_23ck135 = 1.1 time = 680
* CHECK dout0_24 vdout0_24ck135 = 1.1 time = 680
* CHECK dout0_25 vdout0_25ck135 = 1.1 time = 680
* CHECK dout0_26 vdout0_26ck135 = 1.1 time = 680
* CHECK dout0_27 vdout0_27ck135 = 1.1 time = 680
* CHECK dout0_28 vdout0_28ck135 = 1.1 time = 680
* CHECK dout0_29 vdout0_29ck135 = 1.1 time = 680
* CHECK dout0_30 vdout0_30ck135 = 0 time = 680
* CHECK dout0_31 vdout0_31ck135 = 1.1 time = 680
* CHECK dout0_32 vdout0_32ck135 = 1.1 time = 680
* CHECK dout0_33 vdout0_33ck135 = 1.1 time = 680
* CHECK dout0_34 vdout0_34ck135 = 1.1 time = 680
* CHECK dout0_35 vdout0_35ck135 = 1.1 time = 680
* CHECK dout0_36 vdout0_36ck135 = 0 time = 680
* CHECK dout0_37 vdout0_37ck135 = 1.1 time = 680
* CHECK dout0_38 vdout0_38ck135 = 1.1 time = 680
* CHECK dout0_39 vdout0_39ck135 = 1.1 time = 680
* CHECK dout0_40 vdout0_40ck135 = 0 time = 680
* CHECK dout0_41 vdout0_41ck135 = 0 time = 680
* CHECK dout0_42 vdout0_42ck135 = 1.1 time = 680
* CHECK dout0_43 vdout0_43ck135 = 1.1 time = 680
* CHECK dout0_44 vdout0_44ck135 = 0 time = 680
* CHECK dout0_45 vdout0_45ck135 = 1.1 time = 680
* CHECK dout0_46 vdout0_46ck135 = 1.1 time = 680
* CHECK dout0_47 vdout0_47ck135 = 1.1 time = 680
* CHECK dout0_48 vdout0_48ck135 = 0 time = 680
* CHECK dout0_49 vdout0_49ck135 = 1.1 time = 680
* CHECK dout0_50 vdout0_50ck135 = 1.1 time = 680
* CHECK dout0_51 vdout0_51ck135 = 1.1 time = 680
* CHECK dout0_52 vdout0_52ck135 = 1.1 time = 680
* CHECK dout0_53 vdout0_53ck135 = 1.1 time = 680
* CHECK dout0_54 vdout0_54ck135 = 1.1 time = 680
* CHECK dout0_55 vdout0_55ck135 = 1.1 time = 680
* CHECK dout0_56 vdout0_56ck135 = 1.1 time = 680
* CHECK dout0_57 vdout0_57ck135 = 0 time = 680
* CHECK dout0_58 vdout0_58ck135 = 0 time = 680
* CHECK dout0_59 vdout0_59ck135 = 0 time = 680
* CHECK dout0_60 vdout0_60ck135 = 1.1 time = 680
* CHECK dout0_61 vdout0_61ck135 = 0 time = 680
* CHECK dout0_62 vdout0_62ck135 = 1.1 time = 680
* CHECK dout0_63 vdout0_63ck135 = 1.1 time = 680
* CHECK dout0_0 vdout0_0ck136 = 0 time = 685
* CHECK dout0_1 vdout0_1ck136 = 0 time = 685
* CHECK dout0_2 vdout0_2ck136 = 0 time = 685
* CHECK dout0_3 vdout0_3ck136 = 1.1 time = 685
* CHECK dout0_4 vdout0_4ck136 = 0 time = 685
* CHECK dout0_5 vdout0_5ck136 = 1.1 time = 685
* CHECK dout0_6 vdout0_6ck136 = 1.1 time = 685
* CHECK dout0_7 vdout0_7ck136 = 1.1 time = 685
* CHECK dout0_8 vdout0_8ck136 = 1.1 time = 685
* CHECK dout0_9 vdout0_9ck136 = 0 time = 685
* CHECK dout0_10 vdout0_10ck136 = 0 time = 685
* CHECK dout0_11 vdout0_11ck136 = 0 time = 685
* CHECK dout0_12 vdout0_12ck136 = 1.1 time = 685
* CHECK dout0_13 vdout0_13ck136 = 1.1 time = 685
* CHECK dout0_14 vdout0_14ck136 = 0 time = 685
* CHECK dout0_15 vdout0_15ck136 = 0 time = 685
* CHECK dout0_16 vdout0_16ck136 = 1.1 time = 685
* CHECK dout0_17 vdout0_17ck136 = 1.1 time = 685
* CHECK dout0_18 vdout0_18ck136 = 1.1 time = 685
* CHECK dout0_19 vdout0_19ck136 = 1.1 time = 685
* CHECK dout0_20 vdout0_20ck136 = 0 time = 685
* CHECK dout0_21 vdout0_21ck136 = 0 time = 685
* CHECK dout0_22 vdout0_22ck136 = 0 time = 685
* CHECK dout0_23 vdout0_23ck136 = 0 time = 685
* CHECK dout0_24 vdout0_24ck136 = 1.1 time = 685
* CHECK dout0_25 vdout0_25ck136 = 0 time = 685
* CHECK dout0_26 vdout0_26ck136 = 0 time = 685
* CHECK dout0_27 vdout0_27ck136 = 1.1 time = 685
* CHECK dout0_28 vdout0_28ck136 = 0 time = 685
* CHECK dout0_29 vdout0_29ck136 = 0 time = 685
* CHECK dout0_30 vdout0_30ck136 = 0 time = 685
* CHECK dout0_31 vdout0_31ck136 = 1.1 time = 685
* CHECK dout0_32 vdout0_32ck136 = 0 time = 685
* CHECK dout0_33 vdout0_33ck136 = 0 time = 685
* CHECK dout0_34 vdout0_34ck136 = 0 time = 685
* CHECK dout0_35 vdout0_35ck136 = 0 time = 685
* CHECK dout0_36 vdout0_36ck136 = 0 time = 685
* CHECK dout0_37 vdout0_37ck136 = 1.1 time = 685
* CHECK dout0_38 vdout0_38ck136 = 1.1 time = 685
* CHECK dout0_39 vdout0_39ck136 = 1.1 time = 685
* CHECK dout0_40 vdout0_40ck136 = 0 time = 685
* CHECK dout0_41 vdout0_41ck136 = 0 time = 685
* CHECK dout0_42 vdout0_42ck136 = 0 time = 685
* CHECK dout0_43 vdout0_43ck136 = 0 time = 685
* CHECK dout0_44 vdout0_44ck136 = 1.1 time = 685
* CHECK dout0_45 vdout0_45ck136 = 0 time = 685
* CHECK dout0_46 vdout0_46ck136 = 1.1 time = 685
* CHECK dout0_47 vdout0_47ck136 = 1.1 time = 685
* CHECK dout0_48 vdout0_48ck136 = 0 time = 685
* CHECK dout0_49 vdout0_49ck136 = 1.1 time = 685
* CHECK dout0_50 vdout0_50ck136 = 1.1 time = 685
* CHECK dout0_51 vdout0_51ck136 = 0 time = 685
* CHECK dout0_52 vdout0_52ck136 = 1.1 time = 685
* CHECK dout0_53 vdout0_53ck136 = 1.1 time = 685
* CHECK dout0_54 vdout0_54ck136 = 0 time = 685
* CHECK dout0_55 vdout0_55ck136 = 0 time = 685
* CHECK dout0_56 vdout0_56ck136 = 0 time = 685
* CHECK dout0_57 vdout0_57ck136 = 0 time = 685
* CHECK dout0_58 vdout0_58ck136 = 0 time = 685
* CHECK dout0_59 vdout0_59ck136 = 0 time = 685
* CHECK dout0_60 vdout0_60ck136 = 0 time = 685
* CHECK dout0_61 vdout0_61ck136 = 1.1 time = 685
* CHECK dout0_62 vdout0_62ck136 = 1.1 time = 685
* CHECK dout0_63 vdout0_63ck136 = 0 time = 685
* CHECK dout0_0 vdout0_0ck137 = 0 time = 690
* CHECK dout0_1 vdout0_1ck137 = 0 time = 690
* CHECK dout0_2 vdout0_2ck137 = 0 time = 690
* CHECK dout0_3 vdout0_3ck137 = 1.1 time = 690
* CHECK dout0_4 vdout0_4ck137 = 0 time = 690
* CHECK dout0_5 vdout0_5ck137 = 1.1 time = 690
* CHECK dout0_6 vdout0_6ck137 = 0 time = 690
* CHECK dout0_7 vdout0_7ck137 = 1.1 time = 690
* CHECK dout0_8 vdout0_8ck137 = 0 time = 690
* CHECK dout0_9 vdout0_9ck137 = 0 time = 690
* CHECK dout0_10 vdout0_10ck137 = 1.1 time = 690
* CHECK dout0_11 vdout0_11ck137 = 1.1 time = 690
* CHECK dout0_12 vdout0_12ck137 = 1.1 time = 690
* CHECK dout0_13 vdout0_13ck137 = 0 time = 690
* CHECK dout0_14 vdout0_14ck137 = 1.1 time = 690
* CHECK dout0_15 vdout0_15ck137 = 0 time = 690
* CHECK dout0_16 vdout0_16ck137 = 1.1 time = 690
* CHECK dout0_17 vdout0_17ck137 = 1.1 time = 690
* CHECK dout0_18 vdout0_18ck137 = 0 time = 690
* CHECK dout0_19 vdout0_19ck137 = 0 time = 690
* CHECK dout0_20 vdout0_20ck137 = 1.1 time = 690
* CHECK dout0_21 vdout0_21ck137 = 1.1 time = 690
* CHECK dout0_22 vdout0_22ck137 = 1.1 time = 690
* CHECK dout0_23 vdout0_23ck137 = 1.1 time = 690
* CHECK dout0_24 vdout0_24ck137 = 0 time = 690
* CHECK dout0_25 vdout0_25ck137 = 0 time = 690
* CHECK dout0_26 vdout0_26ck137 = 1.1 time = 690
* CHECK dout0_27 vdout0_27ck137 = 1.1 time = 690
* CHECK dout0_28 vdout0_28ck137 = 1.1 time = 690
* CHECK dout0_29 vdout0_29ck137 = 0 time = 690
* CHECK dout0_30 vdout0_30ck137 = 0 time = 690
* CHECK dout0_31 vdout0_31ck137 = 0 time = 690
* CHECK dout0_32 vdout0_32ck137 = 1.1 time = 690
* CHECK dout0_33 vdout0_33ck137 = 0 time = 690
* CHECK dout0_34 vdout0_34ck137 = 0 time = 690
* CHECK dout0_35 vdout0_35ck137 = 1.1 time = 690
* CHECK dout0_36 vdout0_36ck137 = 1.1 time = 690
* CHECK dout0_37 vdout0_37ck137 = 1.1 time = 690
* CHECK dout0_38 vdout0_38ck137 = 1.1 time = 690
* CHECK dout0_39 vdout0_39ck137 = 1.1 time = 690
* CHECK dout0_40 vdout0_40ck137 = 0 time = 690
* CHECK dout0_41 vdout0_41ck137 = 1.1 time = 690
* CHECK dout0_42 vdout0_42ck137 = 0 time = 690
* CHECK dout0_43 vdout0_43ck137 = 0 time = 690
* CHECK dout0_44 vdout0_44ck137 = 0 time = 690
* CHECK dout0_45 vdout0_45ck137 = 0 time = 690
* CHECK dout0_46 vdout0_46ck137 = 1.1 time = 690
* CHECK dout0_47 vdout0_47ck137 = 0 time = 690
* CHECK dout0_48 vdout0_48ck137 = 1.1 time = 690
* CHECK dout0_49 vdout0_49ck137 = 0 time = 690
* CHECK dout0_50 vdout0_50ck137 = 0 time = 690
* CHECK dout0_51 vdout0_51ck137 = 1.1 time = 690
* CHECK dout0_52 vdout0_52ck137 = 0 time = 690
* CHECK dout0_53 vdout0_53ck137 = 1.1 time = 690
* CHECK dout0_54 vdout0_54ck137 = 0 time = 690
* CHECK dout0_55 vdout0_55ck137 = 1.1 time = 690
* CHECK dout0_56 vdout0_56ck137 = 0 time = 690
* CHECK dout0_57 vdout0_57ck137 = 1.1 time = 690
* CHECK dout0_58 vdout0_58ck137 = 0 time = 690
* CHECK dout0_59 vdout0_59ck137 = 1.1 time = 690
* CHECK dout0_60 vdout0_60ck137 = 0 time = 690
* CHECK dout0_61 vdout0_61ck137 = 0 time = 690
* CHECK dout0_62 vdout0_62ck137 = 1.1 time = 690
* CHECK dout0_63 vdout0_63ck137 = 0 time = 690
* CHECK dout0_0 vdout0_0ck138 = 1.1 time = 695
* CHECK dout0_1 vdout0_1ck138 = 0 time = 695
* CHECK dout0_2 vdout0_2ck138 = 1.1 time = 695
* CHECK dout0_3 vdout0_3ck138 = 0 time = 695
* CHECK dout0_4 vdout0_4ck138 = 1.1 time = 695
* CHECK dout0_5 vdout0_5ck138 = 1.1 time = 695
* CHECK dout0_6 vdout0_6ck138 = 1.1 time = 695
* CHECK dout0_7 vdout0_7ck138 = 1.1 time = 695
* CHECK dout0_8 vdout0_8ck138 = 0 time = 695
* CHECK dout0_9 vdout0_9ck138 = 0 time = 695
* CHECK dout0_10 vdout0_10ck138 = 0 time = 695
* CHECK dout0_11 vdout0_11ck138 = 1.1 time = 695
* CHECK dout0_12 vdout0_12ck138 = 1.1 time = 695
* CHECK dout0_13 vdout0_13ck138 = 1.1 time = 695
* CHECK dout0_14 vdout0_14ck138 = 0 time = 695
* CHECK dout0_15 vdout0_15ck138 = 1.1 time = 695
* CHECK dout0_16 vdout0_16ck138 = 0 time = 695
* CHECK dout0_17 vdout0_17ck138 = 1.1 time = 695
* CHECK dout0_18 vdout0_18ck138 = 0 time = 695
* CHECK dout0_19 vdout0_19ck138 = 0 time = 695
* CHECK dout0_20 vdout0_20ck138 = 1.1 time = 695
* CHECK dout0_21 vdout0_21ck138 = 0 time = 695
* CHECK dout0_22 vdout0_22ck138 = 0 time = 695
* CHECK dout0_23 vdout0_23ck138 = 0 time = 695
* CHECK dout0_24 vdout0_24ck138 = 1.1 time = 695
* CHECK dout0_25 vdout0_25ck138 = 1.1 time = 695
* CHECK dout0_26 vdout0_26ck138 = 1.1 time = 695
* CHECK dout0_27 vdout0_27ck138 = 0 time = 695
* CHECK dout0_28 vdout0_28ck138 = 1.1 time = 695
* CHECK dout0_29 vdout0_29ck138 = 0 time = 695
* CHECK dout0_30 vdout0_30ck138 = 1.1 time = 695
* CHECK dout0_31 vdout0_31ck138 = 1.1 time = 695
* CHECK dout0_32 vdout0_32ck138 = 1.1 time = 695
* CHECK dout0_33 vdout0_33ck138 = 0 time = 695
* CHECK dout0_34 vdout0_34ck138 = 0 time = 695
* CHECK dout0_35 vdout0_35ck138 = 0 time = 695
* CHECK dout0_36 vdout0_36ck138 = 1.1 time = 695
* CHECK dout0_37 vdout0_37ck138 = 1.1 time = 695
* CHECK dout0_38 vdout0_38ck138 = 1.1 time = 695
* CHECK dout0_39 vdout0_39ck138 = 0 time = 695
* CHECK dout0_40 vdout0_40ck138 = 1.1 time = 695
* CHECK dout0_41 vdout0_41ck138 = 1.1 time = 695
* CHECK dout0_42 vdout0_42ck138 = 0 time = 695
* CHECK dout0_43 vdout0_43ck138 = 0 time = 695
* CHECK dout0_44 vdout0_44ck138 = 1.1 time = 695
* CHECK dout0_45 vdout0_45ck138 = 1.1 time = 695
* CHECK dout0_46 vdout0_46ck138 = 1.1 time = 695
* CHECK dout0_47 vdout0_47ck138 = 0 time = 695
* CHECK dout0_48 vdout0_48ck138 = 1.1 time = 695
* CHECK dout0_49 vdout0_49ck138 = 0 time = 695
* CHECK dout0_50 vdout0_50ck138 = 1.1 time = 695
* CHECK dout0_51 vdout0_51ck138 = 0 time = 695
* CHECK dout0_52 vdout0_52ck138 = 0 time = 695
* CHECK dout0_53 vdout0_53ck138 = 0 time = 695
* CHECK dout0_54 vdout0_54ck138 = 1.1 time = 695
* CHECK dout0_55 vdout0_55ck138 = 1.1 time = 695
* CHECK dout0_56 vdout0_56ck138 = 0 time = 695
* CHECK dout0_57 vdout0_57ck138 = 0 time = 695
* CHECK dout0_58 vdout0_58ck138 = 1.1 time = 695
* CHECK dout0_59 vdout0_59ck138 = 1.1 time = 695
* CHECK dout0_60 vdout0_60ck138 = 0 time = 695
* CHECK dout0_61 vdout0_61ck138 = 1.1 time = 695
* CHECK dout0_62 vdout0_62ck138 = 0 time = 695
* CHECK dout0_63 vdout0_63ck138 = 1.1 time = 695
* CHECK dout0_0 vdout0_0ck139 = 0 time = 700
* CHECK dout0_1 vdout0_1ck139 = 0 time = 700
* CHECK dout0_2 vdout0_2ck139 = 0 time = 700
* CHECK dout0_3 vdout0_3ck139 = 1.1 time = 700
* CHECK dout0_4 vdout0_4ck139 = 1.1 time = 700
* CHECK dout0_5 vdout0_5ck139 = 1.1 time = 700
* CHECK dout0_6 vdout0_6ck139 = 1.1 time = 700
* CHECK dout0_7 vdout0_7ck139 = 1.1 time = 700
* CHECK dout0_8 vdout0_8ck139 = 0 time = 700
* CHECK dout0_9 vdout0_9ck139 = 1.1 time = 700
* CHECK dout0_10 vdout0_10ck139 = 0 time = 700
* CHECK dout0_11 vdout0_11ck139 = 0 time = 700
* CHECK dout0_12 vdout0_12ck139 = 1.1 time = 700
* CHECK dout0_13 vdout0_13ck139 = 0 time = 700
* CHECK dout0_14 vdout0_14ck139 = 0 time = 700
* CHECK dout0_15 vdout0_15ck139 = 0 time = 700
* CHECK dout0_16 vdout0_16ck139 = 1.1 time = 700
* CHECK dout0_17 vdout0_17ck139 = 1.1 time = 700
* CHECK dout0_18 vdout0_18ck139 = 1.1 time = 700
* CHECK dout0_19 vdout0_19ck139 = 1.1 time = 700
* CHECK dout0_20 vdout0_20ck139 = 1.1 time = 700
* CHECK dout0_21 vdout0_21ck139 = 1.1 time = 700
* CHECK dout0_22 vdout0_22ck139 = 1.1 time = 700
* CHECK dout0_23 vdout0_23ck139 = 1.1 time = 700
* CHECK dout0_24 vdout0_24ck139 = 1.1 time = 700
* CHECK dout0_25 vdout0_25ck139 = 1.1 time = 700
* CHECK dout0_26 vdout0_26ck139 = 1.1 time = 700
* CHECK dout0_27 vdout0_27ck139 = 1.1 time = 700
* CHECK dout0_28 vdout0_28ck139 = 1.1 time = 700
* CHECK dout0_29 vdout0_29ck139 = 1.1 time = 700
* CHECK dout0_30 vdout0_30ck139 = 0 time = 700
* CHECK dout0_31 vdout0_31ck139 = 1.1 time = 700
* CHECK dout0_32 vdout0_32ck139 = 1.1 time = 700
* CHECK dout0_33 vdout0_33ck139 = 1.1 time = 700
* CHECK dout0_34 vdout0_34ck139 = 1.1 time = 700
* CHECK dout0_35 vdout0_35ck139 = 1.1 time = 700
* CHECK dout0_36 vdout0_36ck139 = 0 time = 700
* CHECK dout0_37 vdout0_37ck139 = 1.1 time = 700
* CHECK dout0_38 vdout0_38ck139 = 1.1 time = 700
* CHECK dout0_39 vdout0_39ck139 = 1.1 time = 700
* CHECK dout0_40 vdout0_40ck139 = 0 time = 700
* CHECK dout0_41 vdout0_41ck139 = 0 time = 700
* CHECK dout0_42 vdout0_42ck139 = 1.1 time = 700
* CHECK dout0_43 vdout0_43ck139 = 1.1 time = 700
* CHECK dout0_44 vdout0_44ck139 = 0 time = 700
* CHECK dout0_45 vdout0_45ck139 = 1.1 time = 700
* CHECK dout0_46 vdout0_46ck139 = 1.1 time = 700
* CHECK dout0_47 vdout0_47ck139 = 1.1 time = 700
* CHECK dout0_48 vdout0_48ck139 = 0 time = 700
* CHECK dout0_49 vdout0_49ck139 = 1.1 time = 700
* CHECK dout0_50 vdout0_50ck139 = 1.1 time = 700
* CHECK dout0_51 vdout0_51ck139 = 1.1 time = 700
* CHECK dout0_52 vdout0_52ck139 = 1.1 time = 700
* CHECK dout0_53 vdout0_53ck139 = 1.1 time = 700
* CHECK dout0_54 vdout0_54ck139 = 1.1 time = 700
* CHECK dout0_55 vdout0_55ck139 = 1.1 time = 700
* CHECK dout0_56 vdout0_56ck139 = 1.1 time = 700
* CHECK dout0_57 vdout0_57ck139 = 0 time = 700
* CHECK dout0_58 vdout0_58ck139 = 0 time = 700
* CHECK dout0_59 vdout0_59ck139 = 0 time = 700
* CHECK dout0_60 vdout0_60ck139 = 1.1 time = 700
* CHECK dout0_61 vdout0_61ck139 = 0 time = 700
* CHECK dout0_62 vdout0_62ck139 = 1.1 time = 700
* CHECK dout0_63 vdout0_63ck139 = 1.1 time = 700
* CHECK dout0_0 vdout0_0ck144 = 1.1 time = 725
* CHECK dout0_1 vdout0_1ck144 = 0 time = 725
* CHECK dout0_2 vdout0_2ck144 = 1.1 time = 725
* CHECK dout0_3 vdout0_3ck144 = 0 time = 725
* CHECK dout0_4 vdout0_4ck144 = 1.1 time = 725
* CHECK dout0_5 vdout0_5ck144 = 1.1 time = 725
* CHECK dout0_6 vdout0_6ck144 = 1.1 time = 725
* CHECK dout0_7 vdout0_7ck144 = 1.1 time = 725
* CHECK dout0_8 vdout0_8ck144 = 0 time = 725
* CHECK dout0_9 vdout0_9ck144 = 0 time = 725
* CHECK dout0_10 vdout0_10ck144 = 0 time = 725
* CHECK dout0_11 vdout0_11ck144 = 1.1 time = 725
* CHECK dout0_12 vdout0_12ck144 = 1.1 time = 725
* CHECK dout0_13 vdout0_13ck144 = 1.1 time = 725
* CHECK dout0_14 vdout0_14ck144 = 0 time = 725
* CHECK dout0_15 vdout0_15ck144 = 1.1 time = 725
* CHECK dout0_16 vdout0_16ck144 = 0 time = 725
* CHECK dout0_17 vdout0_17ck144 = 1.1 time = 725
* CHECK dout0_18 vdout0_18ck144 = 0 time = 725
* CHECK dout0_19 vdout0_19ck144 = 0 time = 725
* CHECK dout0_20 vdout0_20ck144 = 1.1 time = 725
* CHECK dout0_21 vdout0_21ck144 = 0 time = 725
* CHECK dout0_22 vdout0_22ck144 = 0 time = 725
* CHECK dout0_23 vdout0_23ck144 = 0 time = 725
* CHECK dout0_24 vdout0_24ck144 = 1.1 time = 725
* CHECK dout0_25 vdout0_25ck144 = 1.1 time = 725
* CHECK dout0_26 vdout0_26ck144 = 1.1 time = 725
* CHECK dout0_27 vdout0_27ck144 = 0 time = 725
* CHECK dout0_28 vdout0_28ck144 = 1.1 time = 725
* CHECK dout0_29 vdout0_29ck144 = 0 time = 725
* CHECK dout0_30 vdout0_30ck144 = 1.1 time = 725
* CHECK dout0_31 vdout0_31ck144 = 1.1 time = 725
* CHECK dout0_32 vdout0_32ck144 = 1.1 time = 725
* CHECK dout0_33 vdout0_33ck144 = 0 time = 725
* CHECK dout0_34 vdout0_34ck144 = 0 time = 725
* CHECK dout0_35 vdout0_35ck144 = 0 time = 725
* CHECK dout0_36 vdout0_36ck144 = 1.1 time = 725
* CHECK dout0_37 vdout0_37ck144 = 1.1 time = 725
* CHECK dout0_38 vdout0_38ck144 = 1.1 time = 725
* CHECK dout0_39 vdout0_39ck144 = 0 time = 725
* CHECK dout0_40 vdout0_40ck144 = 1.1 time = 725
* CHECK dout0_41 vdout0_41ck144 = 1.1 time = 725
* CHECK dout0_42 vdout0_42ck144 = 0 time = 725
* CHECK dout0_43 vdout0_43ck144 = 0 time = 725
* CHECK dout0_44 vdout0_44ck144 = 1.1 time = 725
* CHECK dout0_45 vdout0_45ck144 = 1.1 time = 725
* CHECK dout0_46 vdout0_46ck144 = 1.1 time = 725
* CHECK dout0_47 vdout0_47ck144 = 0 time = 725
* CHECK dout0_48 vdout0_48ck144 = 1.1 time = 725
* CHECK dout0_49 vdout0_49ck144 = 0 time = 725
* CHECK dout0_50 vdout0_50ck144 = 1.1 time = 725
* CHECK dout0_51 vdout0_51ck144 = 0 time = 725
* CHECK dout0_52 vdout0_52ck144 = 0 time = 725
* CHECK dout0_53 vdout0_53ck144 = 0 time = 725
* CHECK dout0_54 vdout0_54ck144 = 1.1 time = 725
* CHECK dout0_55 vdout0_55ck144 = 1.1 time = 725
* CHECK dout0_56 vdout0_56ck144 = 0 time = 725
* CHECK dout0_57 vdout0_57ck144 = 0 time = 725
* CHECK dout0_58 vdout0_58ck144 = 1.1 time = 725
* CHECK dout0_59 vdout0_59ck144 = 1.1 time = 725
* CHECK dout0_60 vdout0_60ck144 = 0 time = 725
* CHECK dout0_61 vdout0_61ck144 = 1.1 time = 725
* CHECK dout0_62 vdout0_62ck144 = 0 time = 725
* CHECK dout0_63 vdout0_63ck144 = 1.1 time = 725
* CHECK dout0_0 vdout0_0ck145 = 1.1 time = 730
* CHECK dout0_1 vdout0_1ck145 = 1.1 time = 730
* CHECK dout0_2 vdout0_2ck145 = 0 time = 730
* CHECK dout0_3 vdout0_3ck145 = 0 time = 730
* CHECK dout0_4 vdout0_4ck145 = 1.1 time = 730
* CHECK dout0_5 vdout0_5ck145 = 1.1 time = 730
* CHECK dout0_6 vdout0_6ck145 = 0 time = 730
* CHECK dout0_7 vdout0_7ck145 = 0 time = 730
* CHECK dout0_8 vdout0_8ck145 = 0 time = 730
* CHECK dout0_9 vdout0_9ck145 = 0 time = 730
* CHECK dout0_10 vdout0_10ck145 = 0 time = 730
* CHECK dout0_11 vdout0_11ck145 = 0 time = 730
* CHECK dout0_12 vdout0_12ck145 = 0 time = 730
* CHECK dout0_13 vdout0_13ck145 = 0 time = 730
* CHECK dout0_14 vdout0_14ck145 = 1.1 time = 730
* CHECK dout0_15 vdout0_15ck145 = 1.1 time = 730
* CHECK dout0_16 vdout0_16ck145 = 0 time = 730
* CHECK dout0_17 vdout0_17ck145 = 1.1 time = 730
* CHECK dout0_18 vdout0_18ck145 = 1.1 time = 730
* CHECK dout0_19 vdout0_19ck145 = 0 time = 730
* CHECK dout0_20 vdout0_20ck145 = 1.1 time = 730
* CHECK dout0_21 vdout0_21ck145 = 1.1 time = 730
* CHECK dout0_22 vdout0_22ck145 = 1.1 time = 730
* CHECK dout0_23 vdout0_23ck145 = 1.1 time = 730
* CHECK dout0_24 vdout0_24ck145 = 0 time = 730
* CHECK dout0_25 vdout0_25ck145 = 1.1 time = 730
* CHECK dout0_26 vdout0_26ck145 = 1.1 time = 730
* CHECK dout0_27 vdout0_27ck145 = 0 time = 730
* CHECK dout0_28 vdout0_28ck145 = 0 time = 730
* CHECK dout0_29 vdout0_29ck145 = 0 time = 730
* CHECK dout0_30 vdout0_30ck145 = 0 time = 730
* CHECK dout0_31 vdout0_31ck145 = 1.1 time = 730
* CHECK dout0_32 vdout0_32ck145 = 0 time = 730
* CHECK dout0_33 vdout0_33ck145 = 1.1 time = 730
* CHECK dout0_34 vdout0_34ck145 = 1.1 time = 730
* CHECK dout0_35 vdout0_35ck145 = 0 time = 730
* CHECK dout0_36 vdout0_36ck145 = 1.1 time = 730
* CHECK dout0_37 vdout0_37ck145 = 0 time = 730
* CHECK dout0_38 vdout0_38ck145 = 1.1 time = 730
* CHECK dout0_39 vdout0_39ck145 = 0 time = 730
* CHECK dout0_40 vdout0_40ck145 = 0 time = 730
* CHECK dout0_41 vdout0_41ck145 = 0 time = 730
* CHECK dout0_42 vdout0_42ck145 = 1.1 time = 730
* CHECK dout0_43 vdout0_43ck145 = 1.1 time = 730
* CHECK dout0_44 vdout0_44ck145 = 1.1 time = 730
* CHECK dout0_45 vdout0_45ck145 = 1.1 time = 730
* CHECK dout0_46 vdout0_46ck145 = 1.1 time = 730
* CHECK dout0_47 vdout0_47ck145 = 0 time = 730
* CHECK dout0_48 vdout0_48ck145 = 0 time = 730
* CHECK dout0_49 vdout0_49ck145 = 1.1 time = 730
* CHECK dout0_50 vdout0_50ck145 = 0 time = 730
* CHECK dout0_51 vdout0_51ck145 = 1.1 time = 730
* CHECK dout0_52 vdout0_52ck145 = 0 time = 730
* CHECK dout0_53 vdout0_53ck145 = 1.1 time = 730
* CHECK dout0_54 vdout0_54ck145 = 0 time = 730
* CHECK dout0_55 vdout0_55ck145 = 1.1 time = 730
* CHECK dout0_56 vdout0_56ck145 = 0 time = 730
* CHECK dout0_57 vdout0_57ck145 = 1.1 time = 730
* CHECK dout0_58 vdout0_58ck145 = 1.1 time = 730
* CHECK dout0_59 vdout0_59ck145 = 1.1 time = 730
* CHECK dout0_60 vdout0_60ck145 = 0 time = 730
* CHECK dout0_61 vdout0_61ck145 = 1.1 time = 730
* CHECK dout0_62 vdout0_62ck145 = 1.1 time = 730
* CHECK dout0_63 vdout0_63ck145 = 0 time = 730
* CHECK dout0_0 vdout0_0ck149 = 1.1 time = 750
* CHECK dout0_1 vdout0_1ck149 = 0 time = 750
* CHECK dout0_2 vdout0_2ck149 = 0 time = 750
* CHECK dout0_3 vdout0_3ck149 = 0 time = 750
* CHECK dout0_4 vdout0_4ck149 = 1.1 time = 750
* CHECK dout0_5 vdout0_5ck149 = 0 time = 750
* CHECK dout0_6 vdout0_6ck149 = 0 time = 750
* CHECK dout0_7 vdout0_7ck149 = 0 time = 750
* CHECK dout0_8 vdout0_8ck149 = 0 time = 750
* CHECK dout0_9 vdout0_9ck149 = 0 time = 750
* CHECK dout0_10 vdout0_10ck149 = 1.1 time = 750
* CHECK dout0_11 vdout0_11ck149 = 1.1 time = 750
* CHECK dout0_12 vdout0_12ck149 = 0 time = 750
* CHECK dout0_13 vdout0_13ck149 = 1.1 time = 750
* CHECK dout0_14 vdout0_14ck149 = 0 time = 750
* CHECK dout0_15 vdout0_15ck149 = 1.1 time = 750
* CHECK dout0_16 vdout0_16ck149 = 1.1 time = 750
* CHECK dout0_17 vdout0_17ck149 = 0 time = 750
* CHECK dout0_18 vdout0_18ck149 = 0 time = 750
* CHECK dout0_19 vdout0_19ck149 = 0 time = 750
* CHECK dout0_20 vdout0_20ck149 = 0 time = 750
* CHECK dout0_21 vdout0_21ck149 = 0 time = 750
* CHECK dout0_22 vdout0_22ck149 = 1.1 time = 750
* CHECK dout0_23 vdout0_23ck149 = 1.1 time = 750
* CHECK dout0_24 vdout0_24ck149 = 0 time = 750
* CHECK dout0_25 vdout0_25ck149 = 0 time = 750
* CHECK dout0_26 vdout0_26ck149 = 1.1 time = 750
* CHECK dout0_27 vdout0_27ck149 = 1.1 time = 750
* CHECK dout0_28 vdout0_28ck149 = 1.1 time = 750
* CHECK dout0_29 vdout0_29ck149 = 1.1 time = 750
* CHECK dout0_30 vdout0_30ck149 = 1.1 time = 750
* CHECK dout0_31 vdout0_31ck149 = 0 time = 750
* CHECK dout0_32 vdout0_32ck149 = 1.1 time = 750
* CHECK dout0_33 vdout0_33ck149 = 1.1 time = 750
* CHECK dout0_34 vdout0_34ck149 = 0 time = 750
* CHECK dout0_35 vdout0_35ck149 = 0 time = 750
* CHECK dout0_36 vdout0_36ck149 = 0 time = 750
* CHECK dout0_37 vdout0_37ck149 = 0 time = 750
* CHECK dout0_38 vdout0_38ck149 = 0 time = 750
* CHECK dout0_39 vdout0_39ck149 = 0 time = 750
* CHECK dout0_40 vdout0_40ck149 = 0 time = 750
* CHECK dout0_41 vdout0_41ck149 = 1.1 time = 750
* CHECK dout0_42 vdout0_42ck149 = 1.1 time = 750
* CHECK dout0_43 vdout0_43ck149 = 1.1 time = 750
* CHECK dout0_44 vdout0_44ck149 = 1.1 time = 750
* CHECK dout0_45 vdout0_45ck149 = 0 time = 750
* CHECK dout0_46 vdout0_46ck149 = 1.1 time = 750
* CHECK dout0_47 vdout0_47ck149 = 0 time = 750
* CHECK dout0_48 vdout0_48ck149 = 1.1 time = 750
* CHECK dout0_49 vdout0_49ck149 = 0 time = 750
* CHECK dout0_50 vdout0_50ck149 = 0 time = 750
* CHECK dout0_51 vdout0_51ck149 = 0 time = 750
* CHECK dout0_52 vdout0_52ck149 = 0 time = 750
* CHECK dout0_53 vdout0_53ck149 = 0 time = 750
* CHECK dout0_54 vdout0_54ck149 = 0 time = 750
* CHECK dout0_55 vdout0_55ck149 = 0 time = 750
* CHECK dout0_56 vdout0_56ck149 = 1.1 time = 750
* CHECK dout0_57 vdout0_57ck149 = 1.1 time = 750
* CHECK dout0_58 vdout0_58ck149 = 0 time = 750
* CHECK dout0_59 vdout0_59ck149 = 0 time = 750
* CHECK dout0_60 vdout0_60ck149 = 0 time = 750
* CHECK dout0_61 vdout0_61ck149 = 1.1 time = 750
* CHECK dout0_62 vdout0_62ck149 = 1.1 time = 750
* CHECK dout0_63 vdout0_63ck149 = 0 time = 750
* CHECK dout0_0 vdout0_0ck152 = 0 time = 765
* CHECK dout0_1 vdout0_1ck152 = 1.1 time = 765
* CHECK dout0_2 vdout0_2ck152 = 0 time = 765
* CHECK dout0_3 vdout0_3ck152 = 0 time = 765
* CHECK dout0_4 vdout0_4ck152 = 0 time = 765
* CHECK dout0_5 vdout0_5ck152 = 1.1 time = 765
* CHECK dout0_6 vdout0_6ck152 = 1.1 time = 765
* CHECK dout0_7 vdout0_7ck152 = 1.1 time = 765
* CHECK dout0_8 vdout0_8ck152 = 0 time = 765
* CHECK dout0_9 vdout0_9ck152 = 1.1 time = 765
* CHECK dout0_10 vdout0_10ck152 = 1.1 time = 765
* CHECK dout0_11 vdout0_11ck152 = 0 time = 765
* CHECK dout0_12 vdout0_12ck152 = 0 time = 765
* CHECK dout0_13 vdout0_13ck152 = 1.1 time = 765
* CHECK dout0_14 vdout0_14ck152 = 0 time = 765
* CHECK dout0_15 vdout0_15ck152 = 1.1 time = 765
* CHECK dout0_16 vdout0_16ck152 = 1.1 time = 765
* CHECK dout0_17 vdout0_17ck152 = 1.1 time = 765
* CHECK dout0_18 vdout0_18ck152 = 1.1 time = 765
* CHECK dout0_19 vdout0_19ck152 = 0 time = 765
* CHECK dout0_20 vdout0_20ck152 = 1.1 time = 765
* CHECK dout0_21 vdout0_21ck152 = 0 time = 765
* CHECK dout0_22 vdout0_22ck152 = 1.1 time = 765
* CHECK dout0_23 vdout0_23ck152 = 1.1 time = 765
* CHECK dout0_24 vdout0_24ck152 = 0 time = 765
* CHECK dout0_25 vdout0_25ck152 = 0 time = 765
* CHECK dout0_26 vdout0_26ck152 = 0 time = 765
* CHECK dout0_27 vdout0_27ck152 = 0 time = 765
* CHECK dout0_28 vdout0_28ck152 = 0 time = 765
* CHECK dout0_29 vdout0_29ck152 = 1.1 time = 765
* CHECK dout0_30 vdout0_30ck152 = 1.1 time = 765
* CHECK dout0_31 vdout0_31ck152 = 1.1 time = 765
* CHECK dout0_32 vdout0_32ck152 = 1.1 time = 765
* CHECK dout0_33 vdout0_33ck152 = 1.1 time = 765
* CHECK dout0_34 vdout0_34ck152 = 1.1 time = 765
* CHECK dout0_35 vdout0_35ck152 = 1.1 time = 765
* CHECK dout0_36 vdout0_36ck152 = 1.1 time = 765
* CHECK dout0_37 vdout0_37ck152 = 0 time = 765
* CHECK dout0_38 vdout0_38ck152 = 0 time = 765
* CHECK dout0_39 vdout0_39ck152 = 1.1 time = 765
* CHECK dout0_40 vdout0_40ck152 = 1.1 time = 765
* CHECK dout0_41 vdout0_41ck152 = 0 time = 765
* CHECK dout0_42 vdout0_42ck152 = 0 time = 765
* CHECK dout0_43 vdout0_43ck152 = 1.1 time = 765
* CHECK dout0_44 vdout0_44ck152 = 1.1 time = 765
* CHECK dout0_45 vdout0_45ck152 = 0 time = 765
* CHECK dout0_46 vdout0_46ck152 = 1.1 time = 765
* CHECK dout0_47 vdout0_47ck152 = 0 time = 765
* CHECK dout0_48 vdout0_48ck152 = 0 time = 765
* CHECK dout0_49 vdout0_49ck152 = 1.1 time = 765
* CHECK dout0_50 vdout0_50ck152 = 0 time = 765
* CHECK dout0_51 vdout0_51ck152 = 0 time = 765
* CHECK dout0_52 vdout0_52ck152 = 0 time = 765
* CHECK dout0_53 vdout0_53ck152 = 0 time = 765
* CHECK dout0_54 vdout0_54ck152 = 0 time = 765
* CHECK dout0_55 vdout0_55ck152 = 1.1 time = 765
* CHECK dout0_56 vdout0_56ck152 = 0 time = 765
* CHECK dout0_57 vdout0_57ck152 = 0 time = 765
* CHECK dout0_58 vdout0_58ck152 = 0 time = 765
* CHECK dout0_59 vdout0_59ck152 = 1.1 time = 765
* CHECK dout0_60 vdout0_60ck152 = 0 time = 765
* CHECK dout0_61 vdout0_61ck152 = 0 time = 765
* CHECK dout0_62 vdout0_62ck152 = 1.1 time = 765
* CHECK dout0_63 vdout0_63ck152 = 0 time = 765
* CHECK dout0_0 vdout0_0ck153 = 0 time = 770
* CHECK dout0_1 vdout0_1ck153 = 1.1 time = 770
* CHECK dout0_2 vdout0_2ck153 = 0 time = 770
* CHECK dout0_3 vdout0_3ck153 = 0 time = 770
* CHECK dout0_4 vdout0_4ck153 = 0 time = 770
* CHECK dout0_5 vdout0_5ck153 = 1.1 time = 770
* CHECK dout0_6 vdout0_6ck153 = 1.1 time = 770
* CHECK dout0_7 vdout0_7ck153 = 1.1 time = 770
* CHECK dout0_8 vdout0_8ck153 = 0 time = 770
* CHECK dout0_9 vdout0_9ck153 = 1.1 time = 770
* CHECK dout0_10 vdout0_10ck153 = 1.1 time = 770
* CHECK dout0_11 vdout0_11ck153 = 0 time = 770
* CHECK dout0_12 vdout0_12ck153 = 0 time = 770
* CHECK dout0_13 vdout0_13ck153 = 1.1 time = 770
* CHECK dout0_14 vdout0_14ck153 = 0 time = 770
* CHECK dout0_15 vdout0_15ck153 = 1.1 time = 770
* CHECK dout0_16 vdout0_16ck153 = 1.1 time = 770
* CHECK dout0_17 vdout0_17ck153 = 1.1 time = 770
* CHECK dout0_18 vdout0_18ck153 = 1.1 time = 770
* CHECK dout0_19 vdout0_19ck153 = 0 time = 770
* CHECK dout0_20 vdout0_20ck153 = 1.1 time = 770
* CHECK dout0_21 vdout0_21ck153 = 0 time = 770
* CHECK dout0_22 vdout0_22ck153 = 1.1 time = 770
* CHECK dout0_23 vdout0_23ck153 = 1.1 time = 770
* CHECK dout0_24 vdout0_24ck153 = 0 time = 770
* CHECK dout0_25 vdout0_25ck153 = 0 time = 770
* CHECK dout0_26 vdout0_26ck153 = 0 time = 770
* CHECK dout0_27 vdout0_27ck153 = 0 time = 770
* CHECK dout0_28 vdout0_28ck153 = 0 time = 770
* CHECK dout0_29 vdout0_29ck153 = 1.1 time = 770
* CHECK dout0_30 vdout0_30ck153 = 1.1 time = 770
* CHECK dout0_31 vdout0_31ck153 = 1.1 time = 770
* CHECK dout0_32 vdout0_32ck153 = 1.1 time = 770
* CHECK dout0_33 vdout0_33ck153 = 1.1 time = 770
* CHECK dout0_34 vdout0_34ck153 = 1.1 time = 770
* CHECK dout0_35 vdout0_35ck153 = 1.1 time = 770
* CHECK dout0_36 vdout0_36ck153 = 1.1 time = 770
* CHECK dout0_37 vdout0_37ck153 = 0 time = 770
* CHECK dout0_38 vdout0_38ck153 = 0 time = 770
* CHECK dout0_39 vdout0_39ck153 = 1.1 time = 770
* CHECK dout0_40 vdout0_40ck153 = 1.1 time = 770
* CHECK dout0_41 vdout0_41ck153 = 0 time = 770
* CHECK dout0_42 vdout0_42ck153 = 0 time = 770
* CHECK dout0_43 vdout0_43ck153 = 1.1 time = 770
* CHECK dout0_44 vdout0_44ck153 = 1.1 time = 770
* CHECK dout0_45 vdout0_45ck153 = 0 time = 770
* CHECK dout0_46 vdout0_46ck153 = 1.1 time = 770
* CHECK dout0_47 vdout0_47ck153 = 0 time = 770
* CHECK dout0_48 vdout0_48ck153 = 0 time = 770
* CHECK dout0_49 vdout0_49ck153 = 1.1 time = 770
* CHECK dout0_50 vdout0_50ck153 = 0 time = 770
* CHECK dout0_51 vdout0_51ck153 = 0 time = 770
* CHECK dout0_52 vdout0_52ck153 = 0 time = 770
* CHECK dout0_53 vdout0_53ck153 = 0 time = 770
* CHECK dout0_54 vdout0_54ck153 = 0 time = 770
* CHECK dout0_55 vdout0_55ck153 = 1.1 time = 770
* CHECK dout0_56 vdout0_56ck153 = 0 time = 770
* CHECK dout0_57 vdout0_57ck153 = 0 time = 770
* CHECK dout0_58 vdout0_58ck153 = 0 time = 770
* CHECK dout0_59 vdout0_59ck153 = 1.1 time = 770
* CHECK dout0_60 vdout0_60ck153 = 0 time = 770
* CHECK dout0_61 vdout0_61ck153 = 0 time = 770
* CHECK dout0_62 vdout0_62ck153 = 1.1 time = 770
* CHECK dout0_63 vdout0_63ck153 = 0 time = 770
* CHECK dout0_0 vdout0_0ck156 = 0 time = 785
* CHECK dout0_1 vdout0_1ck156 = 0 time = 785
* CHECK dout0_2 vdout0_2ck156 = 1.1 time = 785
* CHECK dout0_3 vdout0_3ck156 = 1.1 time = 785
* CHECK dout0_4 vdout0_4ck156 = 0 time = 785
* CHECK dout0_5 vdout0_5ck156 = 0 time = 785
* CHECK dout0_6 vdout0_6ck156 = 1.1 time = 785
* CHECK dout0_7 vdout0_7ck156 = 1.1 time = 785
* CHECK dout0_8 vdout0_8ck156 = 1.1 time = 785
* CHECK dout0_9 vdout0_9ck156 = 0 time = 785
* CHECK dout0_10 vdout0_10ck156 = 0 time = 785
* CHECK dout0_11 vdout0_11ck156 = 0 time = 785
* CHECK dout0_12 vdout0_12ck156 = 0 time = 785
* CHECK dout0_13 vdout0_13ck156 = 1.1 time = 785
* CHECK dout0_14 vdout0_14ck156 = 0 time = 785
* CHECK dout0_15 vdout0_15ck156 = 1.1 time = 785
* CHECK dout0_16 vdout0_16ck156 = 1.1 time = 785
* CHECK dout0_17 vdout0_17ck156 = 0 time = 785
* CHECK dout0_18 vdout0_18ck156 = 1.1 time = 785
* CHECK dout0_19 vdout0_19ck156 = 0 time = 785
* CHECK dout0_20 vdout0_20ck156 = 0 time = 785
* CHECK dout0_21 vdout0_21ck156 = 0 time = 785
* CHECK dout0_22 vdout0_22ck156 = 1.1 time = 785
* CHECK dout0_23 vdout0_23ck156 = 0 time = 785
* CHECK dout0_24 vdout0_24ck156 = 0 time = 785
* CHECK dout0_25 vdout0_25ck156 = 1.1 time = 785
* CHECK dout0_26 vdout0_26ck156 = 1.1 time = 785
* CHECK dout0_27 vdout0_27ck156 = 0 time = 785
* CHECK dout0_28 vdout0_28ck156 = 0 time = 785
* CHECK dout0_29 vdout0_29ck156 = 0 time = 785
* CHECK dout0_30 vdout0_30ck156 = 1.1 time = 785
* CHECK dout0_31 vdout0_31ck156 = 1.1 time = 785
* CHECK dout0_32 vdout0_32ck156 = 0 time = 785
* CHECK dout0_33 vdout0_33ck156 = 1.1 time = 785
* CHECK dout0_34 vdout0_34ck156 = 0 time = 785
* CHECK dout0_35 vdout0_35ck156 = 1.1 time = 785
* CHECK dout0_36 vdout0_36ck156 = 0 time = 785
* CHECK dout0_37 vdout0_37ck156 = 0 time = 785
* CHECK dout0_38 vdout0_38ck156 = 1.1 time = 785
* CHECK dout0_39 vdout0_39ck156 = 1.1 time = 785
* CHECK dout0_40 vdout0_40ck156 = 1.1 time = 785
* CHECK dout0_41 vdout0_41ck156 = 1.1 time = 785
* CHECK dout0_42 vdout0_42ck156 = 0 time = 785
* CHECK dout0_43 vdout0_43ck156 = 0 time = 785
* CHECK dout0_44 vdout0_44ck156 = 1.1 time = 785
* CHECK dout0_45 vdout0_45ck156 = 1.1 time = 785
* CHECK dout0_46 vdout0_46ck156 = 0 time = 785
* CHECK dout0_47 vdout0_47ck156 = 1.1 time = 785
* CHECK dout0_48 vdout0_48ck156 = 0 time = 785
* CHECK dout0_49 vdout0_49ck156 = 0 time = 785
* CHECK dout0_50 vdout0_50ck156 = 1.1 time = 785
* CHECK dout0_51 vdout0_51ck156 = 0 time = 785
* CHECK dout0_52 vdout0_52ck156 = 0 time = 785
* CHECK dout0_53 vdout0_53ck156 = 1.1 time = 785
* CHECK dout0_54 vdout0_54ck156 = 1.1 time = 785
* CHECK dout0_55 vdout0_55ck156 = 1.1 time = 785
* CHECK dout0_56 vdout0_56ck156 = 1.1 time = 785
* CHECK dout0_57 vdout0_57ck156 = 0 time = 785
* CHECK dout0_58 vdout0_58ck156 = 0 time = 785
* CHECK dout0_59 vdout0_59ck156 = 1.1 time = 785
* CHECK dout0_60 vdout0_60ck156 = 1.1 time = 785
* CHECK dout0_61 vdout0_61ck156 = 0 time = 785
* CHECK dout0_62 vdout0_62ck156 = 1.1 time = 785
* CHECK dout0_63 vdout0_63ck156 = 1.1 time = 785
* CHECK dout0_0 vdout0_0ck161 = 1.1 time = 810
* CHECK dout0_1 vdout0_1ck161 = 0 time = 810
* CHECK dout0_2 vdout0_2ck161 = 0 time = 810
* CHECK dout0_3 vdout0_3ck161 = 1.1 time = 810
* CHECK dout0_4 vdout0_4ck161 = 0 time = 810
* CHECK dout0_5 vdout0_5ck161 = 1.1 time = 810
* CHECK dout0_6 vdout0_6ck161 = 1.1 time = 810
* CHECK dout0_7 vdout0_7ck161 = 0 time = 810
* CHECK dout0_8 vdout0_8ck161 = 0 time = 810
* CHECK dout0_9 vdout0_9ck161 = 0 time = 810
* CHECK dout0_10 vdout0_10ck161 = 1.1 time = 810
* CHECK dout0_11 vdout0_11ck161 = 0 time = 810
* CHECK dout0_12 vdout0_12ck161 = 1.1 time = 810
* CHECK dout0_13 vdout0_13ck161 = 0 time = 810
* CHECK dout0_14 vdout0_14ck161 = 0 time = 810
* CHECK dout0_15 vdout0_15ck161 = 0 time = 810
* CHECK dout0_16 vdout0_16ck161 = 1.1 time = 810
* CHECK dout0_17 vdout0_17ck161 = 0 time = 810
* CHECK dout0_18 vdout0_18ck161 = 0 time = 810
* CHECK dout0_19 vdout0_19ck161 = 0 time = 810
* CHECK dout0_20 vdout0_20ck161 = 0 time = 810
* CHECK dout0_21 vdout0_21ck161 = 0 time = 810
* CHECK dout0_22 vdout0_22ck161 = 0 time = 810
* CHECK dout0_23 vdout0_23ck161 = 0 time = 810
* CHECK dout0_24 vdout0_24ck161 = 0 time = 810
* CHECK dout0_25 vdout0_25ck161 = 0 time = 810
* CHECK dout0_26 vdout0_26ck161 = 1.1 time = 810
* CHECK dout0_27 vdout0_27ck161 = 1.1 time = 810
* CHECK dout0_28 vdout0_28ck161 = 0 time = 810
* CHECK dout0_29 vdout0_29ck161 = 0 time = 810
* CHECK dout0_30 vdout0_30ck161 = 1.1 time = 810
* CHECK dout0_31 vdout0_31ck161 = 1.1 time = 810
* CHECK dout0_32 vdout0_32ck161 = 1.1 time = 810
* CHECK dout0_33 vdout0_33ck161 = 0 time = 810
* CHECK dout0_34 vdout0_34ck161 = 1.1 time = 810
* CHECK dout0_35 vdout0_35ck161 = 0 time = 810
* CHECK dout0_36 vdout0_36ck161 = 1.1 time = 810
* CHECK dout0_37 vdout0_37ck161 = 0 time = 810
* CHECK dout0_38 vdout0_38ck161 = 0 time = 810
* CHECK dout0_39 vdout0_39ck161 = 1.1 time = 810
* CHECK dout0_40 vdout0_40ck161 = 1.1 time = 810
* CHECK dout0_41 vdout0_41ck161 = 1.1 time = 810
* CHECK dout0_42 vdout0_42ck161 = 1.1 time = 810
* CHECK dout0_43 vdout0_43ck161 = 1.1 time = 810
* CHECK dout0_44 vdout0_44ck161 = 0 time = 810
* CHECK dout0_45 vdout0_45ck161 = 0 time = 810
* CHECK dout0_46 vdout0_46ck161 = 0 time = 810
* CHECK dout0_47 vdout0_47ck161 = 1.1 time = 810
* CHECK dout0_48 vdout0_48ck161 = 0 time = 810
* CHECK dout0_49 vdout0_49ck161 = 1.1 time = 810
* CHECK dout0_50 vdout0_50ck161 = 1.1 time = 810
* CHECK dout0_51 vdout0_51ck161 = 0 time = 810
* CHECK dout0_52 vdout0_52ck161 = 1.1 time = 810
* CHECK dout0_53 vdout0_53ck161 = 1.1 time = 810
* CHECK dout0_54 vdout0_54ck161 = 0 time = 810
* CHECK dout0_55 vdout0_55ck161 = 1.1 time = 810
* CHECK dout0_56 vdout0_56ck161 = 0 time = 810
* CHECK dout0_57 vdout0_57ck161 = 1.1 time = 810
* CHECK dout0_58 vdout0_58ck161 = 0 time = 810
* CHECK dout0_59 vdout0_59ck161 = 0 time = 810
* CHECK dout0_60 vdout0_60ck161 = 1.1 time = 810
* CHECK dout0_61 vdout0_61ck161 = 1.1 time = 810
* CHECK dout0_62 vdout0_62ck161 = 0 time = 810
* CHECK dout0_63 vdout0_63ck161 = 1.1 time = 810
* CHECK dout0_0 vdout0_0ck162 = 0 time = 815
* CHECK dout0_1 vdout0_1ck162 = 1.1 time = 815
* CHECK dout0_2 vdout0_2ck162 = 0 time = 815
* CHECK dout0_3 vdout0_3ck162 = 0 time = 815
* CHECK dout0_4 vdout0_4ck162 = 0 time = 815
* CHECK dout0_5 vdout0_5ck162 = 0 time = 815
* CHECK dout0_6 vdout0_6ck162 = 0 time = 815
* CHECK dout0_7 vdout0_7ck162 = 0 time = 815
* CHECK dout0_8 vdout0_8ck162 = 1.1 time = 815
* CHECK dout0_9 vdout0_9ck162 = 0 time = 815
* CHECK dout0_10 vdout0_10ck162 = 0 time = 815
* CHECK dout0_11 vdout0_11ck162 = 0 time = 815
* CHECK dout0_12 vdout0_12ck162 = 1.1 time = 815
* CHECK dout0_13 vdout0_13ck162 = 1.1 time = 815
* CHECK dout0_14 vdout0_14ck162 = 0 time = 815
* CHECK dout0_15 vdout0_15ck162 = 0 time = 815
* CHECK dout0_16 vdout0_16ck162 = 0 time = 815
* CHECK dout0_17 vdout0_17ck162 = 0 time = 815
* CHECK dout0_18 vdout0_18ck162 = 0 time = 815
* CHECK dout0_19 vdout0_19ck162 = 1.1 time = 815
* CHECK dout0_20 vdout0_20ck162 = 1.1 time = 815
* CHECK dout0_21 vdout0_21ck162 = 1.1 time = 815
* CHECK dout0_22 vdout0_22ck162 = 1.1 time = 815
* CHECK dout0_23 vdout0_23ck162 = 0 time = 815
* CHECK dout0_24 vdout0_24ck162 = 1.1 time = 815
* CHECK dout0_25 vdout0_25ck162 = 1.1 time = 815
* CHECK dout0_26 vdout0_26ck162 = 0 time = 815
* CHECK dout0_27 vdout0_27ck162 = 0 time = 815
* CHECK dout0_28 vdout0_28ck162 = 1.1 time = 815
* CHECK dout0_29 vdout0_29ck162 = 1.1 time = 815
* CHECK dout0_30 vdout0_30ck162 = 0 time = 815
* CHECK dout0_31 vdout0_31ck162 = 1.1 time = 815
* CHECK dout0_32 vdout0_32ck162 = 0 time = 815
* CHECK dout0_33 vdout0_33ck162 = 1.1 time = 815
* CHECK dout0_34 vdout0_34ck162 = 0 time = 815
* CHECK dout0_35 vdout0_35ck162 = 0 time = 815
* CHECK dout0_36 vdout0_36ck162 = 0 time = 815
* CHECK dout0_37 vdout0_37ck162 = 1.1 time = 815
* CHECK dout0_38 vdout0_38ck162 = 1.1 time = 815
* CHECK dout0_39 vdout0_39ck162 = 1.1 time = 815
* CHECK dout0_40 vdout0_40ck162 = 1.1 time = 815
* CHECK dout0_41 vdout0_41ck162 = 1.1 time = 815
* CHECK dout0_42 vdout0_42ck162 = 0 time = 815
* CHECK dout0_43 vdout0_43ck162 = 0 time = 815
* CHECK dout0_44 vdout0_44ck162 = 1.1 time = 815
* CHECK dout0_45 vdout0_45ck162 = 0 time = 815
* CHECK dout0_46 vdout0_46ck162 = 0 time = 815
* CHECK dout0_47 vdout0_47ck162 = 0 time = 815
* CHECK dout0_48 vdout0_48ck162 = 1.1 time = 815
* CHECK dout0_49 vdout0_49ck162 = 0 time = 815
* CHECK dout0_50 vdout0_50ck162 = 1.1 time = 815
* CHECK dout0_51 vdout0_51ck162 = 0 time = 815
* CHECK dout0_52 vdout0_52ck162 = 1.1 time = 815
* CHECK dout0_53 vdout0_53ck162 = 0 time = 815
* CHECK dout0_54 vdout0_54ck162 = 0 time = 815
* CHECK dout0_55 vdout0_55ck162 = 1.1 time = 815
* CHECK dout0_56 vdout0_56ck162 = 1.1 time = 815
* CHECK dout0_57 vdout0_57ck162 = 0 time = 815
* CHECK dout0_58 vdout0_58ck162 = 0 time = 815
* CHECK dout0_59 vdout0_59ck162 = 1.1 time = 815
* CHECK dout0_60 vdout0_60ck162 = 1.1 time = 815
* CHECK dout0_61 vdout0_61ck162 = 1.1 time = 815
* CHECK dout0_62 vdout0_62ck162 = 0 time = 815
* CHECK dout0_63 vdout0_63ck162 = 1.1 time = 815
* CHECK dout0_0 vdout0_0ck163 = 1.1 time = 820
* CHECK dout0_1 vdout0_1ck163 = 0 time = 820
* CHECK dout0_2 vdout0_2ck163 = 0 time = 820
* CHECK dout0_3 vdout0_3ck163 = 1.1 time = 820
* CHECK dout0_4 vdout0_4ck163 = 0 time = 820
* CHECK dout0_5 vdout0_5ck163 = 1.1 time = 820
* CHECK dout0_6 vdout0_6ck163 = 1.1 time = 820
* CHECK dout0_7 vdout0_7ck163 = 0 time = 820
* CHECK dout0_8 vdout0_8ck163 = 0 time = 820
* CHECK dout0_9 vdout0_9ck163 = 0 time = 820
* CHECK dout0_10 vdout0_10ck163 = 1.1 time = 820
* CHECK dout0_11 vdout0_11ck163 = 0 time = 820
* CHECK dout0_12 vdout0_12ck163 = 1.1 time = 820
* CHECK dout0_13 vdout0_13ck163 = 0 time = 820
* CHECK dout0_14 vdout0_14ck163 = 0 time = 820
* CHECK dout0_15 vdout0_15ck163 = 0 time = 820
* CHECK dout0_16 vdout0_16ck163 = 1.1 time = 820
* CHECK dout0_17 vdout0_17ck163 = 0 time = 820
* CHECK dout0_18 vdout0_18ck163 = 0 time = 820
* CHECK dout0_19 vdout0_19ck163 = 0 time = 820
* CHECK dout0_20 vdout0_20ck163 = 0 time = 820
* CHECK dout0_21 vdout0_21ck163 = 0 time = 820
* CHECK dout0_22 vdout0_22ck163 = 0 time = 820
* CHECK dout0_23 vdout0_23ck163 = 0 time = 820
* CHECK dout0_24 vdout0_24ck163 = 0 time = 820
* CHECK dout0_25 vdout0_25ck163 = 0 time = 820
* CHECK dout0_26 vdout0_26ck163 = 1.1 time = 820
* CHECK dout0_27 vdout0_27ck163 = 1.1 time = 820
* CHECK dout0_28 vdout0_28ck163 = 0 time = 820
* CHECK dout0_29 vdout0_29ck163 = 0 time = 820
* CHECK dout0_30 vdout0_30ck163 = 1.1 time = 820
* CHECK dout0_31 vdout0_31ck163 = 1.1 time = 820
* CHECK dout0_32 vdout0_32ck163 = 1.1 time = 820
* CHECK dout0_33 vdout0_33ck163 = 0 time = 820
* CHECK dout0_34 vdout0_34ck163 = 1.1 time = 820
* CHECK dout0_35 vdout0_35ck163 = 0 time = 820
* CHECK dout0_36 vdout0_36ck163 = 1.1 time = 820
* CHECK dout0_37 vdout0_37ck163 = 0 time = 820
* CHECK dout0_38 vdout0_38ck163 = 0 time = 820
* CHECK dout0_39 vdout0_39ck163 = 1.1 time = 820
* CHECK dout0_40 vdout0_40ck163 = 1.1 time = 820
* CHECK dout0_41 vdout0_41ck163 = 1.1 time = 820
* CHECK dout0_42 vdout0_42ck163 = 1.1 time = 820
* CHECK dout0_43 vdout0_43ck163 = 1.1 time = 820
* CHECK dout0_44 vdout0_44ck163 = 0 time = 820
* CHECK dout0_45 vdout0_45ck163 = 0 time = 820
* CHECK dout0_46 vdout0_46ck163 = 0 time = 820
* CHECK dout0_47 vdout0_47ck163 = 1.1 time = 820
* CHECK dout0_48 vdout0_48ck163 = 0 time = 820
* CHECK dout0_49 vdout0_49ck163 = 1.1 time = 820
* CHECK dout0_50 vdout0_50ck163 = 1.1 time = 820
* CHECK dout0_51 vdout0_51ck163 = 0 time = 820
* CHECK dout0_52 vdout0_52ck163 = 1.1 time = 820
* CHECK dout0_53 vdout0_53ck163 = 1.1 time = 820
* CHECK dout0_54 vdout0_54ck163 = 0 time = 820
* CHECK dout0_55 vdout0_55ck163 = 1.1 time = 820
* CHECK dout0_56 vdout0_56ck163 = 0 time = 820
* CHECK dout0_57 vdout0_57ck163 = 1.1 time = 820
* CHECK dout0_58 vdout0_58ck163 = 0 time = 820
* CHECK dout0_59 vdout0_59ck163 = 0 time = 820
* CHECK dout0_60 vdout0_60ck163 = 1.1 time = 820
* CHECK dout0_61 vdout0_61ck163 = 1.1 time = 820
* CHECK dout0_62 vdout0_62ck163 = 0 time = 820
* CHECK dout0_63 vdout0_63ck163 = 1.1 time = 820
* CHECK dout0_0 vdout0_0ck165 = 1.1 time = 830
* CHECK dout0_1 vdout0_1ck165 = 0 time = 830
* CHECK dout0_2 vdout0_2ck165 = 0 time = 830
* CHECK dout0_3 vdout0_3ck165 = 1.1 time = 830
* CHECK dout0_4 vdout0_4ck165 = 0 time = 830
* CHECK dout0_5 vdout0_5ck165 = 1.1 time = 830
* CHECK dout0_6 vdout0_6ck165 = 1.1 time = 830
* CHECK dout0_7 vdout0_7ck165 = 0 time = 830
* CHECK dout0_8 vdout0_8ck165 = 0 time = 830
* CHECK dout0_9 vdout0_9ck165 = 0 time = 830
* CHECK dout0_10 vdout0_10ck165 = 1.1 time = 830
* CHECK dout0_11 vdout0_11ck165 = 0 time = 830
* CHECK dout0_12 vdout0_12ck165 = 1.1 time = 830
* CHECK dout0_13 vdout0_13ck165 = 0 time = 830
* CHECK dout0_14 vdout0_14ck165 = 0 time = 830
* CHECK dout0_15 vdout0_15ck165 = 0 time = 830
* CHECK dout0_16 vdout0_16ck165 = 1.1 time = 830
* CHECK dout0_17 vdout0_17ck165 = 0 time = 830
* CHECK dout0_18 vdout0_18ck165 = 0 time = 830
* CHECK dout0_19 vdout0_19ck165 = 0 time = 830
* CHECK dout0_20 vdout0_20ck165 = 0 time = 830
* CHECK dout0_21 vdout0_21ck165 = 0 time = 830
* CHECK dout0_22 vdout0_22ck165 = 0 time = 830
* CHECK dout0_23 vdout0_23ck165 = 0 time = 830
* CHECK dout0_24 vdout0_24ck165 = 0 time = 830
* CHECK dout0_25 vdout0_25ck165 = 0 time = 830
* CHECK dout0_26 vdout0_26ck165 = 1.1 time = 830
* CHECK dout0_27 vdout0_27ck165 = 1.1 time = 830
* CHECK dout0_28 vdout0_28ck165 = 0 time = 830
* CHECK dout0_29 vdout0_29ck165 = 0 time = 830
* CHECK dout0_30 vdout0_30ck165 = 1.1 time = 830
* CHECK dout0_31 vdout0_31ck165 = 1.1 time = 830
* CHECK dout0_32 vdout0_32ck165 = 1.1 time = 830
* CHECK dout0_33 vdout0_33ck165 = 0 time = 830
* CHECK dout0_34 vdout0_34ck165 = 1.1 time = 830
* CHECK dout0_35 vdout0_35ck165 = 0 time = 830
* CHECK dout0_36 vdout0_36ck165 = 1.1 time = 830
* CHECK dout0_37 vdout0_37ck165 = 0 time = 830
* CHECK dout0_38 vdout0_38ck165 = 0 time = 830
* CHECK dout0_39 vdout0_39ck165 = 1.1 time = 830
* CHECK dout0_40 vdout0_40ck165 = 1.1 time = 830
* CHECK dout0_41 vdout0_41ck165 = 1.1 time = 830
* CHECK dout0_42 vdout0_42ck165 = 1.1 time = 830
* CHECK dout0_43 vdout0_43ck165 = 1.1 time = 830
* CHECK dout0_44 vdout0_44ck165 = 0 time = 830
* CHECK dout0_45 vdout0_45ck165 = 0 time = 830
* CHECK dout0_46 vdout0_46ck165 = 0 time = 830
* CHECK dout0_47 vdout0_47ck165 = 1.1 time = 830
* CHECK dout0_48 vdout0_48ck165 = 0 time = 830
* CHECK dout0_49 vdout0_49ck165 = 1.1 time = 830
* CHECK dout0_50 vdout0_50ck165 = 1.1 time = 830
* CHECK dout0_51 vdout0_51ck165 = 0 time = 830
* CHECK dout0_52 vdout0_52ck165 = 1.1 time = 830
* CHECK dout0_53 vdout0_53ck165 = 1.1 time = 830
* CHECK dout0_54 vdout0_54ck165 = 0 time = 830
* CHECK dout0_55 vdout0_55ck165 = 1.1 time = 830
* CHECK dout0_56 vdout0_56ck165 = 0 time = 830
* CHECK dout0_57 vdout0_57ck165 = 1.1 time = 830
* CHECK dout0_58 vdout0_58ck165 = 0 time = 830
* CHECK dout0_59 vdout0_59ck165 = 0 time = 830
* CHECK dout0_60 vdout0_60ck165 = 1.1 time = 830
* CHECK dout0_61 vdout0_61ck165 = 1.1 time = 830
* CHECK dout0_62 vdout0_62ck165 = 0 time = 830
* CHECK dout0_63 vdout0_63ck165 = 1.1 time = 830
* CHECK dout0_0 vdout0_0ck168 = 0 time = 845
* CHECK dout0_1 vdout0_1ck168 = 1.1 time = 845
* CHECK dout0_2 vdout0_2ck168 = 0 time = 845
* CHECK dout0_3 vdout0_3ck168 = 0 time = 845
* CHECK dout0_4 vdout0_4ck168 = 0 time = 845
* CHECK dout0_5 vdout0_5ck168 = 0 time = 845
* CHECK dout0_6 vdout0_6ck168 = 0 time = 845
* CHECK dout0_7 vdout0_7ck168 = 0 time = 845
* CHECK dout0_8 vdout0_8ck168 = 1.1 time = 845
* CHECK dout0_9 vdout0_9ck168 = 0 time = 845
* CHECK dout0_10 vdout0_10ck168 = 0 time = 845
* CHECK dout0_11 vdout0_11ck168 = 0 time = 845
* CHECK dout0_12 vdout0_12ck168 = 1.1 time = 845
* CHECK dout0_13 vdout0_13ck168 = 1.1 time = 845
* CHECK dout0_14 vdout0_14ck168 = 0 time = 845
* CHECK dout0_15 vdout0_15ck168 = 0 time = 845
* CHECK dout0_16 vdout0_16ck168 = 0 time = 845
* CHECK dout0_17 vdout0_17ck168 = 0 time = 845
* CHECK dout0_18 vdout0_18ck168 = 0 time = 845
* CHECK dout0_19 vdout0_19ck168 = 1.1 time = 845
* CHECK dout0_20 vdout0_20ck168 = 1.1 time = 845
* CHECK dout0_21 vdout0_21ck168 = 1.1 time = 845
* CHECK dout0_22 vdout0_22ck168 = 1.1 time = 845
* CHECK dout0_23 vdout0_23ck168 = 0 time = 845
* CHECK dout0_24 vdout0_24ck168 = 1.1 time = 845
* CHECK dout0_25 vdout0_25ck168 = 1.1 time = 845
* CHECK dout0_26 vdout0_26ck168 = 0 time = 845
* CHECK dout0_27 vdout0_27ck168 = 0 time = 845
* CHECK dout0_28 vdout0_28ck168 = 1.1 time = 845
* CHECK dout0_29 vdout0_29ck168 = 1.1 time = 845
* CHECK dout0_30 vdout0_30ck168 = 0 time = 845
* CHECK dout0_31 vdout0_31ck168 = 1.1 time = 845
* CHECK dout0_32 vdout0_32ck168 = 0 time = 845
* CHECK dout0_33 vdout0_33ck168 = 1.1 time = 845
* CHECK dout0_34 vdout0_34ck168 = 0 time = 845
* CHECK dout0_35 vdout0_35ck168 = 0 time = 845
* CHECK dout0_36 vdout0_36ck168 = 0 time = 845
* CHECK dout0_37 vdout0_37ck168 = 1.1 time = 845
* CHECK dout0_38 vdout0_38ck168 = 1.1 time = 845
* CHECK dout0_39 vdout0_39ck168 = 1.1 time = 845
* CHECK dout0_40 vdout0_40ck168 = 1.1 time = 845
* CHECK dout0_41 vdout0_41ck168 = 1.1 time = 845
* CHECK dout0_42 vdout0_42ck168 = 0 time = 845
* CHECK dout0_43 vdout0_43ck168 = 0 time = 845
* CHECK dout0_44 vdout0_44ck168 = 1.1 time = 845
* CHECK dout0_45 vdout0_45ck168 = 0 time = 845
* CHECK dout0_46 vdout0_46ck168 = 0 time = 845
* CHECK dout0_47 vdout0_47ck168 = 0 time = 845
* CHECK dout0_48 vdout0_48ck168 = 1.1 time = 845
* CHECK dout0_49 vdout0_49ck168 = 0 time = 845
* CHECK dout0_50 vdout0_50ck168 = 1.1 time = 845
* CHECK dout0_51 vdout0_51ck168 = 0 time = 845
* CHECK dout0_52 vdout0_52ck168 = 1.1 time = 845
* CHECK dout0_53 vdout0_53ck168 = 0 time = 845
* CHECK dout0_54 vdout0_54ck168 = 0 time = 845
* CHECK dout0_55 vdout0_55ck168 = 1.1 time = 845
* CHECK dout0_56 vdout0_56ck168 = 1.1 time = 845
* CHECK dout0_57 vdout0_57ck168 = 0 time = 845
* CHECK dout0_58 vdout0_58ck168 = 0 time = 845
* CHECK dout0_59 vdout0_59ck168 = 1.1 time = 845
* CHECK dout0_60 vdout0_60ck168 = 1.1 time = 845
* CHECK dout0_61 vdout0_61ck168 = 1.1 time = 845
* CHECK dout0_62 vdout0_62ck168 = 0 time = 845
* CHECK dout0_63 vdout0_63ck168 = 1.1 time = 845
* CHECK dout0_0 vdout0_0ck169 = 0 time = 850
* CHECK dout0_1 vdout0_1ck169 = 1.1 time = 850
* CHECK dout0_2 vdout0_2ck169 = 0 time = 850
* CHECK dout0_3 vdout0_3ck169 = 0 time = 850
* CHECK dout0_4 vdout0_4ck169 = 0 time = 850
* CHECK dout0_5 vdout0_5ck169 = 0 time = 850
* CHECK dout0_6 vdout0_6ck169 = 0 time = 850
* CHECK dout0_7 vdout0_7ck169 = 0 time = 850
* CHECK dout0_8 vdout0_8ck169 = 1.1 time = 850
* CHECK dout0_9 vdout0_9ck169 = 0 time = 850
* CHECK dout0_10 vdout0_10ck169 = 0 time = 850
* CHECK dout0_11 vdout0_11ck169 = 0 time = 850
* CHECK dout0_12 vdout0_12ck169 = 1.1 time = 850
* CHECK dout0_13 vdout0_13ck169 = 1.1 time = 850
* CHECK dout0_14 vdout0_14ck169 = 0 time = 850
* CHECK dout0_15 vdout0_15ck169 = 0 time = 850
* CHECK dout0_16 vdout0_16ck169 = 0 time = 850
* CHECK dout0_17 vdout0_17ck169 = 0 time = 850
* CHECK dout0_18 vdout0_18ck169 = 0 time = 850
* CHECK dout0_19 vdout0_19ck169 = 1.1 time = 850
* CHECK dout0_20 vdout0_20ck169 = 1.1 time = 850
* CHECK dout0_21 vdout0_21ck169 = 1.1 time = 850
* CHECK dout0_22 vdout0_22ck169 = 1.1 time = 850
* CHECK dout0_23 vdout0_23ck169 = 0 time = 850
* CHECK dout0_24 vdout0_24ck169 = 1.1 time = 850
* CHECK dout0_25 vdout0_25ck169 = 1.1 time = 850
* CHECK dout0_26 vdout0_26ck169 = 0 time = 850
* CHECK dout0_27 vdout0_27ck169 = 0 time = 850
* CHECK dout0_28 vdout0_28ck169 = 1.1 time = 850
* CHECK dout0_29 vdout0_29ck169 = 1.1 time = 850
* CHECK dout0_30 vdout0_30ck169 = 0 time = 850
* CHECK dout0_31 vdout0_31ck169 = 1.1 time = 850
* CHECK dout0_32 vdout0_32ck169 = 0 time = 850
* CHECK dout0_33 vdout0_33ck169 = 1.1 time = 850
* CHECK dout0_34 vdout0_34ck169 = 0 time = 850
* CHECK dout0_35 vdout0_35ck169 = 0 time = 850
* CHECK dout0_36 vdout0_36ck169 = 0 time = 850
* CHECK dout0_37 vdout0_37ck169 = 1.1 time = 850
* CHECK dout0_38 vdout0_38ck169 = 1.1 time = 850
* CHECK dout0_39 vdout0_39ck169 = 1.1 time = 850
* CHECK dout0_40 vdout0_40ck169 = 1.1 time = 850
* CHECK dout0_41 vdout0_41ck169 = 1.1 time = 850
* CHECK dout0_42 vdout0_42ck169 = 0 time = 850
* CHECK dout0_43 vdout0_43ck169 = 0 time = 850
* CHECK dout0_44 vdout0_44ck169 = 1.1 time = 850
* CHECK dout0_45 vdout0_45ck169 = 0 time = 850
* CHECK dout0_46 vdout0_46ck169 = 0 time = 850
* CHECK dout0_47 vdout0_47ck169 = 0 time = 850
* CHECK dout0_48 vdout0_48ck169 = 1.1 time = 850
* CHECK dout0_49 vdout0_49ck169 = 0 time = 850
* CHECK dout0_50 vdout0_50ck169 = 1.1 time = 850
* CHECK dout0_51 vdout0_51ck169 = 0 time = 850
* CHECK dout0_52 vdout0_52ck169 = 1.1 time = 850
* CHECK dout0_53 vdout0_53ck169 = 0 time = 850
* CHECK dout0_54 vdout0_54ck169 = 0 time = 850
* CHECK dout0_55 vdout0_55ck169 = 1.1 time = 850
* CHECK dout0_56 vdout0_56ck169 = 1.1 time = 850
* CHECK dout0_57 vdout0_57ck169 = 0 time = 850
* CHECK dout0_58 vdout0_58ck169 = 0 time = 850
* CHECK dout0_59 vdout0_59ck169 = 1.1 time = 850
* CHECK dout0_60 vdout0_60ck169 = 1.1 time = 850
* CHECK dout0_61 vdout0_61ck169 = 1.1 time = 850
* CHECK dout0_62 vdout0_62ck169 = 0 time = 850
* CHECK dout0_63 vdout0_63ck169 = 1.1 time = 850
* CHECK dout0_0 vdout0_0ck178 = 0 time = 895
* CHECK dout0_1 vdout0_1ck178 = 1.1 time = 895
* CHECK dout0_2 vdout0_2ck178 = 1.1 time = 895
* CHECK dout0_3 vdout0_3ck178 = 0 time = 895
* CHECK dout0_4 vdout0_4ck178 = 1.1 time = 895
* CHECK dout0_5 vdout0_5ck178 = 0 time = 895
* CHECK dout0_6 vdout0_6ck178 = 0 time = 895
* CHECK dout0_7 vdout0_7ck178 = 0 time = 895
* CHECK dout0_8 vdout0_8ck178 = 1.1 time = 895
* CHECK dout0_9 vdout0_9ck178 = 1.1 time = 895
* CHECK dout0_10 vdout0_10ck178 = 0 time = 895
* CHECK dout0_11 vdout0_11ck178 = 1.1 time = 895
* CHECK dout0_12 vdout0_12ck178 = 0 time = 895
* CHECK dout0_13 vdout0_13ck178 = 0 time = 895
* CHECK dout0_14 vdout0_14ck178 = 0 time = 895
* CHECK dout0_15 vdout0_15ck178 = 1.1 time = 895
* CHECK dout0_16 vdout0_16ck178 = 0 time = 895
* CHECK dout0_17 vdout0_17ck178 = 1.1 time = 895
* CHECK dout0_18 vdout0_18ck178 = 0 time = 895
* CHECK dout0_19 vdout0_19ck178 = 0 time = 895
* CHECK dout0_20 vdout0_20ck178 = 1.1 time = 895
* CHECK dout0_21 vdout0_21ck178 = 1.1 time = 895
* CHECK dout0_22 vdout0_22ck178 = 0 time = 895
* CHECK dout0_23 vdout0_23ck178 = 0 time = 895
* CHECK dout0_24 vdout0_24ck178 = 0 time = 895
* CHECK dout0_25 vdout0_25ck178 = 1.1 time = 895
* CHECK dout0_26 vdout0_26ck178 = 0 time = 895
* CHECK dout0_27 vdout0_27ck178 = 0 time = 895
* CHECK dout0_28 vdout0_28ck178 = 1.1 time = 895
* CHECK dout0_29 vdout0_29ck178 = 1.1 time = 895
* CHECK dout0_30 vdout0_30ck178 = 1.1 time = 895
* CHECK dout0_31 vdout0_31ck178 = 0 time = 895
* CHECK dout0_32 vdout0_32ck178 = 1.1 time = 895
* CHECK dout0_33 vdout0_33ck178 = 1.1 time = 895
* CHECK dout0_34 vdout0_34ck178 = 0 time = 895
* CHECK dout0_35 vdout0_35ck178 = 1.1 time = 895
* CHECK dout0_36 vdout0_36ck178 = 1.1 time = 895
* CHECK dout0_37 vdout0_37ck178 = 0 time = 895
* CHECK dout0_38 vdout0_38ck178 = 1.1 time = 895
* CHECK dout0_39 vdout0_39ck178 = 1.1 time = 895
* CHECK dout0_40 vdout0_40ck178 = 1.1 time = 895
* CHECK dout0_41 vdout0_41ck178 = 0 time = 895
* CHECK dout0_42 vdout0_42ck178 = 0 time = 895
* CHECK dout0_43 vdout0_43ck178 = 0 time = 895
* CHECK dout0_44 vdout0_44ck178 = 0 time = 895
* CHECK dout0_45 vdout0_45ck178 = 1.1 time = 895
* CHECK dout0_46 vdout0_46ck178 = 0 time = 895
* CHECK dout0_47 vdout0_47ck178 = 0 time = 895
* CHECK dout0_48 vdout0_48ck178 = 0 time = 895
* CHECK dout0_49 vdout0_49ck178 = 0 time = 895
* CHECK dout0_50 vdout0_50ck178 = 1.1 time = 895
* CHECK dout0_51 vdout0_51ck178 = 1.1 time = 895
* CHECK dout0_52 vdout0_52ck178 = 1.1 time = 895
* CHECK dout0_53 vdout0_53ck178 = 1.1 time = 895
* CHECK dout0_54 vdout0_54ck178 = 1.1 time = 895
* CHECK dout0_55 vdout0_55ck178 = 0 time = 895
* CHECK dout0_56 vdout0_56ck178 = 0 time = 895
* CHECK dout0_57 vdout0_57ck178 = 1.1 time = 895
* CHECK dout0_58 vdout0_58ck178 = 1.1 time = 895
* CHECK dout0_59 vdout0_59ck178 = 0 time = 895
* CHECK dout0_60 vdout0_60ck178 = 0 time = 895
* CHECK dout0_61 vdout0_61ck178 = 1.1 time = 895
* CHECK dout0_62 vdout0_62ck178 = 0 time = 895
* CHECK dout0_63 vdout0_63ck178 = 1.1 time = 895
* CHECK dout0_0 vdout0_0ck181 = 1.1 time = 910
* CHECK dout0_1 vdout0_1ck181 = 0 time = 910
* CHECK dout0_2 vdout0_2ck181 = 1.1 time = 910
* CHECK dout0_3 vdout0_3ck181 = 1.1 time = 910
* CHECK dout0_4 vdout0_4ck181 = 1.1 time = 910
* CHECK dout0_5 vdout0_5ck181 = 0 time = 910
* CHECK dout0_6 vdout0_6ck181 = 0 time = 910
* CHECK dout0_7 vdout0_7ck181 = 1.1 time = 910
* CHECK dout0_8 vdout0_8ck181 = 1.1 time = 910
* CHECK dout0_9 vdout0_9ck181 = 1.1 time = 910
* CHECK dout0_10 vdout0_10ck181 = 0 time = 910
* CHECK dout0_11 vdout0_11ck181 = 0 time = 910
* CHECK dout0_12 vdout0_12ck181 = 0 time = 910
* CHECK dout0_13 vdout0_13ck181 = 0 time = 910
* CHECK dout0_14 vdout0_14ck181 = 0 time = 910
* CHECK dout0_15 vdout0_15ck181 = 0 time = 910
* CHECK dout0_16 vdout0_16ck181 = 1.1 time = 910
* CHECK dout0_17 vdout0_17ck181 = 1.1 time = 910
* CHECK dout0_18 vdout0_18ck181 = 1.1 time = 910
* CHECK dout0_19 vdout0_19ck181 = 0 time = 910
* CHECK dout0_20 vdout0_20ck181 = 1.1 time = 910
* CHECK dout0_21 vdout0_21ck181 = 1.1 time = 910
* CHECK dout0_22 vdout0_22ck181 = 0 time = 910
* CHECK dout0_23 vdout0_23ck181 = 1.1 time = 910
* CHECK dout0_24 vdout0_24ck181 = 1.1 time = 910
* CHECK dout0_25 vdout0_25ck181 = 0 time = 910
* CHECK dout0_26 vdout0_26ck181 = 0 time = 910
* CHECK dout0_27 vdout0_27ck181 = 0 time = 910
* CHECK dout0_28 vdout0_28ck181 = 0 time = 910
* CHECK dout0_29 vdout0_29ck181 = 0 time = 910
* CHECK dout0_30 vdout0_30ck181 = 1.1 time = 910
* CHECK dout0_31 vdout0_31ck181 = 0 time = 910
* CHECK dout0_32 vdout0_32ck181 = 1.1 time = 910
* CHECK dout0_33 vdout0_33ck181 = 1.1 time = 910
* CHECK dout0_34 vdout0_34ck181 = 1.1 time = 910
* CHECK dout0_35 vdout0_35ck181 = 1.1 time = 910
* CHECK dout0_36 vdout0_36ck181 = 1.1 time = 910
* CHECK dout0_37 vdout0_37ck181 = 0 time = 910
* CHECK dout0_38 vdout0_38ck181 = 0 time = 910
* CHECK dout0_39 vdout0_39ck181 = 0 time = 910
* CHECK dout0_40 vdout0_40ck181 = 1.1 time = 910
* CHECK dout0_41 vdout0_41ck181 = 0 time = 910
* CHECK dout0_42 vdout0_42ck181 = 1.1 time = 910
* CHECK dout0_43 vdout0_43ck181 = 1.1 time = 910
* CHECK dout0_44 vdout0_44ck181 = 0 time = 910
* CHECK dout0_45 vdout0_45ck181 = 1.1 time = 910
* CHECK dout0_46 vdout0_46ck181 = 0 time = 910
* CHECK dout0_47 vdout0_47ck181 = 0 time = 910
* CHECK dout0_48 vdout0_48ck181 = 1.1 time = 910
* CHECK dout0_49 vdout0_49ck181 = 0 time = 910
* CHECK dout0_50 vdout0_50ck181 = 0 time = 910
* CHECK dout0_51 vdout0_51ck181 = 0 time = 910
* CHECK dout0_52 vdout0_52ck181 = 0 time = 910
* CHECK dout0_53 vdout0_53ck181 = 1.1 time = 910
* CHECK dout0_54 vdout0_54ck181 = 1.1 time = 910
* CHECK dout0_55 vdout0_55ck181 = 1.1 time = 910
* CHECK dout0_56 vdout0_56ck181 = 0 time = 910
* CHECK dout0_57 vdout0_57ck181 = 0 time = 910
* CHECK dout0_58 vdout0_58ck181 = 1.1 time = 910
* CHECK dout0_59 vdout0_59ck181 = 0 time = 910
* CHECK dout0_60 vdout0_60ck181 = 0 time = 910
* CHECK dout0_61 vdout0_61ck181 = 0 time = 910
* CHECK dout0_62 vdout0_62ck181 = 0 time = 910
* CHECK dout0_63 vdout0_63ck181 = 0 time = 910
* CHECK dout0_0 vdout0_0ck183 = 1.1 time = 920
* CHECK dout0_1 vdout0_1ck183 = 0 time = 920
* CHECK dout0_2 vdout0_2ck183 = 1.1 time = 920
* CHECK dout0_3 vdout0_3ck183 = 0 time = 920
* CHECK dout0_4 vdout0_4ck183 = 1.1 time = 920
* CHECK dout0_5 vdout0_5ck183 = 1.1 time = 920
* CHECK dout0_6 vdout0_6ck183 = 0 time = 920
* CHECK dout0_7 vdout0_7ck183 = 1.1 time = 920
* CHECK dout0_8 vdout0_8ck183 = 0 time = 920
* CHECK dout0_9 vdout0_9ck183 = 1.1 time = 920
* CHECK dout0_10 vdout0_10ck183 = 0 time = 920
* CHECK dout0_11 vdout0_11ck183 = 0 time = 920
* CHECK dout0_12 vdout0_12ck183 = 1.1 time = 920
* CHECK dout0_13 vdout0_13ck183 = 1.1 time = 920
* CHECK dout0_14 vdout0_14ck183 = 1.1 time = 920
* CHECK dout0_15 vdout0_15ck183 = 0 time = 920
* CHECK dout0_16 vdout0_16ck183 = 0 time = 920
* CHECK dout0_17 vdout0_17ck183 = 0 time = 920
* CHECK dout0_18 vdout0_18ck183 = 1.1 time = 920
* CHECK dout0_19 vdout0_19ck183 = 1.1 time = 920
* CHECK dout0_20 vdout0_20ck183 = 1.1 time = 920
* CHECK dout0_21 vdout0_21ck183 = 0 time = 920
* CHECK dout0_22 vdout0_22ck183 = 1.1 time = 920
* CHECK dout0_23 vdout0_23ck183 = 1.1 time = 920
* CHECK dout0_24 vdout0_24ck183 = 1.1 time = 920
* CHECK dout0_25 vdout0_25ck183 = 1.1 time = 920
* CHECK dout0_26 vdout0_26ck183 = 0 time = 920
* CHECK dout0_27 vdout0_27ck183 = 1.1 time = 920
* CHECK dout0_28 vdout0_28ck183 = 0 time = 920
* CHECK dout0_29 vdout0_29ck183 = 1.1 time = 920
* CHECK dout0_30 vdout0_30ck183 = 1.1 time = 920
* CHECK dout0_31 vdout0_31ck183 = 1.1 time = 920
* CHECK dout0_32 vdout0_32ck183 = 1.1 time = 920
* CHECK dout0_33 vdout0_33ck183 = 0 time = 920
* CHECK dout0_34 vdout0_34ck183 = 1.1 time = 920
* CHECK dout0_35 vdout0_35ck183 = 1.1 time = 920
* CHECK dout0_36 vdout0_36ck183 = 1.1 time = 920
* CHECK dout0_37 vdout0_37ck183 = 1.1 time = 920
* CHECK dout0_38 vdout0_38ck183 = 1.1 time = 920
* CHECK dout0_39 vdout0_39ck183 = 1.1 time = 920
* CHECK dout0_40 vdout0_40ck183 = 1.1 time = 920
* CHECK dout0_41 vdout0_41ck183 = 0 time = 920
* CHECK dout0_42 vdout0_42ck183 = 1.1 time = 920
* CHECK dout0_43 vdout0_43ck183 = 0 time = 920
* CHECK dout0_44 vdout0_44ck183 = 1.1 time = 920
* CHECK dout0_45 vdout0_45ck183 = 0 time = 920
* CHECK dout0_46 vdout0_46ck183 = 1.1 time = 920
* CHECK dout0_47 vdout0_47ck183 = 1.1 time = 920
* CHECK dout0_48 vdout0_48ck183 = 1.1 time = 920
* CHECK dout0_49 vdout0_49ck183 = 0 time = 920
* CHECK dout0_50 vdout0_50ck183 = 0 time = 920
* CHECK dout0_51 vdout0_51ck183 = 0 time = 920
* CHECK dout0_52 vdout0_52ck183 = 1.1 time = 920
* CHECK dout0_53 vdout0_53ck183 = 1.1 time = 920
* CHECK dout0_54 vdout0_54ck183 = 0 time = 920
* CHECK dout0_55 vdout0_55ck183 = 1.1 time = 920
* CHECK dout0_56 vdout0_56ck183 = 0 time = 920
* CHECK dout0_57 vdout0_57ck183 = 1.1 time = 920
* CHECK dout0_58 vdout0_58ck183 = 0 time = 920
* CHECK dout0_59 vdout0_59ck183 = 1.1 time = 920
* CHECK dout0_60 vdout0_60ck183 = 1.1 time = 920
* CHECK dout0_61 vdout0_61ck183 = 0 time = 920
* CHECK dout0_62 vdout0_62ck183 = 1.1 time = 920
* CHECK dout0_63 vdout0_63ck183 = 0 time = 920
* CHECK dout0_0 vdout0_0ck184 = 1.1 time = 925
* CHECK dout0_1 vdout0_1ck184 = 0 time = 925
* CHECK dout0_2 vdout0_2ck184 = 1.1 time = 925
* CHECK dout0_3 vdout0_3ck184 = 1.1 time = 925
* CHECK dout0_4 vdout0_4ck184 = 1.1 time = 925
* CHECK dout0_5 vdout0_5ck184 = 0 time = 925
* CHECK dout0_6 vdout0_6ck184 = 0 time = 925
* CHECK dout0_7 vdout0_7ck184 = 1.1 time = 925
* CHECK dout0_8 vdout0_8ck184 = 1.1 time = 925
* CHECK dout0_9 vdout0_9ck184 = 1.1 time = 925
* CHECK dout0_10 vdout0_10ck184 = 0 time = 925
* CHECK dout0_11 vdout0_11ck184 = 0 time = 925
* CHECK dout0_12 vdout0_12ck184 = 0 time = 925
* CHECK dout0_13 vdout0_13ck184 = 0 time = 925
* CHECK dout0_14 vdout0_14ck184 = 0 time = 925
* CHECK dout0_15 vdout0_15ck184 = 0 time = 925
* CHECK dout0_16 vdout0_16ck184 = 1.1 time = 925
* CHECK dout0_17 vdout0_17ck184 = 1.1 time = 925
* CHECK dout0_18 vdout0_18ck184 = 1.1 time = 925
* CHECK dout0_19 vdout0_19ck184 = 0 time = 925
* CHECK dout0_20 vdout0_20ck184 = 1.1 time = 925
* CHECK dout0_21 vdout0_21ck184 = 1.1 time = 925
* CHECK dout0_22 vdout0_22ck184 = 0 time = 925
* CHECK dout0_23 vdout0_23ck184 = 1.1 time = 925
* CHECK dout0_24 vdout0_24ck184 = 1.1 time = 925
* CHECK dout0_25 vdout0_25ck184 = 0 time = 925
* CHECK dout0_26 vdout0_26ck184 = 0 time = 925
* CHECK dout0_27 vdout0_27ck184 = 0 time = 925
* CHECK dout0_28 vdout0_28ck184 = 0 time = 925
* CHECK dout0_29 vdout0_29ck184 = 0 time = 925
* CHECK dout0_30 vdout0_30ck184 = 1.1 time = 925
* CHECK dout0_31 vdout0_31ck184 = 0 time = 925
* CHECK dout0_32 vdout0_32ck184 = 1.1 time = 925
* CHECK dout0_33 vdout0_33ck184 = 1.1 time = 925
* CHECK dout0_34 vdout0_34ck184 = 1.1 time = 925
* CHECK dout0_35 vdout0_35ck184 = 1.1 time = 925
* CHECK dout0_36 vdout0_36ck184 = 1.1 time = 925
* CHECK dout0_37 vdout0_37ck184 = 0 time = 925
* CHECK dout0_38 vdout0_38ck184 = 0 time = 925
* CHECK dout0_39 vdout0_39ck184 = 0 time = 925
* CHECK dout0_40 vdout0_40ck184 = 1.1 time = 925
* CHECK dout0_41 vdout0_41ck184 = 0 time = 925
* CHECK dout0_42 vdout0_42ck184 = 1.1 time = 925
* CHECK dout0_43 vdout0_43ck184 = 1.1 time = 925
* CHECK dout0_44 vdout0_44ck184 = 0 time = 925
* CHECK dout0_45 vdout0_45ck184 = 1.1 time = 925
* CHECK dout0_46 vdout0_46ck184 = 0 time = 925
* CHECK dout0_47 vdout0_47ck184 = 0 time = 925
* CHECK dout0_48 vdout0_48ck184 = 1.1 time = 925
* CHECK dout0_49 vdout0_49ck184 = 0 time = 925
* CHECK dout0_50 vdout0_50ck184 = 0 time = 925
* CHECK dout0_51 vdout0_51ck184 = 0 time = 925
* CHECK dout0_52 vdout0_52ck184 = 0 time = 925
* CHECK dout0_53 vdout0_53ck184 = 1.1 time = 925
* CHECK dout0_54 vdout0_54ck184 = 1.1 time = 925
* CHECK dout0_55 vdout0_55ck184 = 1.1 time = 925
* CHECK dout0_56 vdout0_56ck184 = 0 time = 925
* CHECK dout0_57 vdout0_57ck184 = 0 time = 925
* CHECK dout0_58 vdout0_58ck184 = 1.1 time = 925
* CHECK dout0_59 vdout0_59ck184 = 0 time = 925
* CHECK dout0_60 vdout0_60ck184 = 0 time = 925
* CHECK dout0_61 vdout0_61ck184 = 0 time = 925
* CHECK dout0_62 vdout0_62ck184 = 0 time = 925
* CHECK dout0_63 vdout0_63ck184 = 0 time = 925
* CHECK dout0_0 vdout0_0ck185 = 0 time = 930
* CHECK dout0_1 vdout0_1ck185 = 1.1 time = 930
* CHECK dout0_2 vdout0_2ck185 = 1.1 time = 930
* CHECK dout0_3 vdout0_3ck185 = 0 time = 930
* CHECK dout0_4 vdout0_4ck185 = 1.1 time = 930
* CHECK dout0_5 vdout0_5ck185 = 0 time = 930
* CHECK dout0_6 vdout0_6ck185 = 0 time = 930
* CHECK dout0_7 vdout0_7ck185 = 0 time = 930
* CHECK dout0_8 vdout0_8ck185 = 1.1 time = 930
* CHECK dout0_9 vdout0_9ck185 = 1.1 time = 930
* CHECK dout0_10 vdout0_10ck185 = 0 time = 930
* CHECK dout0_11 vdout0_11ck185 = 1.1 time = 930
* CHECK dout0_12 vdout0_12ck185 = 0 time = 930
* CHECK dout0_13 vdout0_13ck185 = 0 time = 930
* CHECK dout0_14 vdout0_14ck185 = 0 time = 930
* CHECK dout0_15 vdout0_15ck185 = 1.1 time = 930
* CHECK dout0_16 vdout0_16ck185 = 0 time = 930
* CHECK dout0_17 vdout0_17ck185 = 1.1 time = 930
* CHECK dout0_18 vdout0_18ck185 = 0 time = 930
* CHECK dout0_19 vdout0_19ck185 = 0 time = 930
* CHECK dout0_20 vdout0_20ck185 = 1.1 time = 930
* CHECK dout0_21 vdout0_21ck185 = 1.1 time = 930
* CHECK dout0_22 vdout0_22ck185 = 0 time = 930
* CHECK dout0_23 vdout0_23ck185 = 0 time = 930
* CHECK dout0_24 vdout0_24ck185 = 0 time = 930
* CHECK dout0_25 vdout0_25ck185 = 1.1 time = 930
* CHECK dout0_26 vdout0_26ck185 = 0 time = 930
* CHECK dout0_27 vdout0_27ck185 = 0 time = 930
* CHECK dout0_28 vdout0_28ck185 = 1.1 time = 930
* CHECK dout0_29 vdout0_29ck185 = 1.1 time = 930
* CHECK dout0_30 vdout0_30ck185 = 1.1 time = 930
* CHECK dout0_31 vdout0_31ck185 = 0 time = 930
* CHECK dout0_32 vdout0_32ck185 = 1.1 time = 930
* CHECK dout0_33 vdout0_33ck185 = 1.1 time = 930
* CHECK dout0_34 vdout0_34ck185 = 0 time = 930
* CHECK dout0_35 vdout0_35ck185 = 1.1 time = 930
* CHECK dout0_36 vdout0_36ck185 = 1.1 time = 930
* CHECK dout0_37 vdout0_37ck185 = 0 time = 930
* CHECK dout0_38 vdout0_38ck185 = 1.1 time = 930
* CHECK dout0_39 vdout0_39ck185 = 1.1 time = 930
* CHECK dout0_40 vdout0_40ck185 = 1.1 time = 930
* CHECK dout0_41 vdout0_41ck185 = 0 time = 930
* CHECK dout0_42 vdout0_42ck185 = 0 time = 930
* CHECK dout0_43 vdout0_43ck185 = 0 time = 930
* CHECK dout0_44 vdout0_44ck185 = 0 time = 930
* CHECK dout0_45 vdout0_45ck185 = 1.1 time = 930
* CHECK dout0_46 vdout0_46ck185 = 0 time = 930
* CHECK dout0_47 vdout0_47ck185 = 0 time = 930
* CHECK dout0_48 vdout0_48ck185 = 0 time = 930
* CHECK dout0_49 vdout0_49ck185 = 0 time = 930
* CHECK dout0_50 vdout0_50ck185 = 1.1 time = 930
* CHECK dout0_51 vdout0_51ck185 = 1.1 time = 930
* CHECK dout0_52 vdout0_52ck185 = 1.1 time = 930
* CHECK dout0_53 vdout0_53ck185 = 1.1 time = 930
* CHECK dout0_54 vdout0_54ck185 = 1.1 time = 930
* CHECK dout0_55 vdout0_55ck185 = 0 time = 930
* CHECK dout0_56 vdout0_56ck185 = 0 time = 930
* CHECK dout0_57 vdout0_57ck185 = 1.1 time = 930
* CHECK dout0_58 vdout0_58ck185 = 1.1 time = 930
* CHECK dout0_59 vdout0_59ck185 = 0 time = 930
* CHECK dout0_60 vdout0_60ck185 = 0 time = 930
* CHECK dout0_61 vdout0_61ck185 = 1.1 time = 930
* CHECK dout0_62 vdout0_62ck185 = 0 time = 930
* CHECK dout0_63 vdout0_63ck185 = 1.1 time = 930
* CHECK dout0_0 vdout0_0ck195 = 1.1 time = 980
* CHECK dout0_1 vdout0_1ck195 = 0 time = 980
* CHECK dout0_2 vdout0_2ck195 = 0 time = 980
* CHECK dout0_3 vdout0_3ck195 = 1.1 time = 980
* CHECK dout0_4 vdout0_4ck195 = 1.1 time = 980
* CHECK dout0_5 vdout0_5ck195 = 0 time = 980
* CHECK dout0_6 vdout0_6ck195 = 1.1 time = 980
* CHECK dout0_7 vdout0_7ck195 = 1.1 time = 980
* CHECK dout0_8 vdout0_8ck195 = 0 time = 980
* CHECK dout0_9 vdout0_9ck195 = 1.1 time = 980
* CHECK dout0_10 vdout0_10ck195 = 0 time = 980
* CHECK dout0_11 vdout0_11ck195 = 0 time = 980
* CHECK dout0_12 vdout0_12ck195 = 1.1 time = 980
* CHECK dout0_13 vdout0_13ck195 = 1.1 time = 980
* CHECK dout0_14 vdout0_14ck195 = 1.1 time = 980
* CHECK dout0_15 vdout0_15ck195 = 1.1 time = 980
* CHECK dout0_16 vdout0_16ck195 = 0 time = 980
* CHECK dout0_17 vdout0_17ck195 = 0 time = 980
* CHECK dout0_18 vdout0_18ck195 = 1.1 time = 980
* CHECK dout0_19 vdout0_19ck195 = 0 time = 980
* CHECK dout0_20 vdout0_20ck195 = 0 time = 980
* CHECK dout0_21 vdout0_21ck195 = 1.1 time = 980
* CHECK dout0_22 vdout0_22ck195 = 0 time = 980
* CHECK dout0_23 vdout0_23ck195 = 1.1 time = 980
* CHECK dout0_24 vdout0_24ck195 = 1.1 time = 980
* CHECK dout0_25 vdout0_25ck195 = 0 time = 980
* CHECK dout0_26 vdout0_26ck195 = 1.1 time = 980
* CHECK dout0_27 vdout0_27ck195 = 1.1 time = 980
* CHECK dout0_28 vdout0_28ck195 = 1.1 time = 980
* CHECK dout0_29 vdout0_29ck195 = 1.1 time = 980
* CHECK dout0_30 vdout0_30ck195 = 0 time = 980
* CHECK dout0_31 vdout0_31ck195 = 0 time = 980
* CHECK dout0_32 vdout0_32ck195 = 0 time = 980
* CHECK dout0_33 vdout0_33ck195 = 1.1 time = 980
* CHECK dout0_34 vdout0_34ck195 = 0 time = 980
* CHECK dout0_35 vdout0_35ck195 = 1.1 time = 980
* CHECK dout0_36 vdout0_36ck195 = 0 time = 980
* CHECK dout0_37 vdout0_37ck195 = 1.1 time = 980
* CHECK dout0_38 vdout0_38ck195 = 1.1 time = 980
* CHECK dout0_39 vdout0_39ck195 = 1.1 time = 980
* CHECK dout0_40 vdout0_40ck195 = 1.1 time = 980
* CHECK dout0_41 vdout0_41ck195 = 1.1 time = 980
* CHECK dout0_42 vdout0_42ck195 = 0 time = 980
* CHECK dout0_43 vdout0_43ck195 = 0 time = 980
* CHECK dout0_44 vdout0_44ck195 = 0 time = 980
* CHECK dout0_45 vdout0_45ck195 = 0 time = 980
* CHECK dout0_46 vdout0_46ck195 = 0 time = 980
* CHECK dout0_47 vdout0_47ck195 = 1.1 time = 980
* CHECK dout0_48 vdout0_48ck195 = 1.1 time = 980
* CHECK dout0_49 vdout0_49ck195 = 0 time = 980
* CHECK dout0_50 vdout0_50ck195 = 1.1 time = 980
* CHECK dout0_51 vdout0_51ck195 = 1.1 time = 980
* CHECK dout0_52 vdout0_52ck195 = 1.1 time = 980
* CHECK dout0_53 vdout0_53ck195 = 1.1 time = 980
* CHECK dout0_54 vdout0_54ck195 = 0 time = 980
* CHECK dout0_55 vdout0_55ck195 = 0 time = 980
* CHECK dout0_56 vdout0_56ck195 = 1.1 time = 980
* CHECK dout0_57 vdout0_57ck195 = 0 time = 980
* CHECK dout0_58 vdout0_58ck195 = 1.1 time = 980
* CHECK dout0_59 vdout0_59ck195 = 1.1 time = 980
* CHECK dout0_60 vdout0_60ck195 = 1.1 time = 980
* CHECK dout0_61 vdout0_61ck195 = 0 time = 980
* CHECK dout0_62 vdout0_62ck195 = 0 time = 980
* CHECK dout0_63 vdout0_63ck195 = 1.1 time = 980
* CHECK dout0_0 vdout0_0ck201 = 0 time = 1010
* CHECK dout0_1 vdout0_1ck201 = 1.1 time = 1010
* CHECK dout0_2 vdout0_2ck201 = 1.1 time = 1010
* CHECK dout0_3 vdout0_3ck201 = 0 time = 1010
* CHECK dout0_4 vdout0_4ck201 = 0 time = 1010
* CHECK dout0_5 vdout0_5ck201 = 0 time = 1010
* CHECK dout0_6 vdout0_6ck201 = 1.1 time = 1010
* CHECK dout0_7 vdout0_7ck201 = 0 time = 1010
* CHECK dout0_8 vdout0_8ck201 = 0 time = 1010
* CHECK dout0_9 vdout0_9ck201 = 1.1 time = 1010
* CHECK dout0_10 vdout0_10ck201 = 0 time = 1010
* CHECK dout0_11 vdout0_11ck201 = 0 time = 1010
* CHECK dout0_12 vdout0_12ck201 = 1.1 time = 1010
* CHECK dout0_13 vdout0_13ck201 = 0 time = 1010
* CHECK dout0_14 vdout0_14ck201 = 1.1 time = 1010
* CHECK dout0_15 vdout0_15ck201 = 1.1 time = 1010
* CHECK dout0_16 vdout0_16ck201 = 0 time = 1010
* CHECK dout0_17 vdout0_17ck201 = 0 time = 1010
* CHECK dout0_18 vdout0_18ck201 = 0 time = 1010
* CHECK dout0_19 vdout0_19ck201 = 1.1 time = 1010
* CHECK dout0_20 vdout0_20ck201 = 0 time = 1010
* CHECK dout0_21 vdout0_21ck201 = 1.1 time = 1010
* CHECK dout0_22 vdout0_22ck201 = 1.1 time = 1010
* CHECK dout0_23 vdout0_23ck201 = 1.1 time = 1010
* CHECK dout0_24 vdout0_24ck201 = 1.1 time = 1010
* CHECK dout0_25 vdout0_25ck201 = 0 time = 1010
* CHECK dout0_26 vdout0_26ck201 = 1.1 time = 1010
* CHECK dout0_27 vdout0_27ck201 = 0 time = 1010
* CHECK dout0_28 vdout0_28ck201 = 1.1 time = 1010
* CHECK dout0_29 vdout0_29ck201 = 1.1 time = 1010
* CHECK dout0_30 vdout0_30ck201 = 0 time = 1010
* CHECK dout0_31 vdout0_31ck201 = 0 time = 1010
* CHECK dout0_32 vdout0_32ck201 = 0 time = 1010
* CHECK dout0_33 vdout0_33ck201 = 1.1 time = 1010
* CHECK dout0_34 vdout0_34ck201 = 1.1 time = 1010
* CHECK dout0_35 vdout0_35ck201 = 0 time = 1010
* CHECK dout0_36 vdout0_36ck201 = 1.1 time = 1010
* CHECK dout0_37 vdout0_37ck201 = 0 time = 1010
* CHECK dout0_38 vdout0_38ck201 = 0 time = 1010
* CHECK dout0_39 vdout0_39ck201 = 0 time = 1010
* CHECK dout0_40 vdout0_40ck201 = 1.1 time = 1010
* CHECK dout0_41 vdout0_41ck201 = 0 time = 1010
* CHECK dout0_42 vdout0_42ck201 = 1.1 time = 1010
* CHECK dout0_43 vdout0_43ck201 = 0 time = 1010
* CHECK dout0_44 vdout0_44ck201 = 0 time = 1010
* CHECK dout0_45 vdout0_45ck201 = 1.1 time = 1010
* CHECK dout0_46 vdout0_46ck201 = 0 time = 1010
* CHECK dout0_47 vdout0_47ck201 = 1.1 time = 1010
* CHECK dout0_48 vdout0_48ck201 = 0 time = 1010
* CHECK dout0_49 vdout0_49ck201 = 1.1 time = 1010
* CHECK dout0_50 vdout0_50ck201 = 1.1 time = 1010
* CHECK dout0_51 vdout0_51ck201 = 1.1 time = 1010
* CHECK dout0_52 vdout0_52ck201 = 1.1 time = 1010
* CHECK dout0_53 vdout0_53ck201 = 1.1 time = 1010
* CHECK dout0_54 vdout0_54ck201 = 1.1 time = 1010
* CHECK dout0_55 vdout0_55ck201 = 1.1 time = 1010
* CHECK dout0_56 vdout0_56ck201 = 0 time = 1010
* CHECK dout0_57 vdout0_57ck201 = 1.1 time = 1010
* CHECK dout0_58 vdout0_58ck201 = 0 time = 1010
* CHECK dout0_59 vdout0_59ck201 = 1.1 time = 1010
* CHECK dout0_60 vdout0_60ck201 = 0 time = 1010
* CHECK dout0_61 vdout0_61ck201 = 0 time = 1010
* CHECK dout0_62 vdout0_62ck201 = 1.1 time = 1010
* CHECK dout0_63 vdout0_63ck201 = 1.1 time = 1010
* CHECK dout0_0 vdout0_0ck202 = 0 time = 1015
* CHECK dout0_1 vdout0_1ck202 = 0 time = 1015
* CHECK dout0_2 vdout0_2ck202 = 0 time = 1015
* CHECK dout0_3 vdout0_3ck202 = 0 time = 1015
* CHECK dout0_4 vdout0_4ck202 = 1.1 time = 1015
* CHECK dout0_5 vdout0_5ck202 = 1.1 time = 1015
* CHECK dout0_6 vdout0_6ck202 = 1.1 time = 1015
* CHECK dout0_7 vdout0_7ck202 = 0 time = 1015
* CHECK dout0_8 vdout0_8ck202 = 0 time = 1015
* CHECK dout0_9 vdout0_9ck202 = 1.1 time = 1015
* CHECK dout0_10 vdout0_10ck202 = 0 time = 1015
* CHECK dout0_11 vdout0_11ck202 = 1.1 time = 1015
* CHECK dout0_12 vdout0_12ck202 = 1.1 time = 1015
* CHECK dout0_13 vdout0_13ck202 = 0 time = 1015
* CHECK dout0_14 vdout0_14ck202 = 1.1 time = 1015
* CHECK dout0_15 vdout0_15ck202 = 1.1 time = 1015
* CHECK dout0_16 vdout0_16ck202 = 0 time = 1015
* CHECK dout0_17 vdout0_17ck202 = 0 time = 1015
* CHECK dout0_18 vdout0_18ck202 = 0 time = 1015
* CHECK dout0_19 vdout0_19ck202 = 0 time = 1015
* CHECK dout0_20 vdout0_20ck202 = 1.1 time = 1015
* CHECK dout0_21 vdout0_21ck202 = 0 time = 1015
* CHECK dout0_22 vdout0_22ck202 = 0 time = 1015
* CHECK dout0_23 vdout0_23ck202 = 0 time = 1015
* CHECK dout0_24 vdout0_24ck202 = 1.1 time = 1015
* CHECK dout0_25 vdout0_25ck202 = 0 time = 1015
* CHECK dout0_26 vdout0_26ck202 = 0 time = 1015
* CHECK dout0_27 vdout0_27ck202 = 0 time = 1015
* CHECK dout0_28 vdout0_28ck202 = 0 time = 1015
* CHECK dout0_29 vdout0_29ck202 = 0 time = 1015
* CHECK dout0_30 vdout0_30ck202 = 1.1 time = 1015
* CHECK dout0_31 vdout0_31ck202 = 1.1 time = 1015
* CHECK dout0_32 vdout0_32ck202 = 0 time = 1015
* CHECK dout0_33 vdout0_33ck202 = 0 time = 1015
* CHECK dout0_34 vdout0_34ck202 = 0 time = 1015
* CHECK dout0_35 vdout0_35ck202 = 0 time = 1015
* CHECK dout0_36 vdout0_36ck202 = 1.1 time = 1015
* CHECK dout0_37 vdout0_37ck202 = 0 time = 1015
* CHECK dout0_38 vdout0_38ck202 = 1.1 time = 1015
* CHECK dout0_39 vdout0_39ck202 = 1.1 time = 1015
* CHECK dout0_40 vdout0_40ck202 = 0 time = 1015
* CHECK dout0_41 vdout0_41ck202 = 1.1 time = 1015
* CHECK dout0_42 vdout0_42ck202 = 1.1 time = 1015
* CHECK dout0_43 vdout0_43ck202 = 0 time = 1015
* CHECK dout0_44 vdout0_44ck202 = 0 time = 1015
* CHECK dout0_45 vdout0_45ck202 = 0 time = 1015
* CHECK dout0_46 vdout0_46ck202 = 1.1 time = 1015
* CHECK dout0_47 vdout0_47ck202 = 0 time = 1015
* CHECK dout0_48 vdout0_48ck202 = 1.1 time = 1015
* CHECK dout0_49 vdout0_49ck202 = 0 time = 1015
* CHECK dout0_50 vdout0_50ck202 = 0 time = 1015
* CHECK dout0_51 vdout0_51ck202 = 0 time = 1015
* CHECK dout0_52 vdout0_52ck202 = 1.1 time = 1015
* CHECK dout0_53 vdout0_53ck202 = 1.1 time = 1015
* CHECK dout0_54 vdout0_54ck202 = 1.1 time = 1015
* CHECK dout0_55 vdout0_55ck202 = 0 time = 1015
* CHECK dout0_56 vdout0_56ck202 = 0 time = 1015
* CHECK dout0_57 vdout0_57ck202 = 0 time = 1015
* CHECK dout0_58 vdout0_58ck202 = 1.1 time = 1015
* CHECK dout0_59 vdout0_59ck202 = 1.1 time = 1015
* CHECK dout0_60 vdout0_60ck202 = 0 time = 1015
* CHECK dout0_61 vdout0_61ck202 = 1.1 time = 1015
* CHECK dout0_62 vdout0_62ck202 = 1.1 time = 1015
* CHECK dout0_63 vdout0_63ck202 = 1.1 time = 1015
* CHECK dout0_0 vdout0_0ck203 = 0 time = 1020
* CHECK dout0_1 vdout0_1ck203 = 0 time = 1020
* CHECK dout0_2 vdout0_2ck203 = 0 time = 1020
* CHECK dout0_3 vdout0_3ck203 = 0 time = 1020
* CHECK dout0_4 vdout0_4ck203 = 1.1 time = 1020
* CHECK dout0_5 vdout0_5ck203 = 1.1 time = 1020
* CHECK dout0_6 vdout0_6ck203 = 1.1 time = 1020
* CHECK dout0_7 vdout0_7ck203 = 0 time = 1020
* CHECK dout0_8 vdout0_8ck203 = 0 time = 1020
* CHECK dout0_9 vdout0_9ck203 = 1.1 time = 1020
* CHECK dout0_10 vdout0_10ck203 = 0 time = 1020
* CHECK dout0_11 vdout0_11ck203 = 1.1 time = 1020
* CHECK dout0_12 vdout0_12ck203 = 1.1 time = 1020
* CHECK dout0_13 vdout0_13ck203 = 0 time = 1020
* CHECK dout0_14 vdout0_14ck203 = 1.1 time = 1020
* CHECK dout0_15 vdout0_15ck203 = 1.1 time = 1020
* CHECK dout0_16 vdout0_16ck203 = 0 time = 1020
* CHECK dout0_17 vdout0_17ck203 = 0 time = 1020
* CHECK dout0_18 vdout0_18ck203 = 0 time = 1020
* CHECK dout0_19 vdout0_19ck203 = 0 time = 1020
* CHECK dout0_20 vdout0_20ck203 = 1.1 time = 1020
* CHECK dout0_21 vdout0_21ck203 = 0 time = 1020
* CHECK dout0_22 vdout0_22ck203 = 0 time = 1020
* CHECK dout0_23 vdout0_23ck203 = 0 time = 1020
* CHECK dout0_24 vdout0_24ck203 = 1.1 time = 1020
* CHECK dout0_25 vdout0_25ck203 = 0 time = 1020
* CHECK dout0_26 vdout0_26ck203 = 0 time = 1020
* CHECK dout0_27 vdout0_27ck203 = 0 time = 1020
* CHECK dout0_28 vdout0_28ck203 = 0 time = 1020
* CHECK dout0_29 vdout0_29ck203 = 0 time = 1020
* CHECK dout0_30 vdout0_30ck203 = 1.1 time = 1020
* CHECK dout0_31 vdout0_31ck203 = 1.1 time = 1020
* CHECK dout0_32 vdout0_32ck203 = 0 time = 1020
* CHECK dout0_33 vdout0_33ck203 = 0 time = 1020
* CHECK dout0_34 vdout0_34ck203 = 0 time = 1020
* CHECK dout0_35 vdout0_35ck203 = 0 time = 1020
* CHECK dout0_36 vdout0_36ck203 = 1.1 time = 1020
* CHECK dout0_37 vdout0_37ck203 = 0 time = 1020
* CHECK dout0_38 vdout0_38ck203 = 1.1 time = 1020
* CHECK dout0_39 vdout0_39ck203 = 1.1 time = 1020
* CHECK dout0_40 vdout0_40ck203 = 0 time = 1020
* CHECK dout0_41 vdout0_41ck203 = 1.1 time = 1020
* CHECK dout0_42 vdout0_42ck203 = 1.1 time = 1020
* CHECK dout0_43 vdout0_43ck203 = 0 time = 1020
* CHECK dout0_44 vdout0_44ck203 = 0 time = 1020
* CHECK dout0_45 vdout0_45ck203 = 0 time = 1020
* CHECK dout0_46 vdout0_46ck203 = 1.1 time = 1020
* CHECK dout0_47 vdout0_47ck203 = 0 time = 1020
* CHECK dout0_48 vdout0_48ck203 = 1.1 time = 1020
* CHECK dout0_49 vdout0_49ck203 = 0 time = 1020
* CHECK dout0_50 vdout0_50ck203 = 0 time = 1020
* CHECK dout0_51 vdout0_51ck203 = 0 time = 1020
* CHECK dout0_52 vdout0_52ck203 = 1.1 time = 1020
* CHECK dout0_53 vdout0_53ck203 = 1.1 time = 1020
* CHECK dout0_54 vdout0_54ck203 = 1.1 time = 1020
* CHECK dout0_55 vdout0_55ck203 = 0 time = 1020
* CHECK dout0_56 vdout0_56ck203 = 0 time = 1020
* CHECK dout0_57 vdout0_57ck203 = 0 time = 1020
* CHECK dout0_58 vdout0_58ck203 = 1.1 time = 1020
* CHECK dout0_59 vdout0_59ck203 = 1.1 time = 1020
* CHECK dout0_60 vdout0_60ck203 = 0 time = 1020
* CHECK dout0_61 vdout0_61ck203 = 1.1 time = 1020
* CHECK dout0_62 vdout0_62ck203 = 1.1 time = 1020
* CHECK dout0_63 vdout0_63ck203 = 1.1 time = 1020
.include /home/kuoping/Projects/jv32/syn/lib/openram/./functional_meas.sp
* probe is used for hspice/xa, while plot is used in ngspice
*.probe V(*)
*.plot V(*)
.end
