* Functional test stimulus file for 5ns period

* TT process corner
.include "/home/kuoping/opt/OpenRAM/technology/freepdk45/models/tran_models/models_nom/PMOS_VTG.inc"
.include "/home/kuoping/opt/OpenRAM/technology/freepdk45/models/tran_models/models_nom/NMOS_VTG.inc"
.include "/tmp/openram_kuoping_4478_temp/sram.sp"

* Global Power Supplies
Vvdd vdd 0 1.1

*Nodes gnd and 0 are the same global ground node in ngspice/hspice/xa. Otherwise, this source may be needed.
*Vgnd gnd 0 0.0

* Instantiation of the SRAM
Xsram_1rw_2048x32 din0_0 din0_1 din0_2 din0_3 din0_4 din0_5 din0_6 din0_7 din0_8 din0_9 din0_10 din0_11 din0_12 din0_13 din0_14 din0_15 din0_16 din0_17 din0_18 din0_19 din0_20 din0_21 din0_22 din0_23 din0_24 din0_25 din0_26 din0_27 din0_28 din0_29 din0_30 din0_31 a0_0 a0_1 a0_2 a0_3 a0_4 a0_5 a0_6 a0_7 a0_8 a0_9 a0_10 CSB0 WEB0 clk0 WMASK0_0 WMASK0_1 WMASK0_2 WMASK0_3 dout0_0 dout0_1 dout0_2 dout0_3 dout0_4 dout0_5 dout0_6 dout0_7 dout0_8 dout0_9 dout0_10 dout0_11 dout0_12 dout0_13 dout0_14 dout0_15 dout0_16 dout0_17 dout0_18 dout0_19 dout0_20 dout0_21 dout0_22 dout0_23 dout0_24 dout0_25 dout0_26 dout0_27 dout0_28 dout0_29 dout0_30 dout0_31 vdd gnd sram_1rw_2048x32

* SRAM output loads
CD00 dout0_0  0 0.8364f
CD01 dout0_1  0 0.8364f
CD02 dout0_2  0 0.8364f
CD03 dout0_3  0 0.8364f
CD04 dout0_4  0 0.8364f
CD05 dout0_5  0 0.8364f
CD06 dout0_6  0 0.8364f
CD07 dout0_7  0 0.8364f
CD08 dout0_8  0 0.8364f
CD09 dout0_9  0 0.8364f
CD010 dout0_10  0 0.8364f
CD011 dout0_11  0 0.8364f
CD012 dout0_12  0 0.8364f
CD013 dout0_13  0 0.8364f
CD014 dout0_14  0 0.8364f
CD015 dout0_15  0 0.8364f
CD016 dout0_16  0 0.8364f
CD017 dout0_17  0 0.8364f
CD018 dout0_18  0 0.8364f
CD019 dout0_19  0 0.8364f
CD020 dout0_20  0 0.8364f
CD021 dout0_21  0 0.8364f
CD022 dout0_22  0 0.8364f
CD023 dout0_23  0 0.8364f
CD024 dout0_24  0 0.8364f
CD025 dout0_25  0 0.8364f
CD026 dout0_26  0 0.8364f
CD027 dout0_27  0 0.8364f
CD028 dout0_28  0 0.8364f
CD029 dout0_29  0 0.8364f
CD030 dout0_30  0 0.8364f
CD031 dout0_31  0 0.8364f

* Important signals for debug
* bl:   xsram:xbank0:bl_0_0
* br:   xsram:xbank0:br_0_0
* s_en: xsram:s_en
* q:    xsram:xbank0:xbitcell_array:xbitcell_array:xbit_r0_c0.Q
* qbar: xsram:xbank0:xbitcell_array:xbitcell_array:xbit_r0_c0.Q_bar

* Sequence of operations
*   Idle during cycle 0 (0ns - 5ns)
*   Writing 01100011010010101111110100010101  to  address 00000000000 (from port 0) during cycle 1 (5ns - 10ns)
*   Writing 10011101100001111001000101111011  to  address 11111111110 (from port 0) during cycle 2 (10ns - 15ns)
*   Writing 11110110101000101100000001001100  to  address 00000000000 (from port 0) during cycle 3 (15ns - 20ns)
*   Reading 10011101100001111001000101111011 from address 11111111110 (from port 0) during cycle 4 (20ns - 25ns)
*   Reading 11110110101000101100000001001100 from address 00000000000 (from port 0) during cycle 5 (25ns - 30ns)
*   Reading 10011101100001111001000101111011 from address 11111111110 (from port 0) during cycle 6 (30ns - 35ns)
*   Writing (partial) 01010110111101100011001010110101  to  address 11111111110 with mask bit 0100 (from port 0) during cycle 7 (35ns - 40ns)
*   Reading 10011101111101101001000101111011 from address 11111111110 (from port 0) during cycle 8 (40ns - 45ns)
*   Writing (partial) 10101101010111110100010111100000  to  address 00000000000 with mask bit 1100 (from port 0) during cycle 9 (45ns - 50ns)
*   Writing (partial) 10000000101001101010000100110010  to  address 11111111110 with mask bit 1000 (from port 0) during cycle 10 (50ns - 55ns)
*   Writing (partial) 01001001000001101000101011101000  to  address 11111111110 with mask bit 0100 (from port 0) during cycle 11 (55ns - 60ns)
*   Reading 10101101010111111100000001001100 from address 00000000000 (from port 0) during cycle 14 (70ns - 75ns)
*   Writing 10111110110110000110011011000000  to  address 00000000001 (from port 0) during cycle 15 (75ns - 80ns)
*   Writing (partial) 10111001010011111010000010000111  to  address 11111111110 with mask bit 0010 (from port 0) during cycle 16 (80ns - 85ns)
*   Reading 10111110110110000110011011000000 from address 00000000001 (from port 0) during cycle 17 (85ns - 90ns)
*   Reading 10111110110110000110011011000000 from address 00000000001 (from port 0) during cycle 18 (90ns - 95ns)
*   Reading 10000000000001101010000001111011 from address 11111111110 (from port 0) during cycle 19 (95ns - 100ns)
*   Reading 10000000000001101010000001111011 from address 11111111110 (from port 0) during cycle 20 (100ns - 105ns)
*   Reading 10000000000001101010000001111011 from address 11111111110 (from port 0) during cycle 22 (110ns - 115ns)
*   Writing (partial) 11101110100001100010010101010010  to  address 00000000000 with mask bit 0100 (from port 0) during cycle 23 (115ns - 120ns)
*   Reading 10101101100001101100000001001100 from address 00000000000 (from port 0) during cycle 24 (120ns - 125ns)
*   Reading 10111110110110000110011011000000 from address 00000000001 (from port 0) during cycle 25 (125ns - 130ns)
*   Writing (partial) 01011000000100000100011011011100  to  address 00000000000 with mask bit 0001 (from port 0) during cycle 27 (135ns - 140ns)
*   Writing (partial) 01010100011010000110101101001001  to  address 00000000000 with mask bit 1000 (from port 0) during cycle 28 (140ns - 145ns)
*   Writing (partial) 11011001010001011001010101011001  to  address 00000000001 with mask bit 1101 (from port 0) during cycle 30 (150ns - 155ns)
*   Reading 11011001010001010110011001011001 from address 00000000001 (from port 0) during cycle 32 (160ns - 165ns)
*   Writing (partial) 00011001110010111111001001111010  to  address 00000000001 with mask bit 0011 (from port 0) during cycle 33 (165ns - 170ns)
*   Reading 10000000000001101010000001111011 from address 11111111110 (from port 0) during cycle 34 (170ns - 175ns)
*   Writing (partial) 11100110100001000110101111000010  to  address 00000000000 with mask bit 1010 (from port 0) during cycle 35 (175ns - 180ns)
*   Writing (partial) 10100111010100010010000110110000  to  address 00000000001 with mask bit 1101 (from port 0) during cycle 36 (180ns - 185ns)
*   Reading 11100110100001100110101111011100 from address 00000000000 (from port 0) during cycle 38 (190ns - 195ns)
*   Writing 01110101011001111000010000010001  to  address 11111111110 (from port 0) during cycle 39 (195ns - 200ns)
*   Reading 10100111010100011111001010110000 from address 00000000001 (from port 0) during cycle 40 (200ns - 205ns)
*   Reading 10100111010100011111001010110000 from address 00000000001 (from port 0) during cycle 41 (205ns - 210ns)
*   Writing (partial) 11011100101101010001000010011110  to  address 11111111110 with mask bit 0111 (from port 0) during cycle 42 (210ns - 215ns)
*   Writing (partial) 01001110000011100000111111101011  to  address 00000000000 with mask bit 0111 (from port 0) during cycle 43 (215ns - 220ns)
*   Reading 01110101101101010001000010011110 from address 11111111110 (from port 0) during cycle 45 (225ns - 230ns)
*   Writing (partial) 00011111111101101011111100111000  to  address 00000000001 with mask bit 1001 (from port 0) during cycle 46 (230ns - 235ns)
*   Reading 01110101101101010001000010011110 from address 11111111110 (from port 0) during cycle 47 (235ns - 240ns)
*   Reading 01110101101101010001000010011110 from address 11111111110 (from port 0) during cycle 48 (240ns - 245ns)
*   Reading 01110101101101010001000010011110 from address 11111111110 (from port 0) during cycle 50 (250ns - 255ns)
*   Reading 00011111010100011111001000111000 from address 00000000001 (from port 0) during cycle 51 (255ns - 260ns)
*   Writing 00101100110011001111100111000011  to  address 11111111110 (from port 0) during cycle 52 (260ns - 265ns)
*   Writing (partial) 00011111001011110011000110101011  to  address 11111111110 with mask bit 1100 (from port 0) during cycle 54 (270ns - 275ns)
*   Reading 00011111010100011111001000111000 from address 00000000001 (from port 0) during cycle 56 (280ns - 285ns)
*   Reading 00011111001011111111100111000011 from address 11111111110 (from port 0) during cycle 57 (285ns - 290ns)
*   Reading 11100110000011100000111111101011 from address 00000000000 (from port 0) during cycle 58 (290ns - 295ns)
*   Writing 10101111101100000100010101100010  to  address 11111111101 (from port 0) during cycle 59 (295ns - 300ns)
*   Reading 00011111001011111111100111000011 from address 11111111110 (from port 0) during cycle 60 (300ns - 305ns)
*   Reading 11100110000011100000111111101011 from address 00000000000 (from port 0) during cycle 61 (305ns - 310ns)
*   Reading 00011111010100011111001000111000 from address 00000000001 (from port 0) during cycle 62 (310ns - 315ns)
*   Writing (partial) 01000110001100001101100111000111  to  address 11111111101 with mask bit 0101 (from port 0) during cycle 63 (315ns - 320ns)
*   Writing 00100101011001011010000111010101  to  address 11111111101 (from port 0) during cycle 64 (320ns - 325ns)
*   Writing (partial) 11001001000111000111000010100110  to  address 11111111101 with mask bit 0010 (from port 0) during cycle 65 (325ns - 330ns)
*   Reading 11100110000011100000111111101011 from address 00000000000 (from port 0) during cycle 68 (340ns - 345ns)
*   Writing (partial) 01010000010110001111100111100001  to  address 11111111110 with mask bit 0010 (from port 0) during cycle 70 (350ns - 355ns)
*   Reading 00011111001011111111100111000011 from address 11111111110 (from port 0) during cycle 71 (355ns - 360ns)
*   Writing (partial) 00001010001011111001000000101110  to  address 00000000000 with mask bit 1101 (from port 0) during cycle 72 (360ns - 365ns)
*   Writing (partial) 00101111010011000001101110001100  to  address 00000000000 with mask bit 1010 (from port 0) during cycle 73 (365ns - 370ns)
*   Writing 10000110011101101111001000000101  to  address 00000000000 (from port 0) during cycle 74 (370ns - 375ns)
*   Writing (partial) 11101101001001100100110110000001  to  address 00000000000 with mask bit 1010 (from port 0) during cycle 76 (380ns - 385ns)
*   Reading 00011111010100011111001000111000 from address 00000000001 (from port 0) during cycle 77 (385ns - 390ns)
*   Reading 11101101011101100100110100000101 from address 00000000000 (from port 0) during cycle 78 (390ns - 395ns)
*   Reading 00011111001011111111100111000011 from address 11111111110 (from port 0) during cycle 79 (395ns - 400ns)
*   Writing 10011100101111011110000001101101  to  address 00000000001 (from port 0) during cycle 80 (400ns - 405ns)
*   Writing (partial) 00111111110111010101001001101100  to  address 11111111110 with mask bit 0100 (from port 0) during cycle 82 (410ns - 415ns)
*   Reading 11101101011101100100110100000101 from address 00000000000 (from port 0) during cycle 83 (415ns - 420ns)
*   Reading 00100101011001010111000011010101 from address 11111111101 (from port 0) during cycle 84 (420ns - 425ns)
*   Reading 11101101011101100100110100000101 from address 00000000000 (from port 0) during cycle 85 (425ns - 430ns)
*   Reading 00011111110111011111100111000011 from address 11111111110 (from port 0) during cycle 86 (430ns - 435ns)
*   Writing (partial) 01110010100011000001000000110111  to  address 11111111101 with mask bit 1101 (from port 0) during cycle 87 (435ns - 440ns)
*   Writing (partial) 10010011110110110101100000111001  to  address 00000000001 with mask bit 0100 (from port 0) during cycle 88 (440ns - 445ns)
*   Reading 10011100110110111110000001101101 from address 00000000001 (from port 0) during cycle 90 (450ns - 455ns)
*   Writing 10101101101100010011100000011101  to  address 11111111101 (from port 0) during cycle 91 (455ns - 460ns)
*   Writing (partial) 00111110000011011000101110011100  to  address 11111111110 with mask bit 0001 (from port 0) during cycle 92 (460ns - 465ns)
*   Reading 00011111110111011111100110011100 from address 11111111110 (from port 0) during cycle 93 (465ns - 470ns)
*   Writing (partial) 11000111001100100000000100101000  to  address 11111111110 with mask bit 1110 (from port 0) during cycle 95 (475ns - 480ns)
*   Reading 11000111001100100000000110011100 from address 11111111110 (from port 0) during cycle 96 (480ns - 485ns)
*   Writing (partial) 10101000000110000101110000100101  to  address 11111111101 with mask bit 1100 (from port 0) during cycle 97 (485ns - 490ns)
*   Writing (partial) 00100011000011011001110100010111  to  address 00000000001 with mask bit 1110 (from port 0) during cycle 99 (495ns - 500ns)
*   Reading 00100011000011011001110101101101 from address 00000000001 (from port 0) during cycle 100 (500ns - 505ns)
*   Writing (partial) 01101001110000100001101111011010  to  address 00000000000 with mask bit 1110 (from port 0) during cycle 101 (505ns - 510ns)
*   Writing 10000111100111000010101100111011  to  address 00000000000 (from port 0) during cycle 103 (515ns - 520ns)
*   Reading 00100011000011011001110101101101 from address 00000000001 (from port 0) during cycle 105 (525ns - 530ns)
*   Reading 10101000000110000011100000011101 from address 11111111101 (from port 0) during cycle 106 (530ns - 535ns)
*   Reading 00100011000011011001110101101101 from address 00000000001 (from port 0) during cycle 107 (535ns - 540ns)
*   Writing 11000000111110000011011001000000  to  address 11111111110 (from port 0) during cycle 108 (540ns - 545ns)
*   Writing 11000100010100011011100110100010  to  address 00000000001 (from port 0) during cycle 109 (545ns - 550ns)
*   Writing (partial) 11001100001111010111110011010100  to  address 11111111110 with mask bit 0111 (from port 0) during cycle 110 (550ns - 555ns)
*   Writing (partial) 00100111101011000100100100101100  to  address 11111111101 with mask bit 0101 (from port 0) during cycle 111 (555ns - 560ns)
*   Reading 11000100010100011011100110100010 from address 00000000001 (from port 0) during cycle 112 (560ns - 565ns)
*   Reading 11000000001111010111110011010100 from address 11111111110 (from port 0) during cycle 113 (565ns - 570ns)
*   Reading 10000111100111000010101100111011 from address 00000000000 (from port 0) during cycle 114 (570ns - 575ns)
*   Writing 01001000101011101110101101101110  to  address 11111111110 (from port 0) during cycle 116 (580ns - 585ns)
*   Writing 11110101111011111110110111100001  to  address 11111111110 (from port 0) during cycle 117 (585ns - 590ns)
*   Reading 10000111100111000010101100111011 from address 00000000000 (from port 0) during cycle 118 (590ns - 595ns)
*   Writing 01111000001110100101000110101000  to  address 00000000000 (from port 0) during cycle 119 (595ns - 600ns)
*   Reading 11110101111011111110110111100001 from address 11111111110 (from port 0) during cycle 120 (600ns - 605ns)
*   Writing 11011010011100001010000001010101  to  address 00000000000 (from port 0) during cycle 121 (605ns - 610ns)
*   Writing (partial) 01101101100111100100100110010011  to  address 11111111101 with mask bit 0011 (from port 0) during cycle 124 (620ns - 625ns)
*   Reading 11011010011100001010000001010101 from address 00000000000 (from port 0) during cycle 125 (625ns - 630ns)
*   Writing 01010110001101100101110101010110  to  address 00000000000 (from port 0) during cycle 126 (630ns - 635ns)
*   Writing 01001100011001111000101101001010  to  address 11111111101 (from port 0) during cycle 127 (635ns - 640ns)
*   Writing (partial) 00111001110001001100110011101000  to  address 11111111101 with mask bit 0010 (from port 0) during cycle 128 (640ns - 645ns)
*   Writing (partial) 10101010100110000010011010000000  to  address 00000000001 with mask bit 0101 (from port 0) during cycle 130 (650ns - 655ns)
*   Reading 01010110001101100101110101010110 from address 00000000000 (from port 0) during cycle 131 (655ns - 660ns)
*   Reading 01001100011001111100110001001010 from address 11111111101 (from port 0) during cycle 132 (660ns - 665ns)
*   Reading 01010110001101100101110101010110 from address 00000000000 (from port 0) during cycle 134 (670ns - 675ns)
*   Reading 01001100011001111100110001001010 from address 11111111101 (from port 0) during cycle 135 (675ns - 680ns)
*   Reading 11000100100110001011100110000000 from address 00000000001 (from port 0) during cycle 138 (690ns - 695ns)
*   Reading 01010110001101100101110101010110 from address 00000000000 (from port 0) during cycle 139 (695ns - 700ns)
*   Writing 00010110011100001000010101111010  to  address 00000000000 (from port 0) during cycle 140 (700ns - 705ns)
*   Writing (partial) 00010111111001110111011111110110  to  address 11111111101 with mask bit 1101 (from port 0) during cycle 141 (705ns - 710ns)
*   Reading 00010110011100001000010101111010 from address 00000000000 (from port 0) during cycle 142 (710ns - 715ns)
*   Reading 00010111111001111100110011110110 from address 11111111101 (from port 0) during cycle 143 (715ns - 720ns)
*   Writing 10111011001111110110100001011111  to  address 00000000000 (from port 0) during cycle 144 (720ns - 725ns)
*   Reading 11110101111011111110110111100001 from address 11111111110 (from port 0) during cycle 145 (725ns - 730ns)
*   Writing (partial) 01100011100101011110100100100101  to  address 00000000001 with mask bit 0101 (from port 0) during cycle 146 (730ns - 735ns)
*   Reading 00010111111001111100110011110110 from address 11111111101 (from port 0) during cycle 147 (735ns - 740ns)
*   Reading 10111011001111110110100001011111 from address 00000000000 (from port 0) during cycle 148 (740ns - 745ns)
*   Reading 10111011001111110110100001011111 from address 00000000000 (from port 0) during cycle 149 (745ns - 750ns)
*   Reading 11110101111011111110110111100001 from address 11111111110 (from port 0) during cycle 150 (750ns - 755ns)
*   Writing 01100110100010010100000000000000  to  address 11111111101 (from port 0) during cycle 151 (755ns - 760ns)
*   Reading 11110101111011111110110111100001 from address 11111111110 (from port 0) during cycle 152 (760ns - 765ns)
*   Writing (partial) 00110101000010010000111010110001  to  address 00000000001 with mask bit 0001 (from port 0) during cycle 153 (765ns - 770ns)
*   Reading 11000100100101011011100110110001 from address 00000000001 (from port 0) during cycle 154 (770ns - 775ns)
*   Reading 11000100100101011011100110110001 from address 00000000001 (from port 0) during cycle 155 (775ns - 780ns)
*   Writing 00101110100110100010001100100001  to  address 11111111101 (from port 0) during cycle 157 (785ns - 790ns)
*   Reading 10111011001111110110100001011111 from address 00000000000 (from port 0) during cycle 158 (790ns - 795ns)
*   Reading 10111011001111110110100001011111 from address 00000000000 (from port 0) during cycle 160 (800ns - 805ns)
*   Writing (partial) 01001001010111000000010100011011  to  address 11111111101 with mask bit 0010 (from port 0) during cycle 161 (805ns - 810ns)
*   Reading 10111011001111110110100001011111 from address 00000000000 (from port 0) during cycle 162 (810ns - 815ns)
*   Writing (partial) 10001010011110010110111111111111  to  address 11111111110 with mask bit 1110 (from port 0) during cycle 163 (815ns - 820ns)
*   Reading 11000100100101011011100110110001 from address 00000000001 (from port 0) during cycle 164 (820ns - 825ns)
*   Writing 01101010010100111001000101001100  to  address 00000000001 (from port 0) during cycle 165 (825ns - 830ns)
*   Writing (partial) 11110001001101111011010100010000  to  address 11111111101 with mask bit 0110 (from port 0) during cycle 166 (830ns - 835ns)
*   Writing 10001000101000110101000001100010  to  address 00000000001 (from port 0) during cycle 167 (835ns - 840ns)
*   Reading 00101110001101111011010100100001 from address 11111111101 (from port 0) during cycle 168 (840ns - 845ns)
*   Reading 10001010011110010110111111100001 from address 11111111110 (from port 0) during cycle 169 (845ns - 850ns)
*   Reading 00101110001101111011010100100001 from address 11111111101 (from port 0) during cycle 171 (855ns - 860ns)
*   Writing 11011111110011101010111100111100  to  address 00000000000 (from port 0) during cycle 172 (860ns - 865ns)
*   Writing (partial) 00001000001010111110011011000101  to  address 11111111110 with mask bit 0101 (from port 0) during cycle 173 (865ns - 870ns)
*   Writing (partial) 11111010000011011000000110000101  to  address 11111111101 with mask bit 0010 (from port 0) during cycle 174 (870ns - 875ns)
*   Reading 10001000101000110101000001100010 from address 00000000001 (from port 0) during cycle 175 (875ns - 880ns)
*   Reading 11011111110011101010111100111100 from address 00000000000 (from port 0) during cycle 176 (880ns - 885ns)
*   Reading 00101110001101111000000100100001 from address 11111111101 (from port 0) during cycle 177 (885ns - 890ns)
*   Reading 10001010001010110110111111000101 from address 11111111110 (from port 0) during cycle 178 (890ns - 895ns)
*   Reading 00101110001101111000000100100001 from address 11111111101 (from port 0) during cycle 179 (895ns - 900ns)
*   Reading 10001010001010110110111111000101 from address 11111111110 (from port 0) during cycle 180 (900ns - 905ns)
*   Writing 11011100100100110111000010100110  to  address 00000000001 (from port 0) during cycle 181 (905ns - 910ns)
*   Reading 11011100100100110111000010100110 from address 00000000001 (from port 0) during cycle 183 (915ns - 920ns)
*   Writing 11010001100010010000001111100010  to  address 11111111110 (from port 0) during cycle 186 (930ns - 935ns)
*   Writing (partial) 00000100001101001111110100010101  to  address 00000000001 with mask bit 1100 (from port 0) during cycle 187 (935ns - 940ns)
*   Writing (partial) 00010101110101100010110110101110  to  address 00000000001 with mask bit 1000 (from port 0) during cycle 189 (945ns - 950ns)
*   Writing 01100101010111100010101001000111  to  address 00000000000 (from port 0) during cycle 190 (950ns - 955ns)
*   Reading 11010001100010010000001111100010 from address 11111111110 (from port 0) during cycle 192 (960ns - 965ns)
*   Reading 00101110001101111000000100100001 from address 11111111101 (from port 0) during cycle 193 (965ns - 970ns)
*   Reading 00101110001101111000000100100001 from address 11111111101 (from port 0) during cycle 194 (970ns - 975ns)
*   Reading 00010101001101000111000010100110 from address 00000000001 (from port 0) during cycle 196 (980ns - 985ns)
*   Writing 01011111000101111010000010100101  to  address 00000000001 (from port 0) during cycle 197 (985ns - 990ns)
*   Writing (partial) 10100111011011110000001101101111  to  address 11111111110 with mask bit 0001 (from port 0) during cycle 198 (990ns - 995ns)
*   Reading 01100101010111100010101001000111 from address 00000000000 (from port 0) during cycle 199 (995ns - 1000ns)
*   Writing (partial) 10111111011000011101011010001010  to  address 11111111110 with mask bit 1100 (from port 0) during cycle 200 (1000ns - 1005ns)
*   Reading 01100101010111100010101001000111 from address 00000000000 (from port 0) during cycle 201 (1005ns - 1010ns)
*   Writing (partial) 10001100000100011010100110110100  to  address 00000000001 with mask bit 0101 (from port 0) during cycle 202 (1010ns - 1015ns)
*   Reading 01011111000100011010000010110100 from address 00000000001 (from port 0) during cycle 203 (1015ns - 1020ns)
*   Reading 00101110001101111000000100100001 from address 11111111101 (from port 0) during cycle 204 (1020ns - 1025ns)
*   Idle during cycle 205 (1025ns - 1030ns)

* Generation of data and address signals
* (time, data): [(0, 0), (5, 1), (10, 1), (15, 0), (20, 0), (25, 0), (30, 0), (35, 1), (40, 1), (45, 0), (50, 0), (55, 0), (60, 0), (65, 0), (70, 0), (75, 0), (80, 1), (85, 1), (90, 1), (95, 1), (100, 1), (105, 1), (110, 1), (115, 0), (120, 0), (125, 0), (130, 0), (135, 0), (140, 1), (145, 1), (150, 1), (155, 1), (160, 1), (165, 0), (170, 0), (175, 0), (180, 0), (185, 0), (190, 0), (195, 1), (200, 1), (205, 1), (210, 0), (215, 1), (220, 1), (225, 1), (230, 0), (235, 0), (240, 0), (245, 0), (250, 0), (255, 0), (260, 1), (265, 1), (270, 1), (275, 1), (280, 1), (285, 1), (290, 1), (295, 0), (300, 0), (305, 0), (310, 0), (315, 1), (320, 1), (325, 0), (330, 0), (335, 0), (340, 0), (345, 0), (350, 1), (355, 1), (360, 0), (365, 0), (370, 1), (375, 1), (380, 1), (385, 1), (390, 1), (395, 1), (400, 1), (405, 1), (410, 0), (415, 0), (420, 0), (425, 0), (430, 0), (435, 1), (440, 1), (445, 1), (450, 1), (455, 1), (460, 0), (465, 0), (470, 0), (475, 0), (480, 0), (485, 1), (490, 1), (495, 1), (500, 1), (505, 0), (510, 0), (515, 1), (520, 1), (525, 1), (530, 1), (535, 1), (540, 0), (545, 0), (550, 0), (555, 0), (560, 0), (565, 0), (570, 0), (575, 0), (580, 0), (585, 1), (590, 1), (595, 0), (600, 0), (605, 1), (610, 1), (615, 1), (620, 1), (625, 1), (630, 0), (635, 0), (640, 0), (645, 0), (650, 0), (655, 0), (660, 0), (665, 0), (670, 0), (675, 0), (680, 0), (685, 0), (690, 0), (695, 0), (700, 0), (705, 0), (710, 0), (715, 0), (720, 1), (725, 1), (730, 1), (735, 1), (740, 1), (745, 1), (750, 1), (755, 0), (760, 0), (765, 1), (770, 1), (775, 1), (780, 1), (785, 1), (790, 1), (795, 1), (800, 1), (805, 1), (810, 1), (815, 1), (820, 1), (825, 0), (830, 0), (835, 0), (840, 0), (845, 0), (850, 0), (855, 0), (860, 0), (865, 1), (870, 1), (875, 1), (880, 1), (885, 1), (890, 1), (895, 1), (900, 1), (905, 0), (910, 0), (915, 0), (920, 0), (925, 0), (930, 0), (935, 1), (940, 1), (945, 0), (950, 1), (955, 1), (960, 1), (965, 1), (970, 1), (975, 1), (980, 1), (985, 1), (990, 1), (995, 1), (1000, 0), (1005, 0), (1010, 0), (1015, 0), (1020, 0), (1025, 0)]
Vdin0_0  din0_0  0 PWL (0n 0.0v 4.745n 0.0v 4.755n 1.1v 9.745n 1.1v 9.755n 1.1v 14.745n 1.1v 14.755n 0.0v 19.745n 0.0v 19.755n 0.0v 24.745n 0.0v 24.755n 0.0v 29.745n 0.0v 29.755n 0.0v 34.745n 0.0v 34.755n 1.1v 39.745n 1.1v 39.755n 1.1v 44.745n 1.1v 44.755n 0.0v 49.745n 0.0v 49.755n 0.0v 54.745n 0.0v 54.755n 0.0v 59.745n 0.0v 59.755n 0.0v 64.745n 0.0v 64.755n 0.0v 69.745n 0.0v 69.755n 0.0v 74.745n 0.0v 74.755n 0.0v 79.745n 0.0v 79.755n 1.1v 84.745n 1.1v 84.755n 1.1v 89.745n 1.1v 89.755n 1.1v 94.745n 1.1v 94.755n 1.1v 99.745n 1.1v 99.755n 1.1v 104.745n 1.1v 104.755n 1.1v 109.745n 1.1v 109.755n 1.1v 114.745n 1.1v 114.755n 0.0v 119.745n 0.0v 119.755n 0.0v 124.745n 0.0v 124.755n 0.0v 129.745n 0.0v 129.755n 0.0v 134.745n 0.0v 134.755n 0.0v 139.745n 0.0v 139.755n 1.1v 144.745n 1.1v 144.755n 1.1v 149.745n 1.1v 149.755n 1.1v 154.745n 1.1v 154.755n 1.1v 159.745n 1.1v 159.755n 1.1v 164.745n 1.1v 164.755n 0.0v 169.745n 0.0v 169.755n 0.0v 174.745n 0.0v 174.755n 0.0v 179.745n 0.0v 179.755n 0.0v 184.745n 0.0v 184.755n 0.0v 189.745n 0.0v 189.755n 0.0v 194.745n 0.0v 194.755n 1.1v 199.745n 1.1v 199.755n 1.1v 204.745n 1.1v 204.755n 1.1v 209.745n 1.1v 209.755n 0.0v 214.745n 0.0v 214.755n 1.1v 219.745n 1.1v 219.755n 1.1v 224.745n 1.1v 224.755n 1.1v 229.745n 1.1v 229.755n 0.0v 234.745n 0.0v 234.755n 0.0v 239.745n 0.0v 239.755n 0.0v 244.745n 0.0v 244.755n 0.0v 249.745n 0.0v 249.755n 0.0v 254.745n 0.0v 254.755n 0.0v 259.745n 0.0v 259.755n 1.1v 264.745n 1.1v 264.755n 1.1v 269.745n 1.1v 269.755n 1.1v 274.745n 1.1v 274.755n 1.1v 279.745n 1.1v 279.755n 1.1v 284.745n 1.1v 284.755n 1.1v 289.745n 1.1v 289.755n 1.1v 294.745n 1.1v 294.755n 0.0v 299.745n 0.0v 299.755n 0.0v 304.745n 0.0v 304.755n 0.0v 309.745n 0.0v 309.755n 0.0v 314.745n 0.0v 314.755n 1.1v 319.745n 1.1v 319.755n 1.1v 324.745n 1.1v 324.755n 0.0v 329.745n 0.0v 329.755n 0.0v 334.745n 0.0v 334.755n 0.0v 339.745n 0.0v 339.755n 0.0v 344.745n 0.0v 344.755n 0.0v 349.745n 0.0v 349.755n 1.1v 354.745n 1.1v 354.755n 1.1v 359.745n 1.1v 359.755n 0.0v 364.745n 0.0v 364.755n 0.0v 369.745n 0.0v 369.755n 1.1v 374.745n 1.1v 374.755n 1.1v 379.745n 1.1v 379.755n 1.1v 384.745n 1.1v 384.755n 1.1v 389.745n 1.1v 389.755n 1.1v 394.745n 1.1v 394.755n 1.1v 399.745n 1.1v 399.755n 1.1v 404.745n 1.1v 404.755n 1.1v 409.745n 1.1v 409.755n 0.0v 414.745n 0.0v 414.755n 0.0v 419.745n 0.0v 419.755n 0.0v 424.745n 0.0v 424.755n 0.0v 429.745n 0.0v 429.755n 0.0v 434.745n 0.0v 434.755n 1.1v 439.745n 1.1v 439.755n 1.1v 444.745n 1.1v 444.755n 1.1v 449.745n 1.1v 449.755n 1.1v 454.745n 1.1v 454.755n 1.1v 459.745n 1.1v 459.755n 0.0v 464.745n 0.0v 464.755n 0.0v 469.745n 0.0v 469.755n 0.0v 474.745n 0.0v 474.755n 0.0v 479.745n 0.0v 479.755n 0.0v 484.745n 0.0v 484.755n 1.1v 489.745n 1.1v 489.755n 1.1v 494.745n 1.1v 494.755n 1.1v 499.745n 1.1v 499.755n 1.1v 504.745n 1.1v 504.755n 0.0v 509.745n 0.0v 509.755n 0.0v 514.745n 0.0v 514.755n 1.1v 519.745n 1.1v 519.755n 1.1v 524.745n 1.1v 524.755n 1.1v 529.745n 1.1v 529.755n 1.1v 534.745n 1.1v 534.755n 1.1v 539.745n 1.1v 539.755n 0.0v 544.745n 0.0v 544.755n 0.0v 549.745n 0.0v 549.755n 0.0v 554.745n 0.0v 554.755n 0.0v 559.745n 0.0v 559.755n 0.0v 564.745n 0.0v 564.755n 0.0v 569.745n 0.0v 569.755n 0.0v 574.745n 0.0v 574.755n 0.0v 579.745n 0.0v 579.755n 0.0v 584.745n 0.0v 584.755n 1.1v 589.745n 1.1v 589.755n 1.1v 594.745n 1.1v 594.755n 0.0v 599.745n 0.0v 599.755n 0.0v 604.745n 0.0v 604.755n 1.1v 609.745n 1.1v 609.755n 1.1v 614.745n 1.1v 614.755n 1.1v 619.745n 1.1v 619.755n 1.1v 624.745n 1.1v 624.755n 1.1v 629.745n 1.1v 629.755n 0.0v 634.745n 0.0v 634.755n 0.0v 639.745n 0.0v 639.755n 0.0v 644.745n 0.0v 644.755n 0.0v 649.745n 0.0v 649.755n 0.0v 654.745n 0.0v 654.755n 0.0v 659.745n 0.0v 659.755n 0.0v 664.745n 0.0v 664.755n 0.0v 669.745n 0.0v 669.755n 0.0v 674.745n 0.0v 674.755n 0.0v 679.745n 0.0v 679.755n 0.0v 684.745n 0.0v 684.755n 0.0v 689.745n 0.0v 689.755n 0.0v 694.745n 0.0v 694.755n 0.0v 699.745n 0.0v 699.755n 0.0v 704.745n 0.0v 704.755n 0.0v 709.745n 0.0v 709.755n 0.0v 714.745n 0.0v 714.755n 0.0v 719.745n 0.0v 719.755n 1.1v 724.745n 1.1v 724.755n 1.1v 729.745n 1.1v 729.755n 1.1v 734.745n 1.1v 734.755n 1.1v 739.745n 1.1v 739.755n 1.1v 744.745n 1.1v 744.755n 1.1v 749.745n 1.1v 749.755n 1.1v 754.745n 1.1v 754.755n 0.0v 759.745n 0.0v 759.755n 0.0v 764.745n 0.0v 764.755n 1.1v 769.745n 1.1v 769.755n 1.1v 774.745n 1.1v 774.755n 1.1v 779.745n 1.1v 779.755n 1.1v 784.745n 1.1v 784.755n 1.1v 789.745n 1.1v 789.755n 1.1v 794.745n 1.1v 794.755n 1.1v 799.745n 1.1v 799.755n 1.1v 804.745n 1.1v 804.755n 1.1v 809.745n 1.1v 809.755n 1.1v 814.745n 1.1v 814.755n 1.1v 819.745n 1.1v 819.755n 1.1v 824.745n 1.1v 824.755n 0.0v 829.745n 0.0v 829.755n 0.0v 834.745n 0.0v 834.755n 0.0v 839.745n 0.0v 839.755n 0.0v 844.745n 0.0v 844.755n 0.0v 849.745n 0.0v 849.755n 0.0v 854.745n 0.0v 854.755n 0.0v 859.745n 0.0v 859.755n 0.0v 864.745n 0.0v 864.755n 1.1v 869.745n 1.1v 869.755n 1.1v 874.745n 1.1v 874.755n 1.1v 879.745n 1.1v 879.755n 1.1v 884.745n 1.1v 884.755n 1.1v 889.745n 1.1v 889.755n 1.1v 894.745n 1.1v 894.755n 1.1v 899.745n 1.1v 899.755n 1.1v 904.745n 1.1v 904.755n 0.0v 909.745n 0.0v 909.755n 0.0v 914.745n 0.0v 914.755n 0.0v 919.745n 0.0v 919.755n 0.0v 924.745n 0.0v 924.755n 0.0v 929.745n 0.0v 929.755n 0.0v 934.745n 0.0v 934.755n 1.1v 939.745n 1.1v 939.755n 1.1v 944.745n 1.1v 944.755n 0.0v 949.745n 0.0v 949.755n 1.1v 954.745n 1.1v 954.755n 1.1v 959.745n 1.1v 959.755n 1.1v 964.745n 1.1v 964.755n 1.1v 969.745n 1.1v 969.755n 1.1v 974.745n 1.1v 974.755n 1.1v 979.745n 1.1v 979.755n 1.1v 984.745n 1.1v 984.755n 1.1v 989.745n 1.1v 989.755n 1.1v 994.745n 1.1v 994.755n 1.1v 999.745n 1.1v 999.755n 0.0v 1004.745n 0.0v 1004.755n 0.0v 1009.745n 0.0v 1009.755n 0.0v 1014.745n 0.0v 1014.755n 0.0v 1019.745n 0.0v 1019.755n 0.0v 1024.745n 0.0v 1024.755n 0.0v )
* (time, data): [(0, 0), (5, 0), (10, 1), (15, 0), (20, 0), (25, 0), (30, 0), (35, 0), (40, 0), (45, 0), (50, 1), (55, 0), (60, 0), (65, 0), (70, 0), (75, 0), (80, 1), (85, 1), (90, 1), (95, 1), (100, 1), (105, 1), (110, 1), (115, 1), (120, 1), (125, 1), (130, 1), (135, 0), (140, 0), (145, 0), (150, 0), (155, 0), (160, 0), (165, 1), (170, 1), (175, 1), (180, 0), (185, 0), (190, 0), (195, 0), (200, 0), (205, 0), (210, 1), (215, 1), (220, 1), (225, 1), (230, 0), (235, 0), (240, 0), (245, 0), (250, 0), (255, 0), (260, 1), (265, 1), (270, 1), (275, 1), (280, 1), (285, 1), (290, 1), (295, 1), (300, 1), (305, 1), (310, 1), (315, 1), (320, 0), (325, 1), (330, 1), (335, 1), (340, 1), (345, 1), (350, 0), (355, 0), (360, 1), (365, 0), (370, 0), (375, 0), (380, 0), (385, 0), (390, 0), (395, 0), (400, 0), (405, 0), (410, 0), (415, 0), (420, 0), (425, 0), (430, 0), (435, 1), (440, 0), (445, 0), (450, 0), (455, 0), (460, 0), (465, 0), (470, 0), (475, 0), (480, 0), (485, 0), (490, 0), (495, 1), (500, 1), (505, 1), (510, 1), (515, 1), (520, 1), (525, 1), (530, 1), (535, 1), (540, 0), (545, 1), (550, 0), (555, 0), (560, 0), (565, 0), (570, 0), (575, 0), (580, 1), (585, 0), (590, 0), (595, 0), (600, 0), (605, 0), (610, 0), (615, 0), (620, 1), (625, 1), (630, 1), (635, 1), (640, 0), (645, 0), (650, 0), (655, 0), (660, 0), (665, 0), (670, 0), (675, 0), (680, 0), (685, 0), (690, 0), (695, 0), (700, 1), (705, 1), (710, 1), (715, 1), (720, 1), (725, 1), (730, 0), (735, 0), (740, 0), (745, 0), (750, 0), (755, 0), (760, 0), (765, 0), (770, 0), (775, 0), (780, 0), (785, 0), (790, 0), (795, 0), (800, 0), (805, 1), (810, 1), (815, 1), (820, 1), (825, 0), (830, 0), (835, 1), (840, 1), (845, 1), (850, 1), (855, 1), (860, 0), (865, 0), (870, 0), (875, 0), (880, 0), (885, 0), (890, 0), (895, 0), (900, 0), (905, 1), (910, 1), (915, 1), (920, 1), (925, 1), (930, 1), (935, 0), (940, 0), (945, 1), (950, 1), (955, 1), (960, 1), (965, 1), (970, 1), (975, 1), (980, 1), (985, 0), (990, 1), (995, 1), (1000, 1), (1005, 1), (1010, 0), (1015, 0), (1020, 0), (1025, 0)]
Vdin0_1  din0_1  0 PWL (0n 0.0v 4.745n 0.0v 4.755n 0.0v 9.745n 0.0v 9.755n 1.1v 14.745n 1.1v 14.755n 0.0v 19.745n 0.0v 19.755n 0.0v 24.745n 0.0v 24.755n 0.0v 29.745n 0.0v 29.755n 0.0v 34.745n 0.0v 34.755n 0.0v 39.745n 0.0v 39.755n 0.0v 44.745n 0.0v 44.755n 0.0v 49.745n 0.0v 49.755n 1.1v 54.745n 1.1v 54.755n 0.0v 59.745n 0.0v 59.755n 0.0v 64.745n 0.0v 64.755n 0.0v 69.745n 0.0v 69.755n 0.0v 74.745n 0.0v 74.755n 0.0v 79.745n 0.0v 79.755n 1.1v 84.745n 1.1v 84.755n 1.1v 89.745n 1.1v 89.755n 1.1v 94.745n 1.1v 94.755n 1.1v 99.745n 1.1v 99.755n 1.1v 104.745n 1.1v 104.755n 1.1v 109.745n 1.1v 109.755n 1.1v 114.745n 1.1v 114.755n 1.1v 119.745n 1.1v 119.755n 1.1v 124.745n 1.1v 124.755n 1.1v 129.745n 1.1v 129.755n 1.1v 134.745n 1.1v 134.755n 0.0v 139.745n 0.0v 139.755n 0.0v 144.745n 0.0v 144.755n 0.0v 149.745n 0.0v 149.755n 0.0v 154.745n 0.0v 154.755n 0.0v 159.745n 0.0v 159.755n 0.0v 164.745n 0.0v 164.755n 1.1v 169.745n 1.1v 169.755n 1.1v 174.745n 1.1v 174.755n 1.1v 179.745n 1.1v 179.755n 0.0v 184.745n 0.0v 184.755n 0.0v 189.745n 0.0v 189.755n 0.0v 194.745n 0.0v 194.755n 0.0v 199.745n 0.0v 199.755n 0.0v 204.745n 0.0v 204.755n 0.0v 209.745n 0.0v 209.755n 1.1v 214.745n 1.1v 214.755n 1.1v 219.745n 1.1v 219.755n 1.1v 224.745n 1.1v 224.755n 1.1v 229.745n 1.1v 229.755n 0.0v 234.745n 0.0v 234.755n 0.0v 239.745n 0.0v 239.755n 0.0v 244.745n 0.0v 244.755n 0.0v 249.745n 0.0v 249.755n 0.0v 254.745n 0.0v 254.755n 0.0v 259.745n 0.0v 259.755n 1.1v 264.745n 1.1v 264.755n 1.1v 269.745n 1.1v 269.755n 1.1v 274.745n 1.1v 274.755n 1.1v 279.745n 1.1v 279.755n 1.1v 284.745n 1.1v 284.755n 1.1v 289.745n 1.1v 289.755n 1.1v 294.745n 1.1v 294.755n 1.1v 299.745n 1.1v 299.755n 1.1v 304.745n 1.1v 304.755n 1.1v 309.745n 1.1v 309.755n 1.1v 314.745n 1.1v 314.755n 1.1v 319.745n 1.1v 319.755n 0.0v 324.745n 0.0v 324.755n 1.1v 329.745n 1.1v 329.755n 1.1v 334.745n 1.1v 334.755n 1.1v 339.745n 1.1v 339.755n 1.1v 344.745n 1.1v 344.755n 1.1v 349.745n 1.1v 349.755n 0.0v 354.745n 0.0v 354.755n 0.0v 359.745n 0.0v 359.755n 1.1v 364.745n 1.1v 364.755n 0.0v 369.745n 0.0v 369.755n 0.0v 374.745n 0.0v 374.755n 0.0v 379.745n 0.0v 379.755n 0.0v 384.745n 0.0v 384.755n 0.0v 389.745n 0.0v 389.755n 0.0v 394.745n 0.0v 394.755n 0.0v 399.745n 0.0v 399.755n 0.0v 404.745n 0.0v 404.755n 0.0v 409.745n 0.0v 409.755n 0.0v 414.745n 0.0v 414.755n 0.0v 419.745n 0.0v 419.755n 0.0v 424.745n 0.0v 424.755n 0.0v 429.745n 0.0v 429.755n 0.0v 434.745n 0.0v 434.755n 1.1v 439.745n 1.1v 439.755n 0.0v 444.745n 0.0v 444.755n 0.0v 449.745n 0.0v 449.755n 0.0v 454.745n 0.0v 454.755n 0.0v 459.745n 0.0v 459.755n 0.0v 464.745n 0.0v 464.755n 0.0v 469.745n 0.0v 469.755n 0.0v 474.745n 0.0v 474.755n 0.0v 479.745n 0.0v 479.755n 0.0v 484.745n 0.0v 484.755n 0.0v 489.745n 0.0v 489.755n 0.0v 494.745n 0.0v 494.755n 1.1v 499.745n 1.1v 499.755n 1.1v 504.745n 1.1v 504.755n 1.1v 509.745n 1.1v 509.755n 1.1v 514.745n 1.1v 514.755n 1.1v 519.745n 1.1v 519.755n 1.1v 524.745n 1.1v 524.755n 1.1v 529.745n 1.1v 529.755n 1.1v 534.745n 1.1v 534.755n 1.1v 539.745n 1.1v 539.755n 0.0v 544.745n 0.0v 544.755n 1.1v 549.745n 1.1v 549.755n 0.0v 554.745n 0.0v 554.755n 0.0v 559.745n 0.0v 559.755n 0.0v 564.745n 0.0v 564.755n 0.0v 569.745n 0.0v 569.755n 0.0v 574.745n 0.0v 574.755n 0.0v 579.745n 0.0v 579.755n 1.1v 584.745n 1.1v 584.755n 0.0v 589.745n 0.0v 589.755n 0.0v 594.745n 0.0v 594.755n 0.0v 599.745n 0.0v 599.755n 0.0v 604.745n 0.0v 604.755n 0.0v 609.745n 0.0v 609.755n 0.0v 614.745n 0.0v 614.755n 0.0v 619.745n 0.0v 619.755n 1.1v 624.745n 1.1v 624.755n 1.1v 629.745n 1.1v 629.755n 1.1v 634.745n 1.1v 634.755n 1.1v 639.745n 1.1v 639.755n 0.0v 644.745n 0.0v 644.755n 0.0v 649.745n 0.0v 649.755n 0.0v 654.745n 0.0v 654.755n 0.0v 659.745n 0.0v 659.755n 0.0v 664.745n 0.0v 664.755n 0.0v 669.745n 0.0v 669.755n 0.0v 674.745n 0.0v 674.755n 0.0v 679.745n 0.0v 679.755n 0.0v 684.745n 0.0v 684.755n 0.0v 689.745n 0.0v 689.755n 0.0v 694.745n 0.0v 694.755n 0.0v 699.745n 0.0v 699.755n 1.1v 704.745n 1.1v 704.755n 1.1v 709.745n 1.1v 709.755n 1.1v 714.745n 1.1v 714.755n 1.1v 719.745n 1.1v 719.755n 1.1v 724.745n 1.1v 724.755n 1.1v 729.745n 1.1v 729.755n 0.0v 734.745n 0.0v 734.755n 0.0v 739.745n 0.0v 739.755n 0.0v 744.745n 0.0v 744.755n 0.0v 749.745n 0.0v 749.755n 0.0v 754.745n 0.0v 754.755n 0.0v 759.745n 0.0v 759.755n 0.0v 764.745n 0.0v 764.755n 0.0v 769.745n 0.0v 769.755n 0.0v 774.745n 0.0v 774.755n 0.0v 779.745n 0.0v 779.755n 0.0v 784.745n 0.0v 784.755n 0.0v 789.745n 0.0v 789.755n 0.0v 794.745n 0.0v 794.755n 0.0v 799.745n 0.0v 799.755n 0.0v 804.745n 0.0v 804.755n 1.1v 809.745n 1.1v 809.755n 1.1v 814.745n 1.1v 814.755n 1.1v 819.745n 1.1v 819.755n 1.1v 824.745n 1.1v 824.755n 0.0v 829.745n 0.0v 829.755n 0.0v 834.745n 0.0v 834.755n 1.1v 839.745n 1.1v 839.755n 1.1v 844.745n 1.1v 844.755n 1.1v 849.745n 1.1v 849.755n 1.1v 854.745n 1.1v 854.755n 1.1v 859.745n 1.1v 859.755n 0.0v 864.745n 0.0v 864.755n 0.0v 869.745n 0.0v 869.755n 0.0v 874.745n 0.0v 874.755n 0.0v 879.745n 0.0v 879.755n 0.0v 884.745n 0.0v 884.755n 0.0v 889.745n 0.0v 889.755n 0.0v 894.745n 0.0v 894.755n 0.0v 899.745n 0.0v 899.755n 0.0v 904.745n 0.0v 904.755n 1.1v 909.745n 1.1v 909.755n 1.1v 914.745n 1.1v 914.755n 1.1v 919.745n 1.1v 919.755n 1.1v 924.745n 1.1v 924.755n 1.1v 929.745n 1.1v 929.755n 1.1v 934.745n 1.1v 934.755n 0.0v 939.745n 0.0v 939.755n 0.0v 944.745n 0.0v 944.755n 1.1v 949.745n 1.1v 949.755n 1.1v 954.745n 1.1v 954.755n 1.1v 959.745n 1.1v 959.755n 1.1v 964.745n 1.1v 964.755n 1.1v 969.745n 1.1v 969.755n 1.1v 974.745n 1.1v 974.755n 1.1v 979.745n 1.1v 979.755n 1.1v 984.745n 1.1v 984.755n 0.0v 989.745n 0.0v 989.755n 1.1v 994.745n 1.1v 994.755n 1.1v 999.745n 1.1v 999.755n 1.1v 1004.745n 1.1v 1004.755n 1.1v 1009.745n 1.1v 1009.755n 0.0v 1014.745n 0.0v 1014.755n 0.0v 1019.745n 0.0v 1019.755n 0.0v 1024.745n 0.0v 1024.755n 0.0v )
* (time, data): [(0, 0), (5, 1), (10, 0), (15, 1), (20, 1), (25, 1), (30, 1), (35, 1), (40, 1), (45, 0), (50, 0), (55, 0), (60, 0), (65, 0), (70, 0), (75, 0), (80, 1), (85, 1), (90, 1), (95, 1), (100, 1), (105, 1), (110, 1), (115, 0), (120, 0), (125, 0), (130, 0), (135, 1), (140, 0), (145, 0), (150, 0), (155, 0), (160, 0), (165, 0), (170, 0), (175, 0), (180, 0), (185, 0), (190, 0), (195, 0), (200, 0), (205, 0), (210, 1), (215, 0), (220, 0), (225, 0), (230, 0), (235, 0), (240, 0), (245, 0), (250, 0), (255, 0), (260, 0), (265, 0), (270, 0), (275, 0), (280, 0), (285, 0), (290, 0), (295, 0), (300, 0), (305, 0), (310, 0), (315, 1), (320, 1), (325, 1), (330, 1), (335, 1), (340, 1), (345, 1), (350, 0), (355, 0), (360, 1), (365, 1), (370, 1), (375, 1), (380, 0), (385, 0), (390, 0), (395, 0), (400, 1), (405, 1), (410, 1), (415, 1), (420, 1), (425, 1), (430, 1), (435, 1), (440, 0), (445, 0), (450, 0), (455, 1), (460, 1), (465, 1), (470, 1), (475, 0), (480, 0), (485, 1), (490, 1), (495, 1), (500, 1), (505, 0), (510, 0), (515, 0), (520, 0), (525, 0), (530, 0), (535, 0), (540, 0), (545, 0), (550, 1), (555, 1), (560, 1), (565, 1), (570, 1), (575, 1), (580, 1), (585, 0), (590, 0), (595, 0), (600, 0), (605, 1), (610, 1), (615, 1), (620, 0), (625, 0), (630, 1), (635, 0), (640, 0), (645, 0), (650, 0), (655, 0), (660, 0), (665, 0), (670, 0), (675, 0), (680, 0), (685, 0), (690, 0), (695, 0), (700, 0), (705, 1), (710, 1), (715, 1), (720, 1), (725, 1), (730, 1), (735, 1), (740, 1), (745, 1), (750, 1), (755, 0), (760, 0), (765, 0), (770, 0), (775, 0), (780, 0), (785, 0), (790, 0), (795, 0), (800, 0), (805, 0), (810, 0), (815, 1), (820, 1), (825, 1), (830, 0), (835, 0), (840, 0), (845, 0), (850, 0), (855, 0), (860, 1), (865, 1), (870, 1), (875, 1), (880, 1), (885, 1), (890, 1), (895, 1), (900, 1), (905, 1), (910, 1), (915, 1), (920, 1), (925, 1), (930, 0), (935, 1), (940, 1), (945, 1), (950, 1), (955, 1), (960, 1), (965, 1), (970, 1), (975, 1), (980, 1), (985, 1), (990, 1), (995, 1), (1000, 0), (1005, 0), (1010, 1), (1015, 1), (1020, 1), (1025, 1)]
Vdin0_2  din0_2  0 PWL (0n 0.0v 4.745n 0.0v 4.755n 1.1v 9.745n 1.1v 9.755n 0.0v 14.745n 0.0v 14.755n 1.1v 19.745n 1.1v 19.755n 1.1v 24.745n 1.1v 24.755n 1.1v 29.745n 1.1v 29.755n 1.1v 34.745n 1.1v 34.755n 1.1v 39.745n 1.1v 39.755n 1.1v 44.745n 1.1v 44.755n 0.0v 49.745n 0.0v 49.755n 0.0v 54.745n 0.0v 54.755n 0.0v 59.745n 0.0v 59.755n 0.0v 64.745n 0.0v 64.755n 0.0v 69.745n 0.0v 69.755n 0.0v 74.745n 0.0v 74.755n 0.0v 79.745n 0.0v 79.755n 1.1v 84.745n 1.1v 84.755n 1.1v 89.745n 1.1v 89.755n 1.1v 94.745n 1.1v 94.755n 1.1v 99.745n 1.1v 99.755n 1.1v 104.745n 1.1v 104.755n 1.1v 109.745n 1.1v 109.755n 1.1v 114.745n 1.1v 114.755n 0.0v 119.745n 0.0v 119.755n 0.0v 124.745n 0.0v 124.755n 0.0v 129.745n 0.0v 129.755n 0.0v 134.745n 0.0v 134.755n 1.1v 139.745n 1.1v 139.755n 0.0v 144.745n 0.0v 144.755n 0.0v 149.745n 0.0v 149.755n 0.0v 154.745n 0.0v 154.755n 0.0v 159.745n 0.0v 159.755n 0.0v 164.745n 0.0v 164.755n 0.0v 169.745n 0.0v 169.755n 0.0v 174.745n 0.0v 174.755n 0.0v 179.745n 0.0v 179.755n 0.0v 184.745n 0.0v 184.755n 0.0v 189.745n 0.0v 189.755n 0.0v 194.745n 0.0v 194.755n 0.0v 199.745n 0.0v 199.755n 0.0v 204.745n 0.0v 204.755n 0.0v 209.745n 0.0v 209.755n 1.1v 214.745n 1.1v 214.755n 0.0v 219.745n 0.0v 219.755n 0.0v 224.745n 0.0v 224.755n 0.0v 229.745n 0.0v 229.755n 0.0v 234.745n 0.0v 234.755n 0.0v 239.745n 0.0v 239.755n 0.0v 244.745n 0.0v 244.755n 0.0v 249.745n 0.0v 249.755n 0.0v 254.745n 0.0v 254.755n 0.0v 259.745n 0.0v 259.755n 0.0v 264.745n 0.0v 264.755n 0.0v 269.745n 0.0v 269.755n 0.0v 274.745n 0.0v 274.755n 0.0v 279.745n 0.0v 279.755n 0.0v 284.745n 0.0v 284.755n 0.0v 289.745n 0.0v 289.755n 0.0v 294.745n 0.0v 294.755n 0.0v 299.745n 0.0v 299.755n 0.0v 304.745n 0.0v 304.755n 0.0v 309.745n 0.0v 309.755n 0.0v 314.745n 0.0v 314.755n 1.1v 319.745n 1.1v 319.755n 1.1v 324.745n 1.1v 324.755n 1.1v 329.745n 1.1v 329.755n 1.1v 334.745n 1.1v 334.755n 1.1v 339.745n 1.1v 339.755n 1.1v 344.745n 1.1v 344.755n 1.1v 349.745n 1.1v 349.755n 0.0v 354.745n 0.0v 354.755n 0.0v 359.745n 0.0v 359.755n 1.1v 364.745n 1.1v 364.755n 1.1v 369.745n 1.1v 369.755n 1.1v 374.745n 1.1v 374.755n 1.1v 379.745n 1.1v 379.755n 0.0v 384.745n 0.0v 384.755n 0.0v 389.745n 0.0v 389.755n 0.0v 394.745n 0.0v 394.755n 0.0v 399.745n 0.0v 399.755n 1.1v 404.745n 1.1v 404.755n 1.1v 409.745n 1.1v 409.755n 1.1v 414.745n 1.1v 414.755n 1.1v 419.745n 1.1v 419.755n 1.1v 424.745n 1.1v 424.755n 1.1v 429.745n 1.1v 429.755n 1.1v 434.745n 1.1v 434.755n 1.1v 439.745n 1.1v 439.755n 0.0v 444.745n 0.0v 444.755n 0.0v 449.745n 0.0v 449.755n 0.0v 454.745n 0.0v 454.755n 1.1v 459.745n 1.1v 459.755n 1.1v 464.745n 1.1v 464.755n 1.1v 469.745n 1.1v 469.755n 1.1v 474.745n 1.1v 474.755n 0.0v 479.745n 0.0v 479.755n 0.0v 484.745n 0.0v 484.755n 1.1v 489.745n 1.1v 489.755n 1.1v 494.745n 1.1v 494.755n 1.1v 499.745n 1.1v 499.755n 1.1v 504.745n 1.1v 504.755n 0.0v 509.745n 0.0v 509.755n 0.0v 514.745n 0.0v 514.755n 0.0v 519.745n 0.0v 519.755n 0.0v 524.745n 0.0v 524.755n 0.0v 529.745n 0.0v 529.755n 0.0v 534.745n 0.0v 534.755n 0.0v 539.745n 0.0v 539.755n 0.0v 544.745n 0.0v 544.755n 0.0v 549.745n 0.0v 549.755n 1.1v 554.745n 1.1v 554.755n 1.1v 559.745n 1.1v 559.755n 1.1v 564.745n 1.1v 564.755n 1.1v 569.745n 1.1v 569.755n 1.1v 574.745n 1.1v 574.755n 1.1v 579.745n 1.1v 579.755n 1.1v 584.745n 1.1v 584.755n 0.0v 589.745n 0.0v 589.755n 0.0v 594.745n 0.0v 594.755n 0.0v 599.745n 0.0v 599.755n 0.0v 604.745n 0.0v 604.755n 1.1v 609.745n 1.1v 609.755n 1.1v 614.745n 1.1v 614.755n 1.1v 619.745n 1.1v 619.755n 0.0v 624.745n 0.0v 624.755n 0.0v 629.745n 0.0v 629.755n 1.1v 634.745n 1.1v 634.755n 0.0v 639.745n 0.0v 639.755n 0.0v 644.745n 0.0v 644.755n 0.0v 649.745n 0.0v 649.755n 0.0v 654.745n 0.0v 654.755n 0.0v 659.745n 0.0v 659.755n 0.0v 664.745n 0.0v 664.755n 0.0v 669.745n 0.0v 669.755n 0.0v 674.745n 0.0v 674.755n 0.0v 679.745n 0.0v 679.755n 0.0v 684.745n 0.0v 684.755n 0.0v 689.745n 0.0v 689.755n 0.0v 694.745n 0.0v 694.755n 0.0v 699.745n 0.0v 699.755n 0.0v 704.745n 0.0v 704.755n 1.1v 709.745n 1.1v 709.755n 1.1v 714.745n 1.1v 714.755n 1.1v 719.745n 1.1v 719.755n 1.1v 724.745n 1.1v 724.755n 1.1v 729.745n 1.1v 729.755n 1.1v 734.745n 1.1v 734.755n 1.1v 739.745n 1.1v 739.755n 1.1v 744.745n 1.1v 744.755n 1.1v 749.745n 1.1v 749.755n 1.1v 754.745n 1.1v 754.755n 0.0v 759.745n 0.0v 759.755n 0.0v 764.745n 0.0v 764.755n 0.0v 769.745n 0.0v 769.755n 0.0v 774.745n 0.0v 774.755n 0.0v 779.745n 0.0v 779.755n 0.0v 784.745n 0.0v 784.755n 0.0v 789.745n 0.0v 789.755n 0.0v 794.745n 0.0v 794.755n 0.0v 799.745n 0.0v 799.755n 0.0v 804.745n 0.0v 804.755n 0.0v 809.745n 0.0v 809.755n 0.0v 814.745n 0.0v 814.755n 1.1v 819.745n 1.1v 819.755n 1.1v 824.745n 1.1v 824.755n 1.1v 829.745n 1.1v 829.755n 0.0v 834.745n 0.0v 834.755n 0.0v 839.745n 0.0v 839.755n 0.0v 844.745n 0.0v 844.755n 0.0v 849.745n 0.0v 849.755n 0.0v 854.745n 0.0v 854.755n 0.0v 859.745n 0.0v 859.755n 1.1v 864.745n 1.1v 864.755n 1.1v 869.745n 1.1v 869.755n 1.1v 874.745n 1.1v 874.755n 1.1v 879.745n 1.1v 879.755n 1.1v 884.745n 1.1v 884.755n 1.1v 889.745n 1.1v 889.755n 1.1v 894.745n 1.1v 894.755n 1.1v 899.745n 1.1v 899.755n 1.1v 904.745n 1.1v 904.755n 1.1v 909.745n 1.1v 909.755n 1.1v 914.745n 1.1v 914.755n 1.1v 919.745n 1.1v 919.755n 1.1v 924.745n 1.1v 924.755n 1.1v 929.745n 1.1v 929.755n 0.0v 934.745n 0.0v 934.755n 1.1v 939.745n 1.1v 939.755n 1.1v 944.745n 1.1v 944.755n 1.1v 949.745n 1.1v 949.755n 1.1v 954.745n 1.1v 954.755n 1.1v 959.745n 1.1v 959.755n 1.1v 964.745n 1.1v 964.755n 1.1v 969.745n 1.1v 969.755n 1.1v 974.745n 1.1v 974.755n 1.1v 979.745n 1.1v 979.755n 1.1v 984.745n 1.1v 984.755n 1.1v 989.745n 1.1v 989.755n 1.1v 994.745n 1.1v 994.755n 1.1v 999.745n 1.1v 999.755n 0.0v 1004.745n 0.0v 1004.755n 0.0v 1009.745n 0.0v 1009.755n 1.1v 1014.745n 1.1v 1014.755n 1.1v 1019.745n 1.1v 1019.755n 1.1v 1024.745n 1.1v 1024.755n 1.1v )
* (time, data): [(0, 0), (5, 0), (10, 1), (15, 1), (20, 1), (25, 1), (30, 1), (35, 0), (40, 0), (45, 0), (50, 0), (55, 1), (60, 1), (65, 1), (70, 1), (75, 0), (80, 0), (85, 0), (90, 0), (95, 0), (100, 0), (105, 0), (110, 0), (115, 0), (120, 0), (125, 0), (130, 0), (135, 1), (140, 1), (145, 1), (150, 1), (155, 1), (160, 1), (165, 1), (170, 1), (175, 0), (180, 0), (185, 0), (190, 0), (195, 0), (200, 0), (205, 0), (210, 1), (215, 1), (220, 1), (225, 1), (230, 1), (235, 1), (240, 1), (245, 1), (250, 1), (255, 1), (260, 0), (265, 0), (270, 1), (275, 1), (280, 1), (285, 1), (290, 1), (295, 0), (300, 0), (305, 0), (310, 0), (315, 0), (320, 0), (325, 0), (330, 0), (335, 0), (340, 0), (345, 0), (350, 0), (355, 0), (360, 1), (365, 1), (370, 0), (375, 0), (380, 0), (385, 0), (390, 0), (395, 0), (400, 1), (405, 1), (410, 1), (415, 1), (420, 1), (425, 1), (430, 1), (435, 0), (440, 1), (445, 1), (450, 1), (455, 1), (460, 1), (465, 1), (470, 1), (475, 1), (480, 1), (485, 0), (490, 0), (495, 0), (500, 0), (505, 1), (510, 1), (515, 1), (520, 1), (525, 1), (530, 1), (535, 1), (540, 0), (545, 0), (550, 0), (555, 1), (560, 1), (565, 1), (570, 1), (575, 1), (580, 1), (585, 0), (590, 0), (595, 1), (600, 1), (605, 0), (610, 0), (615, 0), (620, 0), (625, 0), (630, 0), (635, 1), (640, 1), (645, 1), (650, 0), (655, 0), (660, 0), (665, 0), (670, 0), (675, 0), (680, 0), (685, 0), (690, 0), (695, 0), (700, 1), (705, 0), (710, 0), (715, 0), (720, 1), (725, 1), (730, 0), (735, 0), (740, 0), (745, 0), (750, 0), (755, 0), (760, 0), (765, 0), (770, 0), (775, 0), (780, 0), (785, 0), (790, 0), (795, 0), (800, 0), (805, 1), (810, 1), (815, 1), (820, 1), (825, 1), (830, 0), (835, 0), (840, 0), (845, 0), (850, 0), (855, 0), (860, 1), (865, 0), (870, 0), (875, 0), (880, 0), (885, 0), (890, 0), (895, 0), (900, 0), (905, 0), (910, 0), (915, 0), (920, 0), (925, 0), (930, 0), (935, 0), (940, 0), (945, 1), (950, 0), (955, 0), (960, 0), (965, 0), (970, 0), (975, 0), (980, 0), (985, 0), (990, 1), (995, 1), (1000, 1), (1005, 1), (1010, 0), (1015, 0), (1020, 0), (1025, 0)]
Vdin0_3  din0_3  0 PWL (0n 0.0v 4.745n 0.0v 4.755n 0.0v 9.745n 0.0v 9.755n 1.1v 14.745n 1.1v 14.755n 1.1v 19.745n 1.1v 19.755n 1.1v 24.745n 1.1v 24.755n 1.1v 29.745n 1.1v 29.755n 1.1v 34.745n 1.1v 34.755n 0.0v 39.745n 0.0v 39.755n 0.0v 44.745n 0.0v 44.755n 0.0v 49.745n 0.0v 49.755n 0.0v 54.745n 0.0v 54.755n 1.1v 59.745n 1.1v 59.755n 1.1v 64.745n 1.1v 64.755n 1.1v 69.745n 1.1v 69.755n 1.1v 74.745n 1.1v 74.755n 0.0v 79.745n 0.0v 79.755n 0.0v 84.745n 0.0v 84.755n 0.0v 89.745n 0.0v 89.755n 0.0v 94.745n 0.0v 94.755n 0.0v 99.745n 0.0v 99.755n 0.0v 104.745n 0.0v 104.755n 0.0v 109.745n 0.0v 109.755n 0.0v 114.745n 0.0v 114.755n 0.0v 119.745n 0.0v 119.755n 0.0v 124.745n 0.0v 124.755n 0.0v 129.745n 0.0v 129.755n 0.0v 134.745n 0.0v 134.755n 1.1v 139.745n 1.1v 139.755n 1.1v 144.745n 1.1v 144.755n 1.1v 149.745n 1.1v 149.755n 1.1v 154.745n 1.1v 154.755n 1.1v 159.745n 1.1v 159.755n 1.1v 164.745n 1.1v 164.755n 1.1v 169.745n 1.1v 169.755n 1.1v 174.745n 1.1v 174.755n 0.0v 179.745n 0.0v 179.755n 0.0v 184.745n 0.0v 184.755n 0.0v 189.745n 0.0v 189.755n 0.0v 194.745n 0.0v 194.755n 0.0v 199.745n 0.0v 199.755n 0.0v 204.745n 0.0v 204.755n 0.0v 209.745n 0.0v 209.755n 1.1v 214.745n 1.1v 214.755n 1.1v 219.745n 1.1v 219.755n 1.1v 224.745n 1.1v 224.755n 1.1v 229.745n 1.1v 229.755n 1.1v 234.745n 1.1v 234.755n 1.1v 239.745n 1.1v 239.755n 1.1v 244.745n 1.1v 244.755n 1.1v 249.745n 1.1v 249.755n 1.1v 254.745n 1.1v 254.755n 1.1v 259.745n 1.1v 259.755n 0.0v 264.745n 0.0v 264.755n 0.0v 269.745n 0.0v 269.755n 1.1v 274.745n 1.1v 274.755n 1.1v 279.745n 1.1v 279.755n 1.1v 284.745n 1.1v 284.755n 1.1v 289.745n 1.1v 289.755n 1.1v 294.745n 1.1v 294.755n 0.0v 299.745n 0.0v 299.755n 0.0v 304.745n 0.0v 304.755n 0.0v 309.745n 0.0v 309.755n 0.0v 314.745n 0.0v 314.755n 0.0v 319.745n 0.0v 319.755n 0.0v 324.745n 0.0v 324.755n 0.0v 329.745n 0.0v 329.755n 0.0v 334.745n 0.0v 334.755n 0.0v 339.745n 0.0v 339.755n 0.0v 344.745n 0.0v 344.755n 0.0v 349.745n 0.0v 349.755n 0.0v 354.745n 0.0v 354.755n 0.0v 359.745n 0.0v 359.755n 1.1v 364.745n 1.1v 364.755n 1.1v 369.745n 1.1v 369.755n 0.0v 374.745n 0.0v 374.755n 0.0v 379.745n 0.0v 379.755n 0.0v 384.745n 0.0v 384.755n 0.0v 389.745n 0.0v 389.755n 0.0v 394.745n 0.0v 394.755n 0.0v 399.745n 0.0v 399.755n 1.1v 404.745n 1.1v 404.755n 1.1v 409.745n 1.1v 409.755n 1.1v 414.745n 1.1v 414.755n 1.1v 419.745n 1.1v 419.755n 1.1v 424.745n 1.1v 424.755n 1.1v 429.745n 1.1v 429.755n 1.1v 434.745n 1.1v 434.755n 0.0v 439.745n 0.0v 439.755n 1.1v 444.745n 1.1v 444.755n 1.1v 449.745n 1.1v 449.755n 1.1v 454.745n 1.1v 454.755n 1.1v 459.745n 1.1v 459.755n 1.1v 464.745n 1.1v 464.755n 1.1v 469.745n 1.1v 469.755n 1.1v 474.745n 1.1v 474.755n 1.1v 479.745n 1.1v 479.755n 1.1v 484.745n 1.1v 484.755n 0.0v 489.745n 0.0v 489.755n 0.0v 494.745n 0.0v 494.755n 0.0v 499.745n 0.0v 499.755n 0.0v 504.745n 0.0v 504.755n 1.1v 509.745n 1.1v 509.755n 1.1v 514.745n 1.1v 514.755n 1.1v 519.745n 1.1v 519.755n 1.1v 524.745n 1.1v 524.755n 1.1v 529.745n 1.1v 529.755n 1.1v 534.745n 1.1v 534.755n 1.1v 539.745n 1.1v 539.755n 0.0v 544.745n 0.0v 544.755n 0.0v 549.745n 0.0v 549.755n 0.0v 554.745n 0.0v 554.755n 1.1v 559.745n 1.1v 559.755n 1.1v 564.745n 1.1v 564.755n 1.1v 569.745n 1.1v 569.755n 1.1v 574.745n 1.1v 574.755n 1.1v 579.745n 1.1v 579.755n 1.1v 584.745n 1.1v 584.755n 0.0v 589.745n 0.0v 589.755n 0.0v 594.745n 0.0v 594.755n 1.1v 599.745n 1.1v 599.755n 1.1v 604.745n 1.1v 604.755n 0.0v 609.745n 0.0v 609.755n 0.0v 614.745n 0.0v 614.755n 0.0v 619.745n 0.0v 619.755n 0.0v 624.745n 0.0v 624.755n 0.0v 629.745n 0.0v 629.755n 0.0v 634.745n 0.0v 634.755n 1.1v 639.745n 1.1v 639.755n 1.1v 644.745n 1.1v 644.755n 1.1v 649.745n 1.1v 649.755n 0.0v 654.745n 0.0v 654.755n 0.0v 659.745n 0.0v 659.755n 0.0v 664.745n 0.0v 664.755n 0.0v 669.745n 0.0v 669.755n 0.0v 674.745n 0.0v 674.755n 0.0v 679.745n 0.0v 679.755n 0.0v 684.745n 0.0v 684.755n 0.0v 689.745n 0.0v 689.755n 0.0v 694.745n 0.0v 694.755n 0.0v 699.745n 0.0v 699.755n 1.1v 704.745n 1.1v 704.755n 0.0v 709.745n 0.0v 709.755n 0.0v 714.745n 0.0v 714.755n 0.0v 719.745n 0.0v 719.755n 1.1v 724.745n 1.1v 724.755n 1.1v 729.745n 1.1v 729.755n 0.0v 734.745n 0.0v 734.755n 0.0v 739.745n 0.0v 739.755n 0.0v 744.745n 0.0v 744.755n 0.0v 749.745n 0.0v 749.755n 0.0v 754.745n 0.0v 754.755n 0.0v 759.745n 0.0v 759.755n 0.0v 764.745n 0.0v 764.755n 0.0v 769.745n 0.0v 769.755n 0.0v 774.745n 0.0v 774.755n 0.0v 779.745n 0.0v 779.755n 0.0v 784.745n 0.0v 784.755n 0.0v 789.745n 0.0v 789.755n 0.0v 794.745n 0.0v 794.755n 0.0v 799.745n 0.0v 799.755n 0.0v 804.745n 0.0v 804.755n 1.1v 809.745n 1.1v 809.755n 1.1v 814.745n 1.1v 814.755n 1.1v 819.745n 1.1v 819.755n 1.1v 824.745n 1.1v 824.755n 1.1v 829.745n 1.1v 829.755n 0.0v 834.745n 0.0v 834.755n 0.0v 839.745n 0.0v 839.755n 0.0v 844.745n 0.0v 844.755n 0.0v 849.745n 0.0v 849.755n 0.0v 854.745n 0.0v 854.755n 0.0v 859.745n 0.0v 859.755n 1.1v 864.745n 1.1v 864.755n 0.0v 869.745n 0.0v 869.755n 0.0v 874.745n 0.0v 874.755n 0.0v 879.745n 0.0v 879.755n 0.0v 884.745n 0.0v 884.755n 0.0v 889.745n 0.0v 889.755n 0.0v 894.745n 0.0v 894.755n 0.0v 899.745n 0.0v 899.755n 0.0v 904.745n 0.0v 904.755n 0.0v 909.745n 0.0v 909.755n 0.0v 914.745n 0.0v 914.755n 0.0v 919.745n 0.0v 919.755n 0.0v 924.745n 0.0v 924.755n 0.0v 929.745n 0.0v 929.755n 0.0v 934.745n 0.0v 934.755n 0.0v 939.745n 0.0v 939.755n 0.0v 944.745n 0.0v 944.755n 1.1v 949.745n 1.1v 949.755n 0.0v 954.745n 0.0v 954.755n 0.0v 959.745n 0.0v 959.755n 0.0v 964.745n 0.0v 964.755n 0.0v 969.745n 0.0v 969.755n 0.0v 974.745n 0.0v 974.755n 0.0v 979.745n 0.0v 979.755n 0.0v 984.745n 0.0v 984.755n 0.0v 989.745n 0.0v 989.755n 1.1v 994.745n 1.1v 994.755n 1.1v 999.745n 1.1v 999.755n 1.1v 1004.745n 1.1v 1004.755n 1.1v 1009.745n 1.1v 1009.755n 0.0v 1014.745n 0.0v 1014.755n 0.0v 1019.745n 0.0v 1019.755n 0.0v 1024.745n 0.0v 1024.755n 0.0v )
* (time, data): [(0, 0), (5, 1), (10, 1), (15, 0), (20, 0), (25, 0), (30, 0), (35, 1), (40, 1), (45, 0), (50, 1), (55, 0), (60, 0), (65, 0), (70, 0), (75, 0), (80, 0), (85, 0), (90, 0), (95, 0), (100, 0), (105, 0), (110, 0), (115, 1), (120, 1), (125, 1), (130, 1), (135, 1), (140, 0), (145, 0), (150, 1), (155, 1), (160, 1), (165, 1), (170, 1), (175, 0), (180, 1), (185, 1), (190, 1), (195, 1), (200, 1), (205, 1), (210, 1), (215, 0), (220, 0), (225, 0), (230, 1), (235, 1), (240, 1), (245, 1), (250, 1), (255, 1), (260, 0), (265, 0), (270, 0), (275, 0), (280, 0), (285, 0), (290, 0), (295, 0), (300, 0), (305, 0), (310, 0), (315, 0), (320, 1), (325, 0), (330, 0), (335, 0), (340, 0), (345, 0), (350, 0), (355, 0), (360, 0), (365, 0), (370, 0), (375, 0), (380, 0), (385, 0), (390, 0), (395, 0), (400, 0), (405, 0), (410, 0), (415, 0), (420, 0), (425, 0), (430, 0), (435, 1), (440, 1), (445, 1), (450, 1), (455, 1), (460, 1), (465, 1), (470, 1), (475, 0), (480, 0), (485, 0), (490, 0), (495, 1), (500, 1), (505, 1), (510, 1), (515, 1), (520, 1), (525, 1), (530, 1), (535, 1), (540, 0), (545, 0), (550, 1), (555, 0), (560, 0), (565, 0), (570, 0), (575, 0), (580, 0), (585, 0), (590, 0), (595, 0), (600, 0), (605, 1), (610, 1), (615, 1), (620, 1), (625, 1), (630, 1), (635, 0), (640, 0), (645, 0), (650, 0), (655, 0), (660, 0), (665, 0), (670, 0), (675, 0), (680, 0), (685, 0), (690, 0), (695, 0), (700, 1), (705, 1), (710, 1), (715, 1), (720, 1), (725, 1), (730, 0), (735, 0), (740, 0), (745, 0), (750, 0), (755, 0), (760, 0), (765, 1), (770, 1), (775, 1), (780, 1), (785, 0), (790, 0), (795, 0), (800, 0), (805, 1), (810, 1), (815, 1), (820, 1), (825, 0), (830, 1), (835, 0), (840, 0), (845, 0), (850, 0), (855, 0), (860, 1), (865, 0), (870, 0), (875, 0), (880, 0), (885, 0), (890, 0), (895, 0), (900, 0), (905, 0), (910, 0), (915, 0), (920, 0), (925, 0), (930, 0), (935, 1), (940, 1), (945, 0), (950, 0), (955, 0), (960, 0), (965, 0), (970, 0), (975, 0), (980, 0), (985, 0), (990, 0), (995, 0), (1000, 0), (1005, 0), (1010, 1), (1015, 1), (1020, 1), (1025, 1)]
Vdin0_4  din0_4  0 PWL (0n 0.0v 4.745n 0.0v 4.755n 1.1v 9.745n 1.1v 9.755n 1.1v 14.745n 1.1v 14.755n 0.0v 19.745n 0.0v 19.755n 0.0v 24.745n 0.0v 24.755n 0.0v 29.745n 0.0v 29.755n 0.0v 34.745n 0.0v 34.755n 1.1v 39.745n 1.1v 39.755n 1.1v 44.745n 1.1v 44.755n 0.0v 49.745n 0.0v 49.755n 1.1v 54.745n 1.1v 54.755n 0.0v 59.745n 0.0v 59.755n 0.0v 64.745n 0.0v 64.755n 0.0v 69.745n 0.0v 69.755n 0.0v 74.745n 0.0v 74.755n 0.0v 79.745n 0.0v 79.755n 0.0v 84.745n 0.0v 84.755n 0.0v 89.745n 0.0v 89.755n 0.0v 94.745n 0.0v 94.755n 0.0v 99.745n 0.0v 99.755n 0.0v 104.745n 0.0v 104.755n 0.0v 109.745n 0.0v 109.755n 0.0v 114.745n 0.0v 114.755n 1.1v 119.745n 1.1v 119.755n 1.1v 124.745n 1.1v 124.755n 1.1v 129.745n 1.1v 129.755n 1.1v 134.745n 1.1v 134.755n 1.1v 139.745n 1.1v 139.755n 0.0v 144.745n 0.0v 144.755n 0.0v 149.745n 0.0v 149.755n 1.1v 154.745n 1.1v 154.755n 1.1v 159.745n 1.1v 159.755n 1.1v 164.745n 1.1v 164.755n 1.1v 169.745n 1.1v 169.755n 1.1v 174.745n 1.1v 174.755n 0.0v 179.745n 0.0v 179.755n 1.1v 184.745n 1.1v 184.755n 1.1v 189.745n 1.1v 189.755n 1.1v 194.745n 1.1v 194.755n 1.1v 199.745n 1.1v 199.755n 1.1v 204.745n 1.1v 204.755n 1.1v 209.745n 1.1v 209.755n 1.1v 214.745n 1.1v 214.755n 0.0v 219.745n 0.0v 219.755n 0.0v 224.745n 0.0v 224.755n 0.0v 229.745n 0.0v 229.755n 1.1v 234.745n 1.1v 234.755n 1.1v 239.745n 1.1v 239.755n 1.1v 244.745n 1.1v 244.755n 1.1v 249.745n 1.1v 249.755n 1.1v 254.745n 1.1v 254.755n 1.1v 259.745n 1.1v 259.755n 0.0v 264.745n 0.0v 264.755n 0.0v 269.745n 0.0v 269.755n 0.0v 274.745n 0.0v 274.755n 0.0v 279.745n 0.0v 279.755n 0.0v 284.745n 0.0v 284.755n 0.0v 289.745n 0.0v 289.755n 0.0v 294.745n 0.0v 294.755n 0.0v 299.745n 0.0v 299.755n 0.0v 304.745n 0.0v 304.755n 0.0v 309.745n 0.0v 309.755n 0.0v 314.745n 0.0v 314.755n 0.0v 319.745n 0.0v 319.755n 1.1v 324.745n 1.1v 324.755n 0.0v 329.745n 0.0v 329.755n 0.0v 334.745n 0.0v 334.755n 0.0v 339.745n 0.0v 339.755n 0.0v 344.745n 0.0v 344.755n 0.0v 349.745n 0.0v 349.755n 0.0v 354.745n 0.0v 354.755n 0.0v 359.745n 0.0v 359.755n 0.0v 364.745n 0.0v 364.755n 0.0v 369.745n 0.0v 369.755n 0.0v 374.745n 0.0v 374.755n 0.0v 379.745n 0.0v 379.755n 0.0v 384.745n 0.0v 384.755n 0.0v 389.745n 0.0v 389.755n 0.0v 394.745n 0.0v 394.755n 0.0v 399.745n 0.0v 399.755n 0.0v 404.745n 0.0v 404.755n 0.0v 409.745n 0.0v 409.755n 0.0v 414.745n 0.0v 414.755n 0.0v 419.745n 0.0v 419.755n 0.0v 424.745n 0.0v 424.755n 0.0v 429.745n 0.0v 429.755n 0.0v 434.745n 0.0v 434.755n 1.1v 439.745n 1.1v 439.755n 1.1v 444.745n 1.1v 444.755n 1.1v 449.745n 1.1v 449.755n 1.1v 454.745n 1.1v 454.755n 1.1v 459.745n 1.1v 459.755n 1.1v 464.745n 1.1v 464.755n 1.1v 469.745n 1.1v 469.755n 1.1v 474.745n 1.1v 474.755n 0.0v 479.745n 0.0v 479.755n 0.0v 484.745n 0.0v 484.755n 0.0v 489.745n 0.0v 489.755n 0.0v 494.745n 0.0v 494.755n 1.1v 499.745n 1.1v 499.755n 1.1v 504.745n 1.1v 504.755n 1.1v 509.745n 1.1v 509.755n 1.1v 514.745n 1.1v 514.755n 1.1v 519.745n 1.1v 519.755n 1.1v 524.745n 1.1v 524.755n 1.1v 529.745n 1.1v 529.755n 1.1v 534.745n 1.1v 534.755n 1.1v 539.745n 1.1v 539.755n 0.0v 544.745n 0.0v 544.755n 0.0v 549.745n 0.0v 549.755n 1.1v 554.745n 1.1v 554.755n 0.0v 559.745n 0.0v 559.755n 0.0v 564.745n 0.0v 564.755n 0.0v 569.745n 0.0v 569.755n 0.0v 574.745n 0.0v 574.755n 0.0v 579.745n 0.0v 579.755n 0.0v 584.745n 0.0v 584.755n 0.0v 589.745n 0.0v 589.755n 0.0v 594.745n 0.0v 594.755n 0.0v 599.745n 0.0v 599.755n 0.0v 604.745n 0.0v 604.755n 1.1v 609.745n 1.1v 609.755n 1.1v 614.745n 1.1v 614.755n 1.1v 619.745n 1.1v 619.755n 1.1v 624.745n 1.1v 624.755n 1.1v 629.745n 1.1v 629.755n 1.1v 634.745n 1.1v 634.755n 0.0v 639.745n 0.0v 639.755n 0.0v 644.745n 0.0v 644.755n 0.0v 649.745n 0.0v 649.755n 0.0v 654.745n 0.0v 654.755n 0.0v 659.745n 0.0v 659.755n 0.0v 664.745n 0.0v 664.755n 0.0v 669.745n 0.0v 669.755n 0.0v 674.745n 0.0v 674.755n 0.0v 679.745n 0.0v 679.755n 0.0v 684.745n 0.0v 684.755n 0.0v 689.745n 0.0v 689.755n 0.0v 694.745n 0.0v 694.755n 0.0v 699.745n 0.0v 699.755n 1.1v 704.745n 1.1v 704.755n 1.1v 709.745n 1.1v 709.755n 1.1v 714.745n 1.1v 714.755n 1.1v 719.745n 1.1v 719.755n 1.1v 724.745n 1.1v 724.755n 1.1v 729.745n 1.1v 729.755n 0.0v 734.745n 0.0v 734.755n 0.0v 739.745n 0.0v 739.755n 0.0v 744.745n 0.0v 744.755n 0.0v 749.745n 0.0v 749.755n 0.0v 754.745n 0.0v 754.755n 0.0v 759.745n 0.0v 759.755n 0.0v 764.745n 0.0v 764.755n 1.1v 769.745n 1.1v 769.755n 1.1v 774.745n 1.1v 774.755n 1.1v 779.745n 1.1v 779.755n 1.1v 784.745n 1.1v 784.755n 0.0v 789.745n 0.0v 789.755n 0.0v 794.745n 0.0v 794.755n 0.0v 799.745n 0.0v 799.755n 0.0v 804.745n 0.0v 804.755n 1.1v 809.745n 1.1v 809.755n 1.1v 814.745n 1.1v 814.755n 1.1v 819.745n 1.1v 819.755n 1.1v 824.745n 1.1v 824.755n 0.0v 829.745n 0.0v 829.755n 1.1v 834.745n 1.1v 834.755n 0.0v 839.745n 0.0v 839.755n 0.0v 844.745n 0.0v 844.755n 0.0v 849.745n 0.0v 849.755n 0.0v 854.745n 0.0v 854.755n 0.0v 859.745n 0.0v 859.755n 1.1v 864.745n 1.1v 864.755n 0.0v 869.745n 0.0v 869.755n 0.0v 874.745n 0.0v 874.755n 0.0v 879.745n 0.0v 879.755n 0.0v 884.745n 0.0v 884.755n 0.0v 889.745n 0.0v 889.755n 0.0v 894.745n 0.0v 894.755n 0.0v 899.745n 0.0v 899.755n 0.0v 904.745n 0.0v 904.755n 0.0v 909.745n 0.0v 909.755n 0.0v 914.745n 0.0v 914.755n 0.0v 919.745n 0.0v 919.755n 0.0v 924.745n 0.0v 924.755n 0.0v 929.745n 0.0v 929.755n 0.0v 934.745n 0.0v 934.755n 1.1v 939.745n 1.1v 939.755n 1.1v 944.745n 1.1v 944.755n 0.0v 949.745n 0.0v 949.755n 0.0v 954.745n 0.0v 954.755n 0.0v 959.745n 0.0v 959.755n 0.0v 964.745n 0.0v 964.755n 0.0v 969.745n 0.0v 969.755n 0.0v 974.745n 0.0v 974.755n 0.0v 979.745n 0.0v 979.755n 0.0v 984.745n 0.0v 984.755n 0.0v 989.745n 0.0v 989.755n 0.0v 994.745n 0.0v 994.755n 0.0v 999.745n 0.0v 999.755n 0.0v 1004.745n 0.0v 1004.755n 0.0v 1009.745n 0.0v 1009.755n 1.1v 1014.745n 1.1v 1014.755n 1.1v 1019.745n 1.1v 1019.755n 1.1v 1024.745n 1.1v 1024.755n 1.1v )
* (time, data): [(0, 0), (5, 0), (10, 1), (15, 0), (20, 0), (25, 0), (30, 0), (35, 1), (40, 1), (45, 1), (50, 1), (55, 1), (60, 1), (65, 1), (70, 1), (75, 0), (80, 0), (85, 0), (90, 0), (95, 0), (100, 0), (105, 0), (110, 0), (115, 0), (120, 0), (125, 0), (130, 0), (135, 0), (140, 0), (145, 0), (150, 0), (155, 0), (160, 0), (165, 1), (170, 1), (175, 0), (180, 1), (185, 1), (190, 1), (195, 0), (200, 0), (205, 0), (210, 0), (215, 1), (220, 1), (225, 1), (230, 1), (235, 1), (240, 1), (245, 1), (250, 1), (255, 1), (260, 0), (265, 0), (270, 1), (275, 1), (280, 1), (285, 1), (290, 1), (295, 1), (300, 1), (305, 1), (310, 1), (315, 0), (320, 0), (325, 1), (330, 1), (335, 1), (340, 1), (345, 1), (350, 1), (355, 1), (360, 1), (365, 0), (370, 0), (375, 0), (380, 0), (385, 0), (390, 0), (395, 0), (400, 1), (405, 1), (410, 1), (415, 1), (420, 1), (425, 1), (430, 1), (435, 1), (440, 1), (445, 1), (450, 1), (455, 0), (460, 0), (465, 0), (470, 0), (475, 1), (480, 1), (485, 1), (490, 1), (495, 0), (500, 0), (505, 0), (510, 0), (515, 1), (520, 1), (525, 1), (530, 1), (535, 1), (540, 0), (545, 1), (550, 0), (555, 1), (560, 1), (565, 1), (570, 1), (575, 1), (580, 1), (585, 1), (590, 1), (595, 1), (600, 1), (605, 0), (610, 0), (615, 0), (620, 0), (625, 0), (630, 0), (635, 0), (640, 1), (645, 1), (650, 0), (655, 0), (660, 0), (665, 0), (670, 0), (675, 0), (680, 0), (685, 0), (690, 0), (695, 0), (700, 1), (705, 1), (710, 1), (715, 1), (720, 0), (725, 0), (730, 1), (735, 1), (740, 1), (745, 1), (750, 1), (755, 0), (760, 0), (765, 1), (770, 1), (775, 1), (780, 1), (785, 1), (790, 1), (795, 1), (800, 1), (805, 0), (810, 0), (815, 1), (820, 1), (825, 0), (830, 0), (835, 1), (840, 1), (845, 1), (850, 1), (855, 1), (860, 1), (865, 0), (870, 0), (875, 0), (880, 0), (885, 0), (890, 0), (895, 0), (900, 0), (905, 1), (910, 1), (915, 1), (920, 1), (925, 1), (930, 1), (935, 0), (940, 0), (945, 1), (950, 0), (955, 0), (960, 0), (965, 0), (970, 0), (975, 0), (980, 0), (985, 1), (990, 1), (995, 1), (1000, 0), (1005, 0), (1010, 1), (1015, 1), (1020, 1), (1025, 1)]
Vdin0_5  din0_5  0 PWL (0n 0.0v 4.745n 0.0v 4.755n 0.0v 9.745n 0.0v 9.755n 1.1v 14.745n 1.1v 14.755n 0.0v 19.745n 0.0v 19.755n 0.0v 24.745n 0.0v 24.755n 0.0v 29.745n 0.0v 29.755n 0.0v 34.745n 0.0v 34.755n 1.1v 39.745n 1.1v 39.755n 1.1v 44.745n 1.1v 44.755n 1.1v 49.745n 1.1v 49.755n 1.1v 54.745n 1.1v 54.755n 1.1v 59.745n 1.1v 59.755n 1.1v 64.745n 1.1v 64.755n 1.1v 69.745n 1.1v 69.755n 1.1v 74.745n 1.1v 74.755n 0.0v 79.745n 0.0v 79.755n 0.0v 84.745n 0.0v 84.755n 0.0v 89.745n 0.0v 89.755n 0.0v 94.745n 0.0v 94.755n 0.0v 99.745n 0.0v 99.755n 0.0v 104.745n 0.0v 104.755n 0.0v 109.745n 0.0v 109.755n 0.0v 114.745n 0.0v 114.755n 0.0v 119.745n 0.0v 119.755n 0.0v 124.745n 0.0v 124.755n 0.0v 129.745n 0.0v 129.755n 0.0v 134.745n 0.0v 134.755n 0.0v 139.745n 0.0v 139.755n 0.0v 144.745n 0.0v 144.755n 0.0v 149.745n 0.0v 149.755n 0.0v 154.745n 0.0v 154.755n 0.0v 159.745n 0.0v 159.755n 0.0v 164.745n 0.0v 164.755n 1.1v 169.745n 1.1v 169.755n 1.1v 174.745n 1.1v 174.755n 0.0v 179.745n 0.0v 179.755n 1.1v 184.745n 1.1v 184.755n 1.1v 189.745n 1.1v 189.755n 1.1v 194.745n 1.1v 194.755n 0.0v 199.745n 0.0v 199.755n 0.0v 204.745n 0.0v 204.755n 0.0v 209.745n 0.0v 209.755n 0.0v 214.745n 0.0v 214.755n 1.1v 219.745n 1.1v 219.755n 1.1v 224.745n 1.1v 224.755n 1.1v 229.745n 1.1v 229.755n 1.1v 234.745n 1.1v 234.755n 1.1v 239.745n 1.1v 239.755n 1.1v 244.745n 1.1v 244.755n 1.1v 249.745n 1.1v 249.755n 1.1v 254.745n 1.1v 254.755n 1.1v 259.745n 1.1v 259.755n 0.0v 264.745n 0.0v 264.755n 0.0v 269.745n 0.0v 269.755n 1.1v 274.745n 1.1v 274.755n 1.1v 279.745n 1.1v 279.755n 1.1v 284.745n 1.1v 284.755n 1.1v 289.745n 1.1v 289.755n 1.1v 294.745n 1.1v 294.755n 1.1v 299.745n 1.1v 299.755n 1.1v 304.745n 1.1v 304.755n 1.1v 309.745n 1.1v 309.755n 1.1v 314.745n 1.1v 314.755n 0.0v 319.745n 0.0v 319.755n 0.0v 324.745n 0.0v 324.755n 1.1v 329.745n 1.1v 329.755n 1.1v 334.745n 1.1v 334.755n 1.1v 339.745n 1.1v 339.755n 1.1v 344.745n 1.1v 344.755n 1.1v 349.745n 1.1v 349.755n 1.1v 354.745n 1.1v 354.755n 1.1v 359.745n 1.1v 359.755n 1.1v 364.745n 1.1v 364.755n 0.0v 369.745n 0.0v 369.755n 0.0v 374.745n 0.0v 374.755n 0.0v 379.745n 0.0v 379.755n 0.0v 384.745n 0.0v 384.755n 0.0v 389.745n 0.0v 389.755n 0.0v 394.745n 0.0v 394.755n 0.0v 399.745n 0.0v 399.755n 1.1v 404.745n 1.1v 404.755n 1.1v 409.745n 1.1v 409.755n 1.1v 414.745n 1.1v 414.755n 1.1v 419.745n 1.1v 419.755n 1.1v 424.745n 1.1v 424.755n 1.1v 429.745n 1.1v 429.755n 1.1v 434.745n 1.1v 434.755n 1.1v 439.745n 1.1v 439.755n 1.1v 444.745n 1.1v 444.755n 1.1v 449.745n 1.1v 449.755n 1.1v 454.745n 1.1v 454.755n 0.0v 459.745n 0.0v 459.755n 0.0v 464.745n 0.0v 464.755n 0.0v 469.745n 0.0v 469.755n 0.0v 474.745n 0.0v 474.755n 1.1v 479.745n 1.1v 479.755n 1.1v 484.745n 1.1v 484.755n 1.1v 489.745n 1.1v 489.755n 1.1v 494.745n 1.1v 494.755n 0.0v 499.745n 0.0v 499.755n 0.0v 504.745n 0.0v 504.755n 0.0v 509.745n 0.0v 509.755n 0.0v 514.745n 0.0v 514.755n 1.1v 519.745n 1.1v 519.755n 1.1v 524.745n 1.1v 524.755n 1.1v 529.745n 1.1v 529.755n 1.1v 534.745n 1.1v 534.755n 1.1v 539.745n 1.1v 539.755n 0.0v 544.745n 0.0v 544.755n 1.1v 549.745n 1.1v 549.755n 0.0v 554.745n 0.0v 554.755n 1.1v 559.745n 1.1v 559.755n 1.1v 564.745n 1.1v 564.755n 1.1v 569.745n 1.1v 569.755n 1.1v 574.745n 1.1v 574.755n 1.1v 579.745n 1.1v 579.755n 1.1v 584.745n 1.1v 584.755n 1.1v 589.745n 1.1v 589.755n 1.1v 594.745n 1.1v 594.755n 1.1v 599.745n 1.1v 599.755n 1.1v 604.745n 1.1v 604.755n 0.0v 609.745n 0.0v 609.755n 0.0v 614.745n 0.0v 614.755n 0.0v 619.745n 0.0v 619.755n 0.0v 624.745n 0.0v 624.755n 0.0v 629.745n 0.0v 629.755n 0.0v 634.745n 0.0v 634.755n 0.0v 639.745n 0.0v 639.755n 1.1v 644.745n 1.1v 644.755n 1.1v 649.745n 1.1v 649.755n 0.0v 654.745n 0.0v 654.755n 0.0v 659.745n 0.0v 659.755n 0.0v 664.745n 0.0v 664.755n 0.0v 669.745n 0.0v 669.755n 0.0v 674.745n 0.0v 674.755n 0.0v 679.745n 0.0v 679.755n 0.0v 684.745n 0.0v 684.755n 0.0v 689.745n 0.0v 689.755n 0.0v 694.745n 0.0v 694.755n 0.0v 699.745n 0.0v 699.755n 1.1v 704.745n 1.1v 704.755n 1.1v 709.745n 1.1v 709.755n 1.1v 714.745n 1.1v 714.755n 1.1v 719.745n 1.1v 719.755n 0.0v 724.745n 0.0v 724.755n 0.0v 729.745n 0.0v 729.755n 1.1v 734.745n 1.1v 734.755n 1.1v 739.745n 1.1v 739.755n 1.1v 744.745n 1.1v 744.755n 1.1v 749.745n 1.1v 749.755n 1.1v 754.745n 1.1v 754.755n 0.0v 759.745n 0.0v 759.755n 0.0v 764.745n 0.0v 764.755n 1.1v 769.745n 1.1v 769.755n 1.1v 774.745n 1.1v 774.755n 1.1v 779.745n 1.1v 779.755n 1.1v 784.745n 1.1v 784.755n 1.1v 789.745n 1.1v 789.755n 1.1v 794.745n 1.1v 794.755n 1.1v 799.745n 1.1v 799.755n 1.1v 804.745n 1.1v 804.755n 0.0v 809.745n 0.0v 809.755n 0.0v 814.745n 0.0v 814.755n 1.1v 819.745n 1.1v 819.755n 1.1v 824.745n 1.1v 824.755n 0.0v 829.745n 0.0v 829.755n 0.0v 834.745n 0.0v 834.755n 1.1v 839.745n 1.1v 839.755n 1.1v 844.745n 1.1v 844.755n 1.1v 849.745n 1.1v 849.755n 1.1v 854.745n 1.1v 854.755n 1.1v 859.745n 1.1v 859.755n 1.1v 864.745n 1.1v 864.755n 0.0v 869.745n 0.0v 869.755n 0.0v 874.745n 0.0v 874.755n 0.0v 879.745n 0.0v 879.755n 0.0v 884.745n 0.0v 884.755n 0.0v 889.745n 0.0v 889.755n 0.0v 894.745n 0.0v 894.755n 0.0v 899.745n 0.0v 899.755n 0.0v 904.745n 0.0v 904.755n 1.1v 909.745n 1.1v 909.755n 1.1v 914.745n 1.1v 914.755n 1.1v 919.745n 1.1v 919.755n 1.1v 924.745n 1.1v 924.755n 1.1v 929.745n 1.1v 929.755n 1.1v 934.745n 1.1v 934.755n 0.0v 939.745n 0.0v 939.755n 0.0v 944.745n 0.0v 944.755n 1.1v 949.745n 1.1v 949.755n 0.0v 954.745n 0.0v 954.755n 0.0v 959.745n 0.0v 959.755n 0.0v 964.745n 0.0v 964.755n 0.0v 969.745n 0.0v 969.755n 0.0v 974.745n 0.0v 974.755n 0.0v 979.745n 0.0v 979.755n 0.0v 984.745n 0.0v 984.755n 1.1v 989.745n 1.1v 989.755n 1.1v 994.745n 1.1v 994.755n 1.1v 999.745n 1.1v 999.755n 0.0v 1004.745n 0.0v 1004.755n 0.0v 1009.745n 0.0v 1009.755n 1.1v 1014.745n 1.1v 1014.755n 1.1v 1019.745n 1.1v 1019.755n 1.1v 1024.745n 1.1v 1024.755n 1.1v )
* (time, data): [(0, 0), (5, 0), (10, 1), (15, 1), (20, 1), (25, 1), (30, 1), (35, 0), (40, 0), (45, 1), (50, 0), (55, 1), (60, 1), (65, 1), (70, 1), (75, 1), (80, 0), (85, 0), (90, 0), (95, 0), (100, 0), (105, 0), (110, 0), (115, 1), (120, 1), (125, 1), (130, 1), (135, 1), (140, 1), (145, 1), (150, 1), (155, 1), (160, 1), (165, 1), (170, 1), (175, 1), (180, 0), (185, 0), (190, 0), (195, 0), (200, 0), (205, 0), (210, 0), (215, 1), (220, 1), (225, 1), (230, 0), (235, 0), (240, 0), (245, 0), (250, 0), (255, 0), (260, 1), (265, 1), (270, 0), (275, 0), (280, 0), (285, 0), (290, 0), (295, 1), (300, 1), (305, 1), (310, 1), (315, 1), (320, 1), (325, 0), (330, 0), (335, 0), (340, 0), (345, 0), (350, 1), (355, 1), (360, 0), (365, 0), (370, 0), (375, 0), (380, 0), (385, 0), (390, 0), (395, 0), (400, 1), (405, 1), (410, 1), (415, 1), (420, 1), (425, 1), (430, 1), (435, 0), (440, 0), (445, 0), (450, 0), (455, 0), (460, 0), (465, 0), (470, 0), (475, 0), (480, 0), (485, 0), (490, 0), (495, 0), (500, 0), (505, 1), (510, 1), (515, 0), (520, 0), (525, 0), (530, 0), (535, 0), (540, 1), (545, 0), (550, 1), (555, 0), (560, 0), (565, 0), (570, 0), (575, 0), (580, 1), (585, 1), (590, 1), (595, 0), (600, 0), (605, 1), (610, 1), (615, 1), (620, 0), (625, 0), (630, 1), (635, 1), (640, 1), (645, 1), (650, 0), (655, 0), (660, 0), (665, 0), (670, 0), (675, 0), (680, 0), (685, 0), (690, 0), (695, 0), (700, 1), (705, 1), (710, 1), (715, 1), (720, 1), (725, 1), (730, 0), (735, 0), (740, 0), (745, 0), (750, 0), (755, 0), (760, 0), (765, 0), (770, 0), (775, 0), (780, 0), (785, 0), (790, 0), (795, 0), (800, 0), (805, 0), (810, 0), (815, 1), (820, 1), (825, 1), (830, 0), (835, 1), (840, 1), (845, 1), (850, 1), (855, 1), (860, 0), (865, 1), (870, 0), (875, 0), (880, 0), (885, 0), (890, 0), (895, 0), (900, 0), (905, 0), (910, 0), (915, 0), (920, 0), (925, 0), (930, 1), (935, 0), (940, 0), (945, 0), (950, 1), (955, 1), (960, 1), (965, 1), (970, 1), (975, 1), (980, 1), (985, 0), (990, 1), (995, 1), (1000, 0), (1005, 0), (1010, 0), (1015, 0), (1020, 0), (1025, 0)]
Vdin0_6  din0_6  0 PWL (0n 0.0v 4.745n 0.0v 4.755n 0.0v 9.745n 0.0v 9.755n 1.1v 14.745n 1.1v 14.755n 1.1v 19.745n 1.1v 19.755n 1.1v 24.745n 1.1v 24.755n 1.1v 29.745n 1.1v 29.755n 1.1v 34.745n 1.1v 34.755n 0.0v 39.745n 0.0v 39.755n 0.0v 44.745n 0.0v 44.755n 1.1v 49.745n 1.1v 49.755n 0.0v 54.745n 0.0v 54.755n 1.1v 59.745n 1.1v 59.755n 1.1v 64.745n 1.1v 64.755n 1.1v 69.745n 1.1v 69.755n 1.1v 74.745n 1.1v 74.755n 1.1v 79.745n 1.1v 79.755n 0.0v 84.745n 0.0v 84.755n 0.0v 89.745n 0.0v 89.755n 0.0v 94.745n 0.0v 94.755n 0.0v 99.745n 0.0v 99.755n 0.0v 104.745n 0.0v 104.755n 0.0v 109.745n 0.0v 109.755n 0.0v 114.745n 0.0v 114.755n 1.1v 119.745n 1.1v 119.755n 1.1v 124.745n 1.1v 124.755n 1.1v 129.745n 1.1v 129.755n 1.1v 134.745n 1.1v 134.755n 1.1v 139.745n 1.1v 139.755n 1.1v 144.745n 1.1v 144.755n 1.1v 149.745n 1.1v 149.755n 1.1v 154.745n 1.1v 154.755n 1.1v 159.745n 1.1v 159.755n 1.1v 164.745n 1.1v 164.755n 1.1v 169.745n 1.1v 169.755n 1.1v 174.745n 1.1v 174.755n 1.1v 179.745n 1.1v 179.755n 0.0v 184.745n 0.0v 184.755n 0.0v 189.745n 0.0v 189.755n 0.0v 194.745n 0.0v 194.755n 0.0v 199.745n 0.0v 199.755n 0.0v 204.745n 0.0v 204.755n 0.0v 209.745n 0.0v 209.755n 0.0v 214.745n 0.0v 214.755n 1.1v 219.745n 1.1v 219.755n 1.1v 224.745n 1.1v 224.755n 1.1v 229.745n 1.1v 229.755n 0.0v 234.745n 0.0v 234.755n 0.0v 239.745n 0.0v 239.755n 0.0v 244.745n 0.0v 244.755n 0.0v 249.745n 0.0v 249.755n 0.0v 254.745n 0.0v 254.755n 0.0v 259.745n 0.0v 259.755n 1.1v 264.745n 1.1v 264.755n 1.1v 269.745n 1.1v 269.755n 0.0v 274.745n 0.0v 274.755n 0.0v 279.745n 0.0v 279.755n 0.0v 284.745n 0.0v 284.755n 0.0v 289.745n 0.0v 289.755n 0.0v 294.745n 0.0v 294.755n 1.1v 299.745n 1.1v 299.755n 1.1v 304.745n 1.1v 304.755n 1.1v 309.745n 1.1v 309.755n 1.1v 314.745n 1.1v 314.755n 1.1v 319.745n 1.1v 319.755n 1.1v 324.745n 1.1v 324.755n 0.0v 329.745n 0.0v 329.755n 0.0v 334.745n 0.0v 334.755n 0.0v 339.745n 0.0v 339.755n 0.0v 344.745n 0.0v 344.755n 0.0v 349.745n 0.0v 349.755n 1.1v 354.745n 1.1v 354.755n 1.1v 359.745n 1.1v 359.755n 0.0v 364.745n 0.0v 364.755n 0.0v 369.745n 0.0v 369.755n 0.0v 374.745n 0.0v 374.755n 0.0v 379.745n 0.0v 379.755n 0.0v 384.745n 0.0v 384.755n 0.0v 389.745n 0.0v 389.755n 0.0v 394.745n 0.0v 394.755n 0.0v 399.745n 0.0v 399.755n 1.1v 404.745n 1.1v 404.755n 1.1v 409.745n 1.1v 409.755n 1.1v 414.745n 1.1v 414.755n 1.1v 419.745n 1.1v 419.755n 1.1v 424.745n 1.1v 424.755n 1.1v 429.745n 1.1v 429.755n 1.1v 434.745n 1.1v 434.755n 0.0v 439.745n 0.0v 439.755n 0.0v 444.745n 0.0v 444.755n 0.0v 449.745n 0.0v 449.755n 0.0v 454.745n 0.0v 454.755n 0.0v 459.745n 0.0v 459.755n 0.0v 464.745n 0.0v 464.755n 0.0v 469.745n 0.0v 469.755n 0.0v 474.745n 0.0v 474.755n 0.0v 479.745n 0.0v 479.755n 0.0v 484.745n 0.0v 484.755n 0.0v 489.745n 0.0v 489.755n 0.0v 494.745n 0.0v 494.755n 0.0v 499.745n 0.0v 499.755n 0.0v 504.745n 0.0v 504.755n 1.1v 509.745n 1.1v 509.755n 1.1v 514.745n 1.1v 514.755n 0.0v 519.745n 0.0v 519.755n 0.0v 524.745n 0.0v 524.755n 0.0v 529.745n 0.0v 529.755n 0.0v 534.745n 0.0v 534.755n 0.0v 539.745n 0.0v 539.755n 1.1v 544.745n 1.1v 544.755n 0.0v 549.745n 0.0v 549.755n 1.1v 554.745n 1.1v 554.755n 0.0v 559.745n 0.0v 559.755n 0.0v 564.745n 0.0v 564.755n 0.0v 569.745n 0.0v 569.755n 0.0v 574.745n 0.0v 574.755n 0.0v 579.745n 0.0v 579.755n 1.1v 584.745n 1.1v 584.755n 1.1v 589.745n 1.1v 589.755n 1.1v 594.745n 1.1v 594.755n 0.0v 599.745n 0.0v 599.755n 0.0v 604.745n 0.0v 604.755n 1.1v 609.745n 1.1v 609.755n 1.1v 614.745n 1.1v 614.755n 1.1v 619.745n 1.1v 619.755n 0.0v 624.745n 0.0v 624.755n 0.0v 629.745n 0.0v 629.755n 1.1v 634.745n 1.1v 634.755n 1.1v 639.745n 1.1v 639.755n 1.1v 644.745n 1.1v 644.755n 1.1v 649.745n 1.1v 649.755n 0.0v 654.745n 0.0v 654.755n 0.0v 659.745n 0.0v 659.755n 0.0v 664.745n 0.0v 664.755n 0.0v 669.745n 0.0v 669.755n 0.0v 674.745n 0.0v 674.755n 0.0v 679.745n 0.0v 679.755n 0.0v 684.745n 0.0v 684.755n 0.0v 689.745n 0.0v 689.755n 0.0v 694.745n 0.0v 694.755n 0.0v 699.745n 0.0v 699.755n 1.1v 704.745n 1.1v 704.755n 1.1v 709.745n 1.1v 709.755n 1.1v 714.745n 1.1v 714.755n 1.1v 719.745n 1.1v 719.755n 1.1v 724.745n 1.1v 724.755n 1.1v 729.745n 1.1v 729.755n 0.0v 734.745n 0.0v 734.755n 0.0v 739.745n 0.0v 739.755n 0.0v 744.745n 0.0v 744.755n 0.0v 749.745n 0.0v 749.755n 0.0v 754.745n 0.0v 754.755n 0.0v 759.745n 0.0v 759.755n 0.0v 764.745n 0.0v 764.755n 0.0v 769.745n 0.0v 769.755n 0.0v 774.745n 0.0v 774.755n 0.0v 779.745n 0.0v 779.755n 0.0v 784.745n 0.0v 784.755n 0.0v 789.745n 0.0v 789.755n 0.0v 794.745n 0.0v 794.755n 0.0v 799.745n 0.0v 799.755n 0.0v 804.745n 0.0v 804.755n 0.0v 809.745n 0.0v 809.755n 0.0v 814.745n 0.0v 814.755n 1.1v 819.745n 1.1v 819.755n 1.1v 824.745n 1.1v 824.755n 1.1v 829.745n 1.1v 829.755n 0.0v 834.745n 0.0v 834.755n 1.1v 839.745n 1.1v 839.755n 1.1v 844.745n 1.1v 844.755n 1.1v 849.745n 1.1v 849.755n 1.1v 854.745n 1.1v 854.755n 1.1v 859.745n 1.1v 859.755n 0.0v 864.745n 0.0v 864.755n 1.1v 869.745n 1.1v 869.755n 0.0v 874.745n 0.0v 874.755n 0.0v 879.745n 0.0v 879.755n 0.0v 884.745n 0.0v 884.755n 0.0v 889.745n 0.0v 889.755n 0.0v 894.745n 0.0v 894.755n 0.0v 899.745n 0.0v 899.755n 0.0v 904.745n 0.0v 904.755n 0.0v 909.745n 0.0v 909.755n 0.0v 914.745n 0.0v 914.755n 0.0v 919.745n 0.0v 919.755n 0.0v 924.745n 0.0v 924.755n 0.0v 929.745n 0.0v 929.755n 1.1v 934.745n 1.1v 934.755n 0.0v 939.745n 0.0v 939.755n 0.0v 944.745n 0.0v 944.755n 0.0v 949.745n 0.0v 949.755n 1.1v 954.745n 1.1v 954.755n 1.1v 959.745n 1.1v 959.755n 1.1v 964.745n 1.1v 964.755n 1.1v 969.745n 1.1v 969.755n 1.1v 974.745n 1.1v 974.755n 1.1v 979.745n 1.1v 979.755n 1.1v 984.745n 1.1v 984.755n 0.0v 989.745n 0.0v 989.755n 1.1v 994.745n 1.1v 994.755n 1.1v 999.745n 1.1v 999.755n 0.0v 1004.745n 0.0v 1004.755n 0.0v 1009.745n 0.0v 1009.755n 0.0v 1014.745n 0.0v 1014.755n 0.0v 1019.745n 0.0v 1019.755n 0.0v 1024.745n 0.0v 1024.755n 0.0v )
* (time, data): [(0, 0), (5, 0), (10, 0), (15, 0), (20, 0), (25, 0), (30, 0), (35, 1), (40, 1), (45, 1), (50, 0), (55, 1), (60, 1), (65, 1), (70, 1), (75, 1), (80, 1), (85, 1), (90, 1), (95, 1), (100, 1), (105, 1), (110, 1), (115, 0), (120, 0), (125, 0), (130, 0), (135, 1), (140, 0), (145, 0), (150, 0), (155, 0), (160, 0), (165, 0), (170, 0), (175, 1), (180, 1), (185, 1), (190, 1), (195, 0), (200, 0), (205, 0), (210, 1), (215, 1), (220, 1), (225, 1), (230, 0), (235, 0), (240, 0), (245, 0), (250, 0), (255, 0), (260, 1), (265, 1), (270, 1), (275, 1), (280, 1), (285, 1), (290, 1), (295, 0), (300, 0), (305, 0), (310, 0), (315, 1), (320, 1), (325, 1), (330, 1), (335, 1), (340, 1), (345, 1), (350, 1), (355, 1), (360, 0), (365, 1), (370, 0), (375, 0), (380, 1), (385, 1), (390, 1), (395, 1), (400, 0), (405, 0), (410, 0), (415, 0), (420, 0), (425, 0), (430, 0), (435, 0), (440, 0), (445, 0), (450, 0), (455, 0), (460, 1), (465, 1), (470, 1), (475, 0), (480, 0), (485, 0), (490, 0), (495, 0), (500, 0), (505, 1), (510, 1), (515, 0), (520, 0), (525, 0), (530, 0), (535, 0), (540, 0), (545, 1), (550, 1), (555, 0), (560, 0), (565, 0), (570, 0), (575, 0), (580, 0), (585, 1), (590, 1), (595, 1), (600, 1), (605, 0), (610, 0), (615, 0), (620, 1), (625, 1), (630, 0), (635, 0), (640, 1), (645, 1), (650, 1), (655, 1), (660, 1), (665, 1), (670, 1), (675, 1), (680, 1), (685, 1), (690, 1), (695, 1), (700, 0), (705, 1), (710, 1), (715, 1), (720, 0), (725, 0), (730, 0), (735, 0), (740, 0), (745, 0), (750, 0), (755, 0), (760, 0), (765, 1), (770, 1), (775, 1), (780, 1), (785, 0), (790, 0), (795, 0), (800, 0), (805, 0), (810, 0), (815, 1), (820, 1), (825, 0), (830, 0), (835, 0), (840, 0), (845, 0), (850, 0), (855, 0), (860, 0), (865, 1), (870, 1), (875, 1), (880, 1), (885, 1), (890, 1), (895, 1), (900, 1), (905, 1), (910, 1), (915, 1), (920, 1), (925, 1), (930, 1), (935, 0), (940, 0), (945, 1), (950, 0), (955, 0), (960, 0), (965, 0), (970, 0), (975, 0), (980, 0), (985, 1), (990, 0), (995, 0), (1000, 1), (1005, 1), (1010, 1), (1015, 1), (1020, 1), (1025, 1)]
Vdin0_7  din0_7  0 PWL (0n 0.0v 4.745n 0.0v 4.755n 0.0v 9.745n 0.0v 9.755n 0.0v 14.745n 0.0v 14.755n 0.0v 19.745n 0.0v 19.755n 0.0v 24.745n 0.0v 24.755n 0.0v 29.745n 0.0v 29.755n 0.0v 34.745n 0.0v 34.755n 1.1v 39.745n 1.1v 39.755n 1.1v 44.745n 1.1v 44.755n 1.1v 49.745n 1.1v 49.755n 0.0v 54.745n 0.0v 54.755n 1.1v 59.745n 1.1v 59.755n 1.1v 64.745n 1.1v 64.755n 1.1v 69.745n 1.1v 69.755n 1.1v 74.745n 1.1v 74.755n 1.1v 79.745n 1.1v 79.755n 1.1v 84.745n 1.1v 84.755n 1.1v 89.745n 1.1v 89.755n 1.1v 94.745n 1.1v 94.755n 1.1v 99.745n 1.1v 99.755n 1.1v 104.745n 1.1v 104.755n 1.1v 109.745n 1.1v 109.755n 1.1v 114.745n 1.1v 114.755n 0.0v 119.745n 0.0v 119.755n 0.0v 124.745n 0.0v 124.755n 0.0v 129.745n 0.0v 129.755n 0.0v 134.745n 0.0v 134.755n 1.1v 139.745n 1.1v 139.755n 0.0v 144.745n 0.0v 144.755n 0.0v 149.745n 0.0v 149.755n 0.0v 154.745n 0.0v 154.755n 0.0v 159.745n 0.0v 159.755n 0.0v 164.745n 0.0v 164.755n 0.0v 169.745n 0.0v 169.755n 0.0v 174.745n 0.0v 174.755n 1.1v 179.745n 1.1v 179.755n 1.1v 184.745n 1.1v 184.755n 1.1v 189.745n 1.1v 189.755n 1.1v 194.745n 1.1v 194.755n 0.0v 199.745n 0.0v 199.755n 0.0v 204.745n 0.0v 204.755n 0.0v 209.745n 0.0v 209.755n 1.1v 214.745n 1.1v 214.755n 1.1v 219.745n 1.1v 219.755n 1.1v 224.745n 1.1v 224.755n 1.1v 229.745n 1.1v 229.755n 0.0v 234.745n 0.0v 234.755n 0.0v 239.745n 0.0v 239.755n 0.0v 244.745n 0.0v 244.755n 0.0v 249.745n 0.0v 249.755n 0.0v 254.745n 0.0v 254.755n 0.0v 259.745n 0.0v 259.755n 1.1v 264.745n 1.1v 264.755n 1.1v 269.745n 1.1v 269.755n 1.1v 274.745n 1.1v 274.755n 1.1v 279.745n 1.1v 279.755n 1.1v 284.745n 1.1v 284.755n 1.1v 289.745n 1.1v 289.755n 1.1v 294.745n 1.1v 294.755n 0.0v 299.745n 0.0v 299.755n 0.0v 304.745n 0.0v 304.755n 0.0v 309.745n 0.0v 309.755n 0.0v 314.745n 0.0v 314.755n 1.1v 319.745n 1.1v 319.755n 1.1v 324.745n 1.1v 324.755n 1.1v 329.745n 1.1v 329.755n 1.1v 334.745n 1.1v 334.755n 1.1v 339.745n 1.1v 339.755n 1.1v 344.745n 1.1v 344.755n 1.1v 349.745n 1.1v 349.755n 1.1v 354.745n 1.1v 354.755n 1.1v 359.745n 1.1v 359.755n 0.0v 364.745n 0.0v 364.755n 1.1v 369.745n 1.1v 369.755n 0.0v 374.745n 0.0v 374.755n 0.0v 379.745n 0.0v 379.755n 1.1v 384.745n 1.1v 384.755n 1.1v 389.745n 1.1v 389.755n 1.1v 394.745n 1.1v 394.755n 1.1v 399.745n 1.1v 399.755n 0.0v 404.745n 0.0v 404.755n 0.0v 409.745n 0.0v 409.755n 0.0v 414.745n 0.0v 414.755n 0.0v 419.745n 0.0v 419.755n 0.0v 424.745n 0.0v 424.755n 0.0v 429.745n 0.0v 429.755n 0.0v 434.745n 0.0v 434.755n 0.0v 439.745n 0.0v 439.755n 0.0v 444.745n 0.0v 444.755n 0.0v 449.745n 0.0v 449.755n 0.0v 454.745n 0.0v 454.755n 0.0v 459.745n 0.0v 459.755n 1.1v 464.745n 1.1v 464.755n 1.1v 469.745n 1.1v 469.755n 1.1v 474.745n 1.1v 474.755n 0.0v 479.745n 0.0v 479.755n 0.0v 484.745n 0.0v 484.755n 0.0v 489.745n 0.0v 489.755n 0.0v 494.745n 0.0v 494.755n 0.0v 499.745n 0.0v 499.755n 0.0v 504.745n 0.0v 504.755n 1.1v 509.745n 1.1v 509.755n 1.1v 514.745n 1.1v 514.755n 0.0v 519.745n 0.0v 519.755n 0.0v 524.745n 0.0v 524.755n 0.0v 529.745n 0.0v 529.755n 0.0v 534.745n 0.0v 534.755n 0.0v 539.745n 0.0v 539.755n 0.0v 544.745n 0.0v 544.755n 1.1v 549.745n 1.1v 549.755n 1.1v 554.745n 1.1v 554.755n 0.0v 559.745n 0.0v 559.755n 0.0v 564.745n 0.0v 564.755n 0.0v 569.745n 0.0v 569.755n 0.0v 574.745n 0.0v 574.755n 0.0v 579.745n 0.0v 579.755n 0.0v 584.745n 0.0v 584.755n 1.1v 589.745n 1.1v 589.755n 1.1v 594.745n 1.1v 594.755n 1.1v 599.745n 1.1v 599.755n 1.1v 604.745n 1.1v 604.755n 0.0v 609.745n 0.0v 609.755n 0.0v 614.745n 0.0v 614.755n 0.0v 619.745n 0.0v 619.755n 1.1v 624.745n 1.1v 624.755n 1.1v 629.745n 1.1v 629.755n 0.0v 634.745n 0.0v 634.755n 0.0v 639.745n 0.0v 639.755n 1.1v 644.745n 1.1v 644.755n 1.1v 649.745n 1.1v 649.755n 1.1v 654.745n 1.1v 654.755n 1.1v 659.745n 1.1v 659.755n 1.1v 664.745n 1.1v 664.755n 1.1v 669.745n 1.1v 669.755n 1.1v 674.745n 1.1v 674.755n 1.1v 679.745n 1.1v 679.755n 1.1v 684.745n 1.1v 684.755n 1.1v 689.745n 1.1v 689.755n 1.1v 694.745n 1.1v 694.755n 1.1v 699.745n 1.1v 699.755n 0.0v 704.745n 0.0v 704.755n 1.1v 709.745n 1.1v 709.755n 1.1v 714.745n 1.1v 714.755n 1.1v 719.745n 1.1v 719.755n 0.0v 724.745n 0.0v 724.755n 0.0v 729.745n 0.0v 729.755n 0.0v 734.745n 0.0v 734.755n 0.0v 739.745n 0.0v 739.755n 0.0v 744.745n 0.0v 744.755n 0.0v 749.745n 0.0v 749.755n 0.0v 754.745n 0.0v 754.755n 0.0v 759.745n 0.0v 759.755n 0.0v 764.745n 0.0v 764.755n 1.1v 769.745n 1.1v 769.755n 1.1v 774.745n 1.1v 774.755n 1.1v 779.745n 1.1v 779.755n 1.1v 784.745n 1.1v 784.755n 0.0v 789.745n 0.0v 789.755n 0.0v 794.745n 0.0v 794.755n 0.0v 799.745n 0.0v 799.755n 0.0v 804.745n 0.0v 804.755n 0.0v 809.745n 0.0v 809.755n 0.0v 814.745n 0.0v 814.755n 1.1v 819.745n 1.1v 819.755n 1.1v 824.745n 1.1v 824.755n 0.0v 829.745n 0.0v 829.755n 0.0v 834.745n 0.0v 834.755n 0.0v 839.745n 0.0v 839.755n 0.0v 844.745n 0.0v 844.755n 0.0v 849.745n 0.0v 849.755n 0.0v 854.745n 0.0v 854.755n 0.0v 859.745n 0.0v 859.755n 0.0v 864.745n 0.0v 864.755n 1.1v 869.745n 1.1v 869.755n 1.1v 874.745n 1.1v 874.755n 1.1v 879.745n 1.1v 879.755n 1.1v 884.745n 1.1v 884.755n 1.1v 889.745n 1.1v 889.755n 1.1v 894.745n 1.1v 894.755n 1.1v 899.745n 1.1v 899.755n 1.1v 904.745n 1.1v 904.755n 1.1v 909.745n 1.1v 909.755n 1.1v 914.745n 1.1v 914.755n 1.1v 919.745n 1.1v 919.755n 1.1v 924.745n 1.1v 924.755n 1.1v 929.745n 1.1v 929.755n 1.1v 934.745n 1.1v 934.755n 0.0v 939.745n 0.0v 939.755n 0.0v 944.745n 0.0v 944.755n 1.1v 949.745n 1.1v 949.755n 0.0v 954.745n 0.0v 954.755n 0.0v 959.745n 0.0v 959.755n 0.0v 964.745n 0.0v 964.755n 0.0v 969.745n 0.0v 969.755n 0.0v 974.745n 0.0v 974.755n 0.0v 979.745n 0.0v 979.755n 0.0v 984.745n 0.0v 984.755n 1.1v 989.745n 1.1v 989.755n 0.0v 994.745n 0.0v 994.755n 0.0v 999.745n 0.0v 999.755n 1.1v 1004.745n 1.1v 1004.755n 1.1v 1009.745n 1.1v 1009.755n 1.1v 1014.745n 1.1v 1014.755n 1.1v 1019.745n 1.1v 1019.755n 1.1v 1024.745n 1.1v 1024.755n 1.1v )
* (time, data): [(0, 0), (5, 1), (10, 1), (15, 0), (20, 0), (25, 0), (30, 0), (35, 0), (40, 0), (45, 1), (50, 1), (55, 0), (60, 0), (65, 0), (70, 0), (75, 0), (80, 0), (85, 0), (90, 0), (95, 0), (100, 0), (105, 0), (110, 0), (115, 1), (120, 1), (125, 1), (130, 1), (135, 0), (140, 1), (145, 1), (150, 1), (155, 1), (160, 1), (165, 0), (170, 0), (175, 1), (180, 1), (185, 1), (190, 1), (195, 0), (200, 0), (205, 0), (210, 0), (215, 1), (220, 1), (225, 1), (230, 1), (235, 1), (240, 1), (245, 1), (250, 1), (255, 1), (260, 1), (265, 1), (270, 1), (275, 1), (280, 1), (285, 1), (290, 1), (295, 1), (300, 1), (305, 1), (310, 1), (315, 1), (320, 1), (325, 0), (330, 0), (335, 0), (340, 0), (345, 0), (350, 1), (355, 1), (360, 0), (365, 1), (370, 0), (375, 0), (380, 1), (385, 1), (390, 1), (395, 1), (400, 0), (405, 0), (410, 0), (415, 0), (420, 0), (425, 0), (430, 0), (435, 0), (440, 0), (445, 0), (450, 0), (455, 0), (460, 1), (465, 1), (470, 1), (475, 1), (480, 1), (485, 0), (490, 0), (495, 1), (500, 1), (505, 1), (510, 1), (515, 1), (520, 1), (525, 1), (530, 1), (535, 1), (540, 0), (545, 1), (550, 0), (555, 1), (560, 1), (565, 1), (570, 1), (575, 1), (580, 1), (585, 1), (590, 1), (595, 1), (600, 1), (605, 0), (610, 0), (615, 0), (620, 1), (625, 1), (630, 1), (635, 1), (640, 0), (645, 0), (650, 0), (655, 0), (660, 0), (665, 0), (670, 0), (675, 0), (680, 0), (685, 0), (690, 0), (695, 0), (700, 1), (705, 1), (710, 1), (715, 1), (720, 0), (725, 0), (730, 1), (735, 1), (740, 1), (745, 1), (750, 1), (755, 0), (760, 0), (765, 0), (770, 0), (775, 0), (780, 0), (785, 1), (790, 1), (795, 1), (800, 1), (805, 1), (810, 1), (815, 1), (820, 1), (825, 1), (830, 1), (835, 0), (840, 0), (845, 0), (850, 0), (855, 0), (860, 1), (865, 0), (870, 1), (875, 1), (880, 1), (885, 1), (890, 1), (895, 1), (900, 1), (905, 0), (910, 0), (915, 0), (920, 0), (925, 0), (930, 1), (935, 1), (940, 1), (945, 1), (950, 0), (955, 0), (960, 0), (965, 0), (970, 0), (975, 0), (980, 0), (985, 0), (990, 1), (995, 1), (1000, 0), (1005, 0), (1010, 1), (1015, 1), (1020, 1), (1025, 1)]
Vdin0_8  din0_8  0 PWL (0n 0.0v 4.745n 0.0v 4.755n 1.1v 9.745n 1.1v 9.755n 1.1v 14.745n 1.1v 14.755n 0.0v 19.745n 0.0v 19.755n 0.0v 24.745n 0.0v 24.755n 0.0v 29.745n 0.0v 29.755n 0.0v 34.745n 0.0v 34.755n 0.0v 39.745n 0.0v 39.755n 0.0v 44.745n 0.0v 44.755n 1.1v 49.745n 1.1v 49.755n 1.1v 54.745n 1.1v 54.755n 0.0v 59.745n 0.0v 59.755n 0.0v 64.745n 0.0v 64.755n 0.0v 69.745n 0.0v 69.755n 0.0v 74.745n 0.0v 74.755n 0.0v 79.745n 0.0v 79.755n 0.0v 84.745n 0.0v 84.755n 0.0v 89.745n 0.0v 89.755n 0.0v 94.745n 0.0v 94.755n 0.0v 99.745n 0.0v 99.755n 0.0v 104.745n 0.0v 104.755n 0.0v 109.745n 0.0v 109.755n 0.0v 114.745n 0.0v 114.755n 1.1v 119.745n 1.1v 119.755n 1.1v 124.745n 1.1v 124.755n 1.1v 129.745n 1.1v 129.755n 1.1v 134.745n 1.1v 134.755n 0.0v 139.745n 0.0v 139.755n 1.1v 144.745n 1.1v 144.755n 1.1v 149.745n 1.1v 149.755n 1.1v 154.745n 1.1v 154.755n 1.1v 159.745n 1.1v 159.755n 1.1v 164.745n 1.1v 164.755n 0.0v 169.745n 0.0v 169.755n 0.0v 174.745n 0.0v 174.755n 1.1v 179.745n 1.1v 179.755n 1.1v 184.745n 1.1v 184.755n 1.1v 189.745n 1.1v 189.755n 1.1v 194.745n 1.1v 194.755n 0.0v 199.745n 0.0v 199.755n 0.0v 204.745n 0.0v 204.755n 0.0v 209.745n 0.0v 209.755n 0.0v 214.745n 0.0v 214.755n 1.1v 219.745n 1.1v 219.755n 1.1v 224.745n 1.1v 224.755n 1.1v 229.745n 1.1v 229.755n 1.1v 234.745n 1.1v 234.755n 1.1v 239.745n 1.1v 239.755n 1.1v 244.745n 1.1v 244.755n 1.1v 249.745n 1.1v 249.755n 1.1v 254.745n 1.1v 254.755n 1.1v 259.745n 1.1v 259.755n 1.1v 264.745n 1.1v 264.755n 1.1v 269.745n 1.1v 269.755n 1.1v 274.745n 1.1v 274.755n 1.1v 279.745n 1.1v 279.755n 1.1v 284.745n 1.1v 284.755n 1.1v 289.745n 1.1v 289.755n 1.1v 294.745n 1.1v 294.755n 1.1v 299.745n 1.1v 299.755n 1.1v 304.745n 1.1v 304.755n 1.1v 309.745n 1.1v 309.755n 1.1v 314.745n 1.1v 314.755n 1.1v 319.745n 1.1v 319.755n 1.1v 324.745n 1.1v 324.755n 0.0v 329.745n 0.0v 329.755n 0.0v 334.745n 0.0v 334.755n 0.0v 339.745n 0.0v 339.755n 0.0v 344.745n 0.0v 344.755n 0.0v 349.745n 0.0v 349.755n 1.1v 354.745n 1.1v 354.755n 1.1v 359.745n 1.1v 359.755n 0.0v 364.745n 0.0v 364.755n 1.1v 369.745n 1.1v 369.755n 0.0v 374.745n 0.0v 374.755n 0.0v 379.745n 0.0v 379.755n 1.1v 384.745n 1.1v 384.755n 1.1v 389.745n 1.1v 389.755n 1.1v 394.745n 1.1v 394.755n 1.1v 399.745n 1.1v 399.755n 0.0v 404.745n 0.0v 404.755n 0.0v 409.745n 0.0v 409.755n 0.0v 414.745n 0.0v 414.755n 0.0v 419.745n 0.0v 419.755n 0.0v 424.745n 0.0v 424.755n 0.0v 429.745n 0.0v 429.755n 0.0v 434.745n 0.0v 434.755n 0.0v 439.745n 0.0v 439.755n 0.0v 444.745n 0.0v 444.755n 0.0v 449.745n 0.0v 449.755n 0.0v 454.745n 0.0v 454.755n 0.0v 459.745n 0.0v 459.755n 1.1v 464.745n 1.1v 464.755n 1.1v 469.745n 1.1v 469.755n 1.1v 474.745n 1.1v 474.755n 1.1v 479.745n 1.1v 479.755n 1.1v 484.745n 1.1v 484.755n 0.0v 489.745n 0.0v 489.755n 0.0v 494.745n 0.0v 494.755n 1.1v 499.745n 1.1v 499.755n 1.1v 504.745n 1.1v 504.755n 1.1v 509.745n 1.1v 509.755n 1.1v 514.745n 1.1v 514.755n 1.1v 519.745n 1.1v 519.755n 1.1v 524.745n 1.1v 524.755n 1.1v 529.745n 1.1v 529.755n 1.1v 534.745n 1.1v 534.755n 1.1v 539.745n 1.1v 539.755n 0.0v 544.745n 0.0v 544.755n 1.1v 549.745n 1.1v 549.755n 0.0v 554.745n 0.0v 554.755n 1.1v 559.745n 1.1v 559.755n 1.1v 564.745n 1.1v 564.755n 1.1v 569.745n 1.1v 569.755n 1.1v 574.745n 1.1v 574.755n 1.1v 579.745n 1.1v 579.755n 1.1v 584.745n 1.1v 584.755n 1.1v 589.745n 1.1v 589.755n 1.1v 594.745n 1.1v 594.755n 1.1v 599.745n 1.1v 599.755n 1.1v 604.745n 1.1v 604.755n 0.0v 609.745n 0.0v 609.755n 0.0v 614.745n 0.0v 614.755n 0.0v 619.745n 0.0v 619.755n 1.1v 624.745n 1.1v 624.755n 1.1v 629.745n 1.1v 629.755n 1.1v 634.745n 1.1v 634.755n 1.1v 639.745n 1.1v 639.755n 0.0v 644.745n 0.0v 644.755n 0.0v 649.745n 0.0v 649.755n 0.0v 654.745n 0.0v 654.755n 0.0v 659.745n 0.0v 659.755n 0.0v 664.745n 0.0v 664.755n 0.0v 669.745n 0.0v 669.755n 0.0v 674.745n 0.0v 674.755n 0.0v 679.745n 0.0v 679.755n 0.0v 684.745n 0.0v 684.755n 0.0v 689.745n 0.0v 689.755n 0.0v 694.745n 0.0v 694.755n 0.0v 699.745n 0.0v 699.755n 1.1v 704.745n 1.1v 704.755n 1.1v 709.745n 1.1v 709.755n 1.1v 714.745n 1.1v 714.755n 1.1v 719.745n 1.1v 719.755n 0.0v 724.745n 0.0v 724.755n 0.0v 729.745n 0.0v 729.755n 1.1v 734.745n 1.1v 734.755n 1.1v 739.745n 1.1v 739.755n 1.1v 744.745n 1.1v 744.755n 1.1v 749.745n 1.1v 749.755n 1.1v 754.745n 1.1v 754.755n 0.0v 759.745n 0.0v 759.755n 0.0v 764.745n 0.0v 764.755n 0.0v 769.745n 0.0v 769.755n 0.0v 774.745n 0.0v 774.755n 0.0v 779.745n 0.0v 779.755n 0.0v 784.745n 0.0v 784.755n 1.1v 789.745n 1.1v 789.755n 1.1v 794.745n 1.1v 794.755n 1.1v 799.745n 1.1v 799.755n 1.1v 804.745n 1.1v 804.755n 1.1v 809.745n 1.1v 809.755n 1.1v 814.745n 1.1v 814.755n 1.1v 819.745n 1.1v 819.755n 1.1v 824.745n 1.1v 824.755n 1.1v 829.745n 1.1v 829.755n 1.1v 834.745n 1.1v 834.755n 0.0v 839.745n 0.0v 839.755n 0.0v 844.745n 0.0v 844.755n 0.0v 849.745n 0.0v 849.755n 0.0v 854.745n 0.0v 854.755n 0.0v 859.745n 0.0v 859.755n 1.1v 864.745n 1.1v 864.755n 0.0v 869.745n 0.0v 869.755n 1.1v 874.745n 1.1v 874.755n 1.1v 879.745n 1.1v 879.755n 1.1v 884.745n 1.1v 884.755n 1.1v 889.745n 1.1v 889.755n 1.1v 894.745n 1.1v 894.755n 1.1v 899.745n 1.1v 899.755n 1.1v 904.745n 1.1v 904.755n 0.0v 909.745n 0.0v 909.755n 0.0v 914.745n 0.0v 914.755n 0.0v 919.745n 0.0v 919.755n 0.0v 924.745n 0.0v 924.755n 0.0v 929.745n 0.0v 929.755n 1.1v 934.745n 1.1v 934.755n 1.1v 939.745n 1.1v 939.755n 1.1v 944.745n 1.1v 944.755n 1.1v 949.745n 1.1v 949.755n 0.0v 954.745n 0.0v 954.755n 0.0v 959.745n 0.0v 959.755n 0.0v 964.745n 0.0v 964.755n 0.0v 969.745n 0.0v 969.755n 0.0v 974.745n 0.0v 974.755n 0.0v 979.745n 0.0v 979.755n 0.0v 984.745n 0.0v 984.755n 0.0v 989.745n 0.0v 989.755n 1.1v 994.745n 1.1v 994.755n 1.1v 999.745n 1.1v 999.755n 0.0v 1004.745n 0.0v 1004.755n 0.0v 1009.745n 0.0v 1009.755n 1.1v 1014.745n 1.1v 1014.755n 1.1v 1019.745n 1.1v 1019.755n 1.1v 1024.745n 1.1v 1024.755n 1.1v )
* (time, data): [(0, 0), (5, 0), (10, 0), (15, 0), (20, 0), (25, 0), (30, 0), (35, 1), (40, 1), (45, 0), (50, 0), (55, 1), (60, 1), (65, 1), (70, 1), (75, 1), (80, 0), (85, 0), (90, 0), (95, 0), (100, 0), (105, 0), (110, 0), (115, 0), (120, 0), (125, 0), (130, 0), (135, 1), (140, 1), (145, 1), (150, 0), (155, 0), (160, 0), (165, 1), (170, 1), (175, 1), (180, 0), (185, 0), (190, 0), (195, 0), (200, 0), (205, 0), (210, 0), (215, 1), (220, 1), (225, 1), (230, 1), (235, 1), (240, 1), (245, 1), (250, 1), (255, 1), (260, 0), (265, 0), (270, 0), (275, 0), (280, 0), (285, 0), (290, 0), (295, 0), (300, 0), (305, 0), (310, 0), (315, 0), (320, 0), (325, 0), (330, 0), (335, 0), (340, 0), (345, 0), (350, 0), (355, 0), (360, 0), (365, 1), (370, 1), (375, 1), (380, 0), (385, 0), (390, 0), (395, 0), (400, 0), (405, 0), (410, 1), (415, 1), (420, 1), (425, 1), (430, 1), (435, 0), (440, 0), (445, 0), (450, 0), (455, 0), (460, 1), (465, 1), (470, 1), (475, 0), (480, 0), (485, 0), (490, 0), (495, 0), (500, 0), (505, 1), (510, 1), (515, 1), (520, 1), (525, 1), (530, 1), (535, 1), (540, 1), (545, 0), (550, 0), (555, 0), (560, 0), (565, 0), (570, 0), (575, 0), (580, 1), (585, 0), (590, 0), (595, 0), (600, 0), (605, 0), (610, 0), (615, 0), (620, 0), (625, 0), (630, 0), (635, 1), (640, 0), (645, 0), (650, 1), (655, 1), (660, 1), (665, 1), (670, 1), (675, 1), (680, 1), (685, 1), (690, 1), (695, 1), (700, 0), (705, 1), (710, 1), (715, 1), (720, 0), (725, 0), (730, 0), (735, 0), (740, 0), (745, 0), (750, 0), (755, 0), (760, 0), (765, 1), (770, 1), (775, 1), (780, 1), (785, 1), (790, 1), (795, 1), (800, 1), (805, 0), (810, 0), (815, 1), (820, 1), (825, 0), (830, 0), (835, 0), (840, 0), (845, 0), (850, 0), (855, 0), (860, 1), (865, 1), (870, 0), (875, 0), (880, 0), (885, 0), (890, 0), (895, 0), (900, 0), (905, 0), (910, 0), (915, 0), (920, 0), (925, 0), (930, 1), (935, 0), (940, 0), (945, 0), (950, 1), (955, 1), (960, 1), (965, 1), (970, 1), (975, 1), (980, 1), (985, 0), (990, 1), (995, 1), (1000, 1), (1005, 1), (1010, 0), (1015, 0), (1020, 0), (1025, 0)]
Vdin0_9  din0_9  0 PWL (0n 0.0v 4.745n 0.0v 4.755n 0.0v 9.745n 0.0v 9.755n 0.0v 14.745n 0.0v 14.755n 0.0v 19.745n 0.0v 19.755n 0.0v 24.745n 0.0v 24.755n 0.0v 29.745n 0.0v 29.755n 0.0v 34.745n 0.0v 34.755n 1.1v 39.745n 1.1v 39.755n 1.1v 44.745n 1.1v 44.755n 0.0v 49.745n 0.0v 49.755n 0.0v 54.745n 0.0v 54.755n 1.1v 59.745n 1.1v 59.755n 1.1v 64.745n 1.1v 64.755n 1.1v 69.745n 1.1v 69.755n 1.1v 74.745n 1.1v 74.755n 1.1v 79.745n 1.1v 79.755n 0.0v 84.745n 0.0v 84.755n 0.0v 89.745n 0.0v 89.755n 0.0v 94.745n 0.0v 94.755n 0.0v 99.745n 0.0v 99.755n 0.0v 104.745n 0.0v 104.755n 0.0v 109.745n 0.0v 109.755n 0.0v 114.745n 0.0v 114.755n 0.0v 119.745n 0.0v 119.755n 0.0v 124.745n 0.0v 124.755n 0.0v 129.745n 0.0v 129.755n 0.0v 134.745n 0.0v 134.755n 1.1v 139.745n 1.1v 139.755n 1.1v 144.745n 1.1v 144.755n 1.1v 149.745n 1.1v 149.755n 0.0v 154.745n 0.0v 154.755n 0.0v 159.745n 0.0v 159.755n 0.0v 164.745n 0.0v 164.755n 1.1v 169.745n 1.1v 169.755n 1.1v 174.745n 1.1v 174.755n 1.1v 179.745n 1.1v 179.755n 0.0v 184.745n 0.0v 184.755n 0.0v 189.745n 0.0v 189.755n 0.0v 194.745n 0.0v 194.755n 0.0v 199.745n 0.0v 199.755n 0.0v 204.745n 0.0v 204.755n 0.0v 209.745n 0.0v 209.755n 0.0v 214.745n 0.0v 214.755n 1.1v 219.745n 1.1v 219.755n 1.1v 224.745n 1.1v 224.755n 1.1v 229.745n 1.1v 229.755n 1.1v 234.745n 1.1v 234.755n 1.1v 239.745n 1.1v 239.755n 1.1v 244.745n 1.1v 244.755n 1.1v 249.745n 1.1v 249.755n 1.1v 254.745n 1.1v 254.755n 1.1v 259.745n 1.1v 259.755n 0.0v 264.745n 0.0v 264.755n 0.0v 269.745n 0.0v 269.755n 0.0v 274.745n 0.0v 274.755n 0.0v 279.745n 0.0v 279.755n 0.0v 284.745n 0.0v 284.755n 0.0v 289.745n 0.0v 289.755n 0.0v 294.745n 0.0v 294.755n 0.0v 299.745n 0.0v 299.755n 0.0v 304.745n 0.0v 304.755n 0.0v 309.745n 0.0v 309.755n 0.0v 314.745n 0.0v 314.755n 0.0v 319.745n 0.0v 319.755n 0.0v 324.745n 0.0v 324.755n 0.0v 329.745n 0.0v 329.755n 0.0v 334.745n 0.0v 334.755n 0.0v 339.745n 0.0v 339.755n 0.0v 344.745n 0.0v 344.755n 0.0v 349.745n 0.0v 349.755n 0.0v 354.745n 0.0v 354.755n 0.0v 359.745n 0.0v 359.755n 0.0v 364.745n 0.0v 364.755n 1.1v 369.745n 1.1v 369.755n 1.1v 374.745n 1.1v 374.755n 1.1v 379.745n 1.1v 379.755n 0.0v 384.745n 0.0v 384.755n 0.0v 389.745n 0.0v 389.755n 0.0v 394.745n 0.0v 394.755n 0.0v 399.745n 0.0v 399.755n 0.0v 404.745n 0.0v 404.755n 0.0v 409.745n 0.0v 409.755n 1.1v 414.745n 1.1v 414.755n 1.1v 419.745n 1.1v 419.755n 1.1v 424.745n 1.1v 424.755n 1.1v 429.745n 1.1v 429.755n 1.1v 434.745n 1.1v 434.755n 0.0v 439.745n 0.0v 439.755n 0.0v 444.745n 0.0v 444.755n 0.0v 449.745n 0.0v 449.755n 0.0v 454.745n 0.0v 454.755n 0.0v 459.745n 0.0v 459.755n 1.1v 464.745n 1.1v 464.755n 1.1v 469.745n 1.1v 469.755n 1.1v 474.745n 1.1v 474.755n 0.0v 479.745n 0.0v 479.755n 0.0v 484.745n 0.0v 484.755n 0.0v 489.745n 0.0v 489.755n 0.0v 494.745n 0.0v 494.755n 0.0v 499.745n 0.0v 499.755n 0.0v 504.745n 0.0v 504.755n 1.1v 509.745n 1.1v 509.755n 1.1v 514.745n 1.1v 514.755n 1.1v 519.745n 1.1v 519.755n 1.1v 524.745n 1.1v 524.755n 1.1v 529.745n 1.1v 529.755n 1.1v 534.745n 1.1v 534.755n 1.1v 539.745n 1.1v 539.755n 1.1v 544.745n 1.1v 544.755n 0.0v 549.745n 0.0v 549.755n 0.0v 554.745n 0.0v 554.755n 0.0v 559.745n 0.0v 559.755n 0.0v 564.745n 0.0v 564.755n 0.0v 569.745n 0.0v 569.755n 0.0v 574.745n 0.0v 574.755n 0.0v 579.745n 0.0v 579.755n 1.1v 584.745n 1.1v 584.755n 0.0v 589.745n 0.0v 589.755n 0.0v 594.745n 0.0v 594.755n 0.0v 599.745n 0.0v 599.755n 0.0v 604.745n 0.0v 604.755n 0.0v 609.745n 0.0v 609.755n 0.0v 614.745n 0.0v 614.755n 0.0v 619.745n 0.0v 619.755n 0.0v 624.745n 0.0v 624.755n 0.0v 629.745n 0.0v 629.755n 0.0v 634.745n 0.0v 634.755n 1.1v 639.745n 1.1v 639.755n 0.0v 644.745n 0.0v 644.755n 0.0v 649.745n 0.0v 649.755n 1.1v 654.745n 1.1v 654.755n 1.1v 659.745n 1.1v 659.755n 1.1v 664.745n 1.1v 664.755n 1.1v 669.745n 1.1v 669.755n 1.1v 674.745n 1.1v 674.755n 1.1v 679.745n 1.1v 679.755n 1.1v 684.745n 1.1v 684.755n 1.1v 689.745n 1.1v 689.755n 1.1v 694.745n 1.1v 694.755n 1.1v 699.745n 1.1v 699.755n 0.0v 704.745n 0.0v 704.755n 1.1v 709.745n 1.1v 709.755n 1.1v 714.745n 1.1v 714.755n 1.1v 719.745n 1.1v 719.755n 0.0v 724.745n 0.0v 724.755n 0.0v 729.745n 0.0v 729.755n 0.0v 734.745n 0.0v 734.755n 0.0v 739.745n 0.0v 739.755n 0.0v 744.745n 0.0v 744.755n 0.0v 749.745n 0.0v 749.755n 0.0v 754.745n 0.0v 754.755n 0.0v 759.745n 0.0v 759.755n 0.0v 764.745n 0.0v 764.755n 1.1v 769.745n 1.1v 769.755n 1.1v 774.745n 1.1v 774.755n 1.1v 779.745n 1.1v 779.755n 1.1v 784.745n 1.1v 784.755n 1.1v 789.745n 1.1v 789.755n 1.1v 794.745n 1.1v 794.755n 1.1v 799.745n 1.1v 799.755n 1.1v 804.745n 1.1v 804.755n 0.0v 809.745n 0.0v 809.755n 0.0v 814.745n 0.0v 814.755n 1.1v 819.745n 1.1v 819.755n 1.1v 824.745n 1.1v 824.755n 0.0v 829.745n 0.0v 829.755n 0.0v 834.745n 0.0v 834.755n 0.0v 839.745n 0.0v 839.755n 0.0v 844.745n 0.0v 844.755n 0.0v 849.745n 0.0v 849.755n 0.0v 854.745n 0.0v 854.755n 0.0v 859.745n 0.0v 859.755n 1.1v 864.745n 1.1v 864.755n 1.1v 869.745n 1.1v 869.755n 0.0v 874.745n 0.0v 874.755n 0.0v 879.745n 0.0v 879.755n 0.0v 884.745n 0.0v 884.755n 0.0v 889.745n 0.0v 889.755n 0.0v 894.745n 0.0v 894.755n 0.0v 899.745n 0.0v 899.755n 0.0v 904.745n 0.0v 904.755n 0.0v 909.745n 0.0v 909.755n 0.0v 914.745n 0.0v 914.755n 0.0v 919.745n 0.0v 919.755n 0.0v 924.745n 0.0v 924.755n 0.0v 929.745n 0.0v 929.755n 1.1v 934.745n 1.1v 934.755n 0.0v 939.745n 0.0v 939.755n 0.0v 944.745n 0.0v 944.755n 0.0v 949.745n 0.0v 949.755n 1.1v 954.745n 1.1v 954.755n 1.1v 959.745n 1.1v 959.755n 1.1v 964.745n 1.1v 964.755n 1.1v 969.745n 1.1v 969.755n 1.1v 974.745n 1.1v 974.755n 1.1v 979.745n 1.1v 979.755n 1.1v 984.745n 1.1v 984.755n 0.0v 989.745n 0.0v 989.755n 1.1v 994.745n 1.1v 994.755n 1.1v 999.745n 1.1v 999.755n 1.1v 1004.745n 1.1v 1004.755n 1.1v 1009.745n 1.1v 1009.755n 0.0v 1014.745n 0.0v 1014.755n 0.0v 1019.745n 0.0v 1019.755n 0.0v 1024.745n 0.0v 1024.755n 0.0v )
* (time, data): [(0, 0), (5, 1), (10, 0), (15, 0), (20, 0), (25, 0), (30, 0), (35, 0), (40, 0), (45, 1), (50, 0), (55, 0), (60, 0), (65, 0), (70, 0), (75, 1), (80, 0), (85, 0), (90, 0), (95, 0), (100, 0), (105, 0), (110, 0), (115, 1), (120, 1), (125, 1), (130, 1), (135, 1), (140, 0), (145, 0), (150, 1), (155, 1), (160, 1), (165, 0), (170, 0), (175, 0), (180, 0), (185, 0), (190, 0), (195, 1), (200, 1), (205, 1), (210, 0), (215, 1), (220, 1), (225, 1), (230, 1), (235, 1), (240, 1), (245, 1), (250, 1), (255, 1), (260, 0), (265, 0), (270, 0), (275, 0), (280, 0), (285, 0), (290, 0), (295, 1), (300, 1), (305, 1), (310, 1), (315, 0), (320, 0), (325, 0), (330, 0), (335, 0), (340, 0), (345, 0), (350, 0), (355, 0), (360, 0), (365, 0), (370, 0), (375, 0), (380, 1), (385, 1), (390, 1), (395, 1), (400, 0), (405, 0), (410, 0), (415, 0), (420, 0), (425, 0), (430, 0), (435, 0), (440, 0), (445, 0), (450, 0), (455, 0), (460, 0), (465, 0), (470, 0), (475, 0), (480, 0), (485, 1), (490, 1), (495, 1), (500, 1), (505, 0), (510, 0), (515, 0), (520, 0), (525, 0), (530, 0), (535, 0), (540, 1), (545, 0), (550, 1), (555, 0), (560, 0), (565, 0), (570, 0), (575, 0), (580, 0), (585, 1), (590, 1), (595, 0), (600, 0), (605, 0), (610, 0), (615, 0), (620, 0), (625, 0), (630, 1), (635, 0), (640, 1), (645, 1), (650, 1), (655, 1), (660, 1), (665, 1), (670, 1), (675, 1), (680, 1), (685, 1), (690, 1), (695, 1), (700, 1), (705, 1), (710, 1), (715, 1), (720, 0), (725, 0), (730, 0), (735, 0), (740, 0), (745, 0), (750, 0), (755, 0), (760, 0), (765, 1), (770, 1), (775, 1), (780, 1), (785, 0), (790, 0), (795, 0), (800, 0), (805, 1), (810, 1), (815, 1), (820, 1), (825, 0), (830, 1), (835, 0), (840, 0), (845, 0), (850, 0), (855, 0), (860, 1), (865, 1), (870, 0), (875, 0), (880, 0), (885, 0), (890, 0), (895, 0), (900, 0), (905, 0), (910, 0), (915, 0), (920, 0), (925, 0), (930, 0), (935, 1), (940, 1), (945, 1), (950, 0), (955, 0), (960, 0), (965, 0), (970, 0), (975, 0), (980, 0), (985, 0), (990, 0), (995, 0), (1000, 1), (1005, 1), (1010, 0), (1015, 0), (1020, 0), (1025, 0)]
Vdin0_10  din0_10  0 PWL (0n 0.0v 4.745n 0.0v 4.755n 1.1v 9.745n 1.1v 9.755n 0.0v 14.745n 0.0v 14.755n 0.0v 19.745n 0.0v 19.755n 0.0v 24.745n 0.0v 24.755n 0.0v 29.745n 0.0v 29.755n 0.0v 34.745n 0.0v 34.755n 0.0v 39.745n 0.0v 39.755n 0.0v 44.745n 0.0v 44.755n 1.1v 49.745n 1.1v 49.755n 0.0v 54.745n 0.0v 54.755n 0.0v 59.745n 0.0v 59.755n 0.0v 64.745n 0.0v 64.755n 0.0v 69.745n 0.0v 69.755n 0.0v 74.745n 0.0v 74.755n 1.1v 79.745n 1.1v 79.755n 0.0v 84.745n 0.0v 84.755n 0.0v 89.745n 0.0v 89.755n 0.0v 94.745n 0.0v 94.755n 0.0v 99.745n 0.0v 99.755n 0.0v 104.745n 0.0v 104.755n 0.0v 109.745n 0.0v 109.755n 0.0v 114.745n 0.0v 114.755n 1.1v 119.745n 1.1v 119.755n 1.1v 124.745n 1.1v 124.755n 1.1v 129.745n 1.1v 129.755n 1.1v 134.745n 1.1v 134.755n 1.1v 139.745n 1.1v 139.755n 0.0v 144.745n 0.0v 144.755n 0.0v 149.745n 0.0v 149.755n 1.1v 154.745n 1.1v 154.755n 1.1v 159.745n 1.1v 159.755n 1.1v 164.745n 1.1v 164.755n 0.0v 169.745n 0.0v 169.755n 0.0v 174.745n 0.0v 174.755n 0.0v 179.745n 0.0v 179.755n 0.0v 184.745n 0.0v 184.755n 0.0v 189.745n 0.0v 189.755n 0.0v 194.745n 0.0v 194.755n 1.1v 199.745n 1.1v 199.755n 1.1v 204.745n 1.1v 204.755n 1.1v 209.745n 1.1v 209.755n 0.0v 214.745n 0.0v 214.755n 1.1v 219.745n 1.1v 219.755n 1.1v 224.745n 1.1v 224.755n 1.1v 229.745n 1.1v 229.755n 1.1v 234.745n 1.1v 234.755n 1.1v 239.745n 1.1v 239.755n 1.1v 244.745n 1.1v 244.755n 1.1v 249.745n 1.1v 249.755n 1.1v 254.745n 1.1v 254.755n 1.1v 259.745n 1.1v 259.755n 0.0v 264.745n 0.0v 264.755n 0.0v 269.745n 0.0v 269.755n 0.0v 274.745n 0.0v 274.755n 0.0v 279.745n 0.0v 279.755n 0.0v 284.745n 0.0v 284.755n 0.0v 289.745n 0.0v 289.755n 0.0v 294.745n 0.0v 294.755n 1.1v 299.745n 1.1v 299.755n 1.1v 304.745n 1.1v 304.755n 1.1v 309.745n 1.1v 309.755n 1.1v 314.745n 1.1v 314.755n 0.0v 319.745n 0.0v 319.755n 0.0v 324.745n 0.0v 324.755n 0.0v 329.745n 0.0v 329.755n 0.0v 334.745n 0.0v 334.755n 0.0v 339.745n 0.0v 339.755n 0.0v 344.745n 0.0v 344.755n 0.0v 349.745n 0.0v 349.755n 0.0v 354.745n 0.0v 354.755n 0.0v 359.745n 0.0v 359.755n 0.0v 364.745n 0.0v 364.755n 0.0v 369.745n 0.0v 369.755n 0.0v 374.745n 0.0v 374.755n 0.0v 379.745n 0.0v 379.755n 1.1v 384.745n 1.1v 384.755n 1.1v 389.745n 1.1v 389.755n 1.1v 394.745n 1.1v 394.755n 1.1v 399.745n 1.1v 399.755n 0.0v 404.745n 0.0v 404.755n 0.0v 409.745n 0.0v 409.755n 0.0v 414.745n 0.0v 414.755n 0.0v 419.745n 0.0v 419.755n 0.0v 424.745n 0.0v 424.755n 0.0v 429.745n 0.0v 429.755n 0.0v 434.745n 0.0v 434.755n 0.0v 439.745n 0.0v 439.755n 0.0v 444.745n 0.0v 444.755n 0.0v 449.745n 0.0v 449.755n 0.0v 454.745n 0.0v 454.755n 0.0v 459.745n 0.0v 459.755n 0.0v 464.745n 0.0v 464.755n 0.0v 469.745n 0.0v 469.755n 0.0v 474.745n 0.0v 474.755n 0.0v 479.745n 0.0v 479.755n 0.0v 484.745n 0.0v 484.755n 1.1v 489.745n 1.1v 489.755n 1.1v 494.745n 1.1v 494.755n 1.1v 499.745n 1.1v 499.755n 1.1v 504.745n 1.1v 504.755n 0.0v 509.745n 0.0v 509.755n 0.0v 514.745n 0.0v 514.755n 0.0v 519.745n 0.0v 519.755n 0.0v 524.745n 0.0v 524.755n 0.0v 529.745n 0.0v 529.755n 0.0v 534.745n 0.0v 534.755n 0.0v 539.745n 0.0v 539.755n 1.1v 544.745n 1.1v 544.755n 0.0v 549.745n 0.0v 549.755n 1.1v 554.745n 1.1v 554.755n 0.0v 559.745n 0.0v 559.755n 0.0v 564.745n 0.0v 564.755n 0.0v 569.745n 0.0v 569.755n 0.0v 574.745n 0.0v 574.755n 0.0v 579.745n 0.0v 579.755n 0.0v 584.745n 0.0v 584.755n 1.1v 589.745n 1.1v 589.755n 1.1v 594.745n 1.1v 594.755n 0.0v 599.745n 0.0v 599.755n 0.0v 604.745n 0.0v 604.755n 0.0v 609.745n 0.0v 609.755n 0.0v 614.745n 0.0v 614.755n 0.0v 619.745n 0.0v 619.755n 0.0v 624.745n 0.0v 624.755n 0.0v 629.745n 0.0v 629.755n 1.1v 634.745n 1.1v 634.755n 0.0v 639.745n 0.0v 639.755n 1.1v 644.745n 1.1v 644.755n 1.1v 649.745n 1.1v 649.755n 1.1v 654.745n 1.1v 654.755n 1.1v 659.745n 1.1v 659.755n 1.1v 664.745n 1.1v 664.755n 1.1v 669.745n 1.1v 669.755n 1.1v 674.745n 1.1v 674.755n 1.1v 679.745n 1.1v 679.755n 1.1v 684.745n 1.1v 684.755n 1.1v 689.745n 1.1v 689.755n 1.1v 694.745n 1.1v 694.755n 1.1v 699.745n 1.1v 699.755n 1.1v 704.745n 1.1v 704.755n 1.1v 709.745n 1.1v 709.755n 1.1v 714.745n 1.1v 714.755n 1.1v 719.745n 1.1v 719.755n 0.0v 724.745n 0.0v 724.755n 0.0v 729.745n 0.0v 729.755n 0.0v 734.745n 0.0v 734.755n 0.0v 739.745n 0.0v 739.755n 0.0v 744.745n 0.0v 744.755n 0.0v 749.745n 0.0v 749.755n 0.0v 754.745n 0.0v 754.755n 0.0v 759.745n 0.0v 759.755n 0.0v 764.745n 0.0v 764.755n 1.1v 769.745n 1.1v 769.755n 1.1v 774.745n 1.1v 774.755n 1.1v 779.745n 1.1v 779.755n 1.1v 784.745n 1.1v 784.755n 0.0v 789.745n 0.0v 789.755n 0.0v 794.745n 0.0v 794.755n 0.0v 799.745n 0.0v 799.755n 0.0v 804.745n 0.0v 804.755n 1.1v 809.745n 1.1v 809.755n 1.1v 814.745n 1.1v 814.755n 1.1v 819.745n 1.1v 819.755n 1.1v 824.745n 1.1v 824.755n 0.0v 829.745n 0.0v 829.755n 1.1v 834.745n 1.1v 834.755n 0.0v 839.745n 0.0v 839.755n 0.0v 844.745n 0.0v 844.755n 0.0v 849.745n 0.0v 849.755n 0.0v 854.745n 0.0v 854.755n 0.0v 859.745n 0.0v 859.755n 1.1v 864.745n 1.1v 864.755n 1.1v 869.745n 1.1v 869.755n 0.0v 874.745n 0.0v 874.755n 0.0v 879.745n 0.0v 879.755n 0.0v 884.745n 0.0v 884.755n 0.0v 889.745n 0.0v 889.755n 0.0v 894.745n 0.0v 894.755n 0.0v 899.745n 0.0v 899.755n 0.0v 904.745n 0.0v 904.755n 0.0v 909.745n 0.0v 909.755n 0.0v 914.745n 0.0v 914.755n 0.0v 919.745n 0.0v 919.755n 0.0v 924.745n 0.0v 924.755n 0.0v 929.745n 0.0v 929.755n 0.0v 934.745n 0.0v 934.755n 1.1v 939.745n 1.1v 939.755n 1.1v 944.745n 1.1v 944.755n 1.1v 949.745n 1.1v 949.755n 0.0v 954.745n 0.0v 954.755n 0.0v 959.745n 0.0v 959.755n 0.0v 964.745n 0.0v 964.755n 0.0v 969.745n 0.0v 969.755n 0.0v 974.745n 0.0v 974.755n 0.0v 979.745n 0.0v 979.755n 0.0v 984.745n 0.0v 984.755n 0.0v 989.745n 0.0v 989.755n 0.0v 994.745n 0.0v 994.755n 0.0v 999.745n 0.0v 999.755n 1.1v 1004.745n 1.1v 1004.755n 1.1v 1009.745n 1.1v 1009.755n 0.0v 1014.745n 0.0v 1014.755n 0.0v 1019.745n 0.0v 1019.755n 0.0v 1024.745n 0.0v 1024.755n 0.0v )
* (time, data): [(0, 0), (5, 1), (10, 0), (15, 0), (20, 0), (25, 0), (30, 0), (35, 0), (40, 0), (45, 0), (50, 0), (55, 1), (60, 1), (65, 1), (70, 1), (75, 0), (80, 0), (85, 0), (90, 0), (95, 0), (100, 0), (105, 0), (110, 0), (115, 0), (120, 0), (125, 0), (130, 0), (135, 0), (140, 1), (145, 1), (150, 0), (155, 0), (160, 0), (165, 0), (170, 0), (175, 1), (180, 0), (185, 0), (190, 0), (195, 0), (200, 0), (205, 0), (210, 0), (215, 1), (220, 1), (225, 1), (230, 1), (235, 1), (240, 1), (245, 1), (250, 1), (255, 1), (260, 1), (265, 1), (270, 0), (275, 0), (280, 0), (285, 0), (290, 0), (295, 0), (300, 0), (305, 0), (310, 0), (315, 1), (320, 0), (325, 0), (330, 0), (335, 0), (340, 0), (345, 0), (350, 1), (355, 1), (360, 0), (365, 1), (370, 0), (375, 0), (380, 1), (385, 1), (390, 1), (395, 1), (400, 0), (405, 0), (410, 0), (415, 0), (420, 0), (425, 0), (430, 0), (435, 0), (440, 1), (445, 1), (450, 1), (455, 1), (460, 1), (465, 1), (470, 1), (475, 0), (480, 0), (485, 1), (490, 1), (495, 1), (500, 1), (505, 1), (510, 1), (515, 1), (520, 1), (525, 1), (530, 1), (535, 1), (540, 0), (545, 1), (550, 1), (555, 1), (560, 1), (565, 1), (570, 1), (575, 1), (580, 1), (585, 1), (590, 1), (595, 0), (600, 0), (605, 0), (610, 0), (615, 0), (620, 1), (625, 1), (630, 1), (635, 1), (640, 1), (645, 1), (650, 0), (655, 0), (660, 0), (665, 0), (670, 0), (675, 0), (680, 0), (685, 0), (690, 0), (695, 0), (700, 0), (705, 0), (710, 0), (715, 0), (720, 1), (725, 1), (730, 1), (735, 1), (740, 1), (745, 1), (750, 1), (755, 0), (760, 0), (765, 1), (770, 1), (775, 1), (780, 1), (785, 0), (790, 0), (795, 0), (800, 0), (805, 0), (810, 0), (815, 1), (820, 1), (825, 0), (830, 0), (835, 0), (840, 0), (845, 0), (850, 0), (855, 0), (860, 1), (865, 0), (870, 0), (875, 0), (880, 0), (885, 0), (890, 0), (895, 0), (900, 0), (905, 0), (910, 0), (915, 0), (920, 0), (925, 0), (930, 0), (935, 1), (940, 1), (945, 1), (950, 1), (955, 1), (960, 1), (965, 1), (970, 1), (975, 1), (980, 1), (985, 0), (990, 0), (995, 0), (1000, 0), (1005, 0), (1010, 1), (1015, 1), (1020, 1), (1025, 1)]
Vdin0_11  din0_11  0 PWL (0n 0.0v 4.745n 0.0v 4.755n 1.1v 9.745n 1.1v 9.755n 0.0v 14.745n 0.0v 14.755n 0.0v 19.745n 0.0v 19.755n 0.0v 24.745n 0.0v 24.755n 0.0v 29.745n 0.0v 29.755n 0.0v 34.745n 0.0v 34.755n 0.0v 39.745n 0.0v 39.755n 0.0v 44.745n 0.0v 44.755n 0.0v 49.745n 0.0v 49.755n 0.0v 54.745n 0.0v 54.755n 1.1v 59.745n 1.1v 59.755n 1.1v 64.745n 1.1v 64.755n 1.1v 69.745n 1.1v 69.755n 1.1v 74.745n 1.1v 74.755n 0.0v 79.745n 0.0v 79.755n 0.0v 84.745n 0.0v 84.755n 0.0v 89.745n 0.0v 89.755n 0.0v 94.745n 0.0v 94.755n 0.0v 99.745n 0.0v 99.755n 0.0v 104.745n 0.0v 104.755n 0.0v 109.745n 0.0v 109.755n 0.0v 114.745n 0.0v 114.755n 0.0v 119.745n 0.0v 119.755n 0.0v 124.745n 0.0v 124.755n 0.0v 129.745n 0.0v 129.755n 0.0v 134.745n 0.0v 134.755n 0.0v 139.745n 0.0v 139.755n 1.1v 144.745n 1.1v 144.755n 1.1v 149.745n 1.1v 149.755n 0.0v 154.745n 0.0v 154.755n 0.0v 159.745n 0.0v 159.755n 0.0v 164.745n 0.0v 164.755n 0.0v 169.745n 0.0v 169.755n 0.0v 174.745n 0.0v 174.755n 1.1v 179.745n 1.1v 179.755n 0.0v 184.745n 0.0v 184.755n 0.0v 189.745n 0.0v 189.755n 0.0v 194.745n 0.0v 194.755n 0.0v 199.745n 0.0v 199.755n 0.0v 204.745n 0.0v 204.755n 0.0v 209.745n 0.0v 209.755n 0.0v 214.745n 0.0v 214.755n 1.1v 219.745n 1.1v 219.755n 1.1v 224.745n 1.1v 224.755n 1.1v 229.745n 1.1v 229.755n 1.1v 234.745n 1.1v 234.755n 1.1v 239.745n 1.1v 239.755n 1.1v 244.745n 1.1v 244.755n 1.1v 249.745n 1.1v 249.755n 1.1v 254.745n 1.1v 254.755n 1.1v 259.745n 1.1v 259.755n 1.1v 264.745n 1.1v 264.755n 1.1v 269.745n 1.1v 269.755n 0.0v 274.745n 0.0v 274.755n 0.0v 279.745n 0.0v 279.755n 0.0v 284.745n 0.0v 284.755n 0.0v 289.745n 0.0v 289.755n 0.0v 294.745n 0.0v 294.755n 0.0v 299.745n 0.0v 299.755n 0.0v 304.745n 0.0v 304.755n 0.0v 309.745n 0.0v 309.755n 0.0v 314.745n 0.0v 314.755n 1.1v 319.745n 1.1v 319.755n 0.0v 324.745n 0.0v 324.755n 0.0v 329.745n 0.0v 329.755n 0.0v 334.745n 0.0v 334.755n 0.0v 339.745n 0.0v 339.755n 0.0v 344.745n 0.0v 344.755n 0.0v 349.745n 0.0v 349.755n 1.1v 354.745n 1.1v 354.755n 1.1v 359.745n 1.1v 359.755n 0.0v 364.745n 0.0v 364.755n 1.1v 369.745n 1.1v 369.755n 0.0v 374.745n 0.0v 374.755n 0.0v 379.745n 0.0v 379.755n 1.1v 384.745n 1.1v 384.755n 1.1v 389.745n 1.1v 389.755n 1.1v 394.745n 1.1v 394.755n 1.1v 399.745n 1.1v 399.755n 0.0v 404.745n 0.0v 404.755n 0.0v 409.745n 0.0v 409.755n 0.0v 414.745n 0.0v 414.755n 0.0v 419.745n 0.0v 419.755n 0.0v 424.745n 0.0v 424.755n 0.0v 429.745n 0.0v 429.755n 0.0v 434.745n 0.0v 434.755n 0.0v 439.745n 0.0v 439.755n 1.1v 444.745n 1.1v 444.755n 1.1v 449.745n 1.1v 449.755n 1.1v 454.745n 1.1v 454.755n 1.1v 459.745n 1.1v 459.755n 1.1v 464.745n 1.1v 464.755n 1.1v 469.745n 1.1v 469.755n 1.1v 474.745n 1.1v 474.755n 0.0v 479.745n 0.0v 479.755n 0.0v 484.745n 0.0v 484.755n 1.1v 489.745n 1.1v 489.755n 1.1v 494.745n 1.1v 494.755n 1.1v 499.745n 1.1v 499.755n 1.1v 504.745n 1.1v 504.755n 1.1v 509.745n 1.1v 509.755n 1.1v 514.745n 1.1v 514.755n 1.1v 519.745n 1.1v 519.755n 1.1v 524.745n 1.1v 524.755n 1.1v 529.745n 1.1v 529.755n 1.1v 534.745n 1.1v 534.755n 1.1v 539.745n 1.1v 539.755n 0.0v 544.745n 0.0v 544.755n 1.1v 549.745n 1.1v 549.755n 1.1v 554.745n 1.1v 554.755n 1.1v 559.745n 1.1v 559.755n 1.1v 564.745n 1.1v 564.755n 1.1v 569.745n 1.1v 569.755n 1.1v 574.745n 1.1v 574.755n 1.1v 579.745n 1.1v 579.755n 1.1v 584.745n 1.1v 584.755n 1.1v 589.745n 1.1v 589.755n 1.1v 594.745n 1.1v 594.755n 0.0v 599.745n 0.0v 599.755n 0.0v 604.745n 0.0v 604.755n 0.0v 609.745n 0.0v 609.755n 0.0v 614.745n 0.0v 614.755n 0.0v 619.745n 0.0v 619.755n 1.1v 624.745n 1.1v 624.755n 1.1v 629.745n 1.1v 629.755n 1.1v 634.745n 1.1v 634.755n 1.1v 639.745n 1.1v 639.755n 1.1v 644.745n 1.1v 644.755n 1.1v 649.745n 1.1v 649.755n 0.0v 654.745n 0.0v 654.755n 0.0v 659.745n 0.0v 659.755n 0.0v 664.745n 0.0v 664.755n 0.0v 669.745n 0.0v 669.755n 0.0v 674.745n 0.0v 674.755n 0.0v 679.745n 0.0v 679.755n 0.0v 684.745n 0.0v 684.755n 0.0v 689.745n 0.0v 689.755n 0.0v 694.745n 0.0v 694.755n 0.0v 699.745n 0.0v 699.755n 0.0v 704.745n 0.0v 704.755n 0.0v 709.745n 0.0v 709.755n 0.0v 714.745n 0.0v 714.755n 0.0v 719.745n 0.0v 719.755n 1.1v 724.745n 1.1v 724.755n 1.1v 729.745n 1.1v 729.755n 1.1v 734.745n 1.1v 734.755n 1.1v 739.745n 1.1v 739.755n 1.1v 744.745n 1.1v 744.755n 1.1v 749.745n 1.1v 749.755n 1.1v 754.745n 1.1v 754.755n 0.0v 759.745n 0.0v 759.755n 0.0v 764.745n 0.0v 764.755n 1.1v 769.745n 1.1v 769.755n 1.1v 774.745n 1.1v 774.755n 1.1v 779.745n 1.1v 779.755n 1.1v 784.745n 1.1v 784.755n 0.0v 789.745n 0.0v 789.755n 0.0v 794.745n 0.0v 794.755n 0.0v 799.745n 0.0v 799.755n 0.0v 804.745n 0.0v 804.755n 0.0v 809.745n 0.0v 809.755n 0.0v 814.745n 0.0v 814.755n 1.1v 819.745n 1.1v 819.755n 1.1v 824.745n 1.1v 824.755n 0.0v 829.745n 0.0v 829.755n 0.0v 834.745n 0.0v 834.755n 0.0v 839.745n 0.0v 839.755n 0.0v 844.745n 0.0v 844.755n 0.0v 849.745n 0.0v 849.755n 0.0v 854.745n 0.0v 854.755n 0.0v 859.745n 0.0v 859.755n 1.1v 864.745n 1.1v 864.755n 0.0v 869.745n 0.0v 869.755n 0.0v 874.745n 0.0v 874.755n 0.0v 879.745n 0.0v 879.755n 0.0v 884.745n 0.0v 884.755n 0.0v 889.745n 0.0v 889.755n 0.0v 894.745n 0.0v 894.755n 0.0v 899.745n 0.0v 899.755n 0.0v 904.745n 0.0v 904.755n 0.0v 909.745n 0.0v 909.755n 0.0v 914.745n 0.0v 914.755n 0.0v 919.745n 0.0v 919.755n 0.0v 924.745n 0.0v 924.755n 0.0v 929.745n 0.0v 929.755n 0.0v 934.745n 0.0v 934.755n 1.1v 939.745n 1.1v 939.755n 1.1v 944.745n 1.1v 944.755n 1.1v 949.745n 1.1v 949.755n 1.1v 954.745n 1.1v 954.755n 1.1v 959.745n 1.1v 959.755n 1.1v 964.745n 1.1v 964.755n 1.1v 969.745n 1.1v 969.755n 1.1v 974.745n 1.1v 974.755n 1.1v 979.745n 1.1v 979.755n 1.1v 984.745n 1.1v 984.755n 0.0v 989.745n 0.0v 989.755n 0.0v 994.745n 0.0v 994.755n 0.0v 999.745n 0.0v 999.755n 0.0v 1004.745n 0.0v 1004.755n 0.0v 1009.745n 0.0v 1009.755n 1.1v 1014.745n 1.1v 1014.755n 1.1v 1019.745n 1.1v 1019.755n 1.1v 1024.745n 1.1v 1024.755n 1.1v )
* (time, data): [(0, 0), (5, 1), (10, 1), (15, 0), (20, 0), (25, 0), (30, 0), (35, 1), (40, 1), (45, 0), (50, 0), (55, 0), (60, 0), (65, 0), (70, 0), (75, 0), (80, 0), (85, 0), (90, 0), (95, 0), (100, 0), (105, 0), (110, 0), (115, 0), (120, 0), (125, 0), (130, 0), (135, 0), (140, 0), (145, 0), (150, 1), (155, 1), (160, 1), (165, 1), (170, 1), (175, 0), (180, 0), (185, 0), (190, 0), (195, 0), (200, 0), (205, 0), (210, 1), (215, 0), (220, 0), (225, 0), (230, 1), (235, 1), (240, 1), (245, 1), (250, 1), (255, 1), (260, 1), (265, 1), (270, 1), (275, 1), (280, 1), (285, 1), (290, 1), (295, 0), (300, 0), (305, 0), (310, 0), (315, 1), (320, 0), (325, 1), (330, 1), (335, 1), (340, 1), (345, 1), (350, 1), (355, 1), (360, 1), (365, 1), (370, 1), (375, 1), (380, 0), (385, 0), (390, 0), (395, 0), (400, 0), (405, 0), (410, 1), (415, 1), (420, 1), (425, 1), (430, 1), (435, 1), (440, 1), (445, 1), (450, 1), (455, 1), (460, 0), (465, 0), (470, 0), (475, 0), (480, 0), (485, 1), (490, 1), (495, 1), (500, 1), (505, 1), (510, 1), (515, 0), (520, 0), (525, 0), (530, 0), (535, 0), (540, 1), (545, 1), (550, 1), (555, 0), (560, 0), (565, 0), (570, 0), (575, 0), (580, 0), (585, 0), (590, 0), (595, 1), (600, 1), (605, 0), (610, 0), (615, 0), (620, 0), (625, 0), (630, 1), (635, 0), (640, 0), (645, 0), (650, 0), (655, 0), (660, 0), (665, 0), (670, 0), (675, 0), (680, 0), (685, 0), (690, 0), (695, 0), (700, 0), (705, 1), (710, 1), (715, 1), (720, 0), (725, 0), (730, 0), (735, 0), (740, 0), (745, 0), (750, 0), (755, 0), (760, 0), (765, 0), (770, 0), (775, 0), (780, 0), (785, 0), (790, 0), (795, 0), (800, 0), (805, 0), (810, 0), (815, 0), (820, 0), (825, 1), (830, 1), (835, 1), (840, 1), (845, 1), (850, 1), (855, 1), (860, 0), (865, 0), (870, 0), (875, 0), (880, 0), (885, 0), (890, 0), (895, 0), (900, 0), (905, 1), (910, 1), (915, 1), (920, 1), (925, 1), (930, 0), (935, 1), (940, 1), (945, 0), (950, 0), (955, 0), (960, 0), (965, 0), (970, 0), (975, 0), (980, 0), (985, 0), (990, 0), (995, 0), (1000, 1), (1005, 1), (1010, 0), (1015, 0), (1020, 0), (1025, 0)]
Vdin0_12  din0_12  0 PWL (0n 0.0v 4.745n 0.0v 4.755n 1.1v 9.745n 1.1v 9.755n 1.1v 14.745n 1.1v 14.755n 0.0v 19.745n 0.0v 19.755n 0.0v 24.745n 0.0v 24.755n 0.0v 29.745n 0.0v 29.755n 0.0v 34.745n 0.0v 34.755n 1.1v 39.745n 1.1v 39.755n 1.1v 44.745n 1.1v 44.755n 0.0v 49.745n 0.0v 49.755n 0.0v 54.745n 0.0v 54.755n 0.0v 59.745n 0.0v 59.755n 0.0v 64.745n 0.0v 64.755n 0.0v 69.745n 0.0v 69.755n 0.0v 74.745n 0.0v 74.755n 0.0v 79.745n 0.0v 79.755n 0.0v 84.745n 0.0v 84.755n 0.0v 89.745n 0.0v 89.755n 0.0v 94.745n 0.0v 94.755n 0.0v 99.745n 0.0v 99.755n 0.0v 104.745n 0.0v 104.755n 0.0v 109.745n 0.0v 109.755n 0.0v 114.745n 0.0v 114.755n 0.0v 119.745n 0.0v 119.755n 0.0v 124.745n 0.0v 124.755n 0.0v 129.745n 0.0v 129.755n 0.0v 134.745n 0.0v 134.755n 0.0v 139.745n 0.0v 139.755n 0.0v 144.745n 0.0v 144.755n 0.0v 149.745n 0.0v 149.755n 1.1v 154.745n 1.1v 154.755n 1.1v 159.745n 1.1v 159.755n 1.1v 164.745n 1.1v 164.755n 1.1v 169.745n 1.1v 169.755n 1.1v 174.745n 1.1v 174.755n 0.0v 179.745n 0.0v 179.755n 0.0v 184.745n 0.0v 184.755n 0.0v 189.745n 0.0v 189.755n 0.0v 194.745n 0.0v 194.755n 0.0v 199.745n 0.0v 199.755n 0.0v 204.745n 0.0v 204.755n 0.0v 209.745n 0.0v 209.755n 1.1v 214.745n 1.1v 214.755n 0.0v 219.745n 0.0v 219.755n 0.0v 224.745n 0.0v 224.755n 0.0v 229.745n 0.0v 229.755n 1.1v 234.745n 1.1v 234.755n 1.1v 239.745n 1.1v 239.755n 1.1v 244.745n 1.1v 244.755n 1.1v 249.745n 1.1v 249.755n 1.1v 254.745n 1.1v 254.755n 1.1v 259.745n 1.1v 259.755n 1.1v 264.745n 1.1v 264.755n 1.1v 269.745n 1.1v 269.755n 1.1v 274.745n 1.1v 274.755n 1.1v 279.745n 1.1v 279.755n 1.1v 284.745n 1.1v 284.755n 1.1v 289.745n 1.1v 289.755n 1.1v 294.745n 1.1v 294.755n 0.0v 299.745n 0.0v 299.755n 0.0v 304.745n 0.0v 304.755n 0.0v 309.745n 0.0v 309.755n 0.0v 314.745n 0.0v 314.755n 1.1v 319.745n 1.1v 319.755n 0.0v 324.745n 0.0v 324.755n 1.1v 329.745n 1.1v 329.755n 1.1v 334.745n 1.1v 334.755n 1.1v 339.745n 1.1v 339.755n 1.1v 344.745n 1.1v 344.755n 1.1v 349.745n 1.1v 349.755n 1.1v 354.745n 1.1v 354.755n 1.1v 359.745n 1.1v 359.755n 1.1v 364.745n 1.1v 364.755n 1.1v 369.745n 1.1v 369.755n 1.1v 374.745n 1.1v 374.755n 1.1v 379.745n 1.1v 379.755n 0.0v 384.745n 0.0v 384.755n 0.0v 389.745n 0.0v 389.755n 0.0v 394.745n 0.0v 394.755n 0.0v 399.745n 0.0v 399.755n 0.0v 404.745n 0.0v 404.755n 0.0v 409.745n 0.0v 409.755n 1.1v 414.745n 1.1v 414.755n 1.1v 419.745n 1.1v 419.755n 1.1v 424.745n 1.1v 424.755n 1.1v 429.745n 1.1v 429.755n 1.1v 434.745n 1.1v 434.755n 1.1v 439.745n 1.1v 439.755n 1.1v 444.745n 1.1v 444.755n 1.1v 449.745n 1.1v 449.755n 1.1v 454.745n 1.1v 454.755n 1.1v 459.745n 1.1v 459.755n 0.0v 464.745n 0.0v 464.755n 0.0v 469.745n 0.0v 469.755n 0.0v 474.745n 0.0v 474.755n 0.0v 479.745n 0.0v 479.755n 0.0v 484.745n 0.0v 484.755n 1.1v 489.745n 1.1v 489.755n 1.1v 494.745n 1.1v 494.755n 1.1v 499.745n 1.1v 499.755n 1.1v 504.745n 1.1v 504.755n 1.1v 509.745n 1.1v 509.755n 1.1v 514.745n 1.1v 514.755n 0.0v 519.745n 0.0v 519.755n 0.0v 524.745n 0.0v 524.755n 0.0v 529.745n 0.0v 529.755n 0.0v 534.745n 0.0v 534.755n 0.0v 539.745n 0.0v 539.755n 1.1v 544.745n 1.1v 544.755n 1.1v 549.745n 1.1v 549.755n 1.1v 554.745n 1.1v 554.755n 0.0v 559.745n 0.0v 559.755n 0.0v 564.745n 0.0v 564.755n 0.0v 569.745n 0.0v 569.755n 0.0v 574.745n 0.0v 574.755n 0.0v 579.745n 0.0v 579.755n 0.0v 584.745n 0.0v 584.755n 0.0v 589.745n 0.0v 589.755n 0.0v 594.745n 0.0v 594.755n 1.1v 599.745n 1.1v 599.755n 1.1v 604.745n 1.1v 604.755n 0.0v 609.745n 0.0v 609.755n 0.0v 614.745n 0.0v 614.755n 0.0v 619.745n 0.0v 619.755n 0.0v 624.745n 0.0v 624.755n 0.0v 629.745n 0.0v 629.755n 1.1v 634.745n 1.1v 634.755n 0.0v 639.745n 0.0v 639.755n 0.0v 644.745n 0.0v 644.755n 0.0v 649.745n 0.0v 649.755n 0.0v 654.745n 0.0v 654.755n 0.0v 659.745n 0.0v 659.755n 0.0v 664.745n 0.0v 664.755n 0.0v 669.745n 0.0v 669.755n 0.0v 674.745n 0.0v 674.755n 0.0v 679.745n 0.0v 679.755n 0.0v 684.745n 0.0v 684.755n 0.0v 689.745n 0.0v 689.755n 0.0v 694.745n 0.0v 694.755n 0.0v 699.745n 0.0v 699.755n 0.0v 704.745n 0.0v 704.755n 1.1v 709.745n 1.1v 709.755n 1.1v 714.745n 1.1v 714.755n 1.1v 719.745n 1.1v 719.755n 0.0v 724.745n 0.0v 724.755n 0.0v 729.745n 0.0v 729.755n 0.0v 734.745n 0.0v 734.755n 0.0v 739.745n 0.0v 739.755n 0.0v 744.745n 0.0v 744.755n 0.0v 749.745n 0.0v 749.755n 0.0v 754.745n 0.0v 754.755n 0.0v 759.745n 0.0v 759.755n 0.0v 764.745n 0.0v 764.755n 0.0v 769.745n 0.0v 769.755n 0.0v 774.745n 0.0v 774.755n 0.0v 779.745n 0.0v 779.755n 0.0v 784.745n 0.0v 784.755n 0.0v 789.745n 0.0v 789.755n 0.0v 794.745n 0.0v 794.755n 0.0v 799.745n 0.0v 799.755n 0.0v 804.745n 0.0v 804.755n 0.0v 809.745n 0.0v 809.755n 0.0v 814.745n 0.0v 814.755n 0.0v 819.745n 0.0v 819.755n 0.0v 824.745n 0.0v 824.755n 1.1v 829.745n 1.1v 829.755n 1.1v 834.745n 1.1v 834.755n 1.1v 839.745n 1.1v 839.755n 1.1v 844.745n 1.1v 844.755n 1.1v 849.745n 1.1v 849.755n 1.1v 854.745n 1.1v 854.755n 1.1v 859.745n 1.1v 859.755n 0.0v 864.745n 0.0v 864.755n 0.0v 869.745n 0.0v 869.755n 0.0v 874.745n 0.0v 874.755n 0.0v 879.745n 0.0v 879.755n 0.0v 884.745n 0.0v 884.755n 0.0v 889.745n 0.0v 889.755n 0.0v 894.745n 0.0v 894.755n 0.0v 899.745n 0.0v 899.755n 0.0v 904.745n 0.0v 904.755n 1.1v 909.745n 1.1v 909.755n 1.1v 914.745n 1.1v 914.755n 1.1v 919.745n 1.1v 919.755n 1.1v 924.745n 1.1v 924.755n 1.1v 929.745n 1.1v 929.755n 0.0v 934.745n 0.0v 934.755n 1.1v 939.745n 1.1v 939.755n 1.1v 944.745n 1.1v 944.755n 0.0v 949.745n 0.0v 949.755n 0.0v 954.745n 0.0v 954.755n 0.0v 959.745n 0.0v 959.755n 0.0v 964.745n 0.0v 964.755n 0.0v 969.745n 0.0v 969.755n 0.0v 974.745n 0.0v 974.755n 0.0v 979.745n 0.0v 979.755n 0.0v 984.745n 0.0v 984.755n 0.0v 989.745n 0.0v 989.755n 0.0v 994.745n 0.0v 994.755n 0.0v 999.745n 0.0v 999.755n 1.1v 1004.745n 1.1v 1004.755n 1.1v 1009.745n 1.1v 1009.755n 0.0v 1014.745n 0.0v 1014.755n 0.0v 1019.745n 0.0v 1019.755n 0.0v 1024.745n 0.0v 1024.755n 0.0v )
* (time, data): [(0, 0), (5, 1), (10, 0), (15, 0), (20, 0), (25, 0), (30, 0), (35, 1), (40, 1), (45, 0), (50, 1), (55, 0), (60, 0), (65, 0), (70, 0), (75, 1), (80, 1), (85, 1), (90, 1), (95, 1), (100, 1), (105, 1), (110, 1), (115, 1), (120, 1), (125, 1), (130, 1), (135, 0), (140, 1), (145, 1), (150, 0), (155, 0), (160, 0), (165, 1), (170, 1), (175, 1), (180, 1), (185, 1), (190, 1), (195, 0), (200, 0), (205, 0), (210, 0), (215, 0), (220, 0), (225, 0), (230, 1), (235, 1), (240, 1), (245, 1), (250, 1), (255, 1), (260, 1), (265, 1), (270, 1), (275, 1), (280, 1), (285, 1), (290, 1), (295, 0), (300, 0), (305, 0), (310, 0), (315, 0), (320, 1), (325, 1), (330, 1), (335, 1), (340, 1), (345, 1), (350, 1), (355, 1), (360, 0), (365, 0), (370, 1), (375, 1), (380, 0), (385, 0), (390, 0), (395, 0), (400, 1), (405, 1), (410, 0), (415, 0), (420, 0), (425, 0), (430, 0), (435, 0), (440, 0), (445, 0), (450, 0), (455, 1), (460, 0), (465, 0), (470, 0), (475, 0), (480, 0), (485, 0), (490, 0), (495, 0), (500, 0), (505, 0), (510, 0), (515, 1), (520, 1), (525, 1), (530, 1), (535, 1), (540, 1), (545, 1), (550, 1), (555, 0), (560, 0), (565, 0), (570, 0), (575, 0), (580, 1), (585, 1), (590, 1), (595, 0), (600, 0), (605, 1), (610, 1), (615, 1), (620, 0), (625, 0), (630, 0), (635, 0), (640, 0), (645, 0), (650, 1), (655, 1), (660, 1), (665, 1), (670, 1), (675, 1), (680, 1), (685, 1), (690, 1), (695, 1), (700, 0), (705, 1), (710, 1), (715, 1), (720, 1), (725, 1), (730, 1), (735, 1), (740, 1), (745, 1), (750, 1), (755, 0), (760, 0), (765, 0), (770, 0), (775, 0), (780, 0), (785, 1), (790, 1), (795, 1), (800, 1), (805, 0), (810, 0), (815, 1), (820, 1), (825, 0), (830, 1), (835, 0), (840, 0), (845, 0), (850, 0), (855, 0), (860, 1), (865, 1), (870, 0), (875, 0), (880, 0), (885, 0), (890, 0), (895, 0), (900, 0), (905, 1), (910, 1), (915, 1), (920, 1), (925, 1), (930, 0), (935, 1), (940, 1), (945, 1), (950, 1), (955, 1), (960, 1), (965, 1), (970, 1), (975, 1), (980, 1), (985, 1), (990, 0), (995, 0), (1000, 0), (1005, 0), (1010, 1), (1015, 1), (1020, 1), (1025, 1)]
Vdin0_13  din0_13  0 PWL (0n 0.0v 4.745n 0.0v 4.755n 1.1v 9.745n 1.1v 9.755n 0.0v 14.745n 0.0v 14.755n 0.0v 19.745n 0.0v 19.755n 0.0v 24.745n 0.0v 24.755n 0.0v 29.745n 0.0v 29.755n 0.0v 34.745n 0.0v 34.755n 1.1v 39.745n 1.1v 39.755n 1.1v 44.745n 1.1v 44.755n 0.0v 49.745n 0.0v 49.755n 1.1v 54.745n 1.1v 54.755n 0.0v 59.745n 0.0v 59.755n 0.0v 64.745n 0.0v 64.755n 0.0v 69.745n 0.0v 69.755n 0.0v 74.745n 0.0v 74.755n 1.1v 79.745n 1.1v 79.755n 1.1v 84.745n 1.1v 84.755n 1.1v 89.745n 1.1v 89.755n 1.1v 94.745n 1.1v 94.755n 1.1v 99.745n 1.1v 99.755n 1.1v 104.745n 1.1v 104.755n 1.1v 109.745n 1.1v 109.755n 1.1v 114.745n 1.1v 114.755n 1.1v 119.745n 1.1v 119.755n 1.1v 124.745n 1.1v 124.755n 1.1v 129.745n 1.1v 129.755n 1.1v 134.745n 1.1v 134.755n 0.0v 139.745n 0.0v 139.755n 1.1v 144.745n 1.1v 144.755n 1.1v 149.745n 1.1v 149.755n 0.0v 154.745n 0.0v 154.755n 0.0v 159.745n 0.0v 159.755n 0.0v 164.745n 0.0v 164.755n 1.1v 169.745n 1.1v 169.755n 1.1v 174.745n 1.1v 174.755n 1.1v 179.745n 1.1v 179.755n 1.1v 184.745n 1.1v 184.755n 1.1v 189.745n 1.1v 189.755n 1.1v 194.745n 1.1v 194.755n 0.0v 199.745n 0.0v 199.755n 0.0v 204.745n 0.0v 204.755n 0.0v 209.745n 0.0v 209.755n 0.0v 214.745n 0.0v 214.755n 0.0v 219.745n 0.0v 219.755n 0.0v 224.745n 0.0v 224.755n 0.0v 229.745n 0.0v 229.755n 1.1v 234.745n 1.1v 234.755n 1.1v 239.745n 1.1v 239.755n 1.1v 244.745n 1.1v 244.755n 1.1v 249.745n 1.1v 249.755n 1.1v 254.745n 1.1v 254.755n 1.1v 259.745n 1.1v 259.755n 1.1v 264.745n 1.1v 264.755n 1.1v 269.745n 1.1v 269.755n 1.1v 274.745n 1.1v 274.755n 1.1v 279.745n 1.1v 279.755n 1.1v 284.745n 1.1v 284.755n 1.1v 289.745n 1.1v 289.755n 1.1v 294.745n 1.1v 294.755n 0.0v 299.745n 0.0v 299.755n 0.0v 304.745n 0.0v 304.755n 0.0v 309.745n 0.0v 309.755n 0.0v 314.745n 0.0v 314.755n 0.0v 319.745n 0.0v 319.755n 1.1v 324.745n 1.1v 324.755n 1.1v 329.745n 1.1v 329.755n 1.1v 334.745n 1.1v 334.755n 1.1v 339.745n 1.1v 339.755n 1.1v 344.745n 1.1v 344.755n 1.1v 349.745n 1.1v 349.755n 1.1v 354.745n 1.1v 354.755n 1.1v 359.745n 1.1v 359.755n 0.0v 364.745n 0.0v 364.755n 0.0v 369.745n 0.0v 369.755n 1.1v 374.745n 1.1v 374.755n 1.1v 379.745n 1.1v 379.755n 0.0v 384.745n 0.0v 384.755n 0.0v 389.745n 0.0v 389.755n 0.0v 394.745n 0.0v 394.755n 0.0v 399.745n 0.0v 399.755n 1.1v 404.745n 1.1v 404.755n 1.1v 409.745n 1.1v 409.755n 0.0v 414.745n 0.0v 414.755n 0.0v 419.745n 0.0v 419.755n 0.0v 424.745n 0.0v 424.755n 0.0v 429.745n 0.0v 429.755n 0.0v 434.745n 0.0v 434.755n 0.0v 439.745n 0.0v 439.755n 0.0v 444.745n 0.0v 444.755n 0.0v 449.745n 0.0v 449.755n 0.0v 454.745n 0.0v 454.755n 1.1v 459.745n 1.1v 459.755n 0.0v 464.745n 0.0v 464.755n 0.0v 469.745n 0.0v 469.755n 0.0v 474.745n 0.0v 474.755n 0.0v 479.745n 0.0v 479.755n 0.0v 484.745n 0.0v 484.755n 0.0v 489.745n 0.0v 489.755n 0.0v 494.745n 0.0v 494.755n 0.0v 499.745n 0.0v 499.755n 0.0v 504.745n 0.0v 504.755n 0.0v 509.745n 0.0v 509.755n 0.0v 514.745n 0.0v 514.755n 1.1v 519.745n 1.1v 519.755n 1.1v 524.745n 1.1v 524.755n 1.1v 529.745n 1.1v 529.755n 1.1v 534.745n 1.1v 534.755n 1.1v 539.745n 1.1v 539.755n 1.1v 544.745n 1.1v 544.755n 1.1v 549.745n 1.1v 549.755n 1.1v 554.745n 1.1v 554.755n 0.0v 559.745n 0.0v 559.755n 0.0v 564.745n 0.0v 564.755n 0.0v 569.745n 0.0v 569.755n 0.0v 574.745n 0.0v 574.755n 0.0v 579.745n 0.0v 579.755n 1.1v 584.745n 1.1v 584.755n 1.1v 589.745n 1.1v 589.755n 1.1v 594.745n 1.1v 594.755n 0.0v 599.745n 0.0v 599.755n 0.0v 604.745n 0.0v 604.755n 1.1v 609.745n 1.1v 609.755n 1.1v 614.745n 1.1v 614.755n 1.1v 619.745n 1.1v 619.755n 0.0v 624.745n 0.0v 624.755n 0.0v 629.745n 0.0v 629.755n 0.0v 634.745n 0.0v 634.755n 0.0v 639.745n 0.0v 639.755n 0.0v 644.745n 0.0v 644.755n 0.0v 649.745n 0.0v 649.755n 1.1v 654.745n 1.1v 654.755n 1.1v 659.745n 1.1v 659.755n 1.1v 664.745n 1.1v 664.755n 1.1v 669.745n 1.1v 669.755n 1.1v 674.745n 1.1v 674.755n 1.1v 679.745n 1.1v 679.755n 1.1v 684.745n 1.1v 684.755n 1.1v 689.745n 1.1v 689.755n 1.1v 694.745n 1.1v 694.755n 1.1v 699.745n 1.1v 699.755n 0.0v 704.745n 0.0v 704.755n 1.1v 709.745n 1.1v 709.755n 1.1v 714.745n 1.1v 714.755n 1.1v 719.745n 1.1v 719.755n 1.1v 724.745n 1.1v 724.755n 1.1v 729.745n 1.1v 729.755n 1.1v 734.745n 1.1v 734.755n 1.1v 739.745n 1.1v 739.755n 1.1v 744.745n 1.1v 744.755n 1.1v 749.745n 1.1v 749.755n 1.1v 754.745n 1.1v 754.755n 0.0v 759.745n 0.0v 759.755n 0.0v 764.745n 0.0v 764.755n 0.0v 769.745n 0.0v 769.755n 0.0v 774.745n 0.0v 774.755n 0.0v 779.745n 0.0v 779.755n 0.0v 784.745n 0.0v 784.755n 1.1v 789.745n 1.1v 789.755n 1.1v 794.745n 1.1v 794.755n 1.1v 799.745n 1.1v 799.755n 1.1v 804.745n 1.1v 804.755n 0.0v 809.745n 0.0v 809.755n 0.0v 814.745n 0.0v 814.755n 1.1v 819.745n 1.1v 819.755n 1.1v 824.745n 1.1v 824.755n 0.0v 829.745n 0.0v 829.755n 1.1v 834.745n 1.1v 834.755n 0.0v 839.745n 0.0v 839.755n 0.0v 844.745n 0.0v 844.755n 0.0v 849.745n 0.0v 849.755n 0.0v 854.745n 0.0v 854.755n 0.0v 859.745n 0.0v 859.755n 1.1v 864.745n 1.1v 864.755n 1.1v 869.745n 1.1v 869.755n 0.0v 874.745n 0.0v 874.755n 0.0v 879.745n 0.0v 879.755n 0.0v 884.745n 0.0v 884.755n 0.0v 889.745n 0.0v 889.755n 0.0v 894.745n 0.0v 894.755n 0.0v 899.745n 0.0v 899.755n 0.0v 904.745n 0.0v 904.755n 1.1v 909.745n 1.1v 909.755n 1.1v 914.745n 1.1v 914.755n 1.1v 919.745n 1.1v 919.755n 1.1v 924.745n 1.1v 924.755n 1.1v 929.745n 1.1v 929.755n 0.0v 934.745n 0.0v 934.755n 1.1v 939.745n 1.1v 939.755n 1.1v 944.745n 1.1v 944.755n 1.1v 949.745n 1.1v 949.755n 1.1v 954.745n 1.1v 954.755n 1.1v 959.745n 1.1v 959.755n 1.1v 964.745n 1.1v 964.755n 1.1v 969.745n 1.1v 969.755n 1.1v 974.745n 1.1v 974.755n 1.1v 979.745n 1.1v 979.755n 1.1v 984.745n 1.1v 984.755n 1.1v 989.745n 1.1v 989.755n 0.0v 994.745n 0.0v 994.755n 0.0v 999.745n 0.0v 999.755n 0.0v 1004.745n 0.0v 1004.755n 0.0v 1009.745n 0.0v 1009.755n 1.1v 1014.745n 1.1v 1014.755n 1.1v 1019.745n 1.1v 1019.755n 1.1v 1024.745n 1.1v 1024.755n 1.1v )
* (time, data): [(0, 0), (5, 1), (10, 0), (15, 1), (20, 1), (25, 1), (30, 1), (35, 0), (40, 0), (45, 1), (50, 0), (55, 0), (60, 0), (65, 0), (70, 0), (75, 1), (80, 0), (85, 0), (90, 0), (95, 0), (100, 0), (105, 0), (110, 0), (115, 0), (120, 0), (125, 0), (130, 0), (135, 1), (140, 1), (145, 1), (150, 0), (155, 0), (160, 0), (165, 1), (170, 1), (175, 1), (180, 0), (185, 0), (190, 0), (195, 0), (200, 0), (205, 0), (210, 0), (215, 0), (220, 0), (225, 0), (230, 0), (235, 0), (240, 0), (245, 0), (250, 0), (255, 0), (260, 1), (265, 1), (270, 0), (275, 0), (280, 0), (285, 0), (290, 0), (295, 1), (300, 1), (305, 1), (310, 1), (315, 1), (320, 0), (325, 1), (330, 1), (335, 1), (340, 1), (345, 1), (350, 1), (355, 1), (360, 0), (365, 0), (370, 1), (375, 1), (380, 1), (385, 1), (390, 1), (395, 1), (400, 1), (405, 1), (410, 1), (415, 1), (420, 1), (425, 1), (430, 1), (435, 0), (440, 1), (445, 1), (450, 1), (455, 0), (460, 0), (465, 0), (470, 0), (475, 0), (480, 0), (485, 1), (490, 1), (495, 0), (500, 0), (505, 0), (510, 0), (515, 0), (520, 0), (525, 0), (530, 0), (535, 0), (540, 0), (545, 0), (550, 1), (555, 1), (560, 1), (565, 1), (570, 1), (575, 1), (580, 1), (585, 1), (590, 1), (595, 1), (600, 1), (605, 0), (610, 0), (615, 0), (620, 1), (625, 1), (630, 1), (635, 0), (640, 1), (645, 1), (650, 0), (655, 0), (660, 0), (665, 0), (670, 0), (675, 0), (680, 0), (685, 0), (690, 0), (695, 0), (700, 0), (705, 1), (710, 1), (715, 1), (720, 1), (725, 1), (730, 1), (735, 1), (740, 1), (745, 1), (750, 1), (755, 1), (760, 1), (765, 0), (770, 0), (775, 0), (780, 0), (785, 0), (790, 0), (795, 0), (800, 0), (805, 0), (810, 0), (815, 1), (820, 1), (825, 0), (830, 0), (835, 1), (840, 1), (845, 1), (850, 1), (855, 1), (860, 0), (865, 1), (870, 0), (875, 0), (880, 0), (885, 0), (890, 0), (895, 0), (900, 0), (905, 1), (910, 1), (915, 1), (920, 1), (925, 1), (930, 0), (935, 1), (940, 1), (945, 0), (950, 0), (955, 0), (960, 0), (965, 0), (970, 0), (975, 0), (980, 0), (985, 0), (990, 0), (995, 0), (1000, 1), (1005, 1), (1010, 0), (1015, 0), (1020, 0), (1025, 0)]
Vdin0_14  din0_14  0 PWL (0n 0.0v 4.745n 0.0v 4.755n 1.1v 9.745n 1.1v 9.755n 0.0v 14.745n 0.0v 14.755n 1.1v 19.745n 1.1v 19.755n 1.1v 24.745n 1.1v 24.755n 1.1v 29.745n 1.1v 29.755n 1.1v 34.745n 1.1v 34.755n 0.0v 39.745n 0.0v 39.755n 0.0v 44.745n 0.0v 44.755n 1.1v 49.745n 1.1v 49.755n 0.0v 54.745n 0.0v 54.755n 0.0v 59.745n 0.0v 59.755n 0.0v 64.745n 0.0v 64.755n 0.0v 69.745n 0.0v 69.755n 0.0v 74.745n 0.0v 74.755n 1.1v 79.745n 1.1v 79.755n 0.0v 84.745n 0.0v 84.755n 0.0v 89.745n 0.0v 89.755n 0.0v 94.745n 0.0v 94.755n 0.0v 99.745n 0.0v 99.755n 0.0v 104.745n 0.0v 104.755n 0.0v 109.745n 0.0v 109.755n 0.0v 114.745n 0.0v 114.755n 0.0v 119.745n 0.0v 119.755n 0.0v 124.745n 0.0v 124.755n 0.0v 129.745n 0.0v 129.755n 0.0v 134.745n 0.0v 134.755n 1.1v 139.745n 1.1v 139.755n 1.1v 144.745n 1.1v 144.755n 1.1v 149.745n 1.1v 149.755n 0.0v 154.745n 0.0v 154.755n 0.0v 159.745n 0.0v 159.755n 0.0v 164.745n 0.0v 164.755n 1.1v 169.745n 1.1v 169.755n 1.1v 174.745n 1.1v 174.755n 1.1v 179.745n 1.1v 179.755n 0.0v 184.745n 0.0v 184.755n 0.0v 189.745n 0.0v 189.755n 0.0v 194.745n 0.0v 194.755n 0.0v 199.745n 0.0v 199.755n 0.0v 204.745n 0.0v 204.755n 0.0v 209.745n 0.0v 209.755n 0.0v 214.745n 0.0v 214.755n 0.0v 219.745n 0.0v 219.755n 0.0v 224.745n 0.0v 224.755n 0.0v 229.745n 0.0v 229.755n 0.0v 234.745n 0.0v 234.755n 0.0v 239.745n 0.0v 239.755n 0.0v 244.745n 0.0v 244.755n 0.0v 249.745n 0.0v 249.755n 0.0v 254.745n 0.0v 254.755n 0.0v 259.745n 0.0v 259.755n 1.1v 264.745n 1.1v 264.755n 1.1v 269.745n 1.1v 269.755n 0.0v 274.745n 0.0v 274.755n 0.0v 279.745n 0.0v 279.755n 0.0v 284.745n 0.0v 284.755n 0.0v 289.745n 0.0v 289.755n 0.0v 294.745n 0.0v 294.755n 1.1v 299.745n 1.1v 299.755n 1.1v 304.745n 1.1v 304.755n 1.1v 309.745n 1.1v 309.755n 1.1v 314.745n 1.1v 314.755n 1.1v 319.745n 1.1v 319.755n 0.0v 324.745n 0.0v 324.755n 1.1v 329.745n 1.1v 329.755n 1.1v 334.745n 1.1v 334.755n 1.1v 339.745n 1.1v 339.755n 1.1v 344.745n 1.1v 344.755n 1.1v 349.745n 1.1v 349.755n 1.1v 354.745n 1.1v 354.755n 1.1v 359.745n 1.1v 359.755n 0.0v 364.745n 0.0v 364.755n 0.0v 369.745n 0.0v 369.755n 1.1v 374.745n 1.1v 374.755n 1.1v 379.745n 1.1v 379.755n 1.1v 384.745n 1.1v 384.755n 1.1v 389.745n 1.1v 389.755n 1.1v 394.745n 1.1v 394.755n 1.1v 399.745n 1.1v 399.755n 1.1v 404.745n 1.1v 404.755n 1.1v 409.745n 1.1v 409.755n 1.1v 414.745n 1.1v 414.755n 1.1v 419.745n 1.1v 419.755n 1.1v 424.745n 1.1v 424.755n 1.1v 429.745n 1.1v 429.755n 1.1v 434.745n 1.1v 434.755n 0.0v 439.745n 0.0v 439.755n 1.1v 444.745n 1.1v 444.755n 1.1v 449.745n 1.1v 449.755n 1.1v 454.745n 1.1v 454.755n 0.0v 459.745n 0.0v 459.755n 0.0v 464.745n 0.0v 464.755n 0.0v 469.745n 0.0v 469.755n 0.0v 474.745n 0.0v 474.755n 0.0v 479.745n 0.0v 479.755n 0.0v 484.745n 0.0v 484.755n 1.1v 489.745n 1.1v 489.755n 1.1v 494.745n 1.1v 494.755n 0.0v 499.745n 0.0v 499.755n 0.0v 504.745n 0.0v 504.755n 0.0v 509.745n 0.0v 509.755n 0.0v 514.745n 0.0v 514.755n 0.0v 519.745n 0.0v 519.755n 0.0v 524.745n 0.0v 524.755n 0.0v 529.745n 0.0v 529.755n 0.0v 534.745n 0.0v 534.755n 0.0v 539.745n 0.0v 539.755n 0.0v 544.745n 0.0v 544.755n 0.0v 549.745n 0.0v 549.755n 1.1v 554.745n 1.1v 554.755n 1.1v 559.745n 1.1v 559.755n 1.1v 564.745n 1.1v 564.755n 1.1v 569.745n 1.1v 569.755n 1.1v 574.745n 1.1v 574.755n 1.1v 579.745n 1.1v 579.755n 1.1v 584.745n 1.1v 584.755n 1.1v 589.745n 1.1v 589.755n 1.1v 594.745n 1.1v 594.755n 1.1v 599.745n 1.1v 599.755n 1.1v 604.745n 1.1v 604.755n 0.0v 609.745n 0.0v 609.755n 0.0v 614.745n 0.0v 614.755n 0.0v 619.745n 0.0v 619.755n 1.1v 624.745n 1.1v 624.755n 1.1v 629.745n 1.1v 629.755n 1.1v 634.745n 1.1v 634.755n 0.0v 639.745n 0.0v 639.755n 1.1v 644.745n 1.1v 644.755n 1.1v 649.745n 1.1v 649.755n 0.0v 654.745n 0.0v 654.755n 0.0v 659.745n 0.0v 659.755n 0.0v 664.745n 0.0v 664.755n 0.0v 669.745n 0.0v 669.755n 0.0v 674.745n 0.0v 674.755n 0.0v 679.745n 0.0v 679.755n 0.0v 684.745n 0.0v 684.755n 0.0v 689.745n 0.0v 689.755n 0.0v 694.745n 0.0v 694.755n 0.0v 699.745n 0.0v 699.755n 0.0v 704.745n 0.0v 704.755n 1.1v 709.745n 1.1v 709.755n 1.1v 714.745n 1.1v 714.755n 1.1v 719.745n 1.1v 719.755n 1.1v 724.745n 1.1v 724.755n 1.1v 729.745n 1.1v 729.755n 1.1v 734.745n 1.1v 734.755n 1.1v 739.745n 1.1v 739.755n 1.1v 744.745n 1.1v 744.755n 1.1v 749.745n 1.1v 749.755n 1.1v 754.745n 1.1v 754.755n 1.1v 759.745n 1.1v 759.755n 1.1v 764.745n 1.1v 764.755n 0.0v 769.745n 0.0v 769.755n 0.0v 774.745n 0.0v 774.755n 0.0v 779.745n 0.0v 779.755n 0.0v 784.745n 0.0v 784.755n 0.0v 789.745n 0.0v 789.755n 0.0v 794.745n 0.0v 794.755n 0.0v 799.745n 0.0v 799.755n 0.0v 804.745n 0.0v 804.755n 0.0v 809.745n 0.0v 809.755n 0.0v 814.745n 0.0v 814.755n 1.1v 819.745n 1.1v 819.755n 1.1v 824.745n 1.1v 824.755n 0.0v 829.745n 0.0v 829.755n 0.0v 834.745n 0.0v 834.755n 1.1v 839.745n 1.1v 839.755n 1.1v 844.745n 1.1v 844.755n 1.1v 849.745n 1.1v 849.755n 1.1v 854.745n 1.1v 854.755n 1.1v 859.745n 1.1v 859.755n 0.0v 864.745n 0.0v 864.755n 1.1v 869.745n 1.1v 869.755n 0.0v 874.745n 0.0v 874.755n 0.0v 879.745n 0.0v 879.755n 0.0v 884.745n 0.0v 884.755n 0.0v 889.745n 0.0v 889.755n 0.0v 894.745n 0.0v 894.755n 0.0v 899.745n 0.0v 899.755n 0.0v 904.745n 0.0v 904.755n 1.1v 909.745n 1.1v 909.755n 1.1v 914.745n 1.1v 914.755n 1.1v 919.745n 1.1v 919.755n 1.1v 924.745n 1.1v 924.755n 1.1v 929.745n 1.1v 929.755n 0.0v 934.745n 0.0v 934.755n 1.1v 939.745n 1.1v 939.755n 1.1v 944.745n 1.1v 944.755n 0.0v 949.745n 0.0v 949.755n 0.0v 954.745n 0.0v 954.755n 0.0v 959.745n 0.0v 959.755n 0.0v 964.745n 0.0v 964.755n 0.0v 969.745n 0.0v 969.755n 0.0v 974.745n 0.0v 974.755n 0.0v 979.745n 0.0v 979.755n 0.0v 984.745n 0.0v 984.755n 0.0v 989.745n 0.0v 989.755n 0.0v 994.745n 0.0v 994.755n 0.0v 999.745n 0.0v 999.755n 1.1v 1004.745n 1.1v 1004.755n 1.1v 1009.745n 1.1v 1009.755n 0.0v 1014.745n 0.0v 1014.755n 0.0v 1019.745n 0.0v 1019.755n 0.0v 1024.745n 0.0v 1024.755n 0.0v )
* (time, data): [(0, 0), (5, 1), (10, 1), (15, 1), (20, 1), (25, 1), (30, 1), (35, 0), (40, 0), (45, 0), (50, 1), (55, 1), (60, 1), (65, 1), (70, 1), (75, 0), (80, 1), (85, 1), (90, 1), (95, 1), (100, 1), (105, 1), (110, 1), (115, 0), (120, 0), (125, 0), (130, 0), (135, 0), (140, 0), (145, 0), (150, 1), (155, 1), (160, 1), (165, 1), (170, 1), (175, 0), (180, 0), (185, 0), (190, 0), (195, 1), (200, 1), (205, 1), (210, 0), (215, 0), (220, 0), (225, 0), (230, 1), (235, 1), (240, 1), (245, 1), (250, 1), (255, 1), (260, 1), (265, 1), (270, 0), (275, 0), (280, 0), (285, 0), (290, 0), (295, 0), (300, 0), (305, 0), (310, 0), (315, 1), (320, 1), (325, 0), (330, 0), (335, 0), (340, 0), (345, 0), (350, 1), (355, 1), (360, 1), (365, 0), (370, 1), (375, 1), (380, 0), (385, 0), (390, 0), (395, 0), (400, 1), (405, 1), (410, 0), (415, 0), (420, 0), (425, 0), (430, 0), (435, 0), (440, 0), (445, 0), (450, 0), (455, 0), (460, 1), (465, 1), (470, 1), (475, 0), (480, 0), (485, 0), (490, 0), (495, 1), (500, 1), (505, 0), (510, 0), (515, 0), (520, 0), (525, 0), (530, 0), (535, 0), (540, 0), (545, 1), (550, 0), (555, 0), (560, 0), (565, 0), (570, 0), (575, 0), (580, 1), (585, 1), (590, 1), (595, 0), (600, 0), (605, 1), (610, 1), (615, 1), (620, 0), (625, 0), (630, 0), (635, 1), (640, 1), (645, 1), (650, 0), (655, 0), (660, 0), (665, 0), (670, 0), (675, 0), (680, 0), (685, 0), (690, 0), (695, 0), (700, 1), (705, 0), (710, 0), (715, 0), (720, 0), (725, 0), (730, 1), (735, 1), (740, 1), (745, 1), (750, 1), (755, 0), (760, 0), (765, 0), (770, 0), (775, 0), (780, 0), (785, 0), (790, 0), (795, 0), (800, 0), (805, 0), (810, 0), (815, 0), (820, 0), (825, 1), (830, 1), (835, 0), (840, 0), (845, 0), (850, 0), (855, 0), (860, 1), (865, 1), (870, 1), (875, 1), (880, 1), (885, 1), (890, 1), (895, 1), (900, 1), (905, 0), (910, 0), (915, 0), (920, 0), (925, 0), (930, 0), (935, 1), (940, 1), (945, 0), (950, 0), (955, 0), (960, 0), (965, 0), (970, 0), (975, 0), (980, 0), (985, 1), (990, 0), (995, 0), (1000, 1), (1005, 1), (1010, 1), (1015, 1), (1020, 1), (1025, 1)]
Vdin0_15  din0_15  0 PWL (0n 0.0v 4.745n 0.0v 4.755n 1.1v 9.745n 1.1v 9.755n 1.1v 14.745n 1.1v 14.755n 1.1v 19.745n 1.1v 19.755n 1.1v 24.745n 1.1v 24.755n 1.1v 29.745n 1.1v 29.755n 1.1v 34.745n 1.1v 34.755n 0.0v 39.745n 0.0v 39.755n 0.0v 44.745n 0.0v 44.755n 0.0v 49.745n 0.0v 49.755n 1.1v 54.745n 1.1v 54.755n 1.1v 59.745n 1.1v 59.755n 1.1v 64.745n 1.1v 64.755n 1.1v 69.745n 1.1v 69.755n 1.1v 74.745n 1.1v 74.755n 0.0v 79.745n 0.0v 79.755n 1.1v 84.745n 1.1v 84.755n 1.1v 89.745n 1.1v 89.755n 1.1v 94.745n 1.1v 94.755n 1.1v 99.745n 1.1v 99.755n 1.1v 104.745n 1.1v 104.755n 1.1v 109.745n 1.1v 109.755n 1.1v 114.745n 1.1v 114.755n 0.0v 119.745n 0.0v 119.755n 0.0v 124.745n 0.0v 124.755n 0.0v 129.745n 0.0v 129.755n 0.0v 134.745n 0.0v 134.755n 0.0v 139.745n 0.0v 139.755n 0.0v 144.745n 0.0v 144.755n 0.0v 149.745n 0.0v 149.755n 1.1v 154.745n 1.1v 154.755n 1.1v 159.745n 1.1v 159.755n 1.1v 164.745n 1.1v 164.755n 1.1v 169.745n 1.1v 169.755n 1.1v 174.745n 1.1v 174.755n 0.0v 179.745n 0.0v 179.755n 0.0v 184.745n 0.0v 184.755n 0.0v 189.745n 0.0v 189.755n 0.0v 194.745n 0.0v 194.755n 1.1v 199.745n 1.1v 199.755n 1.1v 204.745n 1.1v 204.755n 1.1v 209.745n 1.1v 209.755n 0.0v 214.745n 0.0v 214.755n 0.0v 219.745n 0.0v 219.755n 0.0v 224.745n 0.0v 224.755n 0.0v 229.745n 0.0v 229.755n 1.1v 234.745n 1.1v 234.755n 1.1v 239.745n 1.1v 239.755n 1.1v 244.745n 1.1v 244.755n 1.1v 249.745n 1.1v 249.755n 1.1v 254.745n 1.1v 254.755n 1.1v 259.745n 1.1v 259.755n 1.1v 264.745n 1.1v 264.755n 1.1v 269.745n 1.1v 269.755n 0.0v 274.745n 0.0v 274.755n 0.0v 279.745n 0.0v 279.755n 0.0v 284.745n 0.0v 284.755n 0.0v 289.745n 0.0v 289.755n 0.0v 294.745n 0.0v 294.755n 0.0v 299.745n 0.0v 299.755n 0.0v 304.745n 0.0v 304.755n 0.0v 309.745n 0.0v 309.755n 0.0v 314.745n 0.0v 314.755n 1.1v 319.745n 1.1v 319.755n 1.1v 324.745n 1.1v 324.755n 0.0v 329.745n 0.0v 329.755n 0.0v 334.745n 0.0v 334.755n 0.0v 339.745n 0.0v 339.755n 0.0v 344.745n 0.0v 344.755n 0.0v 349.745n 0.0v 349.755n 1.1v 354.745n 1.1v 354.755n 1.1v 359.745n 1.1v 359.755n 1.1v 364.745n 1.1v 364.755n 0.0v 369.745n 0.0v 369.755n 1.1v 374.745n 1.1v 374.755n 1.1v 379.745n 1.1v 379.755n 0.0v 384.745n 0.0v 384.755n 0.0v 389.745n 0.0v 389.755n 0.0v 394.745n 0.0v 394.755n 0.0v 399.745n 0.0v 399.755n 1.1v 404.745n 1.1v 404.755n 1.1v 409.745n 1.1v 409.755n 0.0v 414.745n 0.0v 414.755n 0.0v 419.745n 0.0v 419.755n 0.0v 424.745n 0.0v 424.755n 0.0v 429.745n 0.0v 429.755n 0.0v 434.745n 0.0v 434.755n 0.0v 439.745n 0.0v 439.755n 0.0v 444.745n 0.0v 444.755n 0.0v 449.745n 0.0v 449.755n 0.0v 454.745n 0.0v 454.755n 0.0v 459.745n 0.0v 459.755n 1.1v 464.745n 1.1v 464.755n 1.1v 469.745n 1.1v 469.755n 1.1v 474.745n 1.1v 474.755n 0.0v 479.745n 0.0v 479.755n 0.0v 484.745n 0.0v 484.755n 0.0v 489.745n 0.0v 489.755n 0.0v 494.745n 0.0v 494.755n 1.1v 499.745n 1.1v 499.755n 1.1v 504.745n 1.1v 504.755n 0.0v 509.745n 0.0v 509.755n 0.0v 514.745n 0.0v 514.755n 0.0v 519.745n 0.0v 519.755n 0.0v 524.745n 0.0v 524.755n 0.0v 529.745n 0.0v 529.755n 0.0v 534.745n 0.0v 534.755n 0.0v 539.745n 0.0v 539.755n 0.0v 544.745n 0.0v 544.755n 1.1v 549.745n 1.1v 549.755n 0.0v 554.745n 0.0v 554.755n 0.0v 559.745n 0.0v 559.755n 0.0v 564.745n 0.0v 564.755n 0.0v 569.745n 0.0v 569.755n 0.0v 574.745n 0.0v 574.755n 0.0v 579.745n 0.0v 579.755n 1.1v 584.745n 1.1v 584.755n 1.1v 589.745n 1.1v 589.755n 1.1v 594.745n 1.1v 594.755n 0.0v 599.745n 0.0v 599.755n 0.0v 604.745n 0.0v 604.755n 1.1v 609.745n 1.1v 609.755n 1.1v 614.745n 1.1v 614.755n 1.1v 619.745n 1.1v 619.755n 0.0v 624.745n 0.0v 624.755n 0.0v 629.745n 0.0v 629.755n 0.0v 634.745n 0.0v 634.755n 1.1v 639.745n 1.1v 639.755n 1.1v 644.745n 1.1v 644.755n 1.1v 649.745n 1.1v 649.755n 0.0v 654.745n 0.0v 654.755n 0.0v 659.745n 0.0v 659.755n 0.0v 664.745n 0.0v 664.755n 0.0v 669.745n 0.0v 669.755n 0.0v 674.745n 0.0v 674.755n 0.0v 679.745n 0.0v 679.755n 0.0v 684.745n 0.0v 684.755n 0.0v 689.745n 0.0v 689.755n 0.0v 694.745n 0.0v 694.755n 0.0v 699.745n 0.0v 699.755n 1.1v 704.745n 1.1v 704.755n 0.0v 709.745n 0.0v 709.755n 0.0v 714.745n 0.0v 714.755n 0.0v 719.745n 0.0v 719.755n 0.0v 724.745n 0.0v 724.755n 0.0v 729.745n 0.0v 729.755n 1.1v 734.745n 1.1v 734.755n 1.1v 739.745n 1.1v 739.755n 1.1v 744.745n 1.1v 744.755n 1.1v 749.745n 1.1v 749.755n 1.1v 754.745n 1.1v 754.755n 0.0v 759.745n 0.0v 759.755n 0.0v 764.745n 0.0v 764.755n 0.0v 769.745n 0.0v 769.755n 0.0v 774.745n 0.0v 774.755n 0.0v 779.745n 0.0v 779.755n 0.0v 784.745n 0.0v 784.755n 0.0v 789.745n 0.0v 789.755n 0.0v 794.745n 0.0v 794.755n 0.0v 799.745n 0.0v 799.755n 0.0v 804.745n 0.0v 804.755n 0.0v 809.745n 0.0v 809.755n 0.0v 814.745n 0.0v 814.755n 0.0v 819.745n 0.0v 819.755n 0.0v 824.745n 0.0v 824.755n 1.1v 829.745n 1.1v 829.755n 1.1v 834.745n 1.1v 834.755n 0.0v 839.745n 0.0v 839.755n 0.0v 844.745n 0.0v 844.755n 0.0v 849.745n 0.0v 849.755n 0.0v 854.745n 0.0v 854.755n 0.0v 859.745n 0.0v 859.755n 1.1v 864.745n 1.1v 864.755n 1.1v 869.745n 1.1v 869.755n 1.1v 874.745n 1.1v 874.755n 1.1v 879.745n 1.1v 879.755n 1.1v 884.745n 1.1v 884.755n 1.1v 889.745n 1.1v 889.755n 1.1v 894.745n 1.1v 894.755n 1.1v 899.745n 1.1v 899.755n 1.1v 904.745n 1.1v 904.755n 0.0v 909.745n 0.0v 909.755n 0.0v 914.745n 0.0v 914.755n 0.0v 919.745n 0.0v 919.755n 0.0v 924.745n 0.0v 924.755n 0.0v 929.745n 0.0v 929.755n 0.0v 934.745n 0.0v 934.755n 1.1v 939.745n 1.1v 939.755n 1.1v 944.745n 1.1v 944.755n 0.0v 949.745n 0.0v 949.755n 0.0v 954.745n 0.0v 954.755n 0.0v 959.745n 0.0v 959.755n 0.0v 964.745n 0.0v 964.755n 0.0v 969.745n 0.0v 969.755n 0.0v 974.745n 0.0v 974.755n 0.0v 979.745n 0.0v 979.755n 0.0v 984.745n 0.0v 984.755n 1.1v 989.745n 1.1v 989.755n 0.0v 994.745n 0.0v 994.755n 0.0v 999.745n 0.0v 999.755n 1.1v 1004.745n 1.1v 1004.755n 1.1v 1009.745n 1.1v 1009.755n 1.1v 1014.745n 1.1v 1014.755n 1.1v 1019.745n 1.1v 1019.755n 1.1v 1024.745n 1.1v 1024.755n 1.1v )
* (time, data): [(0, 0), (5, 0), (10, 1), (15, 0), (20, 0), (25, 0), (30, 0), (35, 0), (40, 0), (45, 1), (50, 0), (55, 0), (60, 0), (65, 0), (70, 0), (75, 0), (80, 1), (85, 1), (90, 1), (95, 1), (100, 1), (105, 1), (110, 1), (115, 0), (120, 0), (125, 0), (130, 0), (135, 0), (140, 0), (145, 0), (150, 1), (155, 1), (160, 1), (165, 1), (170, 1), (175, 0), (180, 1), (185, 1), (190, 1), (195, 1), (200, 1), (205, 1), (210, 1), (215, 0), (220, 0), (225, 0), (230, 0), (235, 0), (240, 0), (245, 0), (250, 0), (255, 0), (260, 0), (265, 0), (270, 1), (275, 1), (280, 1), (285, 1), (290, 1), (295, 0), (300, 0), (305, 0), (310, 0), (315, 0), (320, 1), (325, 0), (330, 0), (335, 0), (340, 0), (345, 0), (350, 0), (355, 0), (360, 1), (365, 0), (370, 0), (375, 0), (380, 0), (385, 0), (390, 0), (395, 0), (400, 1), (405, 1), (410, 1), (415, 1), (420, 1), (425, 1), (430, 1), (435, 0), (440, 1), (445, 1), (450, 1), (455, 1), (460, 1), (465, 1), (470, 1), (475, 0), (480, 0), (485, 0), (490, 0), (495, 1), (500, 1), (505, 0), (510, 0), (515, 0), (520, 0), (525, 0), (530, 0), (535, 0), (540, 0), (545, 1), (550, 1), (555, 0), (560, 0), (565, 0), (570, 0), (575, 0), (580, 0), (585, 1), (590, 1), (595, 0), (600, 0), (605, 0), (610, 0), (615, 0), (620, 0), (625, 0), (630, 0), (635, 1), (640, 0), (645, 0), (650, 0), (655, 0), (660, 0), (665, 0), (670, 0), (675, 0), (680, 0), (685, 0), (690, 0), (695, 0), (700, 0), (705, 1), (710, 1), (715, 1), (720, 1), (725, 1), (730, 1), (735, 1), (740, 1), (745, 1), (750, 1), (755, 1), (760, 1), (765, 1), (770, 1), (775, 1), (780, 1), (785, 0), (790, 0), (795, 0), (800, 0), (805, 0), (810, 0), (815, 1), (820, 1), (825, 1), (830, 1), (835, 1), (840, 1), (845, 1), (850, 1), (855, 1), (860, 0), (865, 1), (870, 1), (875, 1), (880, 1), (885, 1), (890, 1), (895, 1), (900, 1), (905, 1), (910, 1), (915, 1), (920, 1), (925, 1), (930, 1), (935, 0), (940, 0), (945, 0), (950, 0), (955, 0), (960, 0), (965, 0), (970, 0), (975, 0), (980, 0), (985, 1), (990, 1), (995, 1), (1000, 1), (1005, 1), (1010, 1), (1015, 1), (1020, 1), (1025, 1)]
Vdin0_16  din0_16  0 PWL (0n 0.0v 4.745n 0.0v 4.755n 0.0v 9.745n 0.0v 9.755n 1.1v 14.745n 1.1v 14.755n 0.0v 19.745n 0.0v 19.755n 0.0v 24.745n 0.0v 24.755n 0.0v 29.745n 0.0v 29.755n 0.0v 34.745n 0.0v 34.755n 0.0v 39.745n 0.0v 39.755n 0.0v 44.745n 0.0v 44.755n 1.1v 49.745n 1.1v 49.755n 0.0v 54.745n 0.0v 54.755n 0.0v 59.745n 0.0v 59.755n 0.0v 64.745n 0.0v 64.755n 0.0v 69.745n 0.0v 69.755n 0.0v 74.745n 0.0v 74.755n 0.0v 79.745n 0.0v 79.755n 1.1v 84.745n 1.1v 84.755n 1.1v 89.745n 1.1v 89.755n 1.1v 94.745n 1.1v 94.755n 1.1v 99.745n 1.1v 99.755n 1.1v 104.745n 1.1v 104.755n 1.1v 109.745n 1.1v 109.755n 1.1v 114.745n 1.1v 114.755n 0.0v 119.745n 0.0v 119.755n 0.0v 124.745n 0.0v 124.755n 0.0v 129.745n 0.0v 129.755n 0.0v 134.745n 0.0v 134.755n 0.0v 139.745n 0.0v 139.755n 0.0v 144.745n 0.0v 144.755n 0.0v 149.745n 0.0v 149.755n 1.1v 154.745n 1.1v 154.755n 1.1v 159.745n 1.1v 159.755n 1.1v 164.745n 1.1v 164.755n 1.1v 169.745n 1.1v 169.755n 1.1v 174.745n 1.1v 174.755n 0.0v 179.745n 0.0v 179.755n 1.1v 184.745n 1.1v 184.755n 1.1v 189.745n 1.1v 189.755n 1.1v 194.745n 1.1v 194.755n 1.1v 199.745n 1.1v 199.755n 1.1v 204.745n 1.1v 204.755n 1.1v 209.745n 1.1v 209.755n 1.1v 214.745n 1.1v 214.755n 0.0v 219.745n 0.0v 219.755n 0.0v 224.745n 0.0v 224.755n 0.0v 229.745n 0.0v 229.755n 0.0v 234.745n 0.0v 234.755n 0.0v 239.745n 0.0v 239.755n 0.0v 244.745n 0.0v 244.755n 0.0v 249.745n 0.0v 249.755n 0.0v 254.745n 0.0v 254.755n 0.0v 259.745n 0.0v 259.755n 0.0v 264.745n 0.0v 264.755n 0.0v 269.745n 0.0v 269.755n 1.1v 274.745n 1.1v 274.755n 1.1v 279.745n 1.1v 279.755n 1.1v 284.745n 1.1v 284.755n 1.1v 289.745n 1.1v 289.755n 1.1v 294.745n 1.1v 294.755n 0.0v 299.745n 0.0v 299.755n 0.0v 304.745n 0.0v 304.755n 0.0v 309.745n 0.0v 309.755n 0.0v 314.745n 0.0v 314.755n 0.0v 319.745n 0.0v 319.755n 1.1v 324.745n 1.1v 324.755n 0.0v 329.745n 0.0v 329.755n 0.0v 334.745n 0.0v 334.755n 0.0v 339.745n 0.0v 339.755n 0.0v 344.745n 0.0v 344.755n 0.0v 349.745n 0.0v 349.755n 0.0v 354.745n 0.0v 354.755n 0.0v 359.745n 0.0v 359.755n 1.1v 364.745n 1.1v 364.755n 0.0v 369.745n 0.0v 369.755n 0.0v 374.745n 0.0v 374.755n 0.0v 379.745n 0.0v 379.755n 0.0v 384.745n 0.0v 384.755n 0.0v 389.745n 0.0v 389.755n 0.0v 394.745n 0.0v 394.755n 0.0v 399.745n 0.0v 399.755n 1.1v 404.745n 1.1v 404.755n 1.1v 409.745n 1.1v 409.755n 1.1v 414.745n 1.1v 414.755n 1.1v 419.745n 1.1v 419.755n 1.1v 424.745n 1.1v 424.755n 1.1v 429.745n 1.1v 429.755n 1.1v 434.745n 1.1v 434.755n 0.0v 439.745n 0.0v 439.755n 1.1v 444.745n 1.1v 444.755n 1.1v 449.745n 1.1v 449.755n 1.1v 454.745n 1.1v 454.755n 1.1v 459.745n 1.1v 459.755n 1.1v 464.745n 1.1v 464.755n 1.1v 469.745n 1.1v 469.755n 1.1v 474.745n 1.1v 474.755n 0.0v 479.745n 0.0v 479.755n 0.0v 484.745n 0.0v 484.755n 0.0v 489.745n 0.0v 489.755n 0.0v 494.745n 0.0v 494.755n 1.1v 499.745n 1.1v 499.755n 1.1v 504.745n 1.1v 504.755n 0.0v 509.745n 0.0v 509.755n 0.0v 514.745n 0.0v 514.755n 0.0v 519.745n 0.0v 519.755n 0.0v 524.745n 0.0v 524.755n 0.0v 529.745n 0.0v 529.755n 0.0v 534.745n 0.0v 534.755n 0.0v 539.745n 0.0v 539.755n 0.0v 544.745n 0.0v 544.755n 1.1v 549.745n 1.1v 549.755n 1.1v 554.745n 1.1v 554.755n 0.0v 559.745n 0.0v 559.755n 0.0v 564.745n 0.0v 564.755n 0.0v 569.745n 0.0v 569.755n 0.0v 574.745n 0.0v 574.755n 0.0v 579.745n 0.0v 579.755n 0.0v 584.745n 0.0v 584.755n 1.1v 589.745n 1.1v 589.755n 1.1v 594.745n 1.1v 594.755n 0.0v 599.745n 0.0v 599.755n 0.0v 604.745n 0.0v 604.755n 0.0v 609.745n 0.0v 609.755n 0.0v 614.745n 0.0v 614.755n 0.0v 619.745n 0.0v 619.755n 0.0v 624.745n 0.0v 624.755n 0.0v 629.745n 0.0v 629.755n 0.0v 634.745n 0.0v 634.755n 1.1v 639.745n 1.1v 639.755n 0.0v 644.745n 0.0v 644.755n 0.0v 649.745n 0.0v 649.755n 0.0v 654.745n 0.0v 654.755n 0.0v 659.745n 0.0v 659.755n 0.0v 664.745n 0.0v 664.755n 0.0v 669.745n 0.0v 669.755n 0.0v 674.745n 0.0v 674.755n 0.0v 679.745n 0.0v 679.755n 0.0v 684.745n 0.0v 684.755n 0.0v 689.745n 0.0v 689.755n 0.0v 694.745n 0.0v 694.755n 0.0v 699.745n 0.0v 699.755n 0.0v 704.745n 0.0v 704.755n 1.1v 709.745n 1.1v 709.755n 1.1v 714.745n 1.1v 714.755n 1.1v 719.745n 1.1v 719.755n 1.1v 724.745n 1.1v 724.755n 1.1v 729.745n 1.1v 729.755n 1.1v 734.745n 1.1v 734.755n 1.1v 739.745n 1.1v 739.755n 1.1v 744.745n 1.1v 744.755n 1.1v 749.745n 1.1v 749.755n 1.1v 754.745n 1.1v 754.755n 1.1v 759.745n 1.1v 759.755n 1.1v 764.745n 1.1v 764.755n 1.1v 769.745n 1.1v 769.755n 1.1v 774.745n 1.1v 774.755n 1.1v 779.745n 1.1v 779.755n 1.1v 784.745n 1.1v 784.755n 0.0v 789.745n 0.0v 789.755n 0.0v 794.745n 0.0v 794.755n 0.0v 799.745n 0.0v 799.755n 0.0v 804.745n 0.0v 804.755n 0.0v 809.745n 0.0v 809.755n 0.0v 814.745n 0.0v 814.755n 1.1v 819.745n 1.1v 819.755n 1.1v 824.745n 1.1v 824.755n 1.1v 829.745n 1.1v 829.755n 1.1v 834.745n 1.1v 834.755n 1.1v 839.745n 1.1v 839.755n 1.1v 844.745n 1.1v 844.755n 1.1v 849.745n 1.1v 849.755n 1.1v 854.745n 1.1v 854.755n 1.1v 859.745n 1.1v 859.755n 0.0v 864.745n 0.0v 864.755n 1.1v 869.745n 1.1v 869.755n 1.1v 874.745n 1.1v 874.755n 1.1v 879.745n 1.1v 879.755n 1.1v 884.745n 1.1v 884.755n 1.1v 889.745n 1.1v 889.755n 1.1v 894.745n 1.1v 894.755n 1.1v 899.745n 1.1v 899.755n 1.1v 904.745n 1.1v 904.755n 1.1v 909.745n 1.1v 909.755n 1.1v 914.745n 1.1v 914.755n 1.1v 919.745n 1.1v 919.755n 1.1v 924.745n 1.1v 924.755n 1.1v 929.745n 1.1v 929.755n 1.1v 934.745n 1.1v 934.755n 0.0v 939.745n 0.0v 939.755n 0.0v 944.745n 0.0v 944.755n 0.0v 949.745n 0.0v 949.755n 0.0v 954.745n 0.0v 954.755n 0.0v 959.745n 0.0v 959.755n 0.0v 964.745n 0.0v 964.755n 0.0v 969.745n 0.0v 969.755n 0.0v 974.745n 0.0v 974.755n 0.0v 979.745n 0.0v 979.755n 0.0v 984.745n 0.0v 984.755n 1.1v 989.745n 1.1v 989.755n 1.1v 994.745n 1.1v 994.755n 1.1v 999.745n 1.1v 999.755n 1.1v 1004.745n 1.1v 1004.755n 1.1v 1009.745n 1.1v 1009.755n 1.1v 1014.745n 1.1v 1014.755n 1.1v 1019.745n 1.1v 1019.755n 1.1v 1024.745n 1.1v 1024.755n 1.1v )
* (time, data): [(0, 0), (5, 1), (10, 1), (15, 1), (20, 1), (25, 1), (30, 1), (35, 1), (40, 1), (45, 1), (50, 1), (55, 1), (60, 1), (65, 1), (70, 1), (75, 0), (80, 1), (85, 1), (90, 1), (95, 1), (100, 1), (105, 1), (110, 1), (115, 1), (120, 1), (125, 1), (130, 1), (135, 0), (140, 0), (145, 0), (150, 0), (155, 0), (160, 0), (165, 1), (170, 1), (175, 0), (180, 0), (185, 0), (190, 0), (195, 1), (200, 1), (205, 1), (210, 0), (215, 1), (220, 1), (225, 1), (230, 1), (235, 1), (240, 1), (245, 1), (250, 1), (255, 1), (260, 0), (265, 0), (270, 1), (275, 1), (280, 1), (285, 1), (290, 1), (295, 0), (300, 0), (305, 0), (310, 0), (315, 0), (320, 0), (325, 0), (330, 0), (335, 0), (340, 0), (345, 0), (350, 0), (355, 0), (360, 1), (365, 0), (370, 1), (375, 1), (380, 1), (385, 1), (390, 1), (395, 1), (400, 0), (405, 0), (410, 0), (415, 0), (420, 0), (425, 0), (430, 0), (435, 0), (440, 1), (445, 1), (450, 1), (455, 0), (460, 0), (465, 0), (470, 0), (475, 1), (480, 1), (485, 0), (490, 0), (495, 0), (500, 0), (505, 1), (510, 1), (515, 0), (520, 0), (525, 0), (530, 0), (535, 0), (540, 0), (545, 0), (550, 0), (555, 0), (560, 0), (565, 0), (570, 0), (575, 0), (580, 1), (585, 1), (590, 1), (595, 1), (600, 1), (605, 0), (610, 0), (615, 0), (620, 1), (625, 1), (630, 1), (635, 1), (640, 0), (645, 0), (650, 0), (655, 0), (660, 0), (665, 0), (670, 0), (675, 0), (680, 0), (685, 0), (690, 0), (695, 0), (700, 0), (705, 1), (710, 1), (715, 1), (720, 1), (725, 1), (730, 0), (735, 0), (740, 0), (745, 0), (750, 0), (755, 0), (760, 0), (765, 0), (770, 0), (775, 0), (780, 0), (785, 1), (790, 1), (795, 1), (800, 1), (805, 0), (810, 0), (815, 0), (820, 0), (825, 1), (830, 1), (835, 1), (840, 1), (845, 1), (850, 1), (855, 1), (860, 1), (865, 1), (870, 0), (875, 0), (880, 0), (885, 0), (890, 0), (895, 0), (900, 0), (905, 1), (910, 1), (915, 1), (920, 1), (925, 1), (930, 0), (935, 0), (940, 0), (945, 1), (950, 1), (955, 1), (960, 1), (965, 1), (970, 1), (975, 1), (980, 1), (985, 1), (990, 1), (995, 1), (1000, 0), (1005, 0), (1010, 0), (1015, 0), (1020, 0), (1025, 0)]
Vdin0_17  din0_17  0 PWL (0n 0.0v 4.745n 0.0v 4.755n 1.1v 9.745n 1.1v 9.755n 1.1v 14.745n 1.1v 14.755n 1.1v 19.745n 1.1v 19.755n 1.1v 24.745n 1.1v 24.755n 1.1v 29.745n 1.1v 29.755n 1.1v 34.745n 1.1v 34.755n 1.1v 39.745n 1.1v 39.755n 1.1v 44.745n 1.1v 44.755n 1.1v 49.745n 1.1v 49.755n 1.1v 54.745n 1.1v 54.755n 1.1v 59.745n 1.1v 59.755n 1.1v 64.745n 1.1v 64.755n 1.1v 69.745n 1.1v 69.755n 1.1v 74.745n 1.1v 74.755n 0.0v 79.745n 0.0v 79.755n 1.1v 84.745n 1.1v 84.755n 1.1v 89.745n 1.1v 89.755n 1.1v 94.745n 1.1v 94.755n 1.1v 99.745n 1.1v 99.755n 1.1v 104.745n 1.1v 104.755n 1.1v 109.745n 1.1v 109.755n 1.1v 114.745n 1.1v 114.755n 1.1v 119.745n 1.1v 119.755n 1.1v 124.745n 1.1v 124.755n 1.1v 129.745n 1.1v 129.755n 1.1v 134.745n 1.1v 134.755n 0.0v 139.745n 0.0v 139.755n 0.0v 144.745n 0.0v 144.755n 0.0v 149.745n 0.0v 149.755n 0.0v 154.745n 0.0v 154.755n 0.0v 159.745n 0.0v 159.755n 0.0v 164.745n 0.0v 164.755n 1.1v 169.745n 1.1v 169.755n 1.1v 174.745n 1.1v 174.755n 0.0v 179.745n 0.0v 179.755n 0.0v 184.745n 0.0v 184.755n 0.0v 189.745n 0.0v 189.755n 0.0v 194.745n 0.0v 194.755n 1.1v 199.745n 1.1v 199.755n 1.1v 204.745n 1.1v 204.755n 1.1v 209.745n 1.1v 209.755n 0.0v 214.745n 0.0v 214.755n 1.1v 219.745n 1.1v 219.755n 1.1v 224.745n 1.1v 224.755n 1.1v 229.745n 1.1v 229.755n 1.1v 234.745n 1.1v 234.755n 1.1v 239.745n 1.1v 239.755n 1.1v 244.745n 1.1v 244.755n 1.1v 249.745n 1.1v 249.755n 1.1v 254.745n 1.1v 254.755n 1.1v 259.745n 1.1v 259.755n 0.0v 264.745n 0.0v 264.755n 0.0v 269.745n 0.0v 269.755n 1.1v 274.745n 1.1v 274.755n 1.1v 279.745n 1.1v 279.755n 1.1v 284.745n 1.1v 284.755n 1.1v 289.745n 1.1v 289.755n 1.1v 294.745n 1.1v 294.755n 0.0v 299.745n 0.0v 299.755n 0.0v 304.745n 0.0v 304.755n 0.0v 309.745n 0.0v 309.755n 0.0v 314.745n 0.0v 314.755n 0.0v 319.745n 0.0v 319.755n 0.0v 324.745n 0.0v 324.755n 0.0v 329.745n 0.0v 329.755n 0.0v 334.745n 0.0v 334.755n 0.0v 339.745n 0.0v 339.755n 0.0v 344.745n 0.0v 344.755n 0.0v 349.745n 0.0v 349.755n 0.0v 354.745n 0.0v 354.755n 0.0v 359.745n 0.0v 359.755n 1.1v 364.745n 1.1v 364.755n 0.0v 369.745n 0.0v 369.755n 1.1v 374.745n 1.1v 374.755n 1.1v 379.745n 1.1v 379.755n 1.1v 384.745n 1.1v 384.755n 1.1v 389.745n 1.1v 389.755n 1.1v 394.745n 1.1v 394.755n 1.1v 399.745n 1.1v 399.755n 0.0v 404.745n 0.0v 404.755n 0.0v 409.745n 0.0v 409.755n 0.0v 414.745n 0.0v 414.755n 0.0v 419.745n 0.0v 419.755n 0.0v 424.745n 0.0v 424.755n 0.0v 429.745n 0.0v 429.755n 0.0v 434.745n 0.0v 434.755n 0.0v 439.745n 0.0v 439.755n 1.1v 444.745n 1.1v 444.755n 1.1v 449.745n 1.1v 449.755n 1.1v 454.745n 1.1v 454.755n 0.0v 459.745n 0.0v 459.755n 0.0v 464.745n 0.0v 464.755n 0.0v 469.745n 0.0v 469.755n 0.0v 474.745n 0.0v 474.755n 1.1v 479.745n 1.1v 479.755n 1.1v 484.745n 1.1v 484.755n 0.0v 489.745n 0.0v 489.755n 0.0v 494.745n 0.0v 494.755n 0.0v 499.745n 0.0v 499.755n 0.0v 504.745n 0.0v 504.755n 1.1v 509.745n 1.1v 509.755n 1.1v 514.745n 1.1v 514.755n 0.0v 519.745n 0.0v 519.755n 0.0v 524.745n 0.0v 524.755n 0.0v 529.745n 0.0v 529.755n 0.0v 534.745n 0.0v 534.755n 0.0v 539.745n 0.0v 539.755n 0.0v 544.745n 0.0v 544.755n 0.0v 549.745n 0.0v 549.755n 0.0v 554.745n 0.0v 554.755n 0.0v 559.745n 0.0v 559.755n 0.0v 564.745n 0.0v 564.755n 0.0v 569.745n 0.0v 569.755n 0.0v 574.745n 0.0v 574.755n 0.0v 579.745n 0.0v 579.755n 1.1v 584.745n 1.1v 584.755n 1.1v 589.745n 1.1v 589.755n 1.1v 594.745n 1.1v 594.755n 1.1v 599.745n 1.1v 599.755n 1.1v 604.745n 1.1v 604.755n 0.0v 609.745n 0.0v 609.755n 0.0v 614.745n 0.0v 614.755n 0.0v 619.745n 0.0v 619.755n 1.1v 624.745n 1.1v 624.755n 1.1v 629.745n 1.1v 629.755n 1.1v 634.745n 1.1v 634.755n 1.1v 639.745n 1.1v 639.755n 0.0v 644.745n 0.0v 644.755n 0.0v 649.745n 0.0v 649.755n 0.0v 654.745n 0.0v 654.755n 0.0v 659.745n 0.0v 659.755n 0.0v 664.745n 0.0v 664.755n 0.0v 669.745n 0.0v 669.755n 0.0v 674.745n 0.0v 674.755n 0.0v 679.745n 0.0v 679.755n 0.0v 684.745n 0.0v 684.755n 0.0v 689.745n 0.0v 689.755n 0.0v 694.745n 0.0v 694.755n 0.0v 699.745n 0.0v 699.755n 0.0v 704.745n 0.0v 704.755n 1.1v 709.745n 1.1v 709.755n 1.1v 714.745n 1.1v 714.755n 1.1v 719.745n 1.1v 719.755n 1.1v 724.745n 1.1v 724.755n 1.1v 729.745n 1.1v 729.755n 0.0v 734.745n 0.0v 734.755n 0.0v 739.745n 0.0v 739.755n 0.0v 744.745n 0.0v 744.755n 0.0v 749.745n 0.0v 749.755n 0.0v 754.745n 0.0v 754.755n 0.0v 759.745n 0.0v 759.755n 0.0v 764.745n 0.0v 764.755n 0.0v 769.745n 0.0v 769.755n 0.0v 774.745n 0.0v 774.755n 0.0v 779.745n 0.0v 779.755n 0.0v 784.745n 0.0v 784.755n 1.1v 789.745n 1.1v 789.755n 1.1v 794.745n 1.1v 794.755n 1.1v 799.745n 1.1v 799.755n 1.1v 804.745n 1.1v 804.755n 0.0v 809.745n 0.0v 809.755n 0.0v 814.745n 0.0v 814.755n 0.0v 819.745n 0.0v 819.755n 0.0v 824.745n 0.0v 824.755n 1.1v 829.745n 1.1v 829.755n 1.1v 834.745n 1.1v 834.755n 1.1v 839.745n 1.1v 839.755n 1.1v 844.745n 1.1v 844.755n 1.1v 849.745n 1.1v 849.755n 1.1v 854.745n 1.1v 854.755n 1.1v 859.745n 1.1v 859.755n 1.1v 864.745n 1.1v 864.755n 1.1v 869.745n 1.1v 869.755n 0.0v 874.745n 0.0v 874.755n 0.0v 879.745n 0.0v 879.755n 0.0v 884.745n 0.0v 884.755n 0.0v 889.745n 0.0v 889.755n 0.0v 894.745n 0.0v 894.755n 0.0v 899.745n 0.0v 899.755n 0.0v 904.745n 0.0v 904.755n 1.1v 909.745n 1.1v 909.755n 1.1v 914.745n 1.1v 914.755n 1.1v 919.745n 1.1v 919.755n 1.1v 924.745n 1.1v 924.755n 1.1v 929.745n 1.1v 929.755n 0.0v 934.745n 0.0v 934.755n 0.0v 939.745n 0.0v 939.755n 0.0v 944.745n 0.0v 944.755n 1.1v 949.745n 1.1v 949.755n 1.1v 954.745n 1.1v 954.755n 1.1v 959.745n 1.1v 959.755n 1.1v 964.745n 1.1v 964.755n 1.1v 969.745n 1.1v 969.755n 1.1v 974.745n 1.1v 974.755n 1.1v 979.745n 1.1v 979.755n 1.1v 984.745n 1.1v 984.755n 1.1v 989.745n 1.1v 989.755n 1.1v 994.745n 1.1v 994.755n 1.1v 999.745n 1.1v 999.755n 0.0v 1004.745n 0.0v 1004.755n 0.0v 1009.745n 0.0v 1009.755n 0.0v 1014.745n 0.0v 1014.755n 0.0v 1019.745n 0.0v 1019.755n 0.0v 1024.745n 0.0v 1024.755n 0.0v )
* (time, data): [(0, 0), (5, 0), (10, 1), (15, 0), (20, 0), (25, 0), (30, 0), (35, 1), (40, 1), (45, 1), (50, 1), (55, 1), (60, 1), (65, 1), (70, 1), (75, 0), (80, 1), (85, 1), (90, 1), (95, 1), (100, 1), (105, 1), (110, 1), (115, 1), (120, 1), (125, 1), (130, 1), (135, 0), (140, 0), (145, 0), (150, 1), (155, 1), (160, 1), (165, 0), (170, 0), (175, 1), (180, 0), (185, 0), (190, 0), (195, 1), (200, 1), (205, 1), (210, 1), (215, 1), (220, 1), (225, 1), (230, 1), (235, 1), (240, 1), (245, 1), (250, 1), (255, 1), (260, 1), (265, 1), (270, 1), (275, 1), (280, 1), (285, 1), (290, 1), (295, 0), (300, 0), (305, 0), (310, 0), (315, 0), (320, 1), (325, 1), (330, 1), (335, 1), (340, 1), (345, 1), (350, 0), (355, 0), (360, 1), (365, 1), (370, 1), (375, 1), (380, 1), (385, 1), (390, 1), (395, 1), (400, 1), (405, 1), (410, 1), (415, 1), (420, 1), (425, 1), (430, 1), (435, 1), (440, 0), (445, 0), (450, 0), (455, 0), (460, 1), (465, 1), (470, 1), (475, 0), (480, 0), (485, 0), (490, 0), (495, 1), (500, 1), (505, 0), (510, 0), (515, 1), (520, 1), (525, 1), (530, 1), (535, 1), (540, 0), (545, 0), (550, 1), (555, 1), (560, 1), (565, 1), (570, 1), (575, 1), (580, 1), (585, 1), (590, 1), (595, 0), (600, 0), (605, 0), (610, 0), (615, 0), (620, 1), (625, 1), (630, 1), (635, 1), (640, 1), (645, 1), (650, 0), (655, 0), (660, 0), (665, 0), (670, 0), (675, 0), (680, 0), (685, 0), (690, 0), (695, 0), (700, 0), (705, 1), (710, 1), (715, 1), (720, 1), (725, 1), (730, 1), (735, 1), (740, 1), (745, 1), (750, 1), (755, 0), (760, 0), (765, 0), (770, 0), (775, 0), (780, 0), (785, 0), (790, 0), (795, 0), (800, 0), (805, 1), (810, 1), (815, 0), (820, 0), (825, 0), (830, 1), (835, 0), (840, 0), (845, 0), (850, 0), (855, 0), (860, 1), (865, 0), (870, 1), (875, 1), (880, 1), (885, 1), (890, 1), (895, 1), (900, 1), (905, 0), (910, 0), (915, 0), (920, 0), (925, 0), (930, 0), (935, 1), (940, 1), (945, 1), (950, 1), (955, 1), (960, 1), (965, 1), (970, 1), (975, 1), (980, 1), (985, 1), (990, 1), (995, 1), (1000, 0), (1005, 0), (1010, 0), (1015, 0), (1020, 0), (1025, 0)]
Vdin0_18  din0_18  0 PWL (0n 0.0v 4.745n 0.0v 4.755n 0.0v 9.745n 0.0v 9.755n 1.1v 14.745n 1.1v 14.755n 0.0v 19.745n 0.0v 19.755n 0.0v 24.745n 0.0v 24.755n 0.0v 29.745n 0.0v 29.755n 0.0v 34.745n 0.0v 34.755n 1.1v 39.745n 1.1v 39.755n 1.1v 44.745n 1.1v 44.755n 1.1v 49.745n 1.1v 49.755n 1.1v 54.745n 1.1v 54.755n 1.1v 59.745n 1.1v 59.755n 1.1v 64.745n 1.1v 64.755n 1.1v 69.745n 1.1v 69.755n 1.1v 74.745n 1.1v 74.755n 0.0v 79.745n 0.0v 79.755n 1.1v 84.745n 1.1v 84.755n 1.1v 89.745n 1.1v 89.755n 1.1v 94.745n 1.1v 94.755n 1.1v 99.745n 1.1v 99.755n 1.1v 104.745n 1.1v 104.755n 1.1v 109.745n 1.1v 109.755n 1.1v 114.745n 1.1v 114.755n 1.1v 119.745n 1.1v 119.755n 1.1v 124.745n 1.1v 124.755n 1.1v 129.745n 1.1v 129.755n 1.1v 134.745n 1.1v 134.755n 0.0v 139.745n 0.0v 139.755n 0.0v 144.745n 0.0v 144.755n 0.0v 149.745n 0.0v 149.755n 1.1v 154.745n 1.1v 154.755n 1.1v 159.745n 1.1v 159.755n 1.1v 164.745n 1.1v 164.755n 0.0v 169.745n 0.0v 169.755n 0.0v 174.745n 0.0v 174.755n 1.1v 179.745n 1.1v 179.755n 0.0v 184.745n 0.0v 184.755n 0.0v 189.745n 0.0v 189.755n 0.0v 194.745n 0.0v 194.755n 1.1v 199.745n 1.1v 199.755n 1.1v 204.745n 1.1v 204.755n 1.1v 209.745n 1.1v 209.755n 1.1v 214.745n 1.1v 214.755n 1.1v 219.745n 1.1v 219.755n 1.1v 224.745n 1.1v 224.755n 1.1v 229.745n 1.1v 229.755n 1.1v 234.745n 1.1v 234.755n 1.1v 239.745n 1.1v 239.755n 1.1v 244.745n 1.1v 244.755n 1.1v 249.745n 1.1v 249.755n 1.1v 254.745n 1.1v 254.755n 1.1v 259.745n 1.1v 259.755n 1.1v 264.745n 1.1v 264.755n 1.1v 269.745n 1.1v 269.755n 1.1v 274.745n 1.1v 274.755n 1.1v 279.745n 1.1v 279.755n 1.1v 284.745n 1.1v 284.755n 1.1v 289.745n 1.1v 289.755n 1.1v 294.745n 1.1v 294.755n 0.0v 299.745n 0.0v 299.755n 0.0v 304.745n 0.0v 304.755n 0.0v 309.745n 0.0v 309.755n 0.0v 314.745n 0.0v 314.755n 0.0v 319.745n 0.0v 319.755n 1.1v 324.745n 1.1v 324.755n 1.1v 329.745n 1.1v 329.755n 1.1v 334.745n 1.1v 334.755n 1.1v 339.745n 1.1v 339.755n 1.1v 344.745n 1.1v 344.755n 1.1v 349.745n 1.1v 349.755n 0.0v 354.745n 0.0v 354.755n 0.0v 359.745n 0.0v 359.755n 1.1v 364.745n 1.1v 364.755n 1.1v 369.745n 1.1v 369.755n 1.1v 374.745n 1.1v 374.755n 1.1v 379.745n 1.1v 379.755n 1.1v 384.745n 1.1v 384.755n 1.1v 389.745n 1.1v 389.755n 1.1v 394.745n 1.1v 394.755n 1.1v 399.745n 1.1v 399.755n 1.1v 404.745n 1.1v 404.755n 1.1v 409.745n 1.1v 409.755n 1.1v 414.745n 1.1v 414.755n 1.1v 419.745n 1.1v 419.755n 1.1v 424.745n 1.1v 424.755n 1.1v 429.745n 1.1v 429.755n 1.1v 434.745n 1.1v 434.755n 1.1v 439.745n 1.1v 439.755n 0.0v 444.745n 0.0v 444.755n 0.0v 449.745n 0.0v 449.755n 0.0v 454.745n 0.0v 454.755n 0.0v 459.745n 0.0v 459.755n 1.1v 464.745n 1.1v 464.755n 1.1v 469.745n 1.1v 469.755n 1.1v 474.745n 1.1v 474.755n 0.0v 479.745n 0.0v 479.755n 0.0v 484.745n 0.0v 484.755n 0.0v 489.745n 0.0v 489.755n 0.0v 494.745n 0.0v 494.755n 1.1v 499.745n 1.1v 499.755n 1.1v 504.745n 1.1v 504.755n 0.0v 509.745n 0.0v 509.755n 0.0v 514.745n 0.0v 514.755n 1.1v 519.745n 1.1v 519.755n 1.1v 524.745n 1.1v 524.755n 1.1v 529.745n 1.1v 529.755n 1.1v 534.745n 1.1v 534.755n 1.1v 539.745n 1.1v 539.755n 0.0v 544.745n 0.0v 544.755n 0.0v 549.745n 0.0v 549.755n 1.1v 554.745n 1.1v 554.755n 1.1v 559.745n 1.1v 559.755n 1.1v 564.745n 1.1v 564.755n 1.1v 569.745n 1.1v 569.755n 1.1v 574.745n 1.1v 574.755n 1.1v 579.745n 1.1v 579.755n 1.1v 584.745n 1.1v 584.755n 1.1v 589.745n 1.1v 589.755n 1.1v 594.745n 1.1v 594.755n 0.0v 599.745n 0.0v 599.755n 0.0v 604.745n 0.0v 604.755n 0.0v 609.745n 0.0v 609.755n 0.0v 614.745n 0.0v 614.755n 0.0v 619.745n 0.0v 619.755n 1.1v 624.745n 1.1v 624.755n 1.1v 629.745n 1.1v 629.755n 1.1v 634.745n 1.1v 634.755n 1.1v 639.745n 1.1v 639.755n 1.1v 644.745n 1.1v 644.755n 1.1v 649.745n 1.1v 649.755n 0.0v 654.745n 0.0v 654.755n 0.0v 659.745n 0.0v 659.755n 0.0v 664.745n 0.0v 664.755n 0.0v 669.745n 0.0v 669.755n 0.0v 674.745n 0.0v 674.755n 0.0v 679.745n 0.0v 679.755n 0.0v 684.745n 0.0v 684.755n 0.0v 689.745n 0.0v 689.755n 0.0v 694.745n 0.0v 694.755n 0.0v 699.745n 0.0v 699.755n 0.0v 704.745n 0.0v 704.755n 1.1v 709.745n 1.1v 709.755n 1.1v 714.745n 1.1v 714.755n 1.1v 719.745n 1.1v 719.755n 1.1v 724.745n 1.1v 724.755n 1.1v 729.745n 1.1v 729.755n 1.1v 734.745n 1.1v 734.755n 1.1v 739.745n 1.1v 739.755n 1.1v 744.745n 1.1v 744.755n 1.1v 749.745n 1.1v 749.755n 1.1v 754.745n 1.1v 754.755n 0.0v 759.745n 0.0v 759.755n 0.0v 764.745n 0.0v 764.755n 0.0v 769.745n 0.0v 769.755n 0.0v 774.745n 0.0v 774.755n 0.0v 779.745n 0.0v 779.755n 0.0v 784.745n 0.0v 784.755n 0.0v 789.745n 0.0v 789.755n 0.0v 794.745n 0.0v 794.755n 0.0v 799.745n 0.0v 799.755n 0.0v 804.745n 0.0v 804.755n 1.1v 809.745n 1.1v 809.755n 1.1v 814.745n 1.1v 814.755n 0.0v 819.745n 0.0v 819.755n 0.0v 824.745n 0.0v 824.755n 0.0v 829.745n 0.0v 829.755n 1.1v 834.745n 1.1v 834.755n 0.0v 839.745n 0.0v 839.755n 0.0v 844.745n 0.0v 844.755n 0.0v 849.745n 0.0v 849.755n 0.0v 854.745n 0.0v 854.755n 0.0v 859.745n 0.0v 859.755n 1.1v 864.745n 1.1v 864.755n 0.0v 869.745n 0.0v 869.755n 1.1v 874.745n 1.1v 874.755n 1.1v 879.745n 1.1v 879.755n 1.1v 884.745n 1.1v 884.755n 1.1v 889.745n 1.1v 889.755n 1.1v 894.745n 1.1v 894.755n 1.1v 899.745n 1.1v 899.755n 1.1v 904.745n 1.1v 904.755n 0.0v 909.745n 0.0v 909.755n 0.0v 914.745n 0.0v 914.755n 0.0v 919.745n 0.0v 919.755n 0.0v 924.745n 0.0v 924.755n 0.0v 929.745n 0.0v 929.755n 0.0v 934.745n 0.0v 934.755n 1.1v 939.745n 1.1v 939.755n 1.1v 944.745n 1.1v 944.755n 1.1v 949.745n 1.1v 949.755n 1.1v 954.745n 1.1v 954.755n 1.1v 959.745n 1.1v 959.755n 1.1v 964.745n 1.1v 964.755n 1.1v 969.745n 1.1v 969.755n 1.1v 974.745n 1.1v 974.755n 1.1v 979.745n 1.1v 979.755n 1.1v 984.745n 1.1v 984.755n 1.1v 989.745n 1.1v 989.755n 1.1v 994.745n 1.1v 994.755n 1.1v 999.745n 1.1v 999.755n 0.0v 1004.745n 0.0v 1004.755n 0.0v 1009.745n 0.0v 1009.755n 0.0v 1014.745n 0.0v 1014.755n 0.0v 1019.745n 0.0v 1019.755n 0.0v 1024.745n 0.0v 1024.755n 0.0v )
* (time, data): [(0, 0), (5, 1), (10, 0), (15, 0), (20, 0), (25, 0), (30, 0), (35, 0), (40, 0), (45, 1), (50, 0), (55, 0), (60, 0), (65, 0), (70, 0), (75, 1), (80, 1), (85, 1), (90, 1), (95, 1), (100, 1), (105, 1), (110, 1), (115, 0), (120, 0), (125, 0), (130, 0), (135, 0), (140, 1), (145, 1), (150, 0), (155, 0), (160, 0), (165, 1), (170, 1), (175, 0), (180, 0), (185, 0), (190, 0), (195, 0), (200, 0), (205, 0), (210, 0), (215, 1), (220, 1), (225, 1), (230, 0), (235, 0), (240, 0), (245, 0), (250, 0), (255, 0), (260, 1), (265, 1), (270, 1), (275, 1), (280, 1), (285, 1), (290, 1), (295, 0), (300, 0), (305, 0), (310, 0), (315, 0), (320, 0), (325, 1), (330, 1), (335, 1), (340, 1), (345, 1), (350, 1), (355, 1), (360, 1), (365, 1), (370, 0), (375, 0), (380, 0), (385, 0), (390, 0), (395, 0), (400, 1), (405, 1), (410, 1), (415, 1), (420, 1), (425, 1), (430, 1), (435, 1), (440, 1), (445, 1), (450, 1), (455, 0), (460, 1), (465, 1), (470, 1), (475, 0), (480, 0), (485, 1), (490, 1), (495, 1), (500, 1), (505, 0), (510, 0), (515, 1), (520, 1), (525, 1), (530, 1), (535, 1), (540, 1), (545, 0), (550, 1), (555, 1), (560, 1), (565, 1), (570, 1), (575, 1), (580, 1), (585, 1), (590, 1), (595, 1), (600, 1), (605, 0), (610, 0), (615, 0), (620, 1), (625, 1), (630, 0), (635, 0), (640, 0), (645, 0), (650, 1), (655, 1), (660, 1), (665, 1), (670, 1), (675, 1), (680, 1), (685, 1), (690, 1), (695, 1), (700, 0), (705, 0), (710, 0), (715, 0), (720, 1), (725, 1), (730, 0), (735, 0), (740, 0), (745, 0), (750, 0), (755, 1), (760, 1), (765, 1), (770, 1), (775, 1), (780, 1), (785, 1), (790, 1), (795, 1), (800, 1), (805, 1), (810, 1), (815, 1), (820, 1), (825, 0), (830, 0), (835, 0), (840, 0), (845, 0), (850, 0), (855, 0), (860, 1), (865, 1), (870, 1), (875, 1), (880, 1), (885, 1), (890, 1), (895, 1), (900, 1), (905, 0), (910, 0), (915, 0), (920, 0), (925, 0), (930, 1), (935, 0), (940, 0), (945, 0), (950, 1), (955, 1), (960, 1), (965, 1), (970, 1), (975, 1), (980, 1), (985, 0), (990, 1), (995, 1), (1000, 0), (1005, 0), (1010, 0), (1015, 0), (1020, 0), (1025, 0)]
Vdin0_19  din0_19  0 PWL (0n 0.0v 4.745n 0.0v 4.755n 1.1v 9.745n 1.1v 9.755n 0.0v 14.745n 0.0v 14.755n 0.0v 19.745n 0.0v 19.755n 0.0v 24.745n 0.0v 24.755n 0.0v 29.745n 0.0v 29.755n 0.0v 34.745n 0.0v 34.755n 0.0v 39.745n 0.0v 39.755n 0.0v 44.745n 0.0v 44.755n 1.1v 49.745n 1.1v 49.755n 0.0v 54.745n 0.0v 54.755n 0.0v 59.745n 0.0v 59.755n 0.0v 64.745n 0.0v 64.755n 0.0v 69.745n 0.0v 69.755n 0.0v 74.745n 0.0v 74.755n 1.1v 79.745n 1.1v 79.755n 1.1v 84.745n 1.1v 84.755n 1.1v 89.745n 1.1v 89.755n 1.1v 94.745n 1.1v 94.755n 1.1v 99.745n 1.1v 99.755n 1.1v 104.745n 1.1v 104.755n 1.1v 109.745n 1.1v 109.755n 1.1v 114.745n 1.1v 114.755n 0.0v 119.745n 0.0v 119.755n 0.0v 124.745n 0.0v 124.755n 0.0v 129.745n 0.0v 129.755n 0.0v 134.745n 0.0v 134.755n 0.0v 139.745n 0.0v 139.755n 1.1v 144.745n 1.1v 144.755n 1.1v 149.745n 1.1v 149.755n 0.0v 154.745n 0.0v 154.755n 0.0v 159.745n 0.0v 159.755n 0.0v 164.745n 0.0v 164.755n 1.1v 169.745n 1.1v 169.755n 1.1v 174.745n 1.1v 174.755n 0.0v 179.745n 0.0v 179.755n 0.0v 184.745n 0.0v 184.755n 0.0v 189.745n 0.0v 189.755n 0.0v 194.745n 0.0v 194.755n 0.0v 199.745n 0.0v 199.755n 0.0v 204.745n 0.0v 204.755n 0.0v 209.745n 0.0v 209.755n 0.0v 214.745n 0.0v 214.755n 1.1v 219.745n 1.1v 219.755n 1.1v 224.745n 1.1v 224.755n 1.1v 229.745n 1.1v 229.755n 0.0v 234.745n 0.0v 234.755n 0.0v 239.745n 0.0v 239.755n 0.0v 244.745n 0.0v 244.755n 0.0v 249.745n 0.0v 249.755n 0.0v 254.745n 0.0v 254.755n 0.0v 259.745n 0.0v 259.755n 1.1v 264.745n 1.1v 264.755n 1.1v 269.745n 1.1v 269.755n 1.1v 274.745n 1.1v 274.755n 1.1v 279.745n 1.1v 279.755n 1.1v 284.745n 1.1v 284.755n 1.1v 289.745n 1.1v 289.755n 1.1v 294.745n 1.1v 294.755n 0.0v 299.745n 0.0v 299.755n 0.0v 304.745n 0.0v 304.755n 0.0v 309.745n 0.0v 309.755n 0.0v 314.745n 0.0v 314.755n 0.0v 319.745n 0.0v 319.755n 0.0v 324.745n 0.0v 324.755n 1.1v 329.745n 1.1v 329.755n 1.1v 334.745n 1.1v 334.755n 1.1v 339.745n 1.1v 339.755n 1.1v 344.745n 1.1v 344.755n 1.1v 349.745n 1.1v 349.755n 1.1v 354.745n 1.1v 354.755n 1.1v 359.745n 1.1v 359.755n 1.1v 364.745n 1.1v 364.755n 1.1v 369.745n 1.1v 369.755n 0.0v 374.745n 0.0v 374.755n 0.0v 379.745n 0.0v 379.755n 0.0v 384.745n 0.0v 384.755n 0.0v 389.745n 0.0v 389.755n 0.0v 394.745n 0.0v 394.755n 0.0v 399.745n 0.0v 399.755n 1.1v 404.745n 1.1v 404.755n 1.1v 409.745n 1.1v 409.755n 1.1v 414.745n 1.1v 414.755n 1.1v 419.745n 1.1v 419.755n 1.1v 424.745n 1.1v 424.755n 1.1v 429.745n 1.1v 429.755n 1.1v 434.745n 1.1v 434.755n 1.1v 439.745n 1.1v 439.755n 1.1v 444.745n 1.1v 444.755n 1.1v 449.745n 1.1v 449.755n 1.1v 454.745n 1.1v 454.755n 0.0v 459.745n 0.0v 459.755n 1.1v 464.745n 1.1v 464.755n 1.1v 469.745n 1.1v 469.755n 1.1v 474.745n 1.1v 474.755n 0.0v 479.745n 0.0v 479.755n 0.0v 484.745n 0.0v 484.755n 1.1v 489.745n 1.1v 489.755n 1.1v 494.745n 1.1v 494.755n 1.1v 499.745n 1.1v 499.755n 1.1v 504.745n 1.1v 504.755n 0.0v 509.745n 0.0v 509.755n 0.0v 514.745n 0.0v 514.755n 1.1v 519.745n 1.1v 519.755n 1.1v 524.745n 1.1v 524.755n 1.1v 529.745n 1.1v 529.755n 1.1v 534.745n 1.1v 534.755n 1.1v 539.745n 1.1v 539.755n 1.1v 544.745n 1.1v 544.755n 0.0v 549.745n 0.0v 549.755n 1.1v 554.745n 1.1v 554.755n 1.1v 559.745n 1.1v 559.755n 1.1v 564.745n 1.1v 564.755n 1.1v 569.745n 1.1v 569.755n 1.1v 574.745n 1.1v 574.755n 1.1v 579.745n 1.1v 579.755n 1.1v 584.745n 1.1v 584.755n 1.1v 589.745n 1.1v 589.755n 1.1v 594.745n 1.1v 594.755n 1.1v 599.745n 1.1v 599.755n 1.1v 604.745n 1.1v 604.755n 0.0v 609.745n 0.0v 609.755n 0.0v 614.745n 0.0v 614.755n 0.0v 619.745n 0.0v 619.755n 1.1v 624.745n 1.1v 624.755n 1.1v 629.745n 1.1v 629.755n 0.0v 634.745n 0.0v 634.755n 0.0v 639.745n 0.0v 639.755n 0.0v 644.745n 0.0v 644.755n 0.0v 649.745n 0.0v 649.755n 1.1v 654.745n 1.1v 654.755n 1.1v 659.745n 1.1v 659.755n 1.1v 664.745n 1.1v 664.755n 1.1v 669.745n 1.1v 669.755n 1.1v 674.745n 1.1v 674.755n 1.1v 679.745n 1.1v 679.755n 1.1v 684.745n 1.1v 684.755n 1.1v 689.745n 1.1v 689.755n 1.1v 694.745n 1.1v 694.755n 1.1v 699.745n 1.1v 699.755n 0.0v 704.745n 0.0v 704.755n 0.0v 709.745n 0.0v 709.755n 0.0v 714.745n 0.0v 714.755n 0.0v 719.745n 0.0v 719.755n 1.1v 724.745n 1.1v 724.755n 1.1v 729.745n 1.1v 729.755n 0.0v 734.745n 0.0v 734.755n 0.0v 739.745n 0.0v 739.755n 0.0v 744.745n 0.0v 744.755n 0.0v 749.745n 0.0v 749.755n 0.0v 754.745n 0.0v 754.755n 1.1v 759.745n 1.1v 759.755n 1.1v 764.745n 1.1v 764.755n 1.1v 769.745n 1.1v 769.755n 1.1v 774.745n 1.1v 774.755n 1.1v 779.745n 1.1v 779.755n 1.1v 784.745n 1.1v 784.755n 1.1v 789.745n 1.1v 789.755n 1.1v 794.745n 1.1v 794.755n 1.1v 799.745n 1.1v 799.755n 1.1v 804.745n 1.1v 804.755n 1.1v 809.745n 1.1v 809.755n 1.1v 814.745n 1.1v 814.755n 1.1v 819.745n 1.1v 819.755n 1.1v 824.745n 1.1v 824.755n 0.0v 829.745n 0.0v 829.755n 0.0v 834.745n 0.0v 834.755n 0.0v 839.745n 0.0v 839.755n 0.0v 844.745n 0.0v 844.755n 0.0v 849.745n 0.0v 849.755n 0.0v 854.745n 0.0v 854.755n 0.0v 859.745n 0.0v 859.755n 1.1v 864.745n 1.1v 864.755n 1.1v 869.745n 1.1v 869.755n 1.1v 874.745n 1.1v 874.755n 1.1v 879.745n 1.1v 879.755n 1.1v 884.745n 1.1v 884.755n 1.1v 889.745n 1.1v 889.755n 1.1v 894.745n 1.1v 894.755n 1.1v 899.745n 1.1v 899.755n 1.1v 904.745n 1.1v 904.755n 0.0v 909.745n 0.0v 909.755n 0.0v 914.745n 0.0v 914.755n 0.0v 919.745n 0.0v 919.755n 0.0v 924.745n 0.0v 924.755n 0.0v 929.745n 0.0v 929.755n 1.1v 934.745n 1.1v 934.755n 0.0v 939.745n 0.0v 939.755n 0.0v 944.745n 0.0v 944.755n 0.0v 949.745n 0.0v 949.755n 1.1v 954.745n 1.1v 954.755n 1.1v 959.745n 1.1v 959.755n 1.1v 964.745n 1.1v 964.755n 1.1v 969.745n 1.1v 969.755n 1.1v 974.745n 1.1v 974.755n 1.1v 979.745n 1.1v 979.755n 1.1v 984.745n 1.1v 984.755n 0.0v 989.745n 0.0v 989.755n 1.1v 994.745n 1.1v 994.755n 1.1v 999.745n 1.1v 999.755n 0.0v 1004.745n 0.0v 1004.755n 0.0v 1009.745n 0.0v 1009.755n 0.0v 1014.745n 0.0v 1014.755n 0.0v 1019.745n 0.0v 1019.755n 0.0v 1024.745n 0.0v 1024.755n 0.0v )
* (time, data): [(0, 0), (5, 0), (10, 0), (15, 0), (20, 0), (25, 0), (30, 0), (35, 1), (40, 1), (45, 1), (50, 0), (55, 0), (60, 0), (65, 0), (70, 0), (75, 1), (80, 0), (85, 0), (90, 0), (95, 0), (100, 0), (105, 0), (110, 0), (115, 0), (120, 0), (125, 0), (130, 0), (135, 1), (140, 0), (145, 0), (150, 0), (155, 0), (160, 0), (165, 0), (170, 0), (175, 0), (180, 1), (185, 1), (190, 1), (195, 0), (200, 0), (205, 0), (210, 1), (215, 0), (220, 0), (225, 0), (230, 1), (235, 1), (240, 1), (245, 1), (250, 1), (255, 1), (260, 0), (265, 0), (270, 0), (275, 0), (280, 0), (285, 0), (290, 0), (295, 1), (300, 1), (305, 1), (310, 1), (315, 1), (320, 0), (325, 1), (330, 1), (335, 1), (340, 1), (345, 1), (350, 1), (355, 1), (360, 0), (365, 0), (370, 1), (375, 1), (380, 0), (385, 0), (390, 0), (395, 0), (400, 1), (405, 1), (410, 1), (415, 1), (420, 1), (425, 1), (430, 1), (435, 0), (440, 1), (445, 1), (450, 1), (455, 1), (460, 0), (465, 0), (470, 0), (475, 1), (480, 1), (485, 1), (490, 1), (495, 0), (500, 0), (505, 0), (510, 0), (515, 1), (520, 1), (525, 1), (530, 1), (535, 1), (540, 1), (545, 1), (550, 1), (555, 0), (560, 0), (565, 0), (570, 0), (575, 0), (580, 0), (585, 0), (590, 0), (595, 1), (600, 1), (605, 1), (610, 1), (615, 1), (620, 1), (625, 1), (630, 1), (635, 0), (640, 0), (645, 0), (650, 1), (655, 1), (660, 1), (665, 1), (670, 1), (675, 1), (680, 1), (685, 1), (690, 1), (695, 1), (700, 1), (705, 0), (710, 0), (715, 0), (720, 1), (725, 1), (730, 1), (735, 1), (740, 1), (745, 1), (750, 1), (755, 0), (760, 0), (765, 0), (770, 0), (775, 0), (780, 0), (785, 1), (790, 1), (795, 1), (800, 1), (805, 1), (810, 1), (815, 1), (820, 1), (825, 1), (830, 1), (835, 0), (840, 0), (845, 0), (850, 0), (855, 0), (860, 0), (865, 0), (870, 0), (875, 0), (880, 0), (885, 0), (890, 0), (895, 0), (900, 0), (905, 1), (910, 1), (915, 1), (920, 1), (925, 1), (930, 0), (935, 1), (940, 1), (945, 1), (950, 1), (955, 1), (960, 1), (965, 1), (970, 1), (975, 1), (980, 1), (985, 1), (990, 0), (995, 0), (1000, 0), (1005, 0), (1010, 1), (1015, 1), (1020, 1), (1025, 1)]
Vdin0_20  din0_20  0 PWL (0n 0.0v 4.745n 0.0v 4.755n 0.0v 9.745n 0.0v 9.755n 0.0v 14.745n 0.0v 14.755n 0.0v 19.745n 0.0v 19.755n 0.0v 24.745n 0.0v 24.755n 0.0v 29.745n 0.0v 29.755n 0.0v 34.745n 0.0v 34.755n 1.1v 39.745n 1.1v 39.755n 1.1v 44.745n 1.1v 44.755n 1.1v 49.745n 1.1v 49.755n 0.0v 54.745n 0.0v 54.755n 0.0v 59.745n 0.0v 59.755n 0.0v 64.745n 0.0v 64.755n 0.0v 69.745n 0.0v 69.755n 0.0v 74.745n 0.0v 74.755n 1.1v 79.745n 1.1v 79.755n 0.0v 84.745n 0.0v 84.755n 0.0v 89.745n 0.0v 89.755n 0.0v 94.745n 0.0v 94.755n 0.0v 99.745n 0.0v 99.755n 0.0v 104.745n 0.0v 104.755n 0.0v 109.745n 0.0v 109.755n 0.0v 114.745n 0.0v 114.755n 0.0v 119.745n 0.0v 119.755n 0.0v 124.745n 0.0v 124.755n 0.0v 129.745n 0.0v 129.755n 0.0v 134.745n 0.0v 134.755n 1.1v 139.745n 1.1v 139.755n 0.0v 144.745n 0.0v 144.755n 0.0v 149.745n 0.0v 149.755n 0.0v 154.745n 0.0v 154.755n 0.0v 159.745n 0.0v 159.755n 0.0v 164.745n 0.0v 164.755n 0.0v 169.745n 0.0v 169.755n 0.0v 174.745n 0.0v 174.755n 0.0v 179.745n 0.0v 179.755n 1.1v 184.745n 1.1v 184.755n 1.1v 189.745n 1.1v 189.755n 1.1v 194.745n 1.1v 194.755n 0.0v 199.745n 0.0v 199.755n 0.0v 204.745n 0.0v 204.755n 0.0v 209.745n 0.0v 209.755n 1.1v 214.745n 1.1v 214.755n 0.0v 219.745n 0.0v 219.755n 0.0v 224.745n 0.0v 224.755n 0.0v 229.745n 0.0v 229.755n 1.1v 234.745n 1.1v 234.755n 1.1v 239.745n 1.1v 239.755n 1.1v 244.745n 1.1v 244.755n 1.1v 249.745n 1.1v 249.755n 1.1v 254.745n 1.1v 254.755n 1.1v 259.745n 1.1v 259.755n 0.0v 264.745n 0.0v 264.755n 0.0v 269.745n 0.0v 269.755n 0.0v 274.745n 0.0v 274.755n 0.0v 279.745n 0.0v 279.755n 0.0v 284.745n 0.0v 284.755n 0.0v 289.745n 0.0v 289.755n 0.0v 294.745n 0.0v 294.755n 1.1v 299.745n 1.1v 299.755n 1.1v 304.745n 1.1v 304.755n 1.1v 309.745n 1.1v 309.755n 1.1v 314.745n 1.1v 314.755n 1.1v 319.745n 1.1v 319.755n 0.0v 324.745n 0.0v 324.755n 1.1v 329.745n 1.1v 329.755n 1.1v 334.745n 1.1v 334.755n 1.1v 339.745n 1.1v 339.755n 1.1v 344.745n 1.1v 344.755n 1.1v 349.745n 1.1v 349.755n 1.1v 354.745n 1.1v 354.755n 1.1v 359.745n 1.1v 359.755n 0.0v 364.745n 0.0v 364.755n 0.0v 369.745n 0.0v 369.755n 1.1v 374.745n 1.1v 374.755n 1.1v 379.745n 1.1v 379.755n 0.0v 384.745n 0.0v 384.755n 0.0v 389.745n 0.0v 389.755n 0.0v 394.745n 0.0v 394.755n 0.0v 399.745n 0.0v 399.755n 1.1v 404.745n 1.1v 404.755n 1.1v 409.745n 1.1v 409.755n 1.1v 414.745n 1.1v 414.755n 1.1v 419.745n 1.1v 419.755n 1.1v 424.745n 1.1v 424.755n 1.1v 429.745n 1.1v 429.755n 1.1v 434.745n 1.1v 434.755n 0.0v 439.745n 0.0v 439.755n 1.1v 444.745n 1.1v 444.755n 1.1v 449.745n 1.1v 449.755n 1.1v 454.745n 1.1v 454.755n 1.1v 459.745n 1.1v 459.755n 0.0v 464.745n 0.0v 464.755n 0.0v 469.745n 0.0v 469.755n 0.0v 474.745n 0.0v 474.755n 1.1v 479.745n 1.1v 479.755n 1.1v 484.745n 1.1v 484.755n 1.1v 489.745n 1.1v 489.755n 1.1v 494.745n 1.1v 494.755n 0.0v 499.745n 0.0v 499.755n 0.0v 504.745n 0.0v 504.755n 0.0v 509.745n 0.0v 509.755n 0.0v 514.745n 0.0v 514.755n 1.1v 519.745n 1.1v 519.755n 1.1v 524.745n 1.1v 524.755n 1.1v 529.745n 1.1v 529.755n 1.1v 534.745n 1.1v 534.755n 1.1v 539.745n 1.1v 539.755n 1.1v 544.745n 1.1v 544.755n 1.1v 549.745n 1.1v 549.755n 1.1v 554.745n 1.1v 554.755n 0.0v 559.745n 0.0v 559.755n 0.0v 564.745n 0.0v 564.755n 0.0v 569.745n 0.0v 569.755n 0.0v 574.745n 0.0v 574.755n 0.0v 579.745n 0.0v 579.755n 0.0v 584.745n 0.0v 584.755n 0.0v 589.745n 0.0v 589.755n 0.0v 594.745n 0.0v 594.755n 1.1v 599.745n 1.1v 599.755n 1.1v 604.745n 1.1v 604.755n 1.1v 609.745n 1.1v 609.755n 1.1v 614.745n 1.1v 614.755n 1.1v 619.745n 1.1v 619.755n 1.1v 624.745n 1.1v 624.755n 1.1v 629.745n 1.1v 629.755n 1.1v 634.745n 1.1v 634.755n 0.0v 639.745n 0.0v 639.755n 0.0v 644.745n 0.0v 644.755n 0.0v 649.745n 0.0v 649.755n 1.1v 654.745n 1.1v 654.755n 1.1v 659.745n 1.1v 659.755n 1.1v 664.745n 1.1v 664.755n 1.1v 669.745n 1.1v 669.755n 1.1v 674.745n 1.1v 674.755n 1.1v 679.745n 1.1v 679.755n 1.1v 684.745n 1.1v 684.755n 1.1v 689.745n 1.1v 689.755n 1.1v 694.745n 1.1v 694.755n 1.1v 699.745n 1.1v 699.755n 1.1v 704.745n 1.1v 704.755n 0.0v 709.745n 0.0v 709.755n 0.0v 714.745n 0.0v 714.755n 0.0v 719.745n 0.0v 719.755n 1.1v 724.745n 1.1v 724.755n 1.1v 729.745n 1.1v 729.755n 1.1v 734.745n 1.1v 734.755n 1.1v 739.745n 1.1v 739.755n 1.1v 744.745n 1.1v 744.755n 1.1v 749.745n 1.1v 749.755n 1.1v 754.745n 1.1v 754.755n 0.0v 759.745n 0.0v 759.755n 0.0v 764.745n 0.0v 764.755n 0.0v 769.745n 0.0v 769.755n 0.0v 774.745n 0.0v 774.755n 0.0v 779.745n 0.0v 779.755n 0.0v 784.745n 0.0v 784.755n 1.1v 789.745n 1.1v 789.755n 1.1v 794.745n 1.1v 794.755n 1.1v 799.745n 1.1v 799.755n 1.1v 804.745n 1.1v 804.755n 1.1v 809.745n 1.1v 809.755n 1.1v 814.745n 1.1v 814.755n 1.1v 819.745n 1.1v 819.755n 1.1v 824.745n 1.1v 824.755n 1.1v 829.745n 1.1v 829.755n 1.1v 834.745n 1.1v 834.755n 0.0v 839.745n 0.0v 839.755n 0.0v 844.745n 0.0v 844.755n 0.0v 849.745n 0.0v 849.755n 0.0v 854.745n 0.0v 854.755n 0.0v 859.745n 0.0v 859.755n 0.0v 864.745n 0.0v 864.755n 0.0v 869.745n 0.0v 869.755n 0.0v 874.745n 0.0v 874.755n 0.0v 879.745n 0.0v 879.755n 0.0v 884.745n 0.0v 884.755n 0.0v 889.745n 0.0v 889.755n 0.0v 894.745n 0.0v 894.755n 0.0v 899.745n 0.0v 899.755n 0.0v 904.745n 0.0v 904.755n 1.1v 909.745n 1.1v 909.755n 1.1v 914.745n 1.1v 914.755n 1.1v 919.745n 1.1v 919.755n 1.1v 924.745n 1.1v 924.755n 1.1v 929.745n 1.1v 929.755n 0.0v 934.745n 0.0v 934.755n 1.1v 939.745n 1.1v 939.755n 1.1v 944.745n 1.1v 944.755n 1.1v 949.745n 1.1v 949.755n 1.1v 954.745n 1.1v 954.755n 1.1v 959.745n 1.1v 959.755n 1.1v 964.745n 1.1v 964.755n 1.1v 969.745n 1.1v 969.755n 1.1v 974.745n 1.1v 974.755n 1.1v 979.745n 1.1v 979.755n 1.1v 984.745n 1.1v 984.755n 1.1v 989.745n 1.1v 989.755n 0.0v 994.745n 0.0v 994.755n 0.0v 999.745n 0.0v 999.755n 0.0v 1004.745n 0.0v 1004.755n 0.0v 1009.745n 0.0v 1009.755n 1.1v 1014.745n 1.1v 1014.755n 1.1v 1019.745n 1.1v 1019.755n 1.1v 1024.745n 1.1v 1024.755n 1.1v )
* (time, data): [(0, 0), (5, 0), (10, 0), (15, 1), (20, 1), (25, 1), (30, 1), (35, 1), (40, 1), (45, 0), (50, 1), (55, 0), (60, 0), (65, 0), (70, 0), (75, 0), (80, 0), (85, 0), (90, 0), (95, 0), (100, 0), (105, 0), (110, 0), (115, 0), (120, 0), (125, 0), (130, 0), (135, 0), (140, 1), (145, 1), (150, 0), (155, 0), (160, 0), (165, 0), (170, 0), (175, 0), (180, 0), (185, 0), (190, 0), (195, 1), (200, 1), (205, 1), (210, 1), (215, 0), (220, 0), (225, 0), (230, 1), (235, 1), (240, 1), (245, 1), (250, 1), (255, 1), (260, 0), (265, 0), (270, 1), (275, 1), (280, 1), (285, 1), (290, 1), (295, 1), (300, 1), (305, 1), (310, 1), (315, 1), (320, 1), (325, 0), (330, 0), (335, 0), (340, 0), (345, 0), (350, 0), (355, 0), (360, 1), (365, 0), (370, 1), (375, 1), (380, 1), (385, 1), (390, 1), (395, 1), (400, 1), (405, 1), (410, 0), (415, 0), (420, 0), (425, 0), (430, 0), (435, 0), (440, 0), (445, 0), (450, 0), (455, 1), (460, 0), (465, 0), (470, 0), (475, 1), (480, 1), (485, 0), (490, 0), (495, 0), (500, 0), (505, 0), (510, 0), (515, 0), (520, 0), (525, 0), (530, 0), (535, 0), (540, 1), (545, 0), (550, 1), (555, 1), (560, 1), (565, 1), (570, 1), (575, 1), (580, 1), (585, 1), (590, 1), (595, 1), (600, 1), (605, 1), (610, 1), (615, 1), (620, 0), (625, 0), (630, 1), (635, 1), (640, 0), (645, 0), (650, 0), (655, 0), (660, 0), (665, 0), (670, 0), (675, 0), (680, 0), (685, 0), (690, 0), (695, 0), (700, 1), (705, 1), (710, 1), (715, 1), (720, 1), (725, 1), (730, 0), (735, 0), (740, 0), (745, 0), (750, 0), (755, 0), (760, 0), (765, 0), (770, 0), (775, 0), (780, 0), (785, 0), (790, 0), (795, 0), (800, 0), (805, 0), (810, 0), (815, 1), (820, 1), (825, 0), (830, 1), (835, 1), (840, 1), (845, 1), (850, 1), (855, 1), (860, 0), (865, 1), (870, 0), (875, 0), (880, 0), (885, 0), (890, 0), (895, 0), (900, 0), (905, 0), (910, 0), (915, 0), (920, 0), (925, 0), (930, 0), (935, 1), (940, 1), (945, 0), (950, 0), (955, 0), (960, 0), (965, 0), (970, 0), (975, 0), (980, 0), (985, 0), (990, 1), (995, 1), (1000, 1), (1005, 1), (1010, 0), (1015, 0), (1020, 0), (1025, 0)]
Vdin0_21  din0_21  0 PWL (0n 0.0v 4.745n 0.0v 4.755n 0.0v 9.745n 0.0v 9.755n 0.0v 14.745n 0.0v 14.755n 1.1v 19.745n 1.1v 19.755n 1.1v 24.745n 1.1v 24.755n 1.1v 29.745n 1.1v 29.755n 1.1v 34.745n 1.1v 34.755n 1.1v 39.745n 1.1v 39.755n 1.1v 44.745n 1.1v 44.755n 0.0v 49.745n 0.0v 49.755n 1.1v 54.745n 1.1v 54.755n 0.0v 59.745n 0.0v 59.755n 0.0v 64.745n 0.0v 64.755n 0.0v 69.745n 0.0v 69.755n 0.0v 74.745n 0.0v 74.755n 0.0v 79.745n 0.0v 79.755n 0.0v 84.745n 0.0v 84.755n 0.0v 89.745n 0.0v 89.755n 0.0v 94.745n 0.0v 94.755n 0.0v 99.745n 0.0v 99.755n 0.0v 104.745n 0.0v 104.755n 0.0v 109.745n 0.0v 109.755n 0.0v 114.745n 0.0v 114.755n 0.0v 119.745n 0.0v 119.755n 0.0v 124.745n 0.0v 124.755n 0.0v 129.745n 0.0v 129.755n 0.0v 134.745n 0.0v 134.755n 0.0v 139.745n 0.0v 139.755n 1.1v 144.745n 1.1v 144.755n 1.1v 149.745n 1.1v 149.755n 0.0v 154.745n 0.0v 154.755n 0.0v 159.745n 0.0v 159.755n 0.0v 164.745n 0.0v 164.755n 0.0v 169.745n 0.0v 169.755n 0.0v 174.745n 0.0v 174.755n 0.0v 179.745n 0.0v 179.755n 0.0v 184.745n 0.0v 184.755n 0.0v 189.745n 0.0v 189.755n 0.0v 194.745n 0.0v 194.755n 1.1v 199.745n 1.1v 199.755n 1.1v 204.745n 1.1v 204.755n 1.1v 209.745n 1.1v 209.755n 1.1v 214.745n 1.1v 214.755n 0.0v 219.745n 0.0v 219.755n 0.0v 224.745n 0.0v 224.755n 0.0v 229.745n 0.0v 229.755n 1.1v 234.745n 1.1v 234.755n 1.1v 239.745n 1.1v 239.755n 1.1v 244.745n 1.1v 244.755n 1.1v 249.745n 1.1v 249.755n 1.1v 254.745n 1.1v 254.755n 1.1v 259.745n 1.1v 259.755n 0.0v 264.745n 0.0v 264.755n 0.0v 269.745n 0.0v 269.755n 1.1v 274.745n 1.1v 274.755n 1.1v 279.745n 1.1v 279.755n 1.1v 284.745n 1.1v 284.755n 1.1v 289.745n 1.1v 289.755n 1.1v 294.745n 1.1v 294.755n 1.1v 299.745n 1.1v 299.755n 1.1v 304.745n 1.1v 304.755n 1.1v 309.745n 1.1v 309.755n 1.1v 314.745n 1.1v 314.755n 1.1v 319.745n 1.1v 319.755n 1.1v 324.745n 1.1v 324.755n 0.0v 329.745n 0.0v 329.755n 0.0v 334.745n 0.0v 334.755n 0.0v 339.745n 0.0v 339.755n 0.0v 344.745n 0.0v 344.755n 0.0v 349.745n 0.0v 349.755n 0.0v 354.745n 0.0v 354.755n 0.0v 359.745n 0.0v 359.755n 1.1v 364.745n 1.1v 364.755n 0.0v 369.745n 0.0v 369.755n 1.1v 374.745n 1.1v 374.755n 1.1v 379.745n 1.1v 379.755n 1.1v 384.745n 1.1v 384.755n 1.1v 389.745n 1.1v 389.755n 1.1v 394.745n 1.1v 394.755n 1.1v 399.745n 1.1v 399.755n 1.1v 404.745n 1.1v 404.755n 1.1v 409.745n 1.1v 409.755n 0.0v 414.745n 0.0v 414.755n 0.0v 419.745n 0.0v 419.755n 0.0v 424.745n 0.0v 424.755n 0.0v 429.745n 0.0v 429.755n 0.0v 434.745n 0.0v 434.755n 0.0v 439.745n 0.0v 439.755n 0.0v 444.745n 0.0v 444.755n 0.0v 449.745n 0.0v 449.755n 0.0v 454.745n 0.0v 454.755n 1.1v 459.745n 1.1v 459.755n 0.0v 464.745n 0.0v 464.755n 0.0v 469.745n 0.0v 469.755n 0.0v 474.745n 0.0v 474.755n 1.1v 479.745n 1.1v 479.755n 1.1v 484.745n 1.1v 484.755n 0.0v 489.745n 0.0v 489.755n 0.0v 494.745n 0.0v 494.755n 0.0v 499.745n 0.0v 499.755n 0.0v 504.745n 0.0v 504.755n 0.0v 509.745n 0.0v 509.755n 0.0v 514.745n 0.0v 514.755n 0.0v 519.745n 0.0v 519.755n 0.0v 524.745n 0.0v 524.755n 0.0v 529.745n 0.0v 529.755n 0.0v 534.745n 0.0v 534.755n 0.0v 539.745n 0.0v 539.755n 1.1v 544.745n 1.1v 544.755n 0.0v 549.745n 0.0v 549.755n 1.1v 554.745n 1.1v 554.755n 1.1v 559.745n 1.1v 559.755n 1.1v 564.745n 1.1v 564.755n 1.1v 569.745n 1.1v 569.755n 1.1v 574.745n 1.1v 574.755n 1.1v 579.745n 1.1v 579.755n 1.1v 584.745n 1.1v 584.755n 1.1v 589.745n 1.1v 589.755n 1.1v 594.745n 1.1v 594.755n 1.1v 599.745n 1.1v 599.755n 1.1v 604.745n 1.1v 604.755n 1.1v 609.745n 1.1v 609.755n 1.1v 614.745n 1.1v 614.755n 1.1v 619.745n 1.1v 619.755n 0.0v 624.745n 0.0v 624.755n 0.0v 629.745n 0.0v 629.755n 1.1v 634.745n 1.1v 634.755n 1.1v 639.745n 1.1v 639.755n 0.0v 644.745n 0.0v 644.755n 0.0v 649.745n 0.0v 649.755n 0.0v 654.745n 0.0v 654.755n 0.0v 659.745n 0.0v 659.755n 0.0v 664.745n 0.0v 664.755n 0.0v 669.745n 0.0v 669.755n 0.0v 674.745n 0.0v 674.755n 0.0v 679.745n 0.0v 679.755n 0.0v 684.745n 0.0v 684.755n 0.0v 689.745n 0.0v 689.755n 0.0v 694.745n 0.0v 694.755n 0.0v 699.745n 0.0v 699.755n 1.1v 704.745n 1.1v 704.755n 1.1v 709.745n 1.1v 709.755n 1.1v 714.745n 1.1v 714.755n 1.1v 719.745n 1.1v 719.755n 1.1v 724.745n 1.1v 724.755n 1.1v 729.745n 1.1v 729.755n 0.0v 734.745n 0.0v 734.755n 0.0v 739.745n 0.0v 739.755n 0.0v 744.745n 0.0v 744.755n 0.0v 749.745n 0.0v 749.755n 0.0v 754.745n 0.0v 754.755n 0.0v 759.745n 0.0v 759.755n 0.0v 764.745n 0.0v 764.755n 0.0v 769.745n 0.0v 769.755n 0.0v 774.745n 0.0v 774.755n 0.0v 779.745n 0.0v 779.755n 0.0v 784.745n 0.0v 784.755n 0.0v 789.745n 0.0v 789.755n 0.0v 794.745n 0.0v 794.755n 0.0v 799.745n 0.0v 799.755n 0.0v 804.745n 0.0v 804.755n 0.0v 809.745n 0.0v 809.755n 0.0v 814.745n 0.0v 814.755n 1.1v 819.745n 1.1v 819.755n 1.1v 824.745n 1.1v 824.755n 0.0v 829.745n 0.0v 829.755n 1.1v 834.745n 1.1v 834.755n 1.1v 839.745n 1.1v 839.755n 1.1v 844.745n 1.1v 844.755n 1.1v 849.745n 1.1v 849.755n 1.1v 854.745n 1.1v 854.755n 1.1v 859.745n 1.1v 859.755n 0.0v 864.745n 0.0v 864.755n 1.1v 869.745n 1.1v 869.755n 0.0v 874.745n 0.0v 874.755n 0.0v 879.745n 0.0v 879.755n 0.0v 884.745n 0.0v 884.755n 0.0v 889.745n 0.0v 889.755n 0.0v 894.745n 0.0v 894.755n 0.0v 899.745n 0.0v 899.755n 0.0v 904.745n 0.0v 904.755n 0.0v 909.745n 0.0v 909.755n 0.0v 914.745n 0.0v 914.755n 0.0v 919.745n 0.0v 919.755n 0.0v 924.745n 0.0v 924.755n 0.0v 929.745n 0.0v 929.755n 0.0v 934.745n 0.0v 934.755n 1.1v 939.745n 1.1v 939.755n 1.1v 944.745n 1.1v 944.755n 0.0v 949.745n 0.0v 949.755n 0.0v 954.745n 0.0v 954.755n 0.0v 959.745n 0.0v 959.755n 0.0v 964.745n 0.0v 964.755n 0.0v 969.745n 0.0v 969.755n 0.0v 974.745n 0.0v 974.755n 0.0v 979.745n 0.0v 979.755n 0.0v 984.745n 0.0v 984.755n 0.0v 989.745n 0.0v 989.755n 1.1v 994.745n 1.1v 994.755n 1.1v 999.745n 1.1v 999.755n 1.1v 1004.745n 1.1v 1004.755n 1.1v 1009.745n 1.1v 1009.755n 0.0v 1014.745n 0.0v 1014.755n 0.0v 1019.745n 0.0v 1019.755n 0.0v 1024.745n 0.0v 1024.755n 0.0v )
* (time, data): [(0, 0), (5, 1), (10, 0), (15, 0), (20, 0), (25, 0), (30, 0), (35, 1), (40, 1), (45, 1), (50, 0), (55, 0), (60, 0), (65, 0), (70, 0), (75, 1), (80, 1), (85, 1), (90, 1), (95, 1), (100, 1), (105, 1), (110, 1), (115, 0), (120, 0), (125, 0), (130, 0), (135, 0), (140, 1), (145, 1), (150, 1), (155, 1), (160, 1), (165, 1), (170, 1), (175, 0), (180, 1), (185, 1), (190, 1), (195, 1), (200, 1), (205, 1), (210, 0), (215, 0), (220, 0), (225, 0), (230, 1), (235, 1), (240, 1), (245, 1), (250, 1), (255, 1), (260, 1), (265, 1), (270, 0), (275, 0), (280, 0), (285, 0), (290, 0), (295, 0), (300, 0), (305, 0), (310, 0), (315, 0), (320, 1), (325, 0), (330, 0), (335, 0), (340, 0), (345, 0), (350, 1), (355, 1), (360, 0), (365, 1), (370, 1), (375, 1), (380, 0), (385, 0), (390, 0), (395, 0), (400, 0), (405, 0), (410, 1), (415, 1), (420, 1), (425, 1), (430, 1), (435, 0), (440, 1), (445, 1), (450, 1), (455, 0), (460, 0), (465, 0), (470, 0), (475, 0), (480, 0), (485, 0), (490, 0), (495, 0), (500, 0), (505, 1), (510, 1), (515, 0), (520, 0), (525, 0), (530, 0), (535, 0), (540, 1), (545, 1), (550, 0), (555, 0), (560, 0), (565, 0), (570, 0), (575, 0), (580, 0), (585, 1), (590, 1), (595, 0), (600, 0), (605, 1), (610, 1), (615, 1), (620, 0), (625, 0), (630, 0), (635, 1), (640, 1), (645, 1), (650, 0), (655, 0), (660, 0), (665, 0), (670, 0), (675, 0), (680, 0), (685, 0), (690, 0), (695, 0), (700, 1), (705, 1), (710, 1), (715, 1), (720, 0), (725, 0), (730, 0), (735, 0), (740, 0), (745, 0), (750, 0), (755, 0), (760, 0), (765, 0), (770, 0), (775, 0), (780, 0), (785, 0), (790, 0), (795, 0), (800, 0), (805, 1), (810, 1), (815, 1), (820, 1), (825, 1), (830, 0), (835, 0), (840, 0), (845, 0), (850, 0), (855, 0), (860, 1), (865, 0), (870, 0), (875, 0), (880, 0), (885, 0), (890, 0), (895, 0), (900, 0), (905, 0), (910, 0), (915, 0), (920, 0), (925, 0), (930, 0), (935, 0), (940, 0), (945, 1), (950, 1), (955, 1), (960, 1), (965, 1), (970, 1), (975, 1), (980, 1), (985, 0), (990, 1), (995, 1), (1000, 1), (1005, 1), (1010, 0), (1015, 0), (1020, 0), (1025, 0)]
Vdin0_22  din0_22  0 PWL (0n 0.0v 4.745n 0.0v 4.755n 1.1v 9.745n 1.1v 9.755n 0.0v 14.745n 0.0v 14.755n 0.0v 19.745n 0.0v 19.755n 0.0v 24.745n 0.0v 24.755n 0.0v 29.745n 0.0v 29.755n 0.0v 34.745n 0.0v 34.755n 1.1v 39.745n 1.1v 39.755n 1.1v 44.745n 1.1v 44.755n 1.1v 49.745n 1.1v 49.755n 0.0v 54.745n 0.0v 54.755n 0.0v 59.745n 0.0v 59.755n 0.0v 64.745n 0.0v 64.755n 0.0v 69.745n 0.0v 69.755n 0.0v 74.745n 0.0v 74.755n 1.1v 79.745n 1.1v 79.755n 1.1v 84.745n 1.1v 84.755n 1.1v 89.745n 1.1v 89.755n 1.1v 94.745n 1.1v 94.755n 1.1v 99.745n 1.1v 99.755n 1.1v 104.745n 1.1v 104.755n 1.1v 109.745n 1.1v 109.755n 1.1v 114.745n 1.1v 114.755n 0.0v 119.745n 0.0v 119.755n 0.0v 124.745n 0.0v 124.755n 0.0v 129.745n 0.0v 129.755n 0.0v 134.745n 0.0v 134.755n 0.0v 139.745n 0.0v 139.755n 1.1v 144.745n 1.1v 144.755n 1.1v 149.745n 1.1v 149.755n 1.1v 154.745n 1.1v 154.755n 1.1v 159.745n 1.1v 159.755n 1.1v 164.745n 1.1v 164.755n 1.1v 169.745n 1.1v 169.755n 1.1v 174.745n 1.1v 174.755n 0.0v 179.745n 0.0v 179.755n 1.1v 184.745n 1.1v 184.755n 1.1v 189.745n 1.1v 189.755n 1.1v 194.745n 1.1v 194.755n 1.1v 199.745n 1.1v 199.755n 1.1v 204.745n 1.1v 204.755n 1.1v 209.745n 1.1v 209.755n 0.0v 214.745n 0.0v 214.755n 0.0v 219.745n 0.0v 219.755n 0.0v 224.745n 0.0v 224.755n 0.0v 229.745n 0.0v 229.755n 1.1v 234.745n 1.1v 234.755n 1.1v 239.745n 1.1v 239.755n 1.1v 244.745n 1.1v 244.755n 1.1v 249.745n 1.1v 249.755n 1.1v 254.745n 1.1v 254.755n 1.1v 259.745n 1.1v 259.755n 1.1v 264.745n 1.1v 264.755n 1.1v 269.745n 1.1v 269.755n 0.0v 274.745n 0.0v 274.755n 0.0v 279.745n 0.0v 279.755n 0.0v 284.745n 0.0v 284.755n 0.0v 289.745n 0.0v 289.755n 0.0v 294.745n 0.0v 294.755n 0.0v 299.745n 0.0v 299.755n 0.0v 304.745n 0.0v 304.755n 0.0v 309.745n 0.0v 309.755n 0.0v 314.745n 0.0v 314.755n 0.0v 319.745n 0.0v 319.755n 1.1v 324.745n 1.1v 324.755n 0.0v 329.745n 0.0v 329.755n 0.0v 334.745n 0.0v 334.755n 0.0v 339.745n 0.0v 339.755n 0.0v 344.745n 0.0v 344.755n 0.0v 349.745n 0.0v 349.755n 1.1v 354.745n 1.1v 354.755n 1.1v 359.745n 1.1v 359.755n 0.0v 364.745n 0.0v 364.755n 1.1v 369.745n 1.1v 369.755n 1.1v 374.745n 1.1v 374.755n 1.1v 379.745n 1.1v 379.755n 0.0v 384.745n 0.0v 384.755n 0.0v 389.745n 0.0v 389.755n 0.0v 394.745n 0.0v 394.755n 0.0v 399.745n 0.0v 399.755n 0.0v 404.745n 0.0v 404.755n 0.0v 409.745n 0.0v 409.755n 1.1v 414.745n 1.1v 414.755n 1.1v 419.745n 1.1v 419.755n 1.1v 424.745n 1.1v 424.755n 1.1v 429.745n 1.1v 429.755n 1.1v 434.745n 1.1v 434.755n 0.0v 439.745n 0.0v 439.755n 1.1v 444.745n 1.1v 444.755n 1.1v 449.745n 1.1v 449.755n 1.1v 454.745n 1.1v 454.755n 0.0v 459.745n 0.0v 459.755n 0.0v 464.745n 0.0v 464.755n 0.0v 469.745n 0.0v 469.755n 0.0v 474.745n 0.0v 474.755n 0.0v 479.745n 0.0v 479.755n 0.0v 484.745n 0.0v 484.755n 0.0v 489.745n 0.0v 489.755n 0.0v 494.745n 0.0v 494.755n 0.0v 499.745n 0.0v 499.755n 0.0v 504.745n 0.0v 504.755n 1.1v 509.745n 1.1v 509.755n 1.1v 514.745n 1.1v 514.755n 0.0v 519.745n 0.0v 519.755n 0.0v 524.745n 0.0v 524.755n 0.0v 529.745n 0.0v 529.755n 0.0v 534.745n 0.0v 534.755n 0.0v 539.745n 0.0v 539.755n 1.1v 544.745n 1.1v 544.755n 1.1v 549.745n 1.1v 549.755n 0.0v 554.745n 0.0v 554.755n 0.0v 559.745n 0.0v 559.755n 0.0v 564.745n 0.0v 564.755n 0.0v 569.745n 0.0v 569.755n 0.0v 574.745n 0.0v 574.755n 0.0v 579.745n 0.0v 579.755n 0.0v 584.745n 0.0v 584.755n 1.1v 589.745n 1.1v 589.755n 1.1v 594.745n 1.1v 594.755n 0.0v 599.745n 0.0v 599.755n 0.0v 604.745n 0.0v 604.755n 1.1v 609.745n 1.1v 609.755n 1.1v 614.745n 1.1v 614.755n 1.1v 619.745n 1.1v 619.755n 0.0v 624.745n 0.0v 624.755n 0.0v 629.745n 0.0v 629.755n 0.0v 634.745n 0.0v 634.755n 1.1v 639.745n 1.1v 639.755n 1.1v 644.745n 1.1v 644.755n 1.1v 649.745n 1.1v 649.755n 0.0v 654.745n 0.0v 654.755n 0.0v 659.745n 0.0v 659.755n 0.0v 664.745n 0.0v 664.755n 0.0v 669.745n 0.0v 669.755n 0.0v 674.745n 0.0v 674.755n 0.0v 679.745n 0.0v 679.755n 0.0v 684.745n 0.0v 684.755n 0.0v 689.745n 0.0v 689.755n 0.0v 694.745n 0.0v 694.755n 0.0v 699.745n 0.0v 699.755n 1.1v 704.745n 1.1v 704.755n 1.1v 709.745n 1.1v 709.755n 1.1v 714.745n 1.1v 714.755n 1.1v 719.745n 1.1v 719.755n 0.0v 724.745n 0.0v 724.755n 0.0v 729.745n 0.0v 729.755n 0.0v 734.745n 0.0v 734.755n 0.0v 739.745n 0.0v 739.755n 0.0v 744.745n 0.0v 744.755n 0.0v 749.745n 0.0v 749.755n 0.0v 754.745n 0.0v 754.755n 0.0v 759.745n 0.0v 759.755n 0.0v 764.745n 0.0v 764.755n 0.0v 769.745n 0.0v 769.755n 0.0v 774.745n 0.0v 774.755n 0.0v 779.745n 0.0v 779.755n 0.0v 784.745n 0.0v 784.755n 0.0v 789.745n 0.0v 789.755n 0.0v 794.745n 0.0v 794.755n 0.0v 799.745n 0.0v 799.755n 0.0v 804.745n 0.0v 804.755n 1.1v 809.745n 1.1v 809.755n 1.1v 814.745n 1.1v 814.755n 1.1v 819.745n 1.1v 819.755n 1.1v 824.745n 1.1v 824.755n 1.1v 829.745n 1.1v 829.755n 0.0v 834.745n 0.0v 834.755n 0.0v 839.745n 0.0v 839.755n 0.0v 844.745n 0.0v 844.755n 0.0v 849.745n 0.0v 849.755n 0.0v 854.745n 0.0v 854.755n 0.0v 859.745n 0.0v 859.755n 1.1v 864.745n 1.1v 864.755n 0.0v 869.745n 0.0v 869.755n 0.0v 874.745n 0.0v 874.755n 0.0v 879.745n 0.0v 879.755n 0.0v 884.745n 0.0v 884.755n 0.0v 889.745n 0.0v 889.755n 0.0v 894.745n 0.0v 894.755n 0.0v 899.745n 0.0v 899.755n 0.0v 904.745n 0.0v 904.755n 0.0v 909.745n 0.0v 909.755n 0.0v 914.745n 0.0v 914.755n 0.0v 919.745n 0.0v 919.755n 0.0v 924.745n 0.0v 924.755n 0.0v 929.745n 0.0v 929.755n 0.0v 934.745n 0.0v 934.755n 0.0v 939.745n 0.0v 939.755n 0.0v 944.745n 0.0v 944.755n 1.1v 949.745n 1.1v 949.755n 1.1v 954.745n 1.1v 954.755n 1.1v 959.745n 1.1v 959.755n 1.1v 964.745n 1.1v 964.755n 1.1v 969.745n 1.1v 969.755n 1.1v 974.745n 1.1v 974.755n 1.1v 979.745n 1.1v 979.755n 1.1v 984.745n 1.1v 984.755n 0.0v 989.745n 0.0v 989.755n 1.1v 994.745n 1.1v 994.755n 1.1v 999.745n 1.1v 999.755n 1.1v 1004.745n 1.1v 1004.755n 1.1v 1009.745n 1.1v 1009.755n 0.0v 1014.745n 0.0v 1014.755n 0.0v 1019.745n 0.0v 1019.755n 0.0v 1024.745n 0.0v 1024.755n 0.0v )
* (time, data): [(0, 0), (5, 0), (10, 1), (15, 1), (20, 1), (25, 1), (30, 1), (35, 1), (40, 1), (45, 0), (50, 1), (55, 0), (60, 0), (65, 0), (70, 0), (75, 1), (80, 0), (85, 0), (90, 0), (95, 0), (100, 0), (105, 0), (110, 0), (115, 1), (120, 1), (125, 1), (130, 1), (135, 0), (140, 0), (145, 0), (150, 0), (155, 0), (160, 0), (165, 1), (170, 1), (175, 1), (180, 0), (185, 0), (190, 0), (195, 0), (200, 0), (205, 0), (210, 1), (215, 0), (220, 0), (225, 0), (230, 1), (235, 1), (240, 1), (245, 1), (250, 1), (255, 1), (260, 1), (265, 1), (270, 0), (275, 0), (280, 0), (285, 0), (290, 0), (295, 1), (300, 1), (305, 1), (310, 1), (315, 0), (320, 0), (325, 0), (330, 0), (335, 0), (340, 0), (345, 0), (350, 0), (355, 0), (360, 0), (365, 0), (370, 0), (375, 0), (380, 0), (385, 0), (390, 0), (395, 0), (400, 1), (405, 1), (410, 1), (415, 1), (420, 1), (425, 1), (430, 1), (435, 1), (440, 1), (445, 1), (450, 1), (455, 1), (460, 0), (465, 0), (470, 0), (475, 0), (480, 0), (485, 0), (490, 0), (495, 0), (500, 0), (505, 1), (510, 1), (515, 1), (520, 1), (525, 1), (530, 1), (535, 1), (540, 1), (545, 0), (550, 0), (555, 1), (560, 1), (565, 1), (570, 1), (575, 1), (580, 1), (585, 1), (590, 1), (595, 0), (600, 0), (605, 0), (610, 0), (615, 0), (620, 1), (625, 1), (630, 0), (635, 0), (640, 1), (645, 1), (650, 1), (655, 1), (660, 1), (665, 1), (670, 1), (675, 1), (680, 1), (685, 1), (690, 1), (695, 1), (700, 0), (705, 1), (710, 1), (715, 1), (720, 0), (725, 0), (730, 1), (735, 1), (740, 1), (745, 1), (750, 1), (755, 1), (760, 1), (765, 0), (770, 0), (775, 0), (780, 0), (785, 1), (790, 1), (795, 1), (800, 1), (805, 0), (810, 0), (815, 0), (820, 0), (825, 0), (830, 0), (835, 1), (840, 1), (845, 1), (850, 1), (855, 1), (860, 1), (865, 0), (870, 0), (875, 0), (880, 0), (885, 0), (890, 0), (895, 0), (900, 0), (905, 1), (910, 1), (915, 1), (920, 1), (925, 1), (930, 1), (935, 0), (940, 0), (945, 1), (950, 0), (955, 0), (960, 0), (965, 0), (970, 0), (975, 0), (980, 0), (985, 0), (990, 0), (995, 0), (1000, 0), (1005, 0), (1010, 0), (1015, 0), (1020, 0), (1025, 0)]
Vdin0_23  din0_23  0 PWL (0n 0.0v 4.745n 0.0v 4.755n 0.0v 9.745n 0.0v 9.755n 1.1v 14.745n 1.1v 14.755n 1.1v 19.745n 1.1v 19.755n 1.1v 24.745n 1.1v 24.755n 1.1v 29.745n 1.1v 29.755n 1.1v 34.745n 1.1v 34.755n 1.1v 39.745n 1.1v 39.755n 1.1v 44.745n 1.1v 44.755n 0.0v 49.745n 0.0v 49.755n 1.1v 54.745n 1.1v 54.755n 0.0v 59.745n 0.0v 59.755n 0.0v 64.745n 0.0v 64.755n 0.0v 69.745n 0.0v 69.755n 0.0v 74.745n 0.0v 74.755n 1.1v 79.745n 1.1v 79.755n 0.0v 84.745n 0.0v 84.755n 0.0v 89.745n 0.0v 89.755n 0.0v 94.745n 0.0v 94.755n 0.0v 99.745n 0.0v 99.755n 0.0v 104.745n 0.0v 104.755n 0.0v 109.745n 0.0v 109.755n 0.0v 114.745n 0.0v 114.755n 1.1v 119.745n 1.1v 119.755n 1.1v 124.745n 1.1v 124.755n 1.1v 129.745n 1.1v 129.755n 1.1v 134.745n 1.1v 134.755n 0.0v 139.745n 0.0v 139.755n 0.0v 144.745n 0.0v 144.755n 0.0v 149.745n 0.0v 149.755n 0.0v 154.745n 0.0v 154.755n 0.0v 159.745n 0.0v 159.755n 0.0v 164.745n 0.0v 164.755n 1.1v 169.745n 1.1v 169.755n 1.1v 174.745n 1.1v 174.755n 1.1v 179.745n 1.1v 179.755n 0.0v 184.745n 0.0v 184.755n 0.0v 189.745n 0.0v 189.755n 0.0v 194.745n 0.0v 194.755n 0.0v 199.745n 0.0v 199.755n 0.0v 204.745n 0.0v 204.755n 0.0v 209.745n 0.0v 209.755n 1.1v 214.745n 1.1v 214.755n 0.0v 219.745n 0.0v 219.755n 0.0v 224.745n 0.0v 224.755n 0.0v 229.745n 0.0v 229.755n 1.1v 234.745n 1.1v 234.755n 1.1v 239.745n 1.1v 239.755n 1.1v 244.745n 1.1v 244.755n 1.1v 249.745n 1.1v 249.755n 1.1v 254.745n 1.1v 254.755n 1.1v 259.745n 1.1v 259.755n 1.1v 264.745n 1.1v 264.755n 1.1v 269.745n 1.1v 269.755n 0.0v 274.745n 0.0v 274.755n 0.0v 279.745n 0.0v 279.755n 0.0v 284.745n 0.0v 284.755n 0.0v 289.745n 0.0v 289.755n 0.0v 294.745n 0.0v 294.755n 1.1v 299.745n 1.1v 299.755n 1.1v 304.745n 1.1v 304.755n 1.1v 309.745n 1.1v 309.755n 1.1v 314.745n 1.1v 314.755n 0.0v 319.745n 0.0v 319.755n 0.0v 324.745n 0.0v 324.755n 0.0v 329.745n 0.0v 329.755n 0.0v 334.745n 0.0v 334.755n 0.0v 339.745n 0.0v 339.755n 0.0v 344.745n 0.0v 344.755n 0.0v 349.745n 0.0v 349.755n 0.0v 354.745n 0.0v 354.755n 0.0v 359.745n 0.0v 359.755n 0.0v 364.745n 0.0v 364.755n 0.0v 369.745n 0.0v 369.755n 0.0v 374.745n 0.0v 374.755n 0.0v 379.745n 0.0v 379.755n 0.0v 384.745n 0.0v 384.755n 0.0v 389.745n 0.0v 389.755n 0.0v 394.745n 0.0v 394.755n 0.0v 399.745n 0.0v 399.755n 1.1v 404.745n 1.1v 404.755n 1.1v 409.745n 1.1v 409.755n 1.1v 414.745n 1.1v 414.755n 1.1v 419.745n 1.1v 419.755n 1.1v 424.745n 1.1v 424.755n 1.1v 429.745n 1.1v 429.755n 1.1v 434.745n 1.1v 434.755n 1.1v 439.745n 1.1v 439.755n 1.1v 444.745n 1.1v 444.755n 1.1v 449.745n 1.1v 449.755n 1.1v 454.745n 1.1v 454.755n 1.1v 459.745n 1.1v 459.755n 0.0v 464.745n 0.0v 464.755n 0.0v 469.745n 0.0v 469.755n 0.0v 474.745n 0.0v 474.755n 0.0v 479.745n 0.0v 479.755n 0.0v 484.745n 0.0v 484.755n 0.0v 489.745n 0.0v 489.755n 0.0v 494.745n 0.0v 494.755n 0.0v 499.745n 0.0v 499.755n 0.0v 504.745n 0.0v 504.755n 1.1v 509.745n 1.1v 509.755n 1.1v 514.745n 1.1v 514.755n 1.1v 519.745n 1.1v 519.755n 1.1v 524.745n 1.1v 524.755n 1.1v 529.745n 1.1v 529.755n 1.1v 534.745n 1.1v 534.755n 1.1v 539.745n 1.1v 539.755n 1.1v 544.745n 1.1v 544.755n 0.0v 549.745n 0.0v 549.755n 0.0v 554.745n 0.0v 554.755n 1.1v 559.745n 1.1v 559.755n 1.1v 564.745n 1.1v 564.755n 1.1v 569.745n 1.1v 569.755n 1.1v 574.745n 1.1v 574.755n 1.1v 579.745n 1.1v 579.755n 1.1v 584.745n 1.1v 584.755n 1.1v 589.745n 1.1v 589.755n 1.1v 594.745n 1.1v 594.755n 0.0v 599.745n 0.0v 599.755n 0.0v 604.745n 0.0v 604.755n 0.0v 609.745n 0.0v 609.755n 0.0v 614.745n 0.0v 614.755n 0.0v 619.745n 0.0v 619.755n 1.1v 624.745n 1.1v 624.755n 1.1v 629.745n 1.1v 629.755n 0.0v 634.745n 0.0v 634.755n 0.0v 639.745n 0.0v 639.755n 1.1v 644.745n 1.1v 644.755n 1.1v 649.745n 1.1v 649.755n 1.1v 654.745n 1.1v 654.755n 1.1v 659.745n 1.1v 659.755n 1.1v 664.745n 1.1v 664.755n 1.1v 669.745n 1.1v 669.755n 1.1v 674.745n 1.1v 674.755n 1.1v 679.745n 1.1v 679.755n 1.1v 684.745n 1.1v 684.755n 1.1v 689.745n 1.1v 689.755n 1.1v 694.745n 1.1v 694.755n 1.1v 699.745n 1.1v 699.755n 0.0v 704.745n 0.0v 704.755n 1.1v 709.745n 1.1v 709.755n 1.1v 714.745n 1.1v 714.755n 1.1v 719.745n 1.1v 719.755n 0.0v 724.745n 0.0v 724.755n 0.0v 729.745n 0.0v 729.755n 1.1v 734.745n 1.1v 734.755n 1.1v 739.745n 1.1v 739.755n 1.1v 744.745n 1.1v 744.755n 1.1v 749.745n 1.1v 749.755n 1.1v 754.745n 1.1v 754.755n 1.1v 759.745n 1.1v 759.755n 1.1v 764.745n 1.1v 764.755n 0.0v 769.745n 0.0v 769.755n 0.0v 774.745n 0.0v 774.755n 0.0v 779.745n 0.0v 779.755n 0.0v 784.745n 0.0v 784.755n 1.1v 789.745n 1.1v 789.755n 1.1v 794.745n 1.1v 794.755n 1.1v 799.745n 1.1v 799.755n 1.1v 804.745n 1.1v 804.755n 0.0v 809.745n 0.0v 809.755n 0.0v 814.745n 0.0v 814.755n 0.0v 819.745n 0.0v 819.755n 0.0v 824.745n 0.0v 824.755n 0.0v 829.745n 0.0v 829.755n 0.0v 834.745n 0.0v 834.755n 1.1v 839.745n 1.1v 839.755n 1.1v 844.745n 1.1v 844.755n 1.1v 849.745n 1.1v 849.755n 1.1v 854.745n 1.1v 854.755n 1.1v 859.745n 1.1v 859.755n 1.1v 864.745n 1.1v 864.755n 0.0v 869.745n 0.0v 869.755n 0.0v 874.745n 0.0v 874.755n 0.0v 879.745n 0.0v 879.755n 0.0v 884.745n 0.0v 884.755n 0.0v 889.745n 0.0v 889.755n 0.0v 894.745n 0.0v 894.755n 0.0v 899.745n 0.0v 899.755n 0.0v 904.745n 0.0v 904.755n 1.1v 909.745n 1.1v 909.755n 1.1v 914.745n 1.1v 914.755n 1.1v 919.745n 1.1v 919.755n 1.1v 924.745n 1.1v 924.755n 1.1v 929.745n 1.1v 929.755n 1.1v 934.745n 1.1v 934.755n 0.0v 939.745n 0.0v 939.755n 0.0v 944.745n 0.0v 944.755n 1.1v 949.745n 1.1v 949.755n 0.0v 954.745n 0.0v 954.755n 0.0v 959.745n 0.0v 959.755n 0.0v 964.745n 0.0v 964.755n 0.0v 969.745n 0.0v 969.755n 0.0v 974.745n 0.0v 974.755n 0.0v 979.745n 0.0v 979.755n 0.0v 984.745n 0.0v 984.755n 0.0v 989.745n 0.0v 989.755n 0.0v 994.745n 0.0v 994.755n 0.0v 999.745n 0.0v 999.755n 0.0v 1004.745n 0.0v 1004.755n 0.0v 1009.745n 0.0v 1009.755n 0.0v 1014.745n 0.0v 1014.755n 0.0v 1019.745n 0.0v 1019.755n 0.0v 1024.745n 0.0v 1024.755n 0.0v )
* (time, data): [(0, 0), (5, 1), (10, 1), (15, 0), (20, 0), (25, 0), (30, 0), (35, 0), (40, 0), (45, 1), (50, 0), (55, 1), (60, 1), (65, 1), (70, 1), (75, 0), (80, 1), (85, 1), (90, 1), (95, 1), (100, 1), (105, 1), (110, 1), (115, 0), (120, 0), (125, 0), (130, 0), (135, 0), (140, 0), (145, 0), (150, 1), (155, 1), (160, 1), (165, 1), (170, 1), (175, 0), (180, 1), (185, 1), (190, 1), (195, 1), (200, 1), (205, 1), (210, 0), (215, 0), (220, 0), (225, 0), (230, 1), (235, 1), (240, 1), (245, 1), (250, 1), (255, 1), (260, 0), (265, 0), (270, 1), (275, 1), (280, 1), (285, 1), (290, 1), (295, 1), (300, 1), (305, 1), (310, 1), (315, 0), (320, 1), (325, 1), (330, 1), (335, 1), (340, 1), (345, 1), (350, 0), (355, 0), (360, 0), (365, 1), (370, 0), (375, 0), (380, 1), (385, 1), (390, 1), (395, 1), (400, 0), (405, 0), (410, 1), (415, 1), (420, 1), (425, 1), (430, 1), (435, 0), (440, 1), (445, 1), (450, 1), (455, 1), (460, 0), (465, 0), (470, 0), (475, 1), (480, 1), (485, 0), (490, 0), (495, 1), (500, 1), (505, 1), (510, 1), (515, 1), (520, 1), (525, 1), (530, 1), (535, 1), (540, 0), (545, 0), (550, 0), (555, 1), (560, 1), (565, 1), (570, 1), (575, 1), (580, 0), (585, 1), (590, 1), (595, 0), (600, 0), (605, 0), (610, 0), (615, 0), (620, 1), (625, 1), (630, 0), (635, 0), (640, 1), (645, 1), (650, 0), (655, 0), (660, 0), (665, 0), (670, 0), (675, 0), (680, 0), (685, 0), (690, 0), (695, 0), (700, 0), (705, 1), (710, 1), (715, 1), (720, 1), (725, 1), (730, 1), (735, 1), (740, 1), (745, 1), (750, 1), (755, 0), (760, 0), (765, 1), (770, 1), (775, 1), (780, 1), (785, 0), (790, 0), (795, 0), (800, 0), (805, 1), (810, 1), (815, 0), (820, 0), (825, 0), (830, 1), (835, 0), (840, 0), (845, 0), (850, 0), (855, 0), (860, 1), (865, 0), (870, 0), (875, 0), (880, 0), (885, 0), (890, 0), (895, 0), (900, 0), (905, 0), (910, 0), (915, 0), (920, 0), (925, 0), (930, 1), (935, 0), (940, 0), (945, 1), (950, 1), (955, 1), (960, 1), (965, 1), (970, 1), (975, 1), (980, 1), (985, 1), (990, 1), (995, 1), (1000, 1), (1005, 1), (1010, 0), (1015, 0), (1020, 0), (1025, 0)]
Vdin0_24  din0_24  0 PWL (0n 0.0v 4.745n 0.0v 4.755n 1.1v 9.745n 1.1v 9.755n 1.1v 14.745n 1.1v 14.755n 0.0v 19.745n 0.0v 19.755n 0.0v 24.745n 0.0v 24.755n 0.0v 29.745n 0.0v 29.755n 0.0v 34.745n 0.0v 34.755n 0.0v 39.745n 0.0v 39.755n 0.0v 44.745n 0.0v 44.755n 1.1v 49.745n 1.1v 49.755n 0.0v 54.745n 0.0v 54.755n 1.1v 59.745n 1.1v 59.755n 1.1v 64.745n 1.1v 64.755n 1.1v 69.745n 1.1v 69.755n 1.1v 74.745n 1.1v 74.755n 0.0v 79.745n 0.0v 79.755n 1.1v 84.745n 1.1v 84.755n 1.1v 89.745n 1.1v 89.755n 1.1v 94.745n 1.1v 94.755n 1.1v 99.745n 1.1v 99.755n 1.1v 104.745n 1.1v 104.755n 1.1v 109.745n 1.1v 109.755n 1.1v 114.745n 1.1v 114.755n 0.0v 119.745n 0.0v 119.755n 0.0v 124.745n 0.0v 124.755n 0.0v 129.745n 0.0v 129.755n 0.0v 134.745n 0.0v 134.755n 0.0v 139.745n 0.0v 139.755n 0.0v 144.745n 0.0v 144.755n 0.0v 149.745n 0.0v 149.755n 1.1v 154.745n 1.1v 154.755n 1.1v 159.745n 1.1v 159.755n 1.1v 164.745n 1.1v 164.755n 1.1v 169.745n 1.1v 169.755n 1.1v 174.745n 1.1v 174.755n 0.0v 179.745n 0.0v 179.755n 1.1v 184.745n 1.1v 184.755n 1.1v 189.745n 1.1v 189.755n 1.1v 194.745n 1.1v 194.755n 1.1v 199.745n 1.1v 199.755n 1.1v 204.745n 1.1v 204.755n 1.1v 209.745n 1.1v 209.755n 0.0v 214.745n 0.0v 214.755n 0.0v 219.745n 0.0v 219.755n 0.0v 224.745n 0.0v 224.755n 0.0v 229.745n 0.0v 229.755n 1.1v 234.745n 1.1v 234.755n 1.1v 239.745n 1.1v 239.755n 1.1v 244.745n 1.1v 244.755n 1.1v 249.745n 1.1v 249.755n 1.1v 254.745n 1.1v 254.755n 1.1v 259.745n 1.1v 259.755n 0.0v 264.745n 0.0v 264.755n 0.0v 269.745n 0.0v 269.755n 1.1v 274.745n 1.1v 274.755n 1.1v 279.745n 1.1v 279.755n 1.1v 284.745n 1.1v 284.755n 1.1v 289.745n 1.1v 289.755n 1.1v 294.745n 1.1v 294.755n 1.1v 299.745n 1.1v 299.755n 1.1v 304.745n 1.1v 304.755n 1.1v 309.745n 1.1v 309.755n 1.1v 314.745n 1.1v 314.755n 0.0v 319.745n 0.0v 319.755n 1.1v 324.745n 1.1v 324.755n 1.1v 329.745n 1.1v 329.755n 1.1v 334.745n 1.1v 334.755n 1.1v 339.745n 1.1v 339.755n 1.1v 344.745n 1.1v 344.755n 1.1v 349.745n 1.1v 349.755n 0.0v 354.745n 0.0v 354.755n 0.0v 359.745n 0.0v 359.755n 0.0v 364.745n 0.0v 364.755n 1.1v 369.745n 1.1v 369.755n 0.0v 374.745n 0.0v 374.755n 0.0v 379.745n 0.0v 379.755n 1.1v 384.745n 1.1v 384.755n 1.1v 389.745n 1.1v 389.755n 1.1v 394.745n 1.1v 394.755n 1.1v 399.745n 1.1v 399.755n 0.0v 404.745n 0.0v 404.755n 0.0v 409.745n 0.0v 409.755n 1.1v 414.745n 1.1v 414.755n 1.1v 419.745n 1.1v 419.755n 1.1v 424.745n 1.1v 424.755n 1.1v 429.745n 1.1v 429.755n 1.1v 434.745n 1.1v 434.755n 0.0v 439.745n 0.0v 439.755n 1.1v 444.745n 1.1v 444.755n 1.1v 449.745n 1.1v 449.755n 1.1v 454.745n 1.1v 454.755n 1.1v 459.745n 1.1v 459.755n 0.0v 464.745n 0.0v 464.755n 0.0v 469.745n 0.0v 469.755n 0.0v 474.745n 0.0v 474.755n 1.1v 479.745n 1.1v 479.755n 1.1v 484.745n 1.1v 484.755n 0.0v 489.745n 0.0v 489.755n 0.0v 494.745n 0.0v 494.755n 1.1v 499.745n 1.1v 499.755n 1.1v 504.745n 1.1v 504.755n 1.1v 509.745n 1.1v 509.755n 1.1v 514.745n 1.1v 514.755n 1.1v 519.745n 1.1v 519.755n 1.1v 524.745n 1.1v 524.755n 1.1v 529.745n 1.1v 529.755n 1.1v 534.745n 1.1v 534.755n 1.1v 539.745n 1.1v 539.755n 0.0v 544.745n 0.0v 544.755n 0.0v 549.745n 0.0v 549.755n 0.0v 554.745n 0.0v 554.755n 1.1v 559.745n 1.1v 559.755n 1.1v 564.745n 1.1v 564.755n 1.1v 569.745n 1.1v 569.755n 1.1v 574.745n 1.1v 574.755n 1.1v 579.745n 1.1v 579.755n 0.0v 584.745n 0.0v 584.755n 1.1v 589.745n 1.1v 589.755n 1.1v 594.745n 1.1v 594.755n 0.0v 599.745n 0.0v 599.755n 0.0v 604.745n 0.0v 604.755n 0.0v 609.745n 0.0v 609.755n 0.0v 614.745n 0.0v 614.755n 0.0v 619.745n 0.0v 619.755n 1.1v 624.745n 1.1v 624.755n 1.1v 629.745n 1.1v 629.755n 0.0v 634.745n 0.0v 634.755n 0.0v 639.745n 0.0v 639.755n 1.1v 644.745n 1.1v 644.755n 1.1v 649.745n 1.1v 649.755n 0.0v 654.745n 0.0v 654.755n 0.0v 659.745n 0.0v 659.755n 0.0v 664.745n 0.0v 664.755n 0.0v 669.745n 0.0v 669.755n 0.0v 674.745n 0.0v 674.755n 0.0v 679.745n 0.0v 679.755n 0.0v 684.745n 0.0v 684.755n 0.0v 689.745n 0.0v 689.755n 0.0v 694.745n 0.0v 694.755n 0.0v 699.745n 0.0v 699.755n 0.0v 704.745n 0.0v 704.755n 1.1v 709.745n 1.1v 709.755n 1.1v 714.745n 1.1v 714.755n 1.1v 719.745n 1.1v 719.755n 1.1v 724.745n 1.1v 724.755n 1.1v 729.745n 1.1v 729.755n 1.1v 734.745n 1.1v 734.755n 1.1v 739.745n 1.1v 739.755n 1.1v 744.745n 1.1v 744.755n 1.1v 749.745n 1.1v 749.755n 1.1v 754.745n 1.1v 754.755n 0.0v 759.745n 0.0v 759.755n 0.0v 764.745n 0.0v 764.755n 1.1v 769.745n 1.1v 769.755n 1.1v 774.745n 1.1v 774.755n 1.1v 779.745n 1.1v 779.755n 1.1v 784.745n 1.1v 784.755n 0.0v 789.745n 0.0v 789.755n 0.0v 794.745n 0.0v 794.755n 0.0v 799.745n 0.0v 799.755n 0.0v 804.745n 0.0v 804.755n 1.1v 809.745n 1.1v 809.755n 1.1v 814.745n 1.1v 814.755n 0.0v 819.745n 0.0v 819.755n 0.0v 824.745n 0.0v 824.755n 0.0v 829.745n 0.0v 829.755n 1.1v 834.745n 1.1v 834.755n 0.0v 839.745n 0.0v 839.755n 0.0v 844.745n 0.0v 844.755n 0.0v 849.745n 0.0v 849.755n 0.0v 854.745n 0.0v 854.755n 0.0v 859.745n 0.0v 859.755n 1.1v 864.745n 1.1v 864.755n 0.0v 869.745n 0.0v 869.755n 0.0v 874.745n 0.0v 874.755n 0.0v 879.745n 0.0v 879.755n 0.0v 884.745n 0.0v 884.755n 0.0v 889.745n 0.0v 889.755n 0.0v 894.745n 0.0v 894.755n 0.0v 899.745n 0.0v 899.755n 0.0v 904.745n 0.0v 904.755n 0.0v 909.745n 0.0v 909.755n 0.0v 914.745n 0.0v 914.755n 0.0v 919.745n 0.0v 919.755n 0.0v 924.745n 0.0v 924.755n 0.0v 929.745n 0.0v 929.755n 1.1v 934.745n 1.1v 934.755n 0.0v 939.745n 0.0v 939.755n 0.0v 944.745n 0.0v 944.755n 1.1v 949.745n 1.1v 949.755n 1.1v 954.745n 1.1v 954.755n 1.1v 959.745n 1.1v 959.755n 1.1v 964.745n 1.1v 964.755n 1.1v 969.745n 1.1v 969.755n 1.1v 974.745n 1.1v 974.755n 1.1v 979.745n 1.1v 979.755n 1.1v 984.745n 1.1v 984.755n 1.1v 989.745n 1.1v 989.755n 1.1v 994.745n 1.1v 994.755n 1.1v 999.745n 1.1v 999.755n 1.1v 1004.745n 1.1v 1004.755n 1.1v 1009.745n 1.1v 1009.755n 0.0v 1014.745n 0.0v 1014.755n 0.0v 1019.745n 0.0v 1019.755n 0.0v 1024.745n 0.0v 1024.755n 0.0v )
* (time, data): [(0, 0), (5, 1), (10, 0), (15, 1), (20, 1), (25, 1), (30, 1), (35, 1), (40, 1), (45, 0), (50, 0), (55, 0), (60, 0), (65, 0), (70, 0), (75, 1), (80, 0), (85, 0), (90, 0), (95, 0), (100, 0), (105, 0), (110, 0), (115, 1), (120, 1), (125, 1), (130, 1), (135, 0), (140, 0), (145, 0), (150, 0), (155, 0), (160, 0), (165, 0), (170, 0), (175, 1), (180, 1), (185, 1), (190, 1), (195, 0), (200, 0), (205, 0), (210, 0), (215, 1), (220, 1), (225, 1), (230, 1), (235, 1), (240, 1), (245, 1), (250, 1), (255, 1), (260, 0), (265, 0), (270, 1), (275, 1), (280, 1), (285, 1), (290, 1), (295, 1), (300, 1), (305, 1), (310, 1), (315, 1), (320, 0), (325, 0), (330, 0), (335, 0), (340, 0), (345, 0), (350, 0), (355, 0), (360, 1), (365, 1), (370, 1), (375, 1), (380, 0), (385, 0), (390, 0), (395, 0), (400, 0), (405, 0), (410, 1), (415, 1), (420, 1), (425, 1), (430, 1), (435, 1), (440, 1), (445, 1), (450, 1), (455, 0), (460, 1), (465, 1), (470, 1), (475, 1), (480, 1), (485, 0), (490, 0), (495, 1), (500, 1), (505, 0), (510, 0), (515, 1), (520, 1), (525, 1), (530, 1), (535, 1), (540, 0), (545, 0), (550, 0), (555, 1), (560, 1), (565, 1), (570, 1), (575, 1), (580, 0), (585, 0), (590, 0), (595, 0), (600, 0), (605, 1), (610, 1), (615, 1), (620, 0), (625, 0), (630, 1), (635, 0), (640, 0), (645, 0), (650, 1), (655, 1), (660, 1), (665, 1), (670, 1), (675, 1), (680, 1), (685, 1), (690, 1), (695, 1), (700, 1), (705, 1), (710, 1), (715, 1), (720, 1), (725, 1), (730, 1), (735, 1), (740, 1), (745, 1), (750, 1), (755, 1), (760, 1), (765, 0), (770, 0), (775, 0), (780, 0), (785, 1), (790, 1), (795, 1), (800, 1), (805, 0), (810, 0), (815, 1), (820, 1), (825, 1), (830, 0), (835, 0), (840, 0), (845, 0), (850, 0), (855, 0), (860, 1), (865, 0), (870, 1), (875, 1), (880, 1), (885, 1), (890, 1), (895, 1), (900, 1), (905, 0), (910, 0), (915, 0), (920, 0), (925, 0), (930, 0), (935, 0), (940, 0), (945, 0), (950, 0), (955, 0), (960, 0), (965, 0), (970, 0), (975, 0), (980, 0), (985, 1), (990, 1), (995, 1), (1000, 1), (1005, 1), (1010, 0), (1015, 0), (1020, 0), (1025, 0)]
Vdin0_25  din0_25  0 PWL (0n 0.0v 4.745n 0.0v 4.755n 1.1v 9.745n 1.1v 9.755n 0.0v 14.745n 0.0v 14.755n 1.1v 19.745n 1.1v 19.755n 1.1v 24.745n 1.1v 24.755n 1.1v 29.745n 1.1v 29.755n 1.1v 34.745n 1.1v 34.755n 1.1v 39.745n 1.1v 39.755n 1.1v 44.745n 1.1v 44.755n 0.0v 49.745n 0.0v 49.755n 0.0v 54.745n 0.0v 54.755n 0.0v 59.745n 0.0v 59.755n 0.0v 64.745n 0.0v 64.755n 0.0v 69.745n 0.0v 69.755n 0.0v 74.745n 0.0v 74.755n 1.1v 79.745n 1.1v 79.755n 0.0v 84.745n 0.0v 84.755n 0.0v 89.745n 0.0v 89.755n 0.0v 94.745n 0.0v 94.755n 0.0v 99.745n 0.0v 99.755n 0.0v 104.745n 0.0v 104.755n 0.0v 109.745n 0.0v 109.755n 0.0v 114.745n 0.0v 114.755n 1.1v 119.745n 1.1v 119.755n 1.1v 124.745n 1.1v 124.755n 1.1v 129.745n 1.1v 129.755n 1.1v 134.745n 1.1v 134.755n 0.0v 139.745n 0.0v 139.755n 0.0v 144.745n 0.0v 144.755n 0.0v 149.745n 0.0v 149.755n 0.0v 154.745n 0.0v 154.755n 0.0v 159.745n 0.0v 159.755n 0.0v 164.745n 0.0v 164.755n 0.0v 169.745n 0.0v 169.755n 0.0v 174.745n 0.0v 174.755n 1.1v 179.745n 1.1v 179.755n 1.1v 184.745n 1.1v 184.755n 1.1v 189.745n 1.1v 189.755n 1.1v 194.745n 1.1v 194.755n 0.0v 199.745n 0.0v 199.755n 0.0v 204.745n 0.0v 204.755n 0.0v 209.745n 0.0v 209.755n 0.0v 214.745n 0.0v 214.755n 1.1v 219.745n 1.1v 219.755n 1.1v 224.745n 1.1v 224.755n 1.1v 229.745n 1.1v 229.755n 1.1v 234.745n 1.1v 234.755n 1.1v 239.745n 1.1v 239.755n 1.1v 244.745n 1.1v 244.755n 1.1v 249.745n 1.1v 249.755n 1.1v 254.745n 1.1v 254.755n 1.1v 259.745n 1.1v 259.755n 0.0v 264.745n 0.0v 264.755n 0.0v 269.745n 0.0v 269.755n 1.1v 274.745n 1.1v 274.755n 1.1v 279.745n 1.1v 279.755n 1.1v 284.745n 1.1v 284.755n 1.1v 289.745n 1.1v 289.755n 1.1v 294.745n 1.1v 294.755n 1.1v 299.745n 1.1v 299.755n 1.1v 304.745n 1.1v 304.755n 1.1v 309.745n 1.1v 309.755n 1.1v 314.745n 1.1v 314.755n 1.1v 319.745n 1.1v 319.755n 0.0v 324.745n 0.0v 324.755n 0.0v 329.745n 0.0v 329.755n 0.0v 334.745n 0.0v 334.755n 0.0v 339.745n 0.0v 339.755n 0.0v 344.745n 0.0v 344.755n 0.0v 349.745n 0.0v 349.755n 0.0v 354.745n 0.0v 354.755n 0.0v 359.745n 0.0v 359.755n 1.1v 364.745n 1.1v 364.755n 1.1v 369.745n 1.1v 369.755n 1.1v 374.745n 1.1v 374.755n 1.1v 379.745n 1.1v 379.755n 0.0v 384.745n 0.0v 384.755n 0.0v 389.745n 0.0v 389.755n 0.0v 394.745n 0.0v 394.755n 0.0v 399.745n 0.0v 399.755n 0.0v 404.745n 0.0v 404.755n 0.0v 409.745n 0.0v 409.755n 1.1v 414.745n 1.1v 414.755n 1.1v 419.745n 1.1v 419.755n 1.1v 424.745n 1.1v 424.755n 1.1v 429.745n 1.1v 429.755n 1.1v 434.745n 1.1v 434.755n 1.1v 439.745n 1.1v 439.755n 1.1v 444.745n 1.1v 444.755n 1.1v 449.745n 1.1v 449.755n 1.1v 454.745n 1.1v 454.755n 0.0v 459.745n 0.0v 459.755n 1.1v 464.745n 1.1v 464.755n 1.1v 469.745n 1.1v 469.755n 1.1v 474.745n 1.1v 474.755n 1.1v 479.745n 1.1v 479.755n 1.1v 484.745n 1.1v 484.755n 0.0v 489.745n 0.0v 489.755n 0.0v 494.745n 0.0v 494.755n 1.1v 499.745n 1.1v 499.755n 1.1v 504.745n 1.1v 504.755n 0.0v 509.745n 0.0v 509.755n 0.0v 514.745n 0.0v 514.755n 1.1v 519.745n 1.1v 519.755n 1.1v 524.745n 1.1v 524.755n 1.1v 529.745n 1.1v 529.755n 1.1v 534.745n 1.1v 534.755n 1.1v 539.745n 1.1v 539.755n 0.0v 544.745n 0.0v 544.755n 0.0v 549.745n 0.0v 549.755n 0.0v 554.745n 0.0v 554.755n 1.1v 559.745n 1.1v 559.755n 1.1v 564.745n 1.1v 564.755n 1.1v 569.745n 1.1v 569.755n 1.1v 574.745n 1.1v 574.755n 1.1v 579.745n 1.1v 579.755n 0.0v 584.745n 0.0v 584.755n 0.0v 589.745n 0.0v 589.755n 0.0v 594.745n 0.0v 594.755n 0.0v 599.745n 0.0v 599.755n 0.0v 604.745n 0.0v 604.755n 1.1v 609.745n 1.1v 609.755n 1.1v 614.745n 1.1v 614.755n 1.1v 619.745n 1.1v 619.755n 0.0v 624.745n 0.0v 624.755n 0.0v 629.745n 0.0v 629.755n 1.1v 634.745n 1.1v 634.755n 0.0v 639.745n 0.0v 639.755n 0.0v 644.745n 0.0v 644.755n 0.0v 649.745n 0.0v 649.755n 1.1v 654.745n 1.1v 654.755n 1.1v 659.745n 1.1v 659.755n 1.1v 664.745n 1.1v 664.755n 1.1v 669.745n 1.1v 669.755n 1.1v 674.745n 1.1v 674.755n 1.1v 679.745n 1.1v 679.755n 1.1v 684.745n 1.1v 684.755n 1.1v 689.745n 1.1v 689.755n 1.1v 694.745n 1.1v 694.755n 1.1v 699.745n 1.1v 699.755n 1.1v 704.745n 1.1v 704.755n 1.1v 709.745n 1.1v 709.755n 1.1v 714.745n 1.1v 714.755n 1.1v 719.745n 1.1v 719.755n 1.1v 724.745n 1.1v 724.755n 1.1v 729.745n 1.1v 729.755n 1.1v 734.745n 1.1v 734.755n 1.1v 739.745n 1.1v 739.755n 1.1v 744.745n 1.1v 744.755n 1.1v 749.745n 1.1v 749.755n 1.1v 754.745n 1.1v 754.755n 1.1v 759.745n 1.1v 759.755n 1.1v 764.745n 1.1v 764.755n 0.0v 769.745n 0.0v 769.755n 0.0v 774.745n 0.0v 774.755n 0.0v 779.745n 0.0v 779.755n 0.0v 784.745n 0.0v 784.755n 1.1v 789.745n 1.1v 789.755n 1.1v 794.745n 1.1v 794.755n 1.1v 799.745n 1.1v 799.755n 1.1v 804.745n 1.1v 804.755n 0.0v 809.745n 0.0v 809.755n 0.0v 814.745n 0.0v 814.755n 1.1v 819.745n 1.1v 819.755n 1.1v 824.745n 1.1v 824.755n 1.1v 829.745n 1.1v 829.755n 0.0v 834.745n 0.0v 834.755n 0.0v 839.745n 0.0v 839.755n 0.0v 844.745n 0.0v 844.755n 0.0v 849.745n 0.0v 849.755n 0.0v 854.745n 0.0v 854.755n 0.0v 859.745n 0.0v 859.755n 1.1v 864.745n 1.1v 864.755n 0.0v 869.745n 0.0v 869.755n 1.1v 874.745n 1.1v 874.755n 1.1v 879.745n 1.1v 879.755n 1.1v 884.745n 1.1v 884.755n 1.1v 889.745n 1.1v 889.755n 1.1v 894.745n 1.1v 894.755n 1.1v 899.745n 1.1v 899.755n 1.1v 904.745n 1.1v 904.755n 0.0v 909.745n 0.0v 909.755n 0.0v 914.745n 0.0v 914.755n 0.0v 919.745n 0.0v 919.755n 0.0v 924.745n 0.0v 924.755n 0.0v 929.745n 0.0v 929.755n 0.0v 934.745n 0.0v 934.755n 0.0v 939.745n 0.0v 939.755n 0.0v 944.745n 0.0v 944.755n 0.0v 949.745n 0.0v 949.755n 0.0v 954.745n 0.0v 954.755n 0.0v 959.745n 0.0v 959.755n 0.0v 964.745n 0.0v 964.755n 0.0v 969.745n 0.0v 969.755n 0.0v 974.745n 0.0v 974.755n 0.0v 979.745n 0.0v 979.755n 0.0v 984.745n 0.0v 984.755n 1.1v 989.745n 1.1v 989.755n 1.1v 994.745n 1.1v 994.755n 1.1v 999.745n 1.1v 999.755n 1.1v 1004.745n 1.1v 1004.755n 1.1v 1009.745n 1.1v 1009.755n 0.0v 1014.745n 0.0v 1014.755n 0.0v 1019.745n 0.0v 1019.755n 0.0v 1024.745n 0.0v 1024.755n 0.0v )
* (time, data): [(0, 0), (5, 0), (10, 1), (15, 1), (20, 1), (25, 1), (30, 1), (35, 1), (40, 1), (45, 1), (50, 0), (55, 0), (60, 0), (65, 0), (70, 0), (75, 1), (80, 0), (85, 0), (90, 0), (95, 0), (100, 0), (105, 0), (110, 0), (115, 1), (120, 1), (125, 1), (130, 1), (135, 0), (140, 1), (145, 1), (150, 0), (155, 0), (160, 0), (165, 0), (170, 0), (175, 1), (180, 1), (185, 1), (190, 1), (195, 1), (200, 1), (205, 1), (210, 1), (215, 1), (220, 1), (225, 1), (230, 1), (235, 1), (240, 1), (245, 1), (250, 1), (255, 1), (260, 1), (265, 1), (270, 1), (275, 1), (280, 1), (285, 1), (290, 1), (295, 1), (300, 1), (305, 1), (310, 1), (315, 1), (320, 1), (325, 0), (330, 0), (335, 0), (340, 0), (345, 0), (350, 0), (355, 0), (360, 0), (365, 1), (370, 1), (375, 1), (380, 1), (385, 1), (390, 1), (395, 1), (400, 1), (405, 1), (410, 1), (415, 1), (420, 1), (425, 1), (430, 1), (435, 0), (440, 0), (445, 0), (450, 0), (455, 1), (460, 1), (465, 1), (470, 1), (475, 1), (480, 1), (485, 0), (490, 0), (495, 0), (500, 0), (505, 0), (510, 0), (515, 1), (520, 1), (525, 1), (530, 1), (535, 1), (540, 0), (545, 1), (550, 1), (555, 1), (560, 1), (565, 1), (570, 1), (575, 1), (580, 0), (585, 1), (590, 1), (595, 0), (600, 0), (605, 0), (610, 0), (615, 0), (620, 1), (625, 1), (630, 1), (635, 1), (640, 0), (645, 0), (650, 0), (655, 0), (660, 0), (665, 0), (670, 0), (675, 0), (680, 0), (685, 0), (690, 0), (695, 0), (700, 1), (705, 1), (710, 1), (715, 1), (720, 0), (725, 0), (730, 0), (735, 0), (740, 0), (745, 0), (750, 0), (755, 1), (760, 1), (765, 1), (770, 1), (775, 1), (780, 1), (785, 1), (790, 1), (795, 1), (800, 1), (805, 0), (810, 0), (815, 0), (820, 0), (825, 0), (830, 0), (835, 0), (840, 0), (845, 0), (850, 0), (855, 0), (860, 1), (865, 0), (870, 0), (875, 0), (880, 0), (885, 0), (890, 0), (895, 0), (900, 0), (905, 1), (910, 1), (915, 1), (920, 1), (925, 1), (930, 0), (935, 1), (940, 1), (945, 1), (950, 1), (955, 1), (960, 1), (965, 1), (970, 1), (975, 1), (980, 1), (985, 1), (990, 1), (995, 1), (1000, 1), (1005, 1), (1010, 1), (1015, 1), (1020, 1), (1025, 1)]
Vdin0_26  din0_26  0 PWL (0n 0.0v 4.745n 0.0v 4.755n 0.0v 9.745n 0.0v 9.755n 1.1v 14.745n 1.1v 14.755n 1.1v 19.745n 1.1v 19.755n 1.1v 24.745n 1.1v 24.755n 1.1v 29.745n 1.1v 29.755n 1.1v 34.745n 1.1v 34.755n 1.1v 39.745n 1.1v 39.755n 1.1v 44.745n 1.1v 44.755n 1.1v 49.745n 1.1v 49.755n 0.0v 54.745n 0.0v 54.755n 0.0v 59.745n 0.0v 59.755n 0.0v 64.745n 0.0v 64.755n 0.0v 69.745n 0.0v 69.755n 0.0v 74.745n 0.0v 74.755n 1.1v 79.745n 1.1v 79.755n 0.0v 84.745n 0.0v 84.755n 0.0v 89.745n 0.0v 89.755n 0.0v 94.745n 0.0v 94.755n 0.0v 99.745n 0.0v 99.755n 0.0v 104.745n 0.0v 104.755n 0.0v 109.745n 0.0v 109.755n 0.0v 114.745n 0.0v 114.755n 1.1v 119.745n 1.1v 119.755n 1.1v 124.745n 1.1v 124.755n 1.1v 129.745n 1.1v 129.755n 1.1v 134.745n 1.1v 134.755n 0.0v 139.745n 0.0v 139.755n 1.1v 144.745n 1.1v 144.755n 1.1v 149.745n 1.1v 149.755n 0.0v 154.745n 0.0v 154.755n 0.0v 159.745n 0.0v 159.755n 0.0v 164.745n 0.0v 164.755n 0.0v 169.745n 0.0v 169.755n 0.0v 174.745n 0.0v 174.755n 1.1v 179.745n 1.1v 179.755n 1.1v 184.745n 1.1v 184.755n 1.1v 189.745n 1.1v 189.755n 1.1v 194.745n 1.1v 194.755n 1.1v 199.745n 1.1v 199.755n 1.1v 204.745n 1.1v 204.755n 1.1v 209.745n 1.1v 209.755n 1.1v 214.745n 1.1v 214.755n 1.1v 219.745n 1.1v 219.755n 1.1v 224.745n 1.1v 224.755n 1.1v 229.745n 1.1v 229.755n 1.1v 234.745n 1.1v 234.755n 1.1v 239.745n 1.1v 239.755n 1.1v 244.745n 1.1v 244.755n 1.1v 249.745n 1.1v 249.755n 1.1v 254.745n 1.1v 254.755n 1.1v 259.745n 1.1v 259.755n 1.1v 264.745n 1.1v 264.755n 1.1v 269.745n 1.1v 269.755n 1.1v 274.745n 1.1v 274.755n 1.1v 279.745n 1.1v 279.755n 1.1v 284.745n 1.1v 284.755n 1.1v 289.745n 1.1v 289.755n 1.1v 294.745n 1.1v 294.755n 1.1v 299.745n 1.1v 299.755n 1.1v 304.745n 1.1v 304.755n 1.1v 309.745n 1.1v 309.755n 1.1v 314.745n 1.1v 314.755n 1.1v 319.745n 1.1v 319.755n 1.1v 324.745n 1.1v 324.755n 0.0v 329.745n 0.0v 329.755n 0.0v 334.745n 0.0v 334.755n 0.0v 339.745n 0.0v 339.755n 0.0v 344.745n 0.0v 344.755n 0.0v 349.745n 0.0v 349.755n 0.0v 354.745n 0.0v 354.755n 0.0v 359.745n 0.0v 359.755n 0.0v 364.745n 0.0v 364.755n 1.1v 369.745n 1.1v 369.755n 1.1v 374.745n 1.1v 374.755n 1.1v 379.745n 1.1v 379.755n 1.1v 384.745n 1.1v 384.755n 1.1v 389.745n 1.1v 389.755n 1.1v 394.745n 1.1v 394.755n 1.1v 399.745n 1.1v 399.755n 1.1v 404.745n 1.1v 404.755n 1.1v 409.745n 1.1v 409.755n 1.1v 414.745n 1.1v 414.755n 1.1v 419.745n 1.1v 419.755n 1.1v 424.745n 1.1v 424.755n 1.1v 429.745n 1.1v 429.755n 1.1v 434.745n 1.1v 434.755n 0.0v 439.745n 0.0v 439.755n 0.0v 444.745n 0.0v 444.755n 0.0v 449.745n 0.0v 449.755n 0.0v 454.745n 0.0v 454.755n 1.1v 459.745n 1.1v 459.755n 1.1v 464.745n 1.1v 464.755n 1.1v 469.745n 1.1v 469.755n 1.1v 474.745n 1.1v 474.755n 1.1v 479.745n 1.1v 479.755n 1.1v 484.745n 1.1v 484.755n 0.0v 489.745n 0.0v 489.755n 0.0v 494.745n 0.0v 494.755n 0.0v 499.745n 0.0v 499.755n 0.0v 504.745n 0.0v 504.755n 0.0v 509.745n 0.0v 509.755n 0.0v 514.745n 0.0v 514.755n 1.1v 519.745n 1.1v 519.755n 1.1v 524.745n 1.1v 524.755n 1.1v 529.745n 1.1v 529.755n 1.1v 534.745n 1.1v 534.755n 1.1v 539.745n 1.1v 539.755n 0.0v 544.745n 0.0v 544.755n 1.1v 549.745n 1.1v 549.755n 1.1v 554.745n 1.1v 554.755n 1.1v 559.745n 1.1v 559.755n 1.1v 564.745n 1.1v 564.755n 1.1v 569.745n 1.1v 569.755n 1.1v 574.745n 1.1v 574.755n 1.1v 579.745n 1.1v 579.755n 0.0v 584.745n 0.0v 584.755n 1.1v 589.745n 1.1v 589.755n 1.1v 594.745n 1.1v 594.755n 0.0v 599.745n 0.0v 599.755n 0.0v 604.745n 0.0v 604.755n 0.0v 609.745n 0.0v 609.755n 0.0v 614.745n 0.0v 614.755n 0.0v 619.745n 0.0v 619.755n 1.1v 624.745n 1.1v 624.755n 1.1v 629.745n 1.1v 629.755n 1.1v 634.745n 1.1v 634.755n 1.1v 639.745n 1.1v 639.755n 0.0v 644.745n 0.0v 644.755n 0.0v 649.745n 0.0v 649.755n 0.0v 654.745n 0.0v 654.755n 0.0v 659.745n 0.0v 659.755n 0.0v 664.745n 0.0v 664.755n 0.0v 669.745n 0.0v 669.755n 0.0v 674.745n 0.0v 674.755n 0.0v 679.745n 0.0v 679.755n 0.0v 684.745n 0.0v 684.755n 0.0v 689.745n 0.0v 689.755n 0.0v 694.745n 0.0v 694.755n 0.0v 699.745n 0.0v 699.755n 1.1v 704.745n 1.1v 704.755n 1.1v 709.745n 1.1v 709.755n 1.1v 714.745n 1.1v 714.755n 1.1v 719.745n 1.1v 719.755n 0.0v 724.745n 0.0v 724.755n 0.0v 729.745n 0.0v 729.755n 0.0v 734.745n 0.0v 734.755n 0.0v 739.745n 0.0v 739.755n 0.0v 744.745n 0.0v 744.755n 0.0v 749.745n 0.0v 749.755n 0.0v 754.745n 0.0v 754.755n 1.1v 759.745n 1.1v 759.755n 1.1v 764.745n 1.1v 764.755n 1.1v 769.745n 1.1v 769.755n 1.1v 774.745n 1.1v 774.755n 1.1v 779.745n 1.1v 779.755n 1.1v 784.745n 1.1v 784.755n 1.1v 789.745n 1.1v 789.755n 1.1v 794.745n 1.1v 794.755n 1.1v 799.745n 1.1v 799.755n 1.1v 804.745n 1.1v 804.755n 0.0v 809.745n 0.0v 809.755n 0.0v 814.745n 0.0v 814.755n 0.0v 819.745n 0.0v 819.755n 0.0v 824.745n 0.0v 824.755n 0.0v 829.745n 0.0v 829.755n 0.0v 834.745n 0.0v 834.755n 0.0v 839.745n 0.0v 839.755n 0.0v 844.745n 0.0v 844.755n 0.0v 849.745n 0.0v 849.755n 0.0v 854.745n 0.0v 854.755n 0.0v 859.745n 0.0v 859.755n 1.1v 864.745n 1.1v 864.755n 0.0v 869.745n 0.0v 869.755n 0.0v 874.745n 0.0v 874.755n 0.0v 879.745n 0.0v 879.755n 0.0v 884.745n 0.0v 884.755n 0.0v 889.745n 0.0v 889.755n 0.0v 894.745n 0.0v 894.755n 0.0v 899.745n 0.0v 899.755n 0.0v 904.745n 0.0v 904.755n 1.1v 909.745n 1.1v 909.755n 1.1v 914.745n 1.1v 914.755n 1.1v 919.745n 1.1v 919.755n 1.1v 924.745n 1.1v 924.755n 1.1v 929.745n 1.1v 929.755n 0.0v 934.745n 0.0v 934.755n 1.1v 939.745n 1.1v 939.755n 1.1v 944.745n 1.1v 944.755n 1.1v 949.745n 1.1v 949.755n 1.1v 954.745n 1.1v 954.755n 1.1v 959.745n 1.1v 959.755n 1.1v 964.745n 1.1v 964.755n 1.1v 969.745n 1.1v 969.755n 1.1v 974.745n 1.1v 974.755n 1.1v 979.745n 1.1v 979.755n 1.1v 984.745n 1.1v 984.755n 1.1v 989.745n 1.1v 989.755n 1.1v 994.745n 1.1v 994.755n 1.1v 999.745n 1.1v 999.755n 1.1v 1004.745n 1.1v 1004.755n 1.1v 1009.745n 1.1v 1009.755n 1.1v 1014.745n 1.1v 1014.755n 1.1v 1019.745n 1.1v 1019.755n 1.1v 1024.745n 1.1v 1024.755n 1.1v )
* (time, data): [(0, 0), (5, 0), (10, 1), (15, 0), (20, 0), (25, 0), (30, 0), (35, 0), (40, 0), (45, 1), (50, 0), (55, 1), (60, 1), (65, 1), (70, 1), (75, 1), (80, 1), (85, 1), (90, 1), (95, 1), (100, 1), (105, 1), (110, 1), (115, 1), (120, 1), (125, 1), (130, 1), (135, 1), (140, 0), (145, 0), (150, 1), (155, 1), (160, 1), (165, 1), (170, 1), (175, 0), (180, 0), (185, 0), (190, 0), (195, 0), (200, 0), (205, 0), (210, 1), (215, 1), (220, 1), (225, 1), (230, 1), (235, 1), (240, 1), (245, 1), (250, 1), (255, 1), (260, 1), (265, 1), (270, 1), (275, 1), (280, 1), (285, 1), (290, 1), (295, 1), (300, 1), (305, 1), (310, 1), (315, 0), (320, 0), (325, 1), (330, 1), (335, 1), (340, 1), (345, 1), (350, 0), (355, 0), (360, 1), (365, 1), (370, 0), (375, 0), (380, 1), (385, 1), (390, 1), (395, 1), (400, 1), (405, 1), (410, 1), (415, 1), (420, 1), (425, 1), (430, 1), (435, 0), (440, 0), (445, 0), (450, 0), (455, 1), (460, 1), (465, 1), (470, 1), (475, 0), (480, 0), (485, 1), (490, 1), (495, 0), (500, 0), (505, 1), (510, 1), (515, 0), (520, 0), (525, 0), (530, 0), (535, 0), (540, 0), (545, 0), (550, 1), (555, 0), (560, 0), (565, 0), (570, 0), (575, 0), (580, 1), (585, 0), (590, 0), (595, 1), (600, 1), (605, 1), (610, 1), (615, 1), (620, 1), (625, 1), (630, 0), (635, 1), (640, 1), (645, 1), (650, 1), (655, 1), (660, 1), (665, 1), (670, 1), (675, 1), (680, 1), (685, 1), (690, 1), (695, 1), (700, 0), (705, 0), (710, 0), (715, 0), (720, 1), (725, 1), (730, 0), (735, 0), (740, 0), (745, 0), (750, 0), (755, 0), (760, 0), (765, 0), (770, 0), (775, 0), (780, 0), (785, 1), (790, 1), (795, 1), (800, 1), (805, 1), (810, 1), (815, 1), (820, 1), (825, 1), (830, 0), (835, 1), (840, 1), (845, 1), (850, 1), (855, 1), (860, 1), (865, 1), (870, 1), (875, 1), (880, 1), (885, 1), (890, 1), (895, 1), (900, 1), (905, 1), (910, 1), (915, 1), (920, 1), (925, 1), (930, 0), (935, 0), (940, 0), (945, 0), (950, 0), (955, 0), (960, 0), (965, 0), (970, 0), (975, 0), (980, 0), (985, 1), (990, 0), (995, 0), (1000, 1), (1005, 1), (1010, 1), (1015, 1), (1020, 1), (1025, 1)]
Vdin0_27  din0_27  0 PWL (0n 0.0v 4.745n 0.0v 4.755n 0.0v 9.745n 0.0v 9.755n 1.1v 14.745n 1.1v 14.755n 0.0v 19.745n 0.0v 19.755n 0.0v 24.745n 0.0v 24.755n 0.0v 29.745n 0.0v 29.755n 0.0v 34.745n 0.0v 34.755n 0.0v 39.745n 0.0v 39.755n 0.0v 44.745n 0.0v 44.755n 1.1v 49.745n 1.1v 49.755n 0.0v 54.745n 0.0v 54.755n 1.1v 59.745n 1.1v 59.755n 1.1v 64.745n 1.1v 64.755n 1.1v 69.745n 1.1v 69.755n 1.1v 74.745n 1.1v 74.755n 1.1v 79.745n 1.1v 79.755n 1.1v 84.745n 1.1v 84.755n 1.1v 89.745n 1.1v 89.755n 1.1v 94.745n 1.1v 94.755n 1.1v 99.745n 1.1v 99.755n 1.1v 104.745n 1.1v 104.755n 1.1v 109.745n 1.1v 109.755n 1.1v 114.745n 1.1v 114.755n 1.1v 119.745n 1.1v 119.755n 1.1v 124.745n 1.1v 124.755n 1.1v 129.745n 1.1v 129.755n 1.1v 134.745n 1.1v 134.755n 1.1v 139.745n 1.1v 139.755n 0.0v 144.745n 0.0v 144.755n 0.0v 149.745n 0.0v 149.755n 1.1v 154.745n 1.1v 154.755n 1.1v 159.745n 1.1v 159.755n 1.1v 164.745n 1.1v 164.755n 1.1v 169.745n 1.1v 169.755n 1.1v 174.745n 1.1v 174.755n 0.0v 179.745n 0.0v 179.755n 0.0v 184.745n 0.0v 184.755n 0.0v 189.745n 0.0v 189.755n 0.0v 194.745n 0.0v 194.755n 0.0v 199.745n 0.0v 199.755n 0.0v 204.745n 0.0v 204.755n 0.0v 209.745n 0.0v 209.755n 1.1v 214.745n 1.1v 214.755n 1.1v 219.745n 1.1v 219.755n 1.1v 224.745n 1.1v 224.755n 1.1v 229.745n 1.1v 229.755n 1.1v 234.745n 1.1v 234.755n 1.1v 239.745n 1.1v 239.755n 1.1v 244.745n 1.1v 244.755n 1.1v 249.745n 1.1v 249.755n 1.1v 254.745n 1.1v 254.755n 1.1v 259.745n 1.1v 259.755n 1.1v 264.745n 1.1v 264.755n 1.1v 269.745n 1.1v 269.755n 1.1v 274.745n 1.1v 274.755n 1.1v 279.745n 1.1v 279.755n 1.1v 284.745n 1.1v 284.755n 1.1v 289.745n 1.1v 289.755n 1.1v 294.745n 1.1v 294.755n 1.1v 299.745n 1.1v 299.755n 1.1v 304.745n 1.1v 304.755n 1.1v 309.745n 1.1v 309.755n 1.1v 314.745n 1.1v 314.755n 0.0v 319.745n 0.0v 319.755n 0.0v 324.745n 0.0v 324.755n 1.1v 329.745n 1.1v 329.755n 1.1v 334.745n 1.1v 334.755n 1.1v 339.745n 1.1v 339.755n 1.1v 344.745n 1.1v 344.755n 1.1v 349.745n 1.1v 349.755n 0.0v 354.745n 0.0v 354.755n 0.0v 359.745n 0.0v 359.755n 1.1v 364.745n 1.1v 364.755n 1.1v 369.745n 1.1v 369.755n 0.0v 374.745n 0.0v 374.755n 0.0v 379.745n 0.0v 379.755n 1.1v 384.745n 1.1v 384.755n 1.1v 389.745n 1.1v 389.755n 1.1v 394.745n 1.1v 394.755n 1.1v 399.745n 1.1v 399.755n 1.1v 404.745n 1.1v 404.755n 1.1v 409.745n 1.1v 409.755n 1.1v 414.745n 1.1v 414.755n 1.1v 419.745n 1.1v 419.755n 1.1v 424.745n 1.1v 424.755n 1.1v 429.745n 1.1v 429.755n 1.1v 434.745n 1.1v 434.755n 0.0v 439.745n 0.0v 439.755n 0.0v 444.745n 0.0v 444.755n 0.0v 449.745n 0.0v 449.755n 0.0v 454.745n 0.0v 454.755n 1.1v 459.745n 1.1v 459.755n 1.1v 464.745n 1.1v 464.755n 1.1v 469.745n 1.1v 469.755n 1.1v 474.745n 1.1v 474.755n 0.0v 479.745n 0.0v 479.755n 0.0v 484.745n 0.0v 484.755n 1.1v 489.745n 1.1v 489.755n 1.1v 494.745n 1.1v 494.755n 0.0v 499.745n 0.0v 499.755n 0.0v 504.745n 0.0v 504.755n 1.1v 509.745n 1.1v 509.755n 1.1v 514.745n 1.1v 514.755n 0.0v 519.745n 0.0v 519.755n 0.0v 524.745n 0.0v 524.755n 0.0v 529.745n 0.0v 529.755n 0.0v 534.745n 0.0v 534.755n 0.0v 539.745n 0.0v 539.755n 0.0v 544.745n 0.0v 544.755n 0.0v 549.745n 0.0v 549.755n 1.1v 554.745n 1.1v 554.755n 0.0v 559.745n 0.0v 559.755n 0.0v 564.745n 0.0v 564.755n 0.0v 569.745n 0.0v 569.755n 0.0v 574.745n 0.0v 574.755n 0.0v 579.745n 0.0v 579.755n 1.1v 584.745n 1.1v 584.755n 0.0v 589.745n 0.0v 589.755n 0.0v 594.745n 0.0v 594.755n 1.1v 599.745n 1.1v 599.755n 1.1v 604.745n 1.1v 604.755n 1.1v 609.745n 1.1v 609.755n 1.1v 614.745n 1.1v 614.755n 1.1v 619.745n 1.1v 619.755n 1.1v 624.745n 1.1v 624.755n 1.1v 629.745n 1.1v 629.755n 0.0v 634.745n 0.0v 634.755n 1.1v 639.745n 1.1v 639.755n 1.1v 644.745n 1.1v 644.755n 1.1v 649.745n 1.1v 649.755n 1.1v 654.745n 1.1v 654.755n 1.1v 659.745n 1.1v 659.755n 1.1v 664.745n 1.1v 664.755n 1.1v 669.745n 1.1v 669.755n 1.1v 674.745n 1.1v 674.755n 1.1v 679.745n 1.1v 679.755n 1.1v 684.745n 1.1v 684.755n 1.1v 689.745n 1.1v 689.755n 1.1v 694.745n 1.1v 694.755n 1.1v 699.745n 1.1v 699.755n 0.0v 704.745n 0.0v 704.755n 0.0v 709.745n 0.0v 709.755n 0.0v 714.745n 0.0v 714.755n 0.0v 719.745n 0.0v 719.755n 1.1v 724.745n 1.1v 724.755n 1.1v 729.745n 1.1v 729.755n 0.0v 734.745n 0.0v 734.755n 0.0v 739.745n 0.0v 739.755n 0.0v 744.745n 0.0v 744.755n 0.0v 749.745n 0.0v 749.755n 0.0v 754.745n 0.0v 754.755n 0.0v 759.745n 0.0v 759.755n 0.0v 764.745n 0.0v 764.755n 0.0v 769.745n 0.0v 769.755n 0.0v 774.745n 0.0v 774.755n 0.0v 779.745n 0.0v 779.755n 0.0v 784.745n 0.0v 784.755n 1.1v 789.745n 1.1v 789.755n 1.1v 794.745n 1.1v 794.755n 1.1v 799.745n 1.1v 799.755n 1.1v 804.745n 1.1v 804.755n 1.1v 809.745n 1.1v 809.755n 1.1v 814.745n 1.1v 814.755n 1.1v 819.745n 1.1v 819.755n 1.1v 824.745n 1.1v 824.755n 1.1v 829.745n 1.1v 829.755n 0.0v 834.745n 0.0v 834.755n 1.1v 839.745n 1.1v 839.755n 1.1v 844.745n 1.1v 844.755n 1.1v 849.745n 1.1v 849.755n 1.1v 854.745n 1.1v 854.755n 1.1v 859.745n 1.1v 859.755n 1.1v 864.745n 1.1v 864.755n 1.1v 869.745n 1.1v 869.755n 1.1v 874.745n 1.1v 874.755n 1.1v 879.745n 1.1v 879.755n 1.1v 884.745n 1.1v 884.755n 1.1v 889.745n 1.1v 889.755n 1.1v 894.745n 1.1v 894.755n 1.1v 899.745n 1.1v 899.755n 1.1v 904.745n 1.1v 904.755n 1.1v 909.745n 1.1v 909.755n 1.1v 914.745n 1.1v 914.755n 1.1v 919.745n 1.1v 919.755n 1.1v 924.745n 1.1v 924.755n 1.1v 929.745n 1.1v 929.755n 0.0v 934.745n 0.0v 934.755n 0.0v 939.745n 0.0v 939.755n 0.0v 944.745n 0.0v 944.755n 0.0v 949.745n 0.0v 949.755n 0.0v 954.745n 0.0v 954.755n 0.0v 959.745n 0.0v 959.755n 0.0v 964.745n 0.0v 964.755n 0.0v 969.745n 0.0v 969.755n 0.0v 974.745n 0.0v 974.755n 0.0v 979.745n 0.0v 979.755n 0.0v 984.745n 0.0v 984.755n 1.1v 989.745n 1.1v 989.755n 0.0v 994.745n 0.0v 994.755n 0.0v 999.745n 0.0v 999.755n 1.1v 1004.745n 1.1v 1004.755n 1.1v 1009.745n 1.1v 1009.755n 1.1v 1014.745n 1.1v 1014.755n 1.1v 1019.745n 1.1v 1019.755n 1.1v 1024.745n 1.1v 1024.755n 1.1v )
* (time, data): [(0, 0), (5, 0), (10, 1), (15, 1), (20, 1), (25, 1), (30, 1), (35, 1), (40, 1), (45, 0), (50, 0), (55, 0), (60, 0), (65, 0), (70, 0), (75, 1), (80, 1), (85, 1), (90, 1), (95, 1), (100, 1), (105, 1), (110, 1), (115, 0), (120, 0), (125, 0), (130, 0), (135, 1), (140, 1), (145, 1), (150, 1), (155, 1), (160, 1), (165, 1), (170, 1), (175, 0), (180, 0), (185, 0), (190, 0), (195, 1), (200, 1), (205, 1), (210, 1), (215, 0), (220, 0), (225, 0), (230, 1), (235, 1), (240, 1), (245, 1), (250, 1), (255, 1), (260, 0), (265, 0), (270, 1), (275, 1), (280, 1), (285, 1), (290, 1), (295, 0), (300, 0), (305, 0), (310, 0), (315, 0), (320, 0), (325, 0), (330, 0), (335, 0), (340, 0), (345, 0), (350, 1), (355, 1), (360, 0), (365, 0), (370, 0), (375, 0), (380, 0), (385, 0), (390, 0), (395, 0), (400, 1), (405, 1), (410, 1), (415, 1), (420, 1), (425, 1), (430, 1), (435, 1), (440, 1), (445, 1), (450, 1), (455, 0), (460, 1), (465, 1), (470, 1), (475, 0), (480, 0), (485, 0), (490, 0), (495, 0), (500, 0), (505, 0), (510, 0), (515, 0), (520, 0), (525, 0), (530, 0), (535, 0), (540, 0), (545, 0), (550, 0), (555, 0), (560, 0), (565, 0), (570, 0), (575, 0), (580, 0), (585, 1), (590, 1), (595, 1), (600, 1), (605, 1), (610, 1), (615, 1), (620, 0), (625, 0), (630, 1), (635, 0), (640, 1), (645, 1), (650, 0), (655, 0), (660, 0), (665, 0), (670, 0), (675, 0), (680, 0), (685, 0), (690, 0), (695, 0), (700, 1), (705, 1), (710, 1), (715, 1), (720, 1), (725, 1), (730, 0), (735, 0), (740, 0), (745, 0), (750, 0), (755, 0), (760, 0), (765, 1), (770, 1), (775, 1), (780, 1), (785, 0), (790, 0), (795, 0), (800, 0), (805, 0), (810, 0), (815, 0), (820, 0), (825, 0), (830, 1), (835, 0), (840, 0), (845, 0), (850, 0), (855, 0), (860, 1), (865, 0), (870, 1), (875, 1), (880, 1), (885, 1), (890, 1), (895, 1), (900, 1), (905, 1), (910, 1), (915, 1), (920, 1), (925, 1), (930, 1), (935, 0), (940, 0), (945, 1), (950, 0), (955, 0), (960, 0), (965, 0), (970, 0), (975, 0), (980, 0), (985, 1), (990, 0), (995, 0), (1000, 1), (1005, 1), (1010, 0), (1015, 0), (1020, 0), (1025, 0)]
Vdin0_28  din0_28  0 PWL (0n 0.0v 4.745n 0.0v 4.755n 0.0v 9.745n 0.0v 9.755n 1.1v 14.745n 1.1v 14.755n 1.1v 19.745n 1.1v 19.755n 1.1v 24.745n 1.1v 24.755n 1.1v 29.745n 1.1v 29.755n 1.1v 34.745n 1.1v 34.755n 1.1v 39.745n 1.1v 39.755n 1.1v 44.745n 1.1v 44.755n 0.0v 49.745n 0.0v 49.755n 0.0v 54.745n 0.0v 54.755n 0.0v 59.745n 0.0v 59.755n 0.0v 64.745n 0.0v 64.755n 0.0v 69.745n 0.0v 69.755n 0.0v 74.745n 0.0v 74.755n 1.1v 79.745n 1.1v 79.755n 1.1v 84.745n 1.1v 84.755n 1.1v 89.745n 1.1v 89.755n 1.1v 94.745n 1.1v 94.755n 1.1v 99.745n 1.1v 99.755n 1.1v 104.745n 1.1v 104.755n 1.1v 109.745n 1.1v 109.755n 1.1v 114.745n 1.1v 114.755n 0.0v 119.745n 0.0v 119.755n 0.0v 124.745n 0.0v 124.755n 0.0v 129.745n 0.0v 129.755n 0.0v 134.745n 0.0v 134.755n 1.1v 139.745n 1.1v 139.755n 1.1v 144.745n 1.1v 144.755n 1.1v 149.745n 1.1v 149.755n 1.1v 154.745n 1.1v 154.755n 1.1v 159.745n 1.1v 159.755n 1.1v 164.745n 1.1v 164.755n 1.1v 169.745n 1.1v 169.755n 1.1v 174.745n 1.1v 174.755n 0.0v 179.745n 0.0v 179.755n 0.0v 184.745n 0.0v 184.755n 0.0v 189.745n 0.0v 189.755n 0.0v 194.745n 0.0v 194.755n 1.1v 199.745n 1.1v 199.755n 1.1v 204.745n 1.1v 204.755n 1.1v 209.745n 1.1v 209.755n 1.1v 214.745n 1.1v 214.755n 0.0v 219.745n 0.0v 219.755n 0.0v 224.745n 0.0v 224.755n 0.0v 229.745n 0.0v 229.755n 1.1v 234.745n 1.1v 234.755n 1.1v 239.745n 1.1v 239.755n 1.1v 244.745n 1.1v 244.755n 1.1v 249.745n 1.1v 249.755n 1.1v 254.745n 1.1v 254.755n 1.1v 259.745n 1.1v 259.755n 0.0v 264.745n 0.0v 264.755n 0.0v 269.745n 0.0v 269.755n 1.1v 274.745n 1.1v 274.755n 1.1v 279.745n 1.1v 279.755n 1.1v 284.745n 1.1v 284.755n 1.1v 289.745n 1.1v 289.755n 1.1v 294.745n 1.1v 294.755n 0.0v 299.745n 0.0v 299.755n 0.0v 304.745n 0.0v 304.755n 0.0v 309.745n 0.0v 309.755n 0.0v 314.745n 0.0v 314.755n 0.0v 319.745n 0.0v 319.755n 0.0v 324.745n 0.0v 324.755n 0.0v 329.745n 0.0v 329.755n 0.0v 334.745n 0.0v 334.755n 0.0v 339.745n 0.0v 339.755n 0.0v 344.745n 0.0v 344.755n 0.0v 349.745n 0.0v 349.755n 1.1v 354.745n 1.1v 354.755n 1.1v 359.745n 1.1v 359.755n 0.0v 364.745n 0.0v 364.755n 0.0v 369.745n 0.0v 369.755n 0.0v 374.745n 0.0v 374.755n 0.0v 379.745n 0.0v 379.755n 0.0v 384.745n 0.0v 384.755n 0.0v 389.745n 0.0v 389.755n 0.0v 394.745n 0.0v 394.755n 0.0v 399.745n 0.0v 399.755n 1.1v 404.745n 1.1v 404.755n 1.1v 409.745n 1.1v 409.755n 1.1v 414.745n 1.1v 414.755n 1.1v 419.745n 1.1v 419.755n 1.1v 424.745n 1.1v 424.755n 1.1v 429.745n 1.1v 429.755n 1.1v 434.745n 1.1v 434.755n 1.1v 439.745n 1.1v 439.755n 1.1v 444.745n 1.1v 444.755n 1.1v 449.745n 1.1v 449.755n 1.1v 454.745n 1.1v 454.755n 0.0v 459.745n 0.0v 459.755n 1.1v 464.745n 1.1v 464.755n 1.1v 469.745n 1.1v 469.755n 1.1v 474.745n 1.1v 474.755n 0.0v 479.745n 0.0v 479.755n 0.0v 484.745n 0.0v 484.755n 0.0v 489.745n 0.0v 489.755n 0.0v 494.745n 0.0v 494.755n 0.0v 499.745n 0.0v 499.755n 0.0v 504.745n 0.0v 504.755n 0.0v 509.745n 0.0v 509.755n 0.0v 514.745n 0.0v 514.755n 0.0v 519.745n 0.0v 519.755n 0.0v 524.745n 0.0v 524.755n 0.0v 529.745n 0.0v 529.755n 0.0v 534.745n 0.0v 534.755n 0.0v 539.745n 0.0v 539.755n 0.0v 544.745n 0.0v 544.755n 0.0v 549.745n 0.0v 549.755n 0.0v 554.745n 0.0v 554.755n 0.0v 559.745n 0.0v 559.755n 0.0v 564.745n 0.0v 564.755n 0.0v 569.745n 0.0v 569.755n 0.0v 574.745n 0.0v 574.755n 0.0v 579.745n 0.0v 579.755n 0.0v 584.745n 0.0v 584.755n 1.1v 589.745n 1.1v 589.755n 1.1v 594.745n 1.1v 594.755n 1.1v 599.745n 1.1v 599.755n 1.1v 604.745n 1.1v 604.755n 1.1v 609.745n 1.1v 609.755n 1.1v 614.745n 1.1v 614.755n 1.1v 619.745n 1.1v 619.755n 0.0v 624.745n 0.0v 624.755n 0.0v 629.745n 0.0v 629.755n 1.1v 634.745n 1.1v 634.755n 0.0v 639.745n 0.0v 639.755n 1.1v 644.745n 1.1v 644.755n 1.1v 649.745n 1.1v 649.755n 0.0v 654.745n 0.0v 654.755n 0.0v 659.745n 0.0v 659.755n 0.0v 664.745n 0.0v 664.755n 0.0v 669.745n 0.0v 669.755n 0.0v 674.745n 0.0v 674.755n 0.0v 679.745n 0.0v 679.755n 0.0v 684.745n 0.0v 684.755n 0.0v 689.745n 0.0v 689.755n 0.0v 694.745n 0.0v 694.755n 0.0v 699.745n 0.0v 699.755n 1.1v 704.745n 1.1v 704.755n 1.1v 709.745n 1.1v 709.755n 1.1v 714.745n 1.1v 714.755n 1.1v 719.745n 1.1v 719.755n 1.1v 724.745n 1.1v 724.755n 1.1v 729.745n 1.1v 729.755n 0.0v 734.745n 0.0v 734.755n 0.0v 739.745n 0.0v 739.755n 0.0v 744.745n 0.0v 744.755n 0.0v 749.745n 0.0v 749.755n 0.0v 754.745n 0.0v 754.755n 0.0v 759.745n 0.0v 759.755n 0.0v 764.745n 0.0v 764.755n 1.1v 769.745n 1.1v 769.755n 1.1v 774.745n 1.1v 774.755n 1.1v 779.745n 1.1v 779.755n 1.1v 784.745n 1.1v 784.755n 0.0v 789.745n 0.0v 789.755n 0.0v 794.745n 0.0v 794.755n 0.0v 799.745n 0.0v 799.755n 0.0v 804.745n 0.0v 804.755n 0.0v 809.745n 0.0v 809.755n 0.0v 814.745n 0.0v 814.755n 0.0v 819.745n 0.0v 819.755n 0.0v 824.745n 0.0v 824.755n 0.0v 829.745n 0.0v 829.755n 1.1v 834.745n 1.1v 834.755n 0.0v 839.745n 0.0v 839.755n 0.0v 844.745n 0.0v 844.755n 0.0v 849.745n 0.0v 849.755n 0.0v 854.745n 0.0v 854.755n 0.0v 859.745n 0.0v 859.755n 1.1v 864.745n 1.1v 864.755n 0.0v 869.745n 0.0v 869.755n 1.1v 874.745n 1.1v 874.755n 1.1v 879.745n 1.1v 879.755n 1.1v 884.745n 1.1v 884.755n 1.1v 889.745n 1.1v 889.755n 1.1v 894.745n 1.1v 894.755n 1.1v 899.745n 1.1v 899.755n 1.1v 904.745n 1.1v 904.755n 1.1v 909.745n 1.1v 909.755n 1.1v 914.745n 1.1v 914.755n 1.1v 919.745n 1.1v 919.755n 1.1v 924.745n 1.1v 924.755n 1.1v 929.745n 1.1v 929.755n 1.1v 934.745n 1.1v 934.755n 0.0v 939.745n 0.0v 939.755n 0.0v 944.745n 0.0v 944.755n 1.1v 949.745n 1.1v 949.755n 0.0v 954.745n 0.0v 954.755n 0.0v 959.745n 0.0v 959.755n 0.0v 964.745n 0.0v 964.755n 0.0v 969.745n 0.0v 969.755n 0.0v 974.745n 0.0v 974.755n 0.0v 979.745n 0.0v 979.755n 0.0v 984.745n 0.0v 984.755n 1.1v 989.745n 1.1v 989.755n 0.0v 994.745n 0.0v 994.755n 0.0v 999.745n 0.0v 999.755n 1.1v 1004.745n 1.1v 1004.755n 1.1v 1009.745n 1.1v 1009.755n 0.0v 1014.745n 0.0v 1014.755n 0.0v 1019.745n 0.0v 1019.755n 0.0v 1024.745n 0.0v 1024.755n 0.0v )
* (time, data): [(0, 0), (5, 1), (10, 0), (15, 1), (20, 1), (25, 1), (30, 1), (35, 0), (40, 0), (45, 1), (50, 0), (55, 0), (60, 0), (65, 0), (70, 0), (75, 1), (80, 1), (85, 1), (90, 1), (95, 1), (100, 1), (105, 1), (110, 1), (115, 1), (120, 1), (125, 1), (130, 1), (135, 0), (140, 0), (145, 0), (150, 0), (155, 0), (160, 0), (165, 0), (170, 0), (175, 1), (180, 1), (185, 1), (190, 1), (195, 1), (200, 1), (205, 1), (210, 0), (215, 0), (220, 0), (225, 0), (230, 0), (235, 0), (240, 0), (245, 0), (250, 0), (255, 0), (260, 1), (265, 1), (270, 0), (275, 0), (280, 0), (285, 0), (290, 0), (295, 1), (300, 1), (305, 1), (310, 1), (315, 0), (320, 1), (325, 0), (330, 0), (335, 0), (340, 0), (345, 0), (350, 0), (355, 0), (360, 0), (365, 1), (370, 0), (375, 0), (380, 1), (385, 1), (390, 1), (395, 1), (400, 0), (405, 0), (410, 1), (415, 1), (420, 1), (425, 1), (430, 1), (435, 1), (440, 0), (445, 0), (450, 0), (455, 1), (460, 1), (465, 1), (470, 1), (475, 0), (480, 0), (485, 1), (490, 1), (495, 1), (500, 1), (505, 1), (510, 1), (515, 0), (520, 0), (525, 0), (530, 0), (535, 0), (540, 0), (545, 0), (550, 0), (555, 1), (560, 1), (565, 1), (570, 1), (575, 1), (580, 0), (585, 1), (590, 1), (595, 1), (600, 1), (605, 0), (610, 0), (615, 0), (620, 1), (625, 1), (630, 0), (635, 0), (640, 1), (645, 1), (650, 1), (655, 1), (660, 1), (665, 1), (670, 1), (675, 1), (680, 1), (685, 1), (690, 1), (695, 1), (700, 0), (705, 0), (710, 0), (715, 0), (720, 1), (725, 1), (730, 1), (735, 1), (740, 1), (745, 1), (750, 1), (755, 1), (760, 1), (765, 1), (770, 1), (775, 1), (780, 1), (785, 1), (790, 1), (795, 1), (800, 1), (805, 0), (810, 0), (815, 0), (820, 0), (825, 1), (830, 1), (835, 0), (840, 0), (845, 0), (850, 0), (855, 0), (860, 0), (865, 0), (870, 1), (875, 1), (880, 1), (885, 1), (890, 1), (895, 1), (900, 1), (905, 0), (910, 0), (915, 0), (920, 0), (925, 0), (930, 0), (935, 0), (940, 0), (945, 0), (950, 1), (955, 1), (960, 1), (965, 1), (970, 1), (975, 1), (980, 1), (985, 0), (990, 1), (995, 1), (1000, 1), (1005, 1), (1010, 0), (1015, 0), (1020, 0), (1025, 0)]
Vdin0_29  din0_29  0 PWL (0n 0.0v 4.745n 0.0v 4.755n 1.1v 9.745n 1.1v 9.755n 0.0v 14.745n 0.0v 14.755n 1.1v 19.745n 1.1v 19.755n 1.1v 24.745n 1.1v 24.755n 1.1v 29.745n 1.1v 29.755n 1.1v 34.745n 1.1v 34.755n 0.0v 39.745n 0.0v 39.755n 0.0v 44.745n 0.0v 44.755n 1.1v 49.745n 1.1v 49.755n 0.0v 54.745n 0.0v 54.755n 0.0v 59.745n 0.0v 59.755n 0.0v 64.745n 0.0v 64.755n 0.0v 69.745n 0.0v 69.755n 0.0v 74.745n 0.0v 74.755n 1.1v 79.745n 1.1v 79.755n 1.1v 84.745n 1.1v 84.755n 1.1v 89.745n 1.1v 89.755n 1.1v 94.745n 1.1v 94.755n 1.1v 99.745n 1.1v 99.755n 1.1v 104.745n 1.1v 104.755n 1.1v 109.745n 1.1v 109.755n 1.1v 114.745n 1.1v 114.755n 1.1v 119.745n 1.1v 119.755n 1.1v 124.745n 1.1v 124.755n 1.1v 129.745n 1.1v 129.755n 1.1v 134.745n 1.1v 134.755n 0.0v 139.745n 0.0v 139.755n 0.0v 144.745n 0.0v 144.755n 0.0v 149.745n 0.0v 149.755n 0.0v 154.745n 0.0v 154.755n 0.0v 159.745n 0.0v 159.755n 0.0v 164.745n 0.0v 164.755n 0.0v 169.745n 0.0v 169.755n 0.0v 174.745n 0.0v 174.755n 1.1v 179.745n 1.1v 179.755n 1.1v 184.745n 1.1v 184.755n 1.1v 189.745n 1.1v 189.755n 1.1v 194.745n 1.1v 194.755n 1.1v 199.745n 1.1v 199.755n 1.1v 204.745n 1.1v 204.755n 1.1v 209.745n 1.1v 209.755n 0.0v 214.745n 0.0v 214.755n 0.0v 219.745n 0.0v 219.755n 0.0v 224.745n 0.0v 224.755n 0.0v 229.745n 0.0v 229.755n 0.0v 234.745n 0.0v 234.755n 0.0v 239.745n 0.0v 239.755n 0.0v 244.745n 0.0v 244.755n 0.0v 249.745n 0.0v 249.755n 0.0v 254.745n 0.0v 254.755n 0.0v 259.745n 0.0v 259.755n 1.1v 264.745n 1.1v 264.755n 1.1v 269.745n 1.1v 269.755n 0.0v 274.745n 0.0v 274.755n 0.0v 279.745n 0.0v 279.755n 0.0v 284.745n 0.0v 284.755n 0.0v 289.745n 0.0v 289.755n 0.0v 294.745n 0.0v 294.755n 1.1v 299.745n 1.1v 299.755n 1.1v 304.745n 1.1v 304.755n 1.1v 309.745n 1.1v 309.755n 1.1v 314.745n 1.1v 314.755n 0.0v 319.745n 0.0v 319.755n 1.1v 324.745n 1.1v 324.755n 0.0v 329.745n 0.0v 329.755n 0.0v 334.745n 0.0v 334.755n 0.0v 339.745n 0.0v 339.755n 0.0v 344.745n 0.0v 344.755n 0.0v 349.745n 0.0v 349.755n 0.0v 354.745n 0.0v 354.755n 0.0v 359.745n 0.0v 359.755n 0.0v 364.745n 0.0v 364.755n 1.1v 369.745n 1.1v 369.755n 0.0v 374.745n 0.0v 374.755n 0.0v 379.745n 0.0v 379.755n 1.1v 384.745n 1.1v 384.755n 1.1v 389.745n 1.1v 389.755n 1.1v 394.745n 1.1v 394.755n 1.1v 399.745n 1.1v 399.755n 0.0v 404.745n 0.0v 404.755n 0.0v 409.745n 0.0v 409.755n 1.1v 414.745n 1.1v 414.755n 1.1v 419.745n 1.1v 419.755n 1.1v 424.745n 1.1v 424.755n 1.1v 429.745n 1.1v 429.755n 1.1v 434.745n 1.1v 434.755n 1.1v 439.745n 1.1v 439.755n 0.0v 444.745n 0.0v 444.755n 0.0v 449.745n 0.0v 449.755n 0.0v 454.745n 0.0v 454.755n 1.1v 459.745n 1.1v 459.755n 1.1v 464.745n 1.1v 464.755n 1.1v 469.745n 1.1v 469.755n 1.1v 474.745n 1.1v 474.755n 0.0v 479.745n 0.0v 479.755n 0.0v 484.745n 0.0v 484.755n 1.1v 489.745n 1.1v 489.755n 1.1v 494.745n 1.1v 494.755n 1.1v 499.745n 1.1v 499.755n 1.1v 504.745n 1.1v 504.755n 1.1v 509.745n 1.1v 509.755n 1.1v 514.745n 1.1v 514.755n 0.0v 519.745n 0.0v 519.755n 0.0v 524.745n 0.0v 524.755n 0.0v 529.745n 0.0v 529.755n 0.0v 534.745n 0.0v 534.755n 0.0v 539.745n 0.0v 539.755n 0.0v 544.745n 0.0v 544.755n 0.0v 549.745n 0.0v 549.755n 0.0v 554.745n 0.0v 554.755n 1.1v 559.745n 1.1v 559.755n 1.1v 564.745n 1.1v 564.755n 1.1v 569.745n 1.1v 569.755n 1.1v 574.745n 1.1v 574.755n 1.1v 579.745n 1.1v 579.755n 0.0v 584.745n 0.0v 584.755n 1.1v 589.745n 1.1v 589.755n 1.1v 594.745n 1.1v 594.755n 1.1v 599.745n 1.1v 599.755n 1.1v 604.745n 1.1v 604.755n 0.0v 609.745n 0.0v 609.755n 0.0v 614.745n 0.0v 614.755n 0.0v 619.745n 0.0v 619.755n 1.1v 624.745n 1.1v 624.755n 1.1v 629.745n 1.1v 629.755n 0.0v 634.745n 0.0v 634.755n 0.0v 639.745n 0.0v 639.755n 1.1v 644.745n 1.1v 644.755n 1.1v 649.745n 1.1v 649.755n 1.1v 654.745n 1.1v 654.755n 1.1v 659.745n 1.1v 659.755n 1.1v 664.745n 1.1v 664.755n 1.1v 669.745n 1.1v 669.755n 1.1v 674.745n 1.1v 674.755n 1.1v 679.745n 1.1v 679.755n 1.1v 684.745n 1.1v 684.755n 1.1v 689.745n 1.1v 689.755n 1.1v 694.745n 1.1v 694.755n 1.1v 699.745n 1.1v 699.755n 0.0v 704.745n 0.0v 704.755n 0.0v 709.745n 0.0v 709.755n 0.0v 714.745n 0.0v 714.755n 0.0v 719.745n 0.0v 719.755n 1.1v 724.745n 1.1v 724.755n 1.1v 729.745n 1.1v 729.755n 1.1v 734.745n 1.1v 734.755n 1.1v 739.745n 1.1v 739.755n 1.1v 744.745n 1.1v 744.755n 1.1v 749.745n 1.1v 749.755n 1.1v 754.745n 1.1v 754.755n 1.1v 759.745n 1.1v 759.755n 1.1v 764.745n 1.1v 764.755n 1.1v 769.745n 1.1v 769.755n 1.1v 774.745n 1.1v 774.755n 1.1v 779.745n 1.1v 779.755n 1.1v 784.745n 1.1v 784.755n 1.1v 789.745n 1.1v 789.755n 1.1v 794.745n 1.1v 794.755n 1.1v 799.745n 1.1v 799.755n 1.1v 804.745n 1.1v 804.755n 0.0v 809.745n 0.0v 809.755n 0.0v 814.745n 0.0v 814.755n 0.0v 819.745n 0.0v 819.755n 0.0v 824.745n 0.0v 824.755n 1.1v 829.745n 1.1v 829.755n 1.1v 834.745n 1.1v 834.755n 0.0v 839.745n 0.0v 839.755n 0.0v 844.745n 0.0v 844.755n 0.0v 849.745n 0.0v 849.755n 0.0v 854.745n 0.0v 854.755n 0.0v 859.745n 0.0v 859.755n 0.0v 864.745n 0.0v 864.755n 0.0v 869.745n 0.0v 869.755n 1.1v 874.745n 1.1v 874.755n 1.1v 879.745n 1.1v 879.755n 1.1v 884.745n 1.1v 884.755n 1.1v 889.745n 1.1v 889.755n 1.1v 894.745n 1.1v 894.755n 1.1v 899.745n 1.1v 899.755n 1.1v 904.745n 1.1v 904.755n 0.0v 909.745n 0.0v 909.755n 0.0v 914.745n 0.0v 914.755n 0.0v 919.745n 0.0v 919.755n 0.0v 924.745n 0.0v 924.755n 0.0v 929.745n 0.0v 929.755n 0.0v 934.745n 0.0v 934.755n 0.0v 939.745n 0.0v 939.755n 0.0v 944.745n 0.0v 944.755n 0.0v 949.745n 0.0v 949.755n 1.1v 954.745n 1.1v 954.755n 1.1v 959.745n 1.1v 959.755n 1.1v 964.745n 1.1v 964.755n 1.1v 969.745n 1.1v 969.755n 1.1v 974.745n 1.1v 974.755n 1.1v 979.745n 1.1v 979.755n 1.1v 984.745n 1.1v 984.755n 0.0v 989.745n 0.0v 989.755n 1.1v 994.745n 1.1v 994.755n 1.1v 999.745n 1.1v 999.755n 1.1v 1004.745n 1.1v 1004.755n 1.1v 1009.745n 1.1v 1009.755n 0.0v 1014.745n 0.0v 1014.755n 0.0v 1019.745n 0.0v 1019.755n 0.0v 1024.745n 0.0v 1024.755n 0.0v )
* (time, data): [(0, 0), (5, 1), (10, 0), (15, 1), (20, 1), (25, 1), (30, 1), (35, 1), (40, 1), (45, 0), (50, 0), (55, 1), (60, 1), (65, 1), (70, 1), (75, 0), (80, 0), (85, 0), (90, 0), (95, 0), (100, 0), (105, 0), (110, 0), (115, 1), (120, 1), (125, 1), (130, 1), (135, 1), (140, 1), (145, 1), (150, 1), (155, 1), (160, 1), (165, 0), (170, 0), (175, 1), (180, 0), (185, 0), (190, 0), (195, 1), (200, 1), (205, 1), (210, 1), (215, 1), (220, 1), (225, 1), (230, 0), (235, 0), (240, 0), (245, 0), (250, 0), (255, 0), (260, 0), (265, 0), (270, 0), (275, 0), (280, 0), (285, 0), (290, 0), (295, 0), (300, 0), (305, 0), (310, 0), (315, 1), (320, 0), (325, 1), (330, 1), (335, 1), (340, 1), (345, 1), (350, 1), (355, 1), (360, 0), (365, 0), (370, 0), (375, 0), (380, 1), (385, 1), (390, 1), (395, 1), (400, 0), (405, 0), (410, 0), (415, 0), (420, 0), (425, 0), (430, 0), (435, 1), (440, 0), (445, 0), (450, 0), (455, 0), (460, 0), (465, 0), (470, 0), (475, 1), (480, 1), (485, 0), (490, 0), (495, 0), (500, 0), (505, 1), (510, 1), (515, 0), (520, 0), (525, 0), (530, 0), (535, 0), (540, 1), (545, 1), (550, 1), (555, 0), (560, 0), (565, 0), (570, 0), (575, 0), (580, 1), (585, 1), (590, 1), (595, 1), (600, 1), (605, 1), (610, 1), (615, 1), (620, 1), (625, 1), (630, 1), (635, 1), (640, 0), (645, 0), (650, 0), (655, 0), (660, 0), (665, 0), (670, 0), (675, 0), (680, 0), (685, 0), (690, 0), (695, 0), (700, 0), (705, 0), (710, 0), (715, 0), (720, 0), (725, 0), (730, 1), (735, 1), (740, 1), (745, 1), (750, 1), (755, 1), (760, 1), (765, 0), (770, 0), (775, 0), (780, 0), (785, 0), (790, 0), (795, 0), (800, 0), (805, 1), (810, 1), (815, 0), (820, 0), (825, 1), (830, 1), (835, 0), (840, 0), (845, 0), (850, 0), (855, 0), (860, 1), (865, 0), (870, 1), (875, 1), (880, 1), (885, 1), (890, 1), (895, 1), (900, 1), (905, 1), (910, 1), (915, 1), (920, 1), (925, 1), (930, 1), (935, 0), (940, 0), (945, 0), (950, 1), (955, 1), (960, 1), (965, 1), (970, 1), (975, 1), (980, 1), (985, 1), (990, 0), (995, 0), (1000, 0), (1005, 0), (1010, 0), (1015, 0), (1020, 0), (1025, 0)]
Vdin0_30  din0_30  0 PWL (0n 0.0v 4.745n 0.0v 4.755n 1.1v 9.745n 1.1v 9.755n 0.0v 14.745n 0.0v 14.755n 1.1v 19.745n 1.1v 19.755n 1.1v 24.745n 1.1v 24.755n 1.1v 29.745n 1.1v 29.755n 1.1v 34.745n 1.1v 34.755n 1.1v 39.745n 1.1v 39.755n 1.1v 44.745n 1.1v 44.755n 0.0v 49.745n 0.0v 49.755n 0.0v 54.745n 0.0v 54.755n 1.1v 59.745n 1.1v 59.755n 1.1v 64.745n 1.1v 64.755n 1.1v 69.745n 1.1v 69.755n 1.1v 74.745n 1.1v 74.755n 0.0v 79.745n 0.0v 79.755n 0.0v 84.745n 0.0v 84.755n 0.0v 89.745n 0.0v 89.755n 0.0v 94.745n 0.0v 94.755n 0.0v 99.745n 0.0v 99.755n 0.0v 104.745n 0.0v 104.755n 0.0v 109.745n 0.0v 109.755n 0.0v 114.745n 0.0v 114.755n 1.1v 119.745n 1.1v 119.755n 1.1v 124.745n 1.1v 124.755n 1.1v 129.745n 1.1v 129.755n 1.1v 134.745n 1.1v 134.755n 1.1v 139.745n 1.1v 139.755n 1.1v 144.745n 1.1v 144.755n 1.1v 149.745n 1.1v 149.755n 1.1v 154.745n 1.1v 154.755n 1.1v 159.745n 1.1v 159.755n 1.1v 164.745n 1.1v 164.755n 0.0v 169.745n 0.0v 169.755n 0.0v 174.745n 0.0v 174.755n 1.1v 179.745n 1.1v 179.755n 0.0v 184.745n 0.0v 184.755n 0.0v 189.745n 0.0v 189.755n 0.0v 194.745n 0.0v 194.755n 1.1v 199.745n 1.1v 199.755n 1.1v 204.745n 1.1v 204.755n 1.1v 209.745n 1.1v 209.755n 1.1v 214.745n 1.1v 214.755n 1.1v 219.745n 1.1v 219.755n 1.1v 224.745n 1.1v 224.755n 1.1v 229.745n 1.1v 229.755n 0.0v 234.745n 0.0v 234.755n 0.0v 239.745n 0.0v 239.755n 0.0v 244.745n 0.0v 244.755n 0.0v 249.745n 0.0v 249.755n 0.0v 254.745n 0.0v 254.755n 0.0v 259.745n 0.0v 259.755n 0.0v 264.745n 0.0v 264.755n 0.0v 269.745n 0.0v 269.755n 0.0v 274.745n 0.0v 274.755n 0.0v 279.745n 0.0v 279.755n 0.0v 284.745n 0.0v 284.755n 0.0v 289.745n 0.0v 289.755n 0.0v 294.745n 0.0v 294.755n 0.0v 299.745n 0.0v 299.755n 0.0v 304.745n 0.0v 304.755n 0.0v 309.745n 0.0v 309.755n 0.0v 314.745n 0.0v 314.755n 1.1v 319.745n 1.1v 319.755n 0.0v 324.745n 0.0v 324.755n 1.1v 329.745n 1.1v 329.755n 1.1v 334.745n 1.1v 334.755n 1.1v 339.745n 1.1v 339.755n 1.1v 344.745n 1.1v 344.755n 1.1v 349.745n 1.1v 349.755n 1.1v 354.745n 1.1v 354.755n 1.1v 359.745n 1.1v 359.755n 0.0v 364.745n 0.0v 364.755n 0.0v 369.745n 0.0v 369.755n 0.0v 374.745n 0.0v 374.755n 0.0v 379.745n 0.0v 379.755n 1.1v 384.745n 1.1v 384.755n 1.1v 389.745n 1.1v 389.755n 1.1v 394.745n 1.1v 394.755n 1.1v 399.745n 1.1v 399.755n 0.0v 404.745n 0.0v 404.755n 0.0v 409.745n 0.0v 409.755n 0.0v 414.745n 0.0v 414.755n 0.0v 419.745n 0.0v 419.755n 0.0v 424.745n 0.0v 424.755n 0.0v 429.745n 0.0v 429.755n 0.0v 434.745n 0.0v 434.755n 1.1v 439.745n 1.1v 439.755n 0.0v 444.745n 0.0v 444.755n 0.0v 449.745n 0.0v 449.755n 0.0v 454.745n 0.0v 454.755n 0.0v 459.745n 0.0v 459.755n 0.0v 464.745n 0.0v 464.755n 0.0v 469.745n 0.0v 469.755n 0.0v 474.745n 0.0v 474.755n 1.1v 479.745n 1.1v 479.755n 1.1v 484.745n 1.1v 484.755n 0.0v 489.745n 0.0v 489.755n 0.0v 494.745n 0.0v 494.755n 0.0v 499.745n 0.0v 499.755n 0.0v 504.745n 0.0v 504.755n 1.1v 509.745n 1.1v 509.755n 1.1v 514.745n 1.1v 514.755n 0.0v 519.745n 0.0v 519.755n 0.0v 524.745n 0.0v 524.755n 0.0v 529.745n 0.0v 529.755n 0.0v 534.745n 0.0v 534.755n 0.0v 539.745n 0.0v 539.755n 1.1v 544.745n 1.1v 544.755n 1.1v 549.745n 1.1v 549.755n 1.1v 554.745n 1.1v 554.755n 0.0v 559.745n 0.0v 559.755n 0.0v 564.745n 0.0v 564.755n 0.0v 569.745n 0.0v 569.755n 0.0v 574.745n 0.0v 574.755n 0.0v 579.745n 0.0v 579.755n 1.1v 584.745n 1.1v 584.755n 1.1v 589.745n 1.1v 589.755n 1.1v 594.745n 1.1v 594.755n 1.1v 599.745n 1.1v 599.755n 1.1v 604.745n 1.1v 604.755n 1.1v 609.745n 1.1v 609.755n 1.1v 614.745n 1.1v 614.755n 1.1v 619.745n 1.1v 619.755n 1.1v 624.745n 1.1v 624.755n 1.1v 629.745n 1.1v 629.755n 1.1v 634.745n 1.1v 634.755n 1.1v 639.745n 1.1v 639.755n 0.0v 644.745n 0.0v 644.755n 0.0v 649.745n 0.0v 649.755n 0.0v 654.745n 0.0v 654.755n 0.0v 659.745n 0.0v 659.755n 0.0v 664.745n 0.0v 664.755n 0.0v 669.745n 0.0v 669.755n 0.0v 674.745n 0.0v 674.755n 0.0v 679.745n 0.0v 679.755n 0.0v 684.745n 0.0v 684.755n 0.0v 689.745n 0.0v 689.755n 0.0v 694.745n 0.0v 694.755n 0.0v 699.745n 0.0v 699.755n 0.0v 704.745n 0.0v 704.755n 0.0v 709.745n 0.0v 709.755n 0.0v 714.745n 0.0v 714.755n 0.0v 719.745n 0.0v 719.755n 0.0v 724.745n 0.0v 724.755n 0.0v 729.745n 0.0v 729.755n 1.1v 734.745n 1.1v 734.755n 1.1v 739.745n 1.1v 739.755n 1.1v 744.745n 1.1v 744.755n 1.1v 749.745n 1.1v 749.755n 1.1v 754.745n 1.1v 754.755n 1.1v 759.745n 1.1v 759.755n 1.1v 764.745n 1.1v 764.755n 0.0v 769.745n 0.0v 769.755n 0.0v 774.745n 0.0v 774.755n 0.0v 779.745n 0.0v 779.755n 0.0v 784.745n 0.0v 784.755n 0.0v 789.745n 0.0v 789.755n 0.0v 794.745n 0.0v 794.755n 0.0v 799.745n 0.0v 799.755n 0.0v 804.745n 0.0v 804.755n 1.1v 809.745n 1.1v 809.755n 1.1v 814.745n 1.1v 814.755n 0.0v 819.745n 0.0v 819.755n 0.0v 824.745n 0.0v 824.755n 1.1v 829.745n 1.1v 829.755n 1.1v 834.745n 1.1v 834.755n 0.0v 839.745n 0.0v 839.755n 0.0v 844.745n 0.0v 844.755n 0.0v 849.745n 0.0v 849.755n 0.0v 854.745n 0.0v 854.755n 0.0v 859.745n 0.0v 859.755n 1.1v 864.745n 1.1v 864.755n 0.0v 869.745n 0.0v 869.755n 1.1v 874.745n 1.1v 874.755n 1.1v 879.745n 1.1v 879.755n 1.1v 884.745n 1.1v 884.755n 1.1v 889.745n 1.1v 889.755n 1.1v 894.745n 1.1v 894.755n 1.1v 899.745n 1.1v 899.755n 1.1v 904.745n 1.1v 904.755n 1.1v 909.745n 1.1v 909.755n 1.1v 914.745n 1.1v 914.755n 1.1v 919.745n 1.1v 919.755n 1.1v 924.745n 1.1v 924.755n 1.1v 929.745n 1.1v 929.755n 1.1v 934.745n 1.1v 934.755n 0.0v 939.745n 0.0v 939.755n 0.0v 944.745n 0.0v 944.755n 0.0v 949.745n 0.0v 949.755n 1.1v 954.745n 1.1v 954.755n 1.1v 959.745n 1.1v 959.755n 1.1v 964.745n 1.1v 964.755n 1.1v 969.745n 1.1v 969.755n 1.1v 974.745n 1.1v 974.755n 1.1v 979.745n 1.1v 979.755n 1.1v 984.745n 1.1v 984.755n 1.1v 989.745n 1.1v 989.755n 0.0v 994.745n 0.0v 994.755n 0.0v 999.745n 0.0v 999.755n 0.0v 1004.745n 0.0v 1004.755n 0.0v 1009.745n 0.0v 1009.755n 0.0v 1014.745n 0.0v 1014.755n 0.0v 1019.745n 0.0v 1019.755n 0.0v 1024.745n 0.0v 1024.755n 0.0v )
* (time, data): [(0, 0), (5, 0), (10, 1), (15, 1), (20, 1), (25, 1), (30, 1), (35, 0), (40, 0), (45, 1), (50, 1), (55, 0), (60, 0), (65, 0), (70, 0), (75, 1), (80, 1), (85, 1), (90, 1), (95, 1), (100, 1), (105, 1), (110, 1), (115, 1), (120, 1), (125, 1), (130, 1), (135, 0), (140, 0), (145, 0), (150, 1), (155, 1), (160, 1), (165, 0), (170, 0), (175, 1), (180, 1), (185, 1), (190, 1), (195, 0), (200, 0), (205, 0), (210, 1), (215, 0), (220, 0), (225, 0), (230, 0), (235, 0), (240, 0), (245, 0), (250, 0), (255, 0), (260, 0), (265, 0), (270, 0), (275, 0), (280, 0), (285, 0), (290, 0), (295, 1), (300, 1), (305, 1), (310, 1), (315, 0), (320, 0), (325, 1), (330, 1), (335, 1), (340, 1), (345, 1), (350, 0), (355, 0), (360, 0), (365, 0), (370, 1), (375, 1), (380, 1), (385, 1), (390, 1), (395, 1), (400, 1), (405, 1), (410, 0), (415, 0), (420, 0), (425, 0), (430, 0), (435, 0), (440, 1), (445, 1), (450, 1), (455, 1), (460, 0), (465, 0), (470, 0), (475, 1), (480, 1), (485, 1), (490, 1), (495, 0), (500, 0), (505, 0), (510, 0), (515, 1), (520, 1), (525, 1), (530, 1), (535, 1), (540, 1), (545, 1), (550, 1), (555, 0), (560, 0), (565, 0), (570, 0), (575, 0), (580, 0), (585, 1), (590, 1), (595, 0), (600, 0), (605, 1), (610, 1), (615, 1), (620, 0), (625, 0), (630, 0), (635, 0), (640, 0), (645, 0), (650, 1), (655, 1), (660, 1), (665, 1), (670, 1), (675, 1), (680, 1), (685, 1), (690, 1), (695, 1), (700, 0), (705, 0), (710, 0), (715, 0), (720, 1), (725, 1), (730, 0), (735, 0), (740, 0), (745, 0), (750, 0), (755, 0), (760, 0), (765, 0), (770, 0), (775, 0), (780, 0), (785, 0), (790, 0), (795, 0), (800, 0), (805, 0), (810, 0), (815, 1), (820, 1), (825, 0), (830, 1), (835, 1), (840, 1), (845, 1), (850, 1), (855, 1), (860, 1), (865, 0), (870, 1), (875, 1), (880, 1), (885, 1), (890, 1), (895, 1), (900, 1), (905, 1), (910, 1), (915, 1), (920, 1), (925, 1), (930, 1), (935, 0), (940, 0), (945, 0), (950, 0), (955, 0), (960, 0), (965, 0), (970, 0), (975, 0), (980, 0), (985, 0), (990, 1), (995, 1), (1000, 1), (1005, 1), (1010, 1), (1015, 1), (1020, 1), (1025, 1)]
Vdin0_31  din0_31  0 PWL (0n 0.0v 4.745n 0.0v 4.755n 0.0v 9.745n 0.0v 9.755n 1.1v 14.745n 1.1v 14.755n 1.1v 19.745n 1.1v 19.755n 1.1v 24.745n 1.1v 24.755n 1.1v 29.745n 1.1v 29.755n 1.1v 34.745n 1.1v 34.755n 0.0v 39.745n 0.0v 39.755n 0.0v 44.745n 0.0v 44.755n 1.1v 49.745n 1.1v 49.755n 1.1v 54.745n 1.1v 54.755n 0.0v 59.745n 0.0v 59.755n 0.0v 64.745n 0.0v 64.755n 0.0v 69.745n 0.0v 69.755n 0.0v 74.745n 0.0v 74.755n 1.1v 79.745n 1.1v 79.755n 1.1v 84.745n 1.1v 84.755n 1.1v 89.745n 1.1v 89.755n 1.1v 94.745n 1.1v 94.755n 1.1v 99.745n 1.1v 99.755n 1.1v 104.745n 1.1v 104.755n 1.1v 109.745n 1.1v 109.755n 1.1v 114.745n 1.1v 114.755n 1.1v 119.745n 1.1v 119.755n 1.1v 124.745n 1.1v 124.755n 1.1v 129.745n 1.1v 129.755n 1.1v 134.745n 1.1v 134.755n 0.0v 139.745n 0.0v 139.755n 0.0v 144.745n 0.0v 144.755n 0.0v 149.745n 0.0v 149.755n 1.1v 154.745n 1.1v 154.755n 1.1v 159.745n 1.1v 159.755n 1.1v 164.745n 1.1v 164.755n 0.0v 169.745n 0.0v 169.755n 0.0v 174.745n 0.0v 174.755n 1.1v 179.745n 1.1v 179.755n 1.1v 184.745n 1.1v 184.755n 1.1v 189.745n 1.1v 189.755n 1.1v 194.745n 1.1v 194.755n 0.0v 199.745n 0.0v 199.755n 0.0v 204.745n 0.0v 204.755n 0.0v 209.745n 0.0v 209.755n 1.1v 214.745n 1.1v 214.755n 0.0v 219.745n 0.0v 219.755n 0.0v 224.745n 0.0v 224.755n 0.0v 229.745n 0.0v 229.755n 0.0v 234.745n 0.0v 234.755n 0.0v 239.745n 0.0v 239.755n 0.0v 244.745n 0.0v 244.755n 0.0v 249.745n 0.0v 249.755n 0.0v 254.745n 0.0v 254.755n 0.0v 259.745n 0.0v 259.755n 0.0v 264.745n 0.0v 264.755n 0.0v 269.745n 0.0v 269.755n 0.0v 274.745n 0.0v 274.755n 0.0v 279.745n 0.0v 279.755n 0.0v 284.745n 0.0v 284.755n 0.0v 289.745n 0.0v 289.755n 0.0v 294.745n 0.0v 294.755n 1.1v 299.745n 1.1v 299.755n 1.1v 304.745n 1.1v 304.755n 1.1v 309.745n 1.1v 309.755n 1.1v 314.745n 1.1v 314.755n 0.0v 319.745n 0.0v 319.755n 0.0v 324.745n 0.0v 324.755n 1.1v 329.745n 1.1v 329.755n 1.1v 334.745n 1.1v 334.755n 1.1v 339.745n 1.1v 339.755n 1.1v 344.745n 1.1v 344.755n 1.1v 349.745n 1.1v 349.755n 0.0v 354.745n 0.0v 354.755n 0.0v 359.745n 0.0v 359.755n 0.0v 364.745n 0.0v 364.755n 0.0v 369.745n 0.0v 369.755n 1.1v 374.745n 1.1v 374.755n 1.1v 379.745n 1.1v 379.755n 1.1v 384.745n 1.1v 384.755n 1.1v 389.745n 1.1v 389.755n 1.1v 394.745n 1.1v 394.755n 1.1v 399.745n 1.1v 399.755n 1.1v 404.745n 1.1v 404.755n 1.1v 409.745n 1.1v 409.755n 0.0v 414.745n 0.0v 414.755n 0.0v 419.745n 0.0v 419.755n 0.0v 424.745n 0.0v 424.755n 0.0v 429.745n 0.0v 429.755n 0.0v 434.745n 0.0v 434.755n 0.0v 439.745n 0.0v 439.755n 1.1v 444.745n 1.1v 444.755n 1.1v 449.745n 1.1v 449.755n 1.1v 454.745n 1.1v 454.755n 1.1v 459.745n 1.1v 459.755n 0.0v 464.745n 0.0v 464.755n 0.0v 469.745n 0.0v 469.755n 0.0v 474.745n 0.0v 474.755n 1.1v 479.745n 1.1v 479.755n 1.1v 484.745n 1.1v 484.755n 1.1v 489.745n 1.1v 489.755n 1.1v 494.745n 1.1v 494.755n 0.0v 499.745n 0.0v 499.755n 0.0v 504.745n 0.0v 504.755n 0.0v 509.745n 0.0v 509.755n 0.0v 514.745n 0.0v 514.755n 1.1v 519.745n 1.1v 519.755n 1.1v 524.745n 1.1v 524.755n 1.1v 529.745n 1.1v 529.755n 1.1v 534.745n 1.1v 534.755n 1.1v 539.745n 1.1v 539.755n 1.1v 544.745n 1.1v 544.755n 1.1v 549.745n 1.1v 549.755n 1.1v 554.745n 1.1v 554.755n 0.0v 559.745n 0.0v 559.755n 0.0v 564.745n 0.0v 564.755n 0.0v 569.745n 0.0v 569.755n 0.0v 574.745n 0.0v 574.755n 0.0v 579.745n 0.0v 579.755n 0.0v 584.745n 0.0v 584.755n 1.1v 589.745n 1.1v 589.755n 1.1v 594.745n 1.1v 594.755n 0.0v 599.745n 0.0v 599.755n 0.0v 604.745n 0.0v 604.755n 1.1v 609.745n 1.1v 609.755n 1.1v 614.745n 1.1v 614.755n 1.1v 619.745n 1.1v 619.755n 0.0v 624.745n 0.0v 624.755n 0.0v 629.745n 0.0v 629.755n 0.0v 634.745n 0.0v 634.755n 0.0v 639.745n 0.0v 639.755n 0.0v 644.745n 0.0v 644.755n 0.0v 649.745n 0.0v 649.755n 1.1v 654.745n 1.1v 654.755n 1.1v 659.745n 1.1v 659.755n 1.1v 664.745n 1.1v 664.755n 1.1v 669.745n 1.1v 669.755n 1.1v 674.745n 1.1v 674.755n 1.1v 679.745n 1.1v 679.755n 1.1v 684.745n 1.1v 684.755n 1.1v 689.745n 1.1v 689.755n 1.1v 694.745n 1.1v 694.755n 1.1v 699.745n 1.1v 699.755n 0.0v 704.745n 0.0v 704.755n 0.0v 709.745n 0.0v 709.755n 0.0v 714.745n 0.0v 714.755n 0.0v 719.745n 0.0v 719.755n 1.1v 724.745n 1.1v 724.755n 1.1v 729.745n 1.1v 729.755n 0.0v 734.745n 0.0v 734.755n 0.0v 739.745n 0.0v 739.755n 0.0v 744.745n 0.0v 744.755n 0.0v 749.745n 0.0v 749.755n 0.0v 754.745n 0.0v 754.755n 0.0v 759.745n 0.0v 759.755n 0.0v 764.745n 0.0v 764.755n 0.0v 769.745n 0.0v 769.755n 0.0v 774.745n 0.0v 774.755n 0.0v 779.745n 0.0v 779.755n 0.0v 784.745n 0.0v 784.755n 0.0v 789.745n 0.0v 789.755n 0.0v 794.745n 0.0v 794.755n 0.0v 799.745n 0.0v 799.755n 0.0v 804.745n 0.0v 804.755n 0.0v 809.745n 0.0v 809.755n 0.0v 814.745n 0.0v 814.755n 1.1v 819.745n 1.1v 819.755n 1.1v 824.745n 1.1v 824.755n 0.0v 829.745n 0.0v 829.755n 1.1v 834.745n 1.1v 834.755n 1.1v 839.745n 1.1v 839.755n 1.1v 844.745n 1.1v 844.755n 1.1v 849.745n 1.1v 849.755n 1.1v 854.745n 1.1v 854.755n 1.1v 859.745n 1.1v 859.755n 1.1v 864.745n 1.1v 864.755n 0.0v 869.745n 0.0v 869.755n 1.1v 874.745n 1.1v 874.755n 1.1v 879.745n 1.1v 879.755n 1.1v 884.745n 1.1v 884.755n 1.1v 889.745n 1.1v 889.755n 1.1v 894.745n 1.1v 894.755n 1.1v 899.745n 1.1v 899.755n 1.1v 904.745n 1.1v 904.755n 1.1v 909.745n 1.1v 909.755n 1.1v 914.745n 1.1v 914.755n 1.1v 919.745n 1.1v 919.755n 1.1v 924.745n 1.1v 924.755n 1.1v 929.745n 1.1v 929.755n 1.1v 934.745n 1.1v 934.755n 0.0v 939.745n 0.0v 939.755n 0.0v 944.745n 0.0v 944.755n 0.0v 949.745n 0.0v 949.755n 0.0v 954.745n 0.0v 954.755n 0.0v 959.745n 0.0v 959.755n 0.0v 964.745n 0.0v 964.755n 0.0v 969.745n 0.0v 969.755n 0.0v 974.745n 0.0v 974.755n 0.0v 979.745n 0.0v 979.755n 0.0v 984.745n 0.0v 984.755n 0.0v 989.745n 0.0v 989.755n 1.1v 994.745n 1.1v 994.755n 1.1v 999.745n 1.1v 999.755n 1.1v 1004.745n 1.1v 1004.755n 1.1v 1009.745n 1.1v 1009.755n 1.1v 1014.745n 1.1v 1014.755n 1.1v 1019.745n 1.1v 1019.755n 1.1v 1024.745n 1.1v 1024.755n 1.1v )
* (time, data): [(0, 0), (5, 0), (10, 0), (15, 0), (20, 0), (25, 0), (30, 0), (35, 0), (40, 0), (45, 0), (50, 0), (55, 0), (60, 0), (65, 0), (70, 0), (75, 1), (80, 0), (85, 1), (90, 1), (95, 0), (100, 0), (105, 0), (110, 0), (115, 0), (120, 0), (125, 1), (130, 1), (135, 0), (140, 0), (145, 0), (150, 1), (155, 1), (160, 1), (165, 1), (170, 0), (175, 0), (180, 1), (185, 1), (190, 0), (195, 0), (200, 1), (205, 1), (210, 0), (215, 0), (220, 0), (225, 0), (230, 1), (235, 0), (240, 0), (245, 0), (250, 0), (255, 1), (260, 0), (265, 0), (270, 0), (275, 0), (280, 1), (285, 0), (290, 0), (295, 1), (300, 0), (305, 0), (310, 1), (315, 1), (320, 1), (325, 1), (330, 1), (335, 1), (340, 0), (345, 0), (350, 0), (355, 0), (360, 0), (365, 0), (370, 0), (375, 0), (380, 0), (385, 1), (390, 0), (395, 0), (400, 1), (405, 1), (410, 0), (415, 0), (420, 1), (425, 0), (430, 0), (435, 1), (440, 1), (445, 1), (450, 1), (455, 1), (460, 0), (465, 0), (470, 0), (475, 0), (480, 0), (485, 1), (490, 1), (495, 1), (500, 1), (505, 0), (510, 0), (515, 0), (520, 0), (525, 1), (530, 1), (535, 1), (540, 0), (545, 1), (550, 0), (555, 1), (560, 1), (565, 0), (570, 0), (575, 0), (580, 0), (585, 0), (590, 0), (595, 0), (600, 0), (605, 0), (610, 0), (615, 0), (620, 1), (625, 0), (630, 0), (635, 1), (640, 1), (645, 1), (650, 1), (655, 0), (660, 1), (665, 1), (670, 0), (675, 1), (680, 1), (685, 1), (690, 1), (695, 0), (700, 0), (705, 1), (710, 0), (715, 1), (720, 0), (725, 0), (730, 1), (735, 1), (740, 0), (745, 0), (750, 0), (755, 1), (760, 0), (765, 1), (770, 1), (775, 1), (780, 1), (785, 1), (790, 0), (795, 0), (800, 0), (805, 1), (810, 0), (815, 0), (820, 1), (825, 1), (830, 1), (835, 1), (840, 1), (845, 0), (850, 0), (855, 1), (860, 0), (865, 0), (870, 1), (875, 1), (880, 0), (885, 1), (890, 0), (895, 1), (900, 0), (905, 1), (910, 1), (915, 1), (920, 1), (925, 1), (930, 0), (935, 1), (940, 1), (945, 1), (950, 0), (955, 0), (960, 0), (965, 1), (970, 1), (975, 1), (980, 1), (985, 1), (990, 0), (995, 0), (1000, 0), (1005, 0), (1010, 1), (1015, 1), (1020, 1), (1025, 1)]
Va0_0  a0_0  0 PWL (0n 0.0v 4.745n 0.0v 4.755n 0.0v 9.745n 0.0v 9.755n 0.0v 14.745n 0.0v 14.755n 0.0v 19.745n 0.0v 19.755n 0.0v 24.745n 0.0v 24.755n 0.0v 29.745n 0.0v 29.755n 0.0v 34.745n 0.0v 34.755n 0.0v 39.745n 0.0v 39.755n 0.0v 44.745n 0.0v 44.755n 0.0v 49.745n 0.0v 49.755n 0.0v 54.745n 0.0v 54.755n 0.0v 59.745n 0.0v 59.755n 0.0v 64.745n 0.0v 64.755n 0.0v 69.745n 0.0v 69.755n 0.0v 74.745n 0.0v 74.755n 1.1v 79.745n 1.1v 79.755n 0.0v 84.745n 0.0v 84.755n 1.1v 89.745n 1.1v 89.755n 1.1v 94.745n 1.1v 94.755n 0.0v 99.745n 0.0v 99.755n 0.0v 104.745n 0.0v 104.755n 0.0v 109.745n 0.0v 109.755n 0.0v 114.745n 0.0v 114.755n 0.0v 119.745n 0.0v 119.755n 0.0v 124.745n 0.0v 124.755n 1.1v 129.745n 1.1v 129.755n 1.1v 134.745n 1.1v 134.755n 0.0v 139.745n 0.0v 139.755n 0.0v 144.745n 0.0v 144.755n 0.0v 149.745n 0.0v 149.755n 1.1v 154.745n 1.1v 154.755n 1.1v 159.745n 1.1v 159.755n 1.1v 164.745n 1.1v 164.755n 1.1v 169.745n 1.1v 169.755n 0.0v 174.745n 0.0v 174.755n 0.0v 179.745n 0.0v 179.755n 1.1v 184.745n 1.1v 184.755n 1.1v 189.745n 1.1v 189.755n 0.0v 194.745n 0.0v 194.755n 0.0v 199.745n 0.0v 199.755n 1.1v 204.745n 1.1v 204.755n 1.1v 209.745n 1.1v 209.755n 0.0v 214.745n 0.0v 214.755n 0.0v 219.745n 0.0v 219.755n 0.0v 224.745n 0.0v 224.755n 0.0v 229.745n 0.0v 229.755n 1.1v 234.745n 1.1v 234.755n 0.0v 239.745n 0.0v 239.755n 0.0v 244.745n 0.0v 244.755n 0.0v 249.745n 0.0v 249.755n 0.0v 254.745n 0.0v 254.755n 1.1v 259.745n 1.1v 259.755n 0.0v 264.745n 0.0v 264.755n 0.0v 269.745n 0.0v 269.755n 0.0v 274.745n 0.0v 274.755n 0.0v 279.745n 0.0v 279.755n 1.1v 284.745n 1.1v 284.755n 0.0v 289.745n 0.0v 289.755n 0.0v 294.745n 0.0v 294.755n 1.1v 299.745n 1.1v 299.755n 0.0v 304.745n 0.0v 304.755n 0.0v 309.745n 0.0v 309.755n 1.1v 314.745n 1.1v 314.755n 1.1v 319.745n 1.1v 319.755n 1.1v 324.745n 1.1v 324.755n 1.1v 329.745n 1.1v 329.755n 1.1v 334.745n 1.1v 334.755n 1.1v 339.745n 1.1v 339.755n 0.0v 344.745n 0.0v 344.755n 0.0v 349.745n 0.0v 349.755n 0.0v 354.745n 0.0v 354.755n 0.0v 359.745n 0.0v 359.755n 0.0v 364.745n 0.0v 364.755n 0.0v 369.745n 0.0v 369.755n 0.0v 374.745n 0.0v 374.755n 0.0v 379.745n 0.0v 379.755n 0.0v 384.745n 0.0v 384.755n 1.1v 389.745n 1.1v 389.755n 0.0v 394.745n 0.0v 394.755n 0.0v 399.745n 0.0v 399.755n 1.1v 404.745n 1.1v 404.755n 1.1v 409.745n 1.1v 409.755n 0.0v 414.745n 0.0v 414.755n 0.0v 419.745n 0.0v 419.755n 1.1v 424.745n 1.1v 424.755n 0.0v 429.745n 0.0v 429.755n 0.0v 434.745n 0.0v 434.755n 1.1v 439.745n 1.1v 439.755n 1.1v 444.745n 1.1v 444.755n 1.1v 449.745n 1.1v 449.755n 1.1v 454.745n 1.1v 454.755n 1.1v 459.745n 1.1v 459.755n 0.0v 464.745n 0.0v 464.755n 0.0v 469.745n 0.0v 469.755n 0.0v 474.745n 0.0v 474.755n 0.0v 479.745n 0.0v 479.755n 0.0v 484.745n 0.0v 484.755n 1.1v 489.745n 1.1v 489.755n 1.1v 494.745n 1.1v 494.755n 1.1v 499.745n 1.1v 499.755n 1.1v 504.745n 1.1v 504.755n 0.0v 509.745n 0.0v 509.755n 0.0v 514.745n 0.0v 514.755n 0.0v 519.745n 0.0v 519.755n 0.0v 524.745n 0.0v 524.755n 1.1v 529.745n 1.1v 529.755n 1.1v 534.745n 1.1v 534.755n 1.1v 539.745n 1.1v 539.755n 0.0v 544.745n 0.0v 544.755n 1.1v 549.745n 1.1v 549.755n 0.0v 554.745n 0.0v 554.755n 1.1v 559.745n 1.1v 559.755n 1.1v 564.745n 1.1v 564.755n 0.0v 569.745n 0.0v 569.755n 0.0v 574.745n 0.0v 574.755n 0.0v 579.745n 0.0v 579.755n 0.0v 584.745n 0.0v 584.755n 0.0v 589.745n 0.0v 589.755n 0.0v 594.745n 0.0v 594.755n 0.0v 599.745n 0.0v 599.755n 0.0v 604.745n 0.0v 604.755n 0.0v 609.745n 0.0v 609.755n 0.0v 614.745n 0.0v 614.755n 0.0v 619.745n 0.0v 619.755n 1.1v 624.745n 1.1v 624.755n 0.0v 629.745n 0.0v 629.755n 0.0v 634.745n 0.0v 634.755n 1.1v 639.745n 1.1v 639.755n 1.1v 644.745n 1.1v 644.755n 1.1v 649.745n 1.1v 649.755n 1.1v 654.745n 1.1v 654.755n 0.0v 659.745n 0.0v 659.755n 1.1v 664.745n 1.1v 664.755n 1.1v 669.745n 1.1v 669.755n 0.0v 674.745n 0.0v 674.755n 1.1v 679.745n 1.1v 679.755n 1.1v 684.745n 1.1v 684.755n 1.1v 689.745n 1.1v 689.755n 1.1v 694.745n 1.1v 694.755n 0.0v 699.745n 0.0v 699.755n 0.0v 704.745n 0.0v 704.755n 1.1v 709.745n 1.1v 709.755n 0.0v 714.745n 0.0v 714.755n 1.1v 719.745n 1.1v 719.755n 0.0v 724.745n 0.0v 724.755n 0.0v 729.745n 0.0v 729.755n 1.1v 734.745n 1.1v 734.755n 1.1v 739.745n 1.1v 739.755n 0.0v 744.745n 0.0v 744.755n 0.0v 749.745n 0.0v 749.755n 0.0v 754.745n 0.0v 754.755n 1.1v 759.745n 1.1v 759.755n 0.0v 764.745n 0.0v 764.755n 1.1v 769.745n 1.1v 769.755n 1.1v 774.745n 1.1v 774.755n 1.1v 779.745n 1.1v 779.755n 1.1v 784.745n 1.1v 784.755n 1.1v 789.745n 1.1v 789.755n 0.0v 794.745n 0.0v 794.755n 0.0v 799.745n 0.0v 799.755n 0.0v 804.745n 0.0v 804.755n 1.1v 809.745n 1.1v 809.755n 0.0v 814.745n 0.0v 814.755n 0.0v 819.745n 0.0v 819.755n 1.1v 824.745n 1.1v 824.755n 1.1v 829.745n 1.1v 829.755n 1.1v 834.745n 1.1v 834.755n 1.1v 839.745n 1.1v 839.755n 1.1v 844.745n 1.1v 844.755n 0.0v 849.745n 0.0v 849.755n 0.0v 854.745n 0.0v 854.755n 1.1v 859.745n 1.1v 859.755n 0.0v 864.745n 0.0v 864.755n 0.0v 869.745n 0.0v 869.755n 1.1v 874.745n 1.1v 874.755n 1.1v 879.745n 1.1v 879.755n 0.0v 884.745n 0.0v 884.755n 1.1v 889.745n 1.1v 889.755n 0.0v 894.745n 0.0v 894.755n 1.1v 899.745n 1.1v 899.755n 0.0v 904.745n 0.0v 904.755n 1.1v 909.745n 1.1v 909.755n 1.1v 914.745n 1.1v 914.755n 1.1v 919.745n 1.1v 919.755n 1.1v 924.745n 1.1v 924.755n 1.1v 929.745n 1.1v 929.755n 0.0v 934.745n 0.0v 934.755n 1.1v 939.745n 1.1v 939.755n 1.1v 944.745n 1.1v 944.755n 1.1v 949.745n 1.1v 949.755n 0.0v 954.745n 0.0v 954.755n 0.0v 959.745n 0.0v 959.755n 0.0v 964.745n 0.0v 964.755n 1.1v 969.745n 1.1v 969.755n 1.1v 974.745n 1.1v 974.755n 1.1v 979.745n 1.1v 979.755n 1.1v 984.745n 1.1v 984.755n 1.1v 989.745n 1.1v 989.755n 0.0v 994.745n 0.0v 994.755n 0.0v 999.745n 0.0v 999.755n 0.0v 1004.745n 0.0v 1004.755n 0.0v 1009.745n 0.0v 1009.755n 1.1v 1014.745n 1.1v 1014.755n 1.1v 1019.745n 1.1v 1019.755n 1.1v 1024.745n 1.1v 1024.755n 1.1v )
* (time, data): [(0, 0), (5, 0), (10, 1), (15, 0), (20, 1), (25, 0), (30, 1), (35, 1), (40, 1), (45, 0), (50, 1), (55, 1), (60, 1), (65, 1), (70, 0), (75, 0), (80, 1), (85, 0), (90, 0), (95, 1), (100, 1), (105, 1), (110, 1), (115, 0), (120, 0), (125, 0), (130, 0), (135, 0), (140, 0), (145, 0), (150, 0), (155, 0), (160, 0), (165, 0), (170, 1), (175, 0), (180, 0), (185, 0), (190, 0), (195, 1), (200, 0), (205, 0), (210, 1), (215, 0), (220, 0), (225, 1), (230, 0), (235, 1), (240, 1), (245, 1), (250, 1), (255, 0), (260, 1), (265, 1), (270, 1), (275, 1), (280, 0), (285, 1), (290, 0), (295, 0), (300, 1), (305, 0), (310, 0), (315, 0), (320, 0), (325, 0), (330, 0), (335, 0), (340, 0), (345, 0), (350, 1), (355, 1), (360, 0), (365, 0), (370, 0), (375, 0), (380, 0), (385, 0), (390, 0), (395, 1), (400, 0), (405, 0), (410, 1), (415, 0), (420, 0), (425, 0), (430, 1), (435, 0), (440, 0), (445, 0), (450, 0), (455, 0), (460, 1), (465, 1), (470, 1), (475, 1), (480, 1), (485, 0), (490, 0), (495, 0), (500, 0), (505, 0), (510, 0), (515, 0), (520, 0), (525, 0), (530, 0), (535, 0), (540, 1), (545, 0), (550, 1), (555, 0), (560, 0), (565, 1), (570, 0), (575, 0), (580, 1), (585, 1), (590, 0), (595, 0), (600, 1), (605, 0), (610, 0), (615, 0), (620, 0), (625, 0), (630, 0), (635, 0), (640, 0), (645, 0), (650, 0), (655, 0), (660, 0), (665, 0), (670, 0), (675, 0), (680, 0), (685, 0), (690, 0), (695, 0), (700, 0), (705, 0), (710, 0), (715, 0), (720, 0), (725, 1), (730, 0), (735, 0), (740, 0), (745, 0), (750, 1), (755, 0), (760, 1), (765, 0), (770, 0), (775, 0), (780, 0), (785, 0), (790, 0), (795, 0), (800, 0), (805, 0), (810, 0), (815, 1), (820, 0), (825, 0), (830, 0), (835, 0), (840, 0), (845, 1), (850, 1), (855, 0), (860, 0), (865, 1), (870, 0), (875, 0), (880, 0), (885, 0), (890, 1), (895, 0), (900, 1), (905, 0), (910, 0), (915, 0), (920, 0), (925, 0), (930, 1), (935, 0), (940, 0), (945, 0), (950, 0), (955, 0), (960, 1), (965, 0), (970, 0), (975, 0), (980, 0), (985, 0), (990, 1), (995, 0), (1000, 1), (1005, 0), (1010, 0), (1015, 0), (1020, 0), (1025, 0)]
Va0_1  a0_1  0 PWL (0n 0.0v 4.745n 0.0v 4.755n 0.0v 9.745n 0.0v 9.755n 1.1v 14.745n 1.1v 14.755n 0.0v 19.745n 0.0v 19.755n 1.1v 24.745n 1.1v 24.755n 0.0v 29.745n 0.0v 29.755n 1.1v 34.745n 1.1v 34.755n 1.1v 39.745n 1.1v 39.755n 1.1v 44.745n 1.1v 44.755n 0.0v 49.745n 0.0v 49.755n 1.1v 54.745n 1.1v 54.755n 1.1v 59.745n 1.1v 59.755n 1.1v 64.745n 1.1v 64.755n 1.1v 69.745n 1.1v 69.755n 0.0v 74.745n 0.0v 74.755n 0.0v 79.745n 0.0v 79.755n 1.1v 84.745n 1.1v 84.755n 0.0v 89.745n 0.0v 89.755n 0.0v 94.745n 0.0v 94.755n 1.1v 99.745n 1.1v 99.755n 1.1v 104.745n 1.1v 104.755n 1.1v 109.745n 1.1v 109.755n 1.1v 114.745n 1.1v 114.755n 0.0v 119.745n 0.0v 119.755n 0.0v 124.745n 0.0v 124.755n 0.0v 129.745n 0.0v 129.755n 0.0v 134.745n 0.0v 134.755n 0.0v 139.745n 0.0v 139.755n 0.0v 144.745n 0.0v 144.755n 0.0v 149.745n 0.0v 149.755n 0.0v 154.745n 0.0v 154.755n 0.0v 159.745n 0.0v 159.755n 0.0v 164.745n 0.0v 164.755n 0.0v 169.745n 0.0v 169.755n 1.1v 174.745n 1.1v 174.755n 0.0v 179.745n 0.0v 179.755n 0.0v 184.745n 0.0v 184.755n 0.0v 189.745n 0.0v 189.755n 0.0v 194.745n 0.0v 194.755n 1.1v 199.745n 1.1v 199.755n 0.0v 204.745n 0.0v 204.755n 0.0v 209.745n 0.0v 209.755n 1.1v 214.745n 1.1v 214.755n 0.0v 219.745n 0.0v 219.755n 0.0v 224.745n 0.0v 224.755n 1.1v 229.745n 1.1v 229.755n 0.0v 234.745n 0.0v 234.755n 1.1v 239.745n 1.1v 239.755n 1.1v 244.745n 1.1v 244.755n 1.1v 249.745n 1.1v 249.755n 1.1v 254.745n 1.1v 254.755n 0.0v 259.745n 0.0v 259.755n 1.1v 264.745n 1.1v 264.755n 1.1v 269.745n 1.1v 269.755n 1.1v 274.745n 1.1v 274.755n 1.1v 279.745n 1.1v 279.755n 0.0v 284.745n 0.0v 284.755n 1.1v 289.745n 1.1v 289.755n 0.0v 294.745n 0.0v 294.755n 0.0v 299.745n 0.0v 299.755n 1.1v 304.745n 1.1v 304.755n 0.0v 309.745n 0.0v 309.755n 0.0v 314.745n 0.0v 314.755n 0.0v 319.745n 0.0v 319.755n 0.0v 324.745n 0.0v 324.755n 0.0v 329.745n 0.0v 329.755n 0.0v 334.745n 0.0v 334.755n 0.0v 339.745n 0.0v 339.755n 0.0v 344.745n 0.0v 344.755n 0.0v 349.745n 0.0v 349.755n 1.1v 354.745n 1.1v 354.755n 1.1v 359.745n 1.1v 359.755n 0.0v 364.745n 0.0v 364.755n 0.0v 369.745n 0.0v 369.755n 0.0v 374.745n 0.0v 374.755n 0.0v 379.745n 0.0v 379.755n 0.0v 384.745n 0.0v 384.755n 0.0v 389.745n 0.0v 389.755n 0.0v 394.745n 0.0v 394.755n 1.1v 399.745n 1.1v 399.755n 0.0v 404.745n 0.0v 404.755n 0.0v 409.745n 0.0v 409.755n 1.1v 414.745n 1.1v 414.755n 0.0v 419.745n 0.0v 419.755n 0.0v 424.745n 0.0v 424.755n 0.0v 429.745n 0.0v 429.755n 1.1v 434.745n 1.1v 434.755n 0.0v 439.745n 0.0v 439.755n 0.0v 444.745n 0.0v 444.755n 0.0v 449.745n 0.0v 449.755n 0.0v 454.745n 0.0v 454.755n 0.0v 459.745n 0.0v 459.755n 1.1v 464.745n 1.1v 464.755n 1.1v 469.745n 1.1v 469.755n 1.1v 474.745n 1.1v 474.755n 1.1v 479.745n 1.1v 479.755n 1.1v 484.745n 1.1v 484.755n 0.0v 489.745n 0.0v 489.755n 0.0v 494.745n 0.0v 494.755n 0.0v 499.745n 0.0v 499.755n 0.0v 504.745n 0.0v 504.755n 0.0v 509.745n 0.0v 509.755n 0.0v 514.745n 0.0v 514.755n 0.0v 519.745n 0.0v 519.755n 0.0v 524.745n 0.0v 524.755n 0.0v 529.745n 0.0v 529.755n 0.0v 534.745n 0.0v 534.755n 0.0v 539.745n 0.0v 539.755n 1.1v 544.745n 1.1v 544.755n 0.0v 549.745n 0.0v 549.755n 1.1v 554.745n 1.1v 554.755n 0.0v 559.745n 0.0v 559.755n 0.0v 564.745n 0.0v 564.755n 1.1v 569.745n 1.1v 569.755n 0.0v 574.745n 0.0v 574.755n 0.0v 579.745n 0.0v 579.755n 1.1v 584.745n 1.1v 584.755n 1.1v 589.745n 1.1v 589.755n 0.0v 594.745n 0.0v 594.755n 0.0v 599.745n 0.0v 599.755n 1.1v 604.745n 1.1v 604.755n 0.0v 609.745n 0.0v 609.755n 0.0v 614.745n 0.0v 614.755n 0.0v 619.745n 0.0v 619.755n 0.0v 624.745n 0.0v 624.755n 0.0v 629.745n 0.0v 629.755n 0.0v 634.745n 0.0v 634.755n 0.0v 639.745n 0.0v 639.755n 0.0v 644.745n 0.0v 644.755n 0.0v 649.745n 0.0v 649.755n 0.0v 654.745n 0.0v 654.755n 0.0v 659.745n 0.0v 659.755n 0.0v 664.745n 0.0v 664.755n 0.0v 669.745n 0.0v 669.755n 0.0v 674.745n 0.0v 674.755n 0.0v 679.745n 0.0v 679.755n 0.0v 684.745n 0.0v 684.755n 0.0v 689.745n 0.0v 689.755n 0.0v 694.745n 0.0v 694.755n 0.0v 699.745n 0.0v 699.755n 0.0v 704.745n 0.0v 704.755n 0.0v 709.745n 0.0v 709.755n 0.0v 714.745n 0.0v 714.755n 0.0v 719.745n 0.0v 719.755n 0.0v 724.745n 0.0v 724.755n 1.1v 729.745n 1.1v 729.755n 0.0v 734.745n 0.0v 734.755n 0.0v 739.745n 0.0v 739.755n 0.0v 744.745n 0.0v 744.755n 0.0v 749.745n 0.0v 749.755n 1.1v 754.745n 1.1v 754.755n 0.0v 759.745n 0.0v 759.755n 1.1v 764.745n 1.1v 764.755n 0.0v 769.745n 0.0v 769.755n 0.0v 774.745n 0.0v 774.755n 0.0v 779.745n 0.0v 779.755n 0.0v 784.745n 0.0v 784.755n 0.0v 789.745n 0.0v 789.755n 0.0v 794.745n 0.0v 794.755n 0.0v 799.745n 0.0v 799.755n 0.0v 804.745n 0.0v 804.755n 0.0v 809.745n 0.0v 809.755n 0.0v 814.745n 0.0v 814.755n 1.1v 819.745n 1.1v 819.755n 0.0v 824.745n 0.0v 824.755n 0.0v 829.745n 0.0v 829.755n 0.0v 834.745n 0.0v 834.755n 0.0v 839.745n 0.0v 839.755n 0.0v 844.745n 0.0v 844.755n 1.1v 849.745n 1.1v 849.755n 1.1v 854.745n 1.1v 854.755n 0.0v 859.745n 0.0v 859.755n 0.0v 864.745n 0.0v 864.755n 1.1v 869.745n 1.1v 869.755n 0.0v 874.745n 0.0v 874.755n 0.0v 879.745n 0.0v 879.755n 0.0v 884.745n 0.0v 884.755n 0.0v 889.745n 0.0v 889.755n 1.1v 894.745n 1.1v 894.755n 0.0v 899.745n 0.0v 899.755n 1.1v 904.745n 1.1v 904.755n 0.0v 909.745n 0.0v 909.755n 0.0v 914.745n 0.0v 914.755n 0.0v 919.745n 0.0v 919.755n 0.0v 924.745n 0.0v 924.755n 0.0v 929.745n 0.0v 929.755n 1.1v 934.745n 1.1v 934.755n 0.0v 939.745n 0.0v 939.755n 0.0v 944.745n 0.0v 944.755n 0.0v 949.745n 0.0v 949.755n 0.0v 954.745n 0.0v 954.755n 0.0v 959.745n 0.0v 959.755n 1.1v 964.745n 1.1v 964.755n 0.0v 969.745n 0.0v 969.755n 0.0v 974.745n 0.0v 974.755n 0.0v 979.745n 0.0v 979.755n 0.0v 984.745n 0.0v 984.755n 0.0v 989.745n 0.0v 989.755n 1.1v 994.745n 1.1v 994.755n 0.0v 999.745n 0.0v 999.755n 1.1v 1004.745n 1.1v 1004.755n 0.0v 1009.745n 0.0v 1009.755n 0.0v 1014.745n 0.0v 1014.755n 0.0v 1019.745n 0.0v 1019.755n 0.0v 1024.745n 0.0v 1024.755n 0.0v )
* (time, data): [(0, 0), (5, 0), (10, 1), (15, 0), (20, 1), (25, 0), (30, 1), (35, 1), (40, 1), (45, 0), (50, 1), (55, 1), (60, 1), (65, 1), (70, 0), (75, 0), (80, 1), (85, 0), (90, 0), (95, 1), (100, 1), (105, 1), (110, 1), (115, 0), (120, 0), (125, 0), (130, 0), (135, 0), (140, 0), (145, 0), (150, 0), (155, 0), (160, 0), (165, 0), (170, 1), (175, 0), (180, 0), (185, 0), (190, 0), (195, 1), (200, 0), (205, 0), (210, 1), (215, 0), (220, 0), (225, 1), (230, 0), (235, 1), (240, 1), (245, 1), (250, 1), (255, 0), (260, 1), (265, 1), (270, 1), (275, 1), (280, 0), (285, 1), (290, 0), (295, 1), (300, 1), (305, 0), (310, 0), (315, 1), (320, 1), (325, 1), (330, 1), (335, 1), (340, 0), (345, 0), (350, 1), (355, 1), (360, 0), (365, 0), (370, 0), (375, 0), (380, 0), (385, 0), (390, 0), (395, 1), (400, 0), (405, 0), (410, 1), (415, 0), (420, 1), (425, 0), (430, 1), (435, 1), (440, 0), (445, 0), (450, 0), (455, 1), (460, 1), (465, 1), (470, 1), (475, 1), (480, 1), (485, 1), (490, 1), (495, 0), (500, 0), (505, 0), (510, 0), (515, 0), (520, 0), (525, 0), (530, 1), (535, 0), (540, 1), (545, 0), (550, 1), (555, 1), (560, 0), (565, 1), (570, 0), (575, 0), (580, 1), (585, 1), (590, 0), (595, 0), (600, 1), (605, 0), (610, 0), (615, 0), (620, 1), (625, 0), (630, 0), (635, 1), (640, 1), (645, 1), (650, 0), (655, 0), (660, 1), (665, 1), (670, 0), (675, 1), (680, 1), (685, 1), (690, 0), (695, 0), (700, 0), (705, 1), (710, 0), (715, 1), (720, 0), (725, 1), (730, 0), (735, 1), (740, 0), (745, 0), (750, 1), (755, 1), (760, 1), (765, 0), (770, 0), (775, 0), (780, 0), (785, 1), (790, 0), (795, 0), (800, 0), (805, 1), (810, 0), (815, 1), (820, 0), (825, 0), (830, 1), (835, 0), (840, 1), (845, 1), (850, 1), (855, 1), (860, 0), (865, 1), (870, 1), (875, 0), (880, 0), (885, 1), (890, 1), (895, 1), (900, 1), (905, 0), (910, 0), (915, 0), (920, 0), (925, 0), (930, 1), (935, 0), (940, 0), (945, 0), (950, 0), (955, 0), (960, 1), (965, 1), (970, 1), (975, 1), (980, 0), (985, 0), (990, 1), (995, 0), (1000, 1), (1005, 0), (1010, 0), (1015, 0), (1020, 1), (1025, 1)]
Va0_2  a0_2  0 PWL (0n 0.0v 4.745n 0.0v 4.755n 0.0v 9.745n 0.0v 9.755n 1.1v 14.745n 1.1v 14.755n 0.0v 19.745n 0.0v 19.755n 1.1v 24.745n 1.1v 24.755n 0.0v 29.745n 0.0v 29.755n 1.1v 34.745n 1.1v 34.755n 1.1v 39.745n 1.1v 39.755n 1.1v 44.745n 1.1v 44.755n 0.0v 49.745n 0.0v 49.755n 1.1v 54.745n 1.1v 54.755n 1.1v 59.745n 1.1v 59.755n 1.1v 64.745n 1.1v 64.755n 1.1v 69.745n 1.1v 69.755n 0.0v 74.745n 0.0v 74.755n 0.0v 79.745n 0.0v 79.755n 1.1v 84.745n 1.1v 84.755n 0.0v 89.745n 0.0v 89.755n 0.0v 94.745n 0.0v 94.755n 1.1v 99.745n 1.1v 99.755n 1.1v 104.745n 1.1v 104.755n 1.1v 109.745n 1.1v 109.755n 1.1v 114.745n 1.1v 114.755n 0.0v 119.745n 0.0v 119.755n 0.0v 124.745n 0.0v 124.755n 0.0v 129.745n 0.0v 129.755n 0.0v 134.745n 0.0v 134.755n 0.0v 139.745n 0.0v 139.755n 0.0v 144.745n 0.0v 144.755n 0.0v 149.745n 0.0v 149.755n 0.0v 154.745n 0.0v 154.755n 0.0v 159.745n 0.0v 159.755n 0.0v 164.745n 0.0v 164.755n 0.0v 169.745n 0.0v 169.755n 1.1v 174.745n 1.1v 174.755n 0.0v 179.745n 0.0v 179.755n 0.0v 184.745n 0.0v 184.755n 0.0v 189.745n 0.0v 189.755n 0.0v 194.745n 0.0v 194.755n 1.1v 199.745n 1.1v 199.755n 0.0v 204.745n 0.0v 204.755n 0.0v 209.745n 0.0v 209.755n 1.1v 214.745n 1.1v 214.755n 0.0v 219.745n 0.0v 219.755n 0.0v 224.745n 0.0v 224.755n 1.1v 229.745n 1.1v 229.755n 0.0v 234.745n 0.0v 234.755n 1.1v 239.745n 1.1v 239.755n 1.1v 244.745n 1.1v 244.755n 1.1v 249.745n 1.1v 249.755n 1.1v 254.745n 1.1v 254.755n 0.0v 259.745n 0.0v 259.755n 1.1v 264.745n 1.1v 264.755n 1.1v 269.745n 1.1v 269.755n 1.1v 274.745n 1.1v 274.755n 1.1v 279.745n 1.1v 279.755n 0.0v 284.745n 0.0v 284.755n 1.1v 289.745n 1.1v 289.755n 0.0v 294.745n 0.0v 294.755n 1.1v 299.745n 1.1v 299.755n 1.1v 304.745n 1.1v 304.755n 0.0v 309.745n 0.0v 309.755n 0.0v 314.745n 0.0v 314.755n 1.1v 319.745n 1.1v 319.755n 1.1v 324.745n 1.1v 324.755n 1.1v 329.745n 1.1v 329.755n 1.1v 334.745n 1.1v 334.755n 1.1v 339.745n 1.1v 339.755n 0.0v 344.745n 0.0v 344.755n 0.0v 349.745n 0.0v 349.755n 1.1v 354.745n 1.1v 354.755n 1.1v 359.745n 1.1v 359.755n 0.0v 364.745n 0.0v 364.755n 0.0v 369.745n 0.0v 369.755n 0.0v 374.745n 0.0v 374.755n 0.0v 379.745n 0.0v 379.755n 0.0v 384.745n 0.0v 384.755n 0.0v 389.745n 0.0v 389.755n 0.0v 394.745n 0.0v 394.755n 1.1v 399.745n 1.1v 399.755n 0.0v 404.745n 0.0v 404.755n 0.0v 409.745n 0.0v 409.755n 1.1v 414.745n 1.1v 414.755n 0.0v 419.745n 0.0v 419.755n 1.1v 424.745n 1.1v 424.755n 0.0v 429.745n 0.0v 429.755n 1.1v 434.745n 1.1v 434.755n 1.1v 439.745n 1.1v 439.755n 0.0v 444.745n 0.0v 444.755n 0.0v 449.745n 0.0v 449.755n 0.0v 454.745n 0.0v 454.755n 1.1v 459.745n 1.1v 459.755n 1.1v 464.745n 1.1v 464.755n 1.1v 469.745n 1.1v 469.755n 1.1v 474.745n 1.1v 474.755n 1.1v 479.745n 1.1v 479.755n 1.1v 484.745n 1.1v 484.755n 1.1v 489.745n 1.1v 489.755n 1.1v 494.745n 1.1v 494.755n 0.0v 499.745n 0.0v 499.755n 0.0v 504.745n 0.0v 504.755n 0.0v 509.745n 0.0v 509.755n 0.0v 514.745n 0.0v 514.755n 0.0v 519.745n 0.0v 519.755n 0.0v 524.745n 0.0v 524.755n 0.0v 529.745n 0.0v 529.755n 1.1v 534.745n 1.1v 534.755n 0.0v 539.745n 0.0v 539.755n 1.1v 544.745n 1.1v 544.755n 0.0v 549.745n 0.0v 549.755n 1.1v 554.745n 1.1v 554.755n 1.1v 559.745n 1.1v 559.755n 0.0v 564.745n 0.0v 564.755n 1.1v 569.745n 1.1v 569.755n 0.0v 574.745n 0.0v 574.755n 0.0v 579.745n 0.0v 579.755n 1.1v 584.745n 1.1v 584.755n 1.1v 589.745n 1.1v 589.755n 0.0v 594.745n 0.0v 594.755n 0.0v 599.745n 0.0v 599.755n 1.1v 604.745n 1.1v 604.755n 0.0v 609.745n 0.0v 609.755n 0.0v 614.745n 0.0v 614.755n 0.0v 619.745n 0.0v 619.755n 1.1v 624.745n 1.1v 624.755n 0.0v 629.745n 0.0v 629.755n 0.0v 634.745n 0.0v 634.755n 1.1v 639.745n 1.1v 639.755n 1.1v 644.745n 1.1v 644.755n 1.1v 649.745n 1.1v 649.755n 0.0v 654.745n 0.0v 654.755n 0.0v 659.745n 0.0v 659.755n 1.1v 664.745n 1.1v 664.755n 1.1v 669.745n 1.1v 669.755n 0.0v 674.745n 0.0v 674.755n 1.1v 679.745n 1.1v 679.755n 1.1v 684.745n 1.1v 684.755n 1.1v 689.745n 1.1v 689.755n 0.0v 694.745n 0.0v 694.755n 0.0v 699.745n 0.0v 699.755n 0.0v 704.745n 0.0v 704.755n 1.1v 709.745n 1.1v 709.755n 0.0v 714.745n 0.0v 714.755n 1.1v 719.745n 1.1v 719.755n 0.0v 724.745n 0.0v 724.755n 1.1v 729.745n 1.1v 729.755n 0.0v 734.745n 0.0v 734.755n 1.1v 739.745n 1.1v 739.755n 0.0v 744.745n 0.0v 744.755n 0.0v 749.745n 0.0v 749.755n 1.1v 754.745n 1.1v 754.755n 1.1v 759.745n 1.1v 759.755n 1.1v 764.745n 1.1v 764.755n 0.0v 769.745n 0.0v 769.755n 0.0v 774.745n 0.0v 774.755n 0.0v 779.745n 0.0v 779.755n 0.0v 784.745n 0.0v 784.755n 1.1v 789.745n 1.1v 789.755n 0.0v 794.745n 0.0v 794.755n 0.0v 799.745n 0.0v 799.755n 0.0v 804.745n 0.0v 804.755n 1.1v 809.745n 1.1v 809.755n 0.0v 814.745n 0.0v 814.755n 1.1v 819.745n 1.1v 819.755n 0.0v 824.745n 0.0v 824.755n 0.0v 829.745n 0.0v 829.755n 1.1v 834.745n 1.1v 834.755n 0.0v 839.745n 0.0v 839.755n 1.1v 844.745n 1.1v 844.755n 1.1v 849.745n 1.1v 849.755n 1.1v 854.745n 1.1v 854.755n 1.1v 859.745n 1.1v 859.755n 0.0v 864.745n 0.0v 864.755n 1.1v 869.745n 1.1v 869.755n 1.1v 874.745n 1.1v 874.755n 0.0v 879.745n 0.0v 879.755n 0.0v 884.745n 0.0v 884.755n 1.1v 889.745n 1.1v 889.755n 1.1v 894.745n 1.1v 894.755n 1.1v 899.745n 1.1v 899.755n 1.1v 904.745n 1.1v 904.755n 0.0v 909.745n 0.0v 909.755n 0.0v 914.745n 0.0v 914.755n 0.0v 919.745n 0.0v 919.755n 0.0v 924.745n 0.0v 924.755n 0.0v 929.745n 0.0v 929.755n 1.1v 934.745n 1.1v 934.755n 0.0v 939.745n 0.0v 939.755n 0.0v 944.745n 0.0v 944.755n 0.0v 949.745n 0.0v 949.755n 0.0v 954.745n 0.0v 954.755n 0.0v 959.745n 0.0v 959.755n 1.1v 964.745n 1.1v 964.755n 1.1v 969.745n 1.1v 969.755n 1.1v 974.745n 1.1v 974.755n 1.1v 979.745n 1.1v 979.755n 0.0v 984.745n 0.0v 984.755n 0.0v 989.745n 0.0v 989.755n 1.1v 994.745n 1.1v 994.755n 0.0v 999.745n 0.0v 999.755n 1.1v 1004.745n 1.1v 1004.755n 0.0v 1009.745n 0.0v 1009.755n 0.0v 1014.745n 0.0v 1014.755n 0.0v 1019.745n 0.0v 1019.755n 1.1v 1024.745n 1.1v 1024.755n 1.1v )
* (time, data): [(0, 0), (5, 0), (10, 1), (15, 0), (20, 1), (25, 0), (30, 1), (35, 1), (40, 1), (45, 0), (50, 1), (55, 1), (60, 1), (65, 1), (70, 0), (75, 0), (80, 1), (85, 0), (90, 0), (95, 1), (100, 1), (105, 1), (110, 1), (115, 0), (120, 0), (125, 0), (130, 0), (135, 0), (140, 0), (145, 0), (150, 0), (155, 0), (160, 0), (165, 0), (170, 1), (175, 0), (180, 0), (185, 0), (190, 0), (195, 1), (200, 0), (205, 0), (210, 1), (215, 0), (220, 0), (225, 1), (230, 0), (235, 1), (240, 1), (245, 1), (250, 1), (255, 0), (260, 1), (265, 1), (270, 1), (275, 1), (280, 0), (285, 1), (290, 0), (295, 1), (300, 1), (305, 0), (310, 0), (315, 1), (320, 1), (325, 1), (330, 1), (335, 1), (340, 0), (345, 0), (350, 1), (355, 1), (360, 0), (365, 0), (370, 0), (375, 0), (380, 0), (385, 0), (390, 0), (395, 1), (400, 0), (405, 0), (410, 1), (415, 0), (420, 1), (425, 0), (430, 1), (435, 1), (440, 0), (445, 0), (450, 0), (455, 1), (460, 1), (465, 1), (470, 1), (475, 1), (480, 1), (485, 1), (490, 1), (495, 0), (500, 0), (505, 0), (510, 0), (515, 0), (520, 0), (525, 0), (530, 1), (535, 0), (540, 1), (545, 0), (550, 1), (555, 1), (560, 0), (565, 1), (570, 0), (575, 0), (580, 1), (585, 1), (590, 0), (595, 0), (600, 1), (605, 0), (610, 0), (615, 0), (620, 1), (625, 0), (630, 0), (635, 1), (640, 1), (645, 1), (650, 0), (655, 0), (660, 1), (665, 1), (670, 0), (675, 1), (680, 1), (685, 1), (690, 0), (695, 0), (700, 0), (705, 1), (710, 0), (715, 1), (720, 0), (725, 1), (730, 0), (735, 1), (740, 0), (745, 0), (750, 1), (755, 1), (760, 1), (765, 0), (770, 0), (775, 0), (780, 0), (785, 1), (790, 0), (795, 0), (800, 0), (805, 1), (810, 0), (815, 1), (820, 0), (825, 0), (830, 1), (835, 0), (840, 1), (845, 1), (850, 1), (855, 1), (860, 0), (865, 1), (870, 1), (875, 0), (880, 0), (885, 1), (890, 1), (895, 1), (900, 1), (905, 0), (910, 0), (915, 0), (920, 0), (925, 0), (930, 1), (935, 0), (940, 0), (945, 0), (950, 0), (955, 0), (960, 1), (965, 1), (970, 1), (975, 1), (980, 0), (985, 0), (990, 1), (995, 0), (1000, 1), (1005, 0), (1010, 0), (1015, 0), (1020, 1), (1025, 1)]
Va0_3  a0_3  0 PWL (0n 0.0v 4.745n 0.0v 4.755n 0.0v 9.745n 0.0v 9.755n 1.1v 14.745n 1.1v 14.755n 0.0v 19.745n 0.0v 19.755n 1.1v 24.745n 1.1v 24.755n 0.0v 29.745n 0.0v 29.755n 1.1v 34.745n 1.1v 34.755n 1.1v 39.745n 1.1v 39.755n 1.1v 44.745n 1.1v 44.755n 0.0v 49.745n 0.0v 49.755n 1.1v 54.745n 1.1v 54.755n 1.1v 59.745n 1.1v 59.755n 1.1v 64.745n 1.1v 64.755n 1.1v 69.745n 1.1v 69.755n 0.0v 74.745n 0.0v 74.755n 0.0v 79.745n 0.0v 79.755n 1.1v 84.745n 1.1v 84.755n 0.0v 89.745n 0.0v 89.755n 0.0v 94.745n 0.0v 94.755n 1.1v 99.745n 1.1v 99.755n 1.1v 104.745n 1.1v 104.755n 1.1v 109.745n 1.1v 109.755n 1.1v 114.745n 1.1v 114.755n 0.0v 119.745n 0.0v 119.755n 0.0v 124.745n 0.0v 124.755n 0.0v 129.745n 0.0v 129.755n 0.0v 134.745n 0.0v 134.755n 0.0v 139.745n 0.0v 139.755n 0.0v 144.745n 0.0v 144.755n 0.0v 149.745n 0.0v 149.755n 0.0v 154.745n 0.0v 154.755n 0.0v 159.745n 0.0v 159.755n 0.0v 164.745n 0.0v 164.755n 0.0v 169.745n 0.0v 169.755n 1.1v 174.745n 1.1v 174.755n 0.0v 179.745n 0.0v 179.755n 0.0v 184.745n 0.0v 184.755n 0.0v 189.745n 0.0v 189.755n 0.0v 194.745n 0.0v 194.755n 1.1v 199.745n 1.1v 199.755n 0.0v 204.745n 0.0v 204.755n 0.0v 209.745n 0.0v 209.755n 1.1v 214.745n 1.1v 214.755n 0.0v 219.745n 0.0v 219.755n 0.0v 224.745n 0.0v 224.755n 1.1v 229.745n 1.1v 229.755n 0.0v 234.745n 0.0v 234.755n 1.1v 239.745n 1.1v 239.755n 1.1v 244.745n 1.1v 244.755n 1.1v 249.745n 1.1v 249.755n 1.1v 254.745n 1.1v 254.755n 0.0v 259.745n 0.0v 259.755n 1.1v 264.745n 1.1v 264.755n 1.1v 269.745n 1.1v 269.755n 1.1v 274.745n 1.1v 274.755n 1.1v 279.745n 1.1v 279.755n 0.0v 284.745n 0.0v 284.755n 1.1v 289.745n 1.1v 289.755n 0.0v 294.745n 0.0v 294.755n 1.1v 299.745n 1.1v 299.755n 1.1v 304.745n 1.1v 304.755n 0.0v 309.745n 0.0v 309.755n 0.0v 314.745n 0.0v 314.755n 1.1v 319.745n 1.1v 319.755n 1.1v 324.745n 1.1v 324.755n 1.1v 329.745n 1.1v 329.755n 1.1v 334.745n 1.1v 334.755n 1.1v 339.745n 1.1v 339.755n 0.0v 344.745n 0.0v 344.755n 0.0v 349.745n 0.0v 349.755n 1.1v 354.745n 1.1v 354.755n 1.1v 359.745n 1.1v 359.755n 0.0v 364.745n 0.0v 364.755n 0.0v 369.745n 0.0v 369.755n 0.0v 374.745n 0.0v 374.755n 0.0v 379.745n 0.0v 379.755n 0.0v 384.745n 0.0v 384.755n 0.0v 389.745n 0.0v 389.755n 0.0v 394.745n 0.0v 394.755n 1.1v 399.745n 1.1v 399.755n 0.0v 404.745n 0.0v 404.755n 0.0v 409.745n 0.0v 409.755n 1.1v 414.745n 1.1v 414.755n 0.0v 419.745n 0.0v 419.755n 1.1v 424.745n 1.1v 424.755n 0.0v 429.745n 0.0v 429.755n 1.1v 434.745n 1.1v 434.755n 1.1v 439.745n 1.1v 439.755n 0.0v 444.745n 0.0v 444.755n 0.0v 449.745n 0.0v 449.755n 0.0v 454.745n 0.0v 454.755n 1.1v 459.745n 1.1v 459.755n 1.1v 464.745n 1.1v 464.755n 1.1v 469.745n 1.1v 469.755n 1.1v 474.745n 1.1v 474.755n 1.1v 479.745n 1.1v 479.755n 1.1v 484.745n 1.1v 484.755n 1.1v 489.745n 1.1v 489.755n 1.1v 494.745n 1.1v 494.755n 0.0v 499.745n 0.0v 499.755n 0.0v 504.745n 0.0v 504.755n 0.0v 509.745n 0.0v 509.755n 0.0v 514.745n 0.0v 514.755n 0.0v 519.745n 0.0v 519.755n 0.0v 524.745n 0.0v 524.755n 0.0v 529.745n 0.0v 529.755n 1.1v 534.745n 1.1v 534.755n 0.0v 539.745n 0.0v 539.755n 1.1v 544.745n 1.1v 544.755n 0.0v 549.745n 0.0v 549.755n 1.1v 554.745n 1.1v 554.755n 1.1v 559.745n 1.1v 559.755n 0.0v 564.745n 0.0v 564.755n 1.1v 569.745n 1.1v 569.755n 0.0v 574.745n 0.0v 574.755n 0.0v 579.745n 0.0v 579.755n 1.1v 584.745n 1.1v 584.755n 1.1v 589.745n 1.1v 589.755n 0.0v 594.745n 0.0v 594.755n 0.0v 599.745n 0.0v 599.755n 1.1v 604.745n 1.1v 604.755n 0.0v 609.745n 0.0v 609.755n 0.0v 614.745n 0.0v 614.755n 0.0v 619.745n 0.0v 619.755n 1.1v 624.745n 1.1v 624.755n 0.0v 629.745n 0.0v 629.755n 0.0v 634.745n 0.0v 634.755n 1.1v 639.745n 1.1v 639.755n 1.1v 644.745n 1.1v 644.755n 1.1v 649.745n 1.1v 649.755n 0.0v 654.745n 0.0v 654.755n 0.0v 659.745n 0.0v 659.755n 1.1v 664.745n 1.1v 664.755n 1.1v 669.745n 1.1v 669.755n 0.0v 674.745n 0.0v 674.755n 1.1v 679.745n 1.1v 679.755n 1.1v 684.745n 1.1v 684.755n 1.1v 689.745n 1.1v 689.755n 0.0v 694.745n 0.0v 694.755n 0.0v 699.745n 0.0v 699.755n 0.0v 704.745n 0.0v 704.755n 1.1v 709.745n 1.1v 709.755n 0.0v 714.745n 0.0v 714.755n 1.1v 719.745n 1.1v 719.755n 0.0v 724.745n 0.0v 724.755n 1.1v 729.745n 1.1v 729.755n 0.0v 734.745n 0.0v 734.755n 1.1v 739.745n 1.1v 739.755n 0.0v 744.745n 0.0v 744.755n 0.0v 749.745n 0.0v 749.755n 1.1v 754.745n 1.1v 754.755n 1.1v 759.745n 1.1v 759.755n 1.1v 764.745n 1.1v 764.755n 0.0v 769.745n 0.0v 769.755n 0.0v 774.745n 0.0v 774.755n 0.0v 779.745n 0.0v 779.755n 0.0v 784.745n 0.0v 784.755n 1.1v 789.745n 1.1v 789.755n 0.0v 794.745n 0.0v 794.755n 0.0v 799.745n 0.0v 799.755n 0.0v 804.745n 0.0v 804.755n 1.1v 809.745n 1.1v 809.755n 0.0v 814.745n 0.0v 814.755n 1.1v 819.745n 1.1v 819.755n 0.0v 824.745n 0.0v 824.755n 0.0v 829.745n 0.0v 829.755n 1.1v 834.745n 1.1v 834.755n 0.0v 839.745n 0.0v 839.755n 1.1v 844.745n 1.1v 844.755n 1.1v 849.745n 1.1v 849.755n 1.1v 854.745n 1.1v 854.755n 1.1v 859.745n 1.1v 859.755n 0.0v 864.745n 0.0v 864.755n 1.1v 869.745n 1.1v 869.755n 1.1v 874.745n 1.1v 874.755n 0.0v 879.745n 0.0v 879.755n 0.0v 884.745n 0.0v 884.755n 1.1v 889.745n 1.1v 889.755n 1.1v 894.745n 1.1v 894.755n 1.1v 899.745n 1.1v 899.755n 1.1v 904.745n 1.1v 904.755n 0.0v 909.745n 0.0v 909.755n 0.0v 914.745n 0.0v 914.755n 0.0v 919.745n 0.0v 919.755n 0.0v 924.745n 0.0v 924.755n 0.0v 929.745n 0.0v 929.755n 1.1v 934.745n 1.1v 934.755n 0.0v 939.745n 0.0v 939.755n 0.0v 944.745n 0.0v 944.755n 0.0v 949.745n 0.0v 949.755n 0.0v 954.745n 0.0v 954.755n 0.0v 959.745n 0.0v 959.755n 1.1v 964.745n 1.1v 964.755n 1.1v 969.745n 1.1v 969.755n 1.1v 974.745n 1.1v 974.755n 1.1v 979.745n 1.1v 979.755n 0.0v 984.745n 0.0v 984.755n 0.0v 989.745n 0.0v 989.755n 1.1v 994.745n 1.1v 994.755n 0.0v 999.745n 0.0v 999.755n 1.1v 1004.745n 1.1v 1004.755n 0.0v 1009.745n 0.0v 1009.755n 0.0v 1014.745n 0.0v 1014.755n 0.0v 1019.745n 0.0v 1019.755n 1.1v 1024.745n 1.1v 1024.755n 1.1v )
* (time, data): [(0, 0), (5, 0), (10, 1), (15, 0), (20, 1), (25, 0), (30, 1), (35, 1), (40, 1), (45, 0), (50, 1), (55, 1), (60, 1), (65, 1), (70, 0), (75, 0), (80, 1), (85, 0), (90, 0), (95, 1), (100, 1), (105, 1), (110, 1), (115, 0), (120, 0), (125, 0), (130, 0), (135, 0), (140, 0), (145, 0), (150, 0), (155, 0), (160, 0), (165, 0), (170, 1), (175, 0), (180, 0), (185, 0), (190, 0), (195, 1), (200, 0), (205, 0), (210, 1), (215, 0), (220, 0), (225, 1), (230, 0), (235, 1), (240, 1), (245, 1), (250, 1), (255, 0), (260, 1), (265, 1), (270, 1), (275, 1), (280, 0), (285, 1), (290, 0), (295, 1), (300, 1), (305, 0), (310, 0), (315, 1), (320, 1), (325, 1), (330, 1), (335, 1), (340, 0), (345, 0), (350, 1), (355, 1), (360, 0), (365, 0), (370, 0), (375, 0), (380, 0), (385, 0), (390, 0), (395, 1), (400, 0), (405, 0), (410, 1), (415, 0), (420, 1), (425, 0), (430, 1), (435, 1), (440, 0), (445, 0), (450, 0), (455, 1), (460, 1), (465, 1), (470, 1), (475, 1), (480, 1), (485, 1), (490, 1), (495, 0), (500, 0), (505, 0), (510, 0), (515, 0), (520, 0), (525, 0), (530, 1), (535, 0), (540, 1), (545, 0), (550, 1), (555, 1), (560, 0), (565, 1), (570, 0), (575, 0), (580, 1), (585, 1), (590, 0), (595, 0), (600, 1), (605, 0), (610, 0), (615, 0), (620, 1), (625, 0), (630, 0), (635, 1), (640, 1), (645, 1), (650, 0), (655, 0), (660, 1), (665, 1), (670, 0), (675, 1), (680, 1), (685, 1), (690, 0), (695, 0), (700, 0), (705, 1), (710, 0), (715, 1), (720, 0), (725, 1), (730, 0), (735, 1), (740, 0), (745, 0), (750, 1), (755, 1), (760, 1), (765, 0), (770, 0), (775, 0), (780, 0), (785, 1), (790, 0), (795, 0), (800, 0), (805, 1), (810, 0), (815, 1), (820, 0), (825, 0), (830, 1), (835, 0), (840, 1), (845, 1), (850, 1), (855, 1), (860, 0), (865, 1), (870, 1), (875, 0), (880, 0), (885, 1), (890, 1), (895, 1), (900, 1), (905, 0), (910, 0), (915, 0), (920, 0), (925, 0), (930, 1), (935, 0), (940, 0), (945, 0), (950, 0), (955, 0), (960, 1), (965, 1), (970, 1), (975, 1), (980, 0), (985, 0), (990, 1), (995, 0), (1000, 1), (1005, 0), (1010, 0), (1015, 0), (1020, 1), (1025, 1)]
Va0_4  a0_4  0 PWL (0n 0.0v 4.745n 0.0v 4.755n 0.0v 9.745n 0.0v 9.755n 1.1v 14.745n 1.1v 14.755n 0.0v 19.745n 0.0v 19.755n 1.1v 24.745n 1.1v 24.755n 0.0v 29.745n 0.0v 29.755n 1.1v 34.745n 1.1v 34.755n 1.1v 39.745n 1.1v 39.755n 1.1v 44.745n 1.1v 44.755n 0.0v 49.745n 0.0v 49.755n 1.1v 54.745n 1.1v 54.755n 1.1v 59.745n 1.1v 59.755n 1.1v 64.745n 1.1v 64.755n 1.1v 69.745n 1.1v 69.755n 0.0v 74.745n 0.0v 74.755n 0.0v 79.745n 0.0v 79.755n 1.1v 84.745n 1.1v 84.755n 0.0v 89.745n 0.0v 89.755n 0.0v 94.745n 0.0v 94.755n 1.1v 99.745n 1.1v 99.755n 1.1v 104.745n 1.1v 104.755n 1.1v 109.745n 1.1v 109.755n 1.1v 114.745n 1.1v 114.755n 0.0v 119.745n 0.0v 119.755n 0.0v 124.745n 0.0v 124.755n 0.0v 129.745n 0.0v 129.755n 0.0v 134.745n 0.0v 134.755n 0.0v 139.745n 0.0v 139.755n 0.0v 144.745n 0.0v 144.755n 0.0v 149.745n 0.0v 149.755n 0.0v 154.745n 0.0v 154.755n 0.0v 159.745n 0.0v 159.755n 0.0v 164.745n 0.0v 164.755n 0.0v 169.745n 0.0v 169.755n 1.1v 174.745n 1.1v 174.755n 0.0v 179.745n 0.0v 179.755n 0.0v 184.745n 0.0v 184.755n 0.0v 189.745n 0.0v 189.755n 0.0v 194.745n 0.0v 194.755n 1.1v 199.745n 1.1v 199.755n 0.0v 204.745n 0.0v 204.755n 0.0v 209.745n 0.0v 209.755n 1.1v 214.745n 1.1v 214.755n 0.0v 219.745n 0.0v 219.755n 0.0v 224.745n 0.0v 224.755n 1.1v 229.745n 1.1v 229.755n 0.0v 234.745n 0.0v 234.755n 1.1v 239.745n 1.1v 239.755n 1.1v 244.745n 1.1v 244.755n 1.1v 249.745n 1.1v 249.755n 1.1v 254.745n 1.1v 254.755n 0.0v 259.745n 0.0v 259.755n 1.1v 264.745n 1.1v 264.755n 1.1v 269.745n 1.1v 269.755n 1.1v 274.745n 1.1v 274.755n 1.1v 279.745n 1.1v 279.755n 0.0v 284.745n 0.0v 284.755n 1.1v 289.745n 1.1v 289.755n 0.0v 294.745n 0.0v 294.755n 1.1v 299.745n 1.1v 299.755n 1.1v 304.745n 1.1v 304.755n 0.0v 309.745n 0.0v 309.755n 0.0v 314.745n 0.0v 314.755n 1.1v 319.745n 1.1v 319.755n 1.1v 324.745n 1.1v 324.755n 1.1v 329.745n 1.1v 329.755n 1.1v 334.745n 1.1v 334.755n 1.1v 339.745n 1.1v 339.755n 0.0v 344.745n 0.0v 344.755n 0.0v 349.745n 0.0v 349.755n 1.1v 354.745n 1.1v 354.755n 1.1v 359.745n 1.1v 359.755n 0.0v 364.745n 0.0v 364.755n 0.0v 369.745n 0.0v 369.755n 0.0v 374.745n 0.0v 374.755n 0.0v 379.745n 0.0v 379.755n 0.0v 384.745n 0.0v 384.755n 0.0v 389.745n 0.0v 389.755n 0.0v 394.745n 0.0v 394.755n 1.1v 399.745n 1.1v 399.755n 0.0v 404.745n 0.0v 404.755n 0.0v 409.745n 0.0v 409.755n 1.1v 414.745n 1.1v 414.755n 0.0v 419.745n 0.0v 419.755n 1.1v 424.745n 1.1v 424.755n 0.0v 429.745n 0.0v 429.755n 1.1v 434.745n 1.1v 434.755n 1.1v 439.745n 1.1v 439.755n 0.0v 444.745n 0.0v 444.755n 0.0v 449.745n 0.0v 449.755n 0.0v 454.745n 0.0v 454.755n 1.1v 459.745n 1.1v 459.755n 1.1v 464.745n 1.1v 464.755n 1.1v 469.745n 1.1v 469.755n 1.1v 474.745n 1.1v 474.755n 1.1v 479.745n 1.1v 479.755n 1.1v 484.745n 1.1v 484.755n 1.1v 489.745n 1.1v 489.755n 1.1v 494.745n 1.1v 494.755n 0.0v 499.745n 0.0v 499.755n 0.0v 504.745n 0.0v 504.755n 0.0v 509.745n 0.0v 509.755n 0.0v 514.745n 0.0v 514.755n 0.0v 519.745n 0.0v 519.755n 0.0v 524.745n 0.0v 524.755n 0.0v 529.745n 0.0v 529.755n 1.1v 534.745n 1.1v 534.755n 0.0v 539.745n 0.0v 539.755n 1.1v 544.745n 1.1v 544.755n 0.0v 549.745n 0.0v 549.755n 1.1v 554.745n 1.1v 554.755n 1.1v 559.745n 1.1v 559.755n 0.0v 564.745n 0.0v 564.755n 1.1v 569.745n 1.1v 569.755n 0.0v 574.745n 0.0v 574.755n 0.0v 579.745n 0.0v 579.755n 1.1v 584.745n 1.1v 584.755n 1.1v 589.745n 1.1v 589.755n 0.0v 594.745n 0.0v 594.755n 0.0v 599.745n 0.0v 599.755n 1.1v 604.745n 1.1v 604.755n 0.0v 609.745n 0.0v 609.755n 0.0v 614.745n 0.0v 614.755n 0.0v 619.745n 0.0v 619.755n 1.1v 624.745n 1.1v 624.755n 0.0v 629.745n 0.0v 629.755n 0.0v 634.745n 0.0v 634.755n 1.1v 639.745n 1.1v 639.755n 1.1v 644.745n 1.1v 644.755n 1.1v 649.745n 1.1v 649.755n 0.0v 654.745n 0.0v 654.755n 0.0v 659.745n 0.0v 659.755n 1.1v 664.745n 1.1v 664.755n 1.1v 669.745n 1.1v 669.755n 0.0v 674.745n 0.0v 674.755n 1.1v 679.745n 1.1v 679.755n 1.1v 684.745n 1.1v 684.755n 1.1v 689.745n 1.1v 689.755n 0.0v 694.745n 0.0v 694.755n 0.0v 699.745n 0.0v 699.755n 0.0v 704.745n 0.0v 704.755n 1.1v 709.745n 1.1v 709.755n 0.0v 714.745n 0.0v 714.755n 1.1v 719.745n 1.1v 719.755n 0.0v 724.745n 0.0v 724.755n 1.1v 729.745n 1.1v 729.755n 0.0v 734.745n 0.0v 734.755n 1.1v 739.745n 1.1v 739.755n 0.0v 744.745n 0.0v 744.755n 0.0v 749.745n 0.0v 749.755n 1.1v 754.745n 1.1v 754.755n 1.1v 759.745n 1.1v 759.755n 1.1v 764.745n 1.1v 764.755n 0.0v 769.745n 0.0v 769.755n 0.0v 774.745n 0.0v 774.755n 0.0v 779.745n 0.0v 779.755n 0.0v 784.745n 0.0v 784.755n 1.1v 789.745n 1.1v 789.755n 0.0v 794.745n 0.0v 794.755n 0.0v 799.745n 0.0v 799.755n 0.0v 804.745n 0.0v 804.755n 1.1v 809.745n 1.1v 809.755n 0.0v 814.745n 0.0v 814.755n 1.1v 819.745n 1.1v 819.755n 0.0v 824.745n 0.0v 824.755n 0.0v 829.745n 0.0v 829.755n 1.1v 834.745n 1.1v 834.755n 0.0v 839.745n 0.0v 839.755n 1.1v 844.745n 1.1v 844.755n 1.1v 849.745n 1.1v 849.755n 1.1v 854.745n 1.1v 854.755n 1.1v 859.745n 1.1v 859.755n 0.0v 864.745n 0.0v 864.755n 1.1v 869.745n 1.1v 869.755n 1.1v 874.745n 1.1v 874.755n 0.0v 879.745n 0.0v 879.755n 0.0v 884.745n 0.0v 884.755n 1.1v 889.745n 1.1v 889.755n 1.1v 894.745n 1.1v 894.755n 1.1v 899.745n 1.1v 899.755n 1.1v 904.745n 1.1v 904.755n 0.0v 909.745n 0.0v 909.755n 0.0v 914.745n 0.0v 914.755n 0.0v 919.745n 0.0v 919.755n 0.0v 924.745n 0.0v 924.755n 0.0v 929.745n 0.0v 929.755n 1.1v 934.745n 1.1v 934.755n 0.0v 939.745n 0.0v 939.755n 0.0v 944.745n 0.0v 944.755n 0.0v 949.745n 0.0v 949.755n 0.0v 954.745n 0.0v 954.755n 0.0v 959.745n 0.0v 959.755n 1.1v 964.745n 1.1v 964.755n 1.1v 969.745n 1.1v 969.755n 1.1v 974.745n 1.1v 974.755n 1.1v 979.745n 1.1v 979.755n 0.0v 984.745n 0.0v 984.755n 0.0v 989.745n 0.0v 989.755n 1.1v 994.745n 1.1v 994.755n 0.0v 999.745n 0.0v 999.755n 1.1v 1004.745n 1.1v 1004.755n 0.0v 1009.745n 0.0v 1009.755n 0.0v 1014.745n 0.0v 1014.755n 0.0v 1019.745n 0.0v 1019.755n 1.1v 1024.745n 1.1v 1024.755n 1.1v )
* (time, data): [(0, 0), (5, 0), (10, 1), (15, 0), (20, 1), (25, 0), (30, 1), (35, 1), (40, 1), (45, 0), (50, 1), (55, 1), (60, 1), (65, 1), (70, 0), (75, 0), (80, 1), (85, 0), (90, 0), (95, 1), (100, 1), (105, 1), (110, 1), (115, 0), (120, 0), (125, 0), (130, 0), (135, 0), (140, 0), (145, 0), (150, 0), (155, 0), (160, 0), (165, 0), (170, 1), (175, 0), (180, 0), (185, 0), (190, 0), (195, 1), (200, 0), (205, 0), (210, 1), (215, 0), (220, 0), (225, 1), (230, 0), (235, 1), (240, 1), (245, 1), (250, 1), (255, 0), (260, 1), (265, 1), (270, 1), (275, 1), (280, 0), (285, 1), (290, 0), (295, 1), (300, 1), (305, 0), (310, 0), (315, 1), (320, 1), (325, 1), (330, 1), (335, 1), (340, 0), (345, 0), (350, 1), (355, 1), (360, 0), (365, 0), (370, 0), (375, 0), (380, 0), (385, 0), (390, 0), (395, 1), (400, 0), (405, 0), (410, 1), (415, 0), (420, 1), (425, 0), (430, 1), (435, 1), (440, 0), (445, 0), (450, 0), (455, 1), (460, 1), (465, 1), (470, 1), (475, 1), (480, 1), (485, 1), (490, 1), (495, 0), (500, 0), (505, 0), (510, 0), (515, 0), (520, 0), (525, 0), (530, 1), (535, 0), (540, 1), (545, 0), (550, 1), (555, 1), (560, 0), (565, 1), (570, 0), (575, 0), (580, 1), (585, 1), (590, 0), (595, 0), (600, 1), (605, 0), (610, 0), (615, 0), (620, 1), (625, 0), (630, 0), (635, 1), (640, 1), (645, 1), (650, 0), (655, 0), (660, 1), (665, 1), (670, 0), (675, 1), (680, 1), (685, 1), (690, 0), (695, 0), (700, 0), (705, 1), (710, 0), (715, 1), (720, 0), (725, 1), (730, 0), (735, 1), (740, 0), (745, 0), (750, 1), (755, 1), (760, 1), (765, 0), (770, 0), (775, 0), (780, 0), (785, 1), (790, 0), (795, 0), (800, 0), (805, 1), (810, 0), (815, 1), (820, 0), (825, 0), (830, 1), (835, 0), (840, 1), (845, 1), (850, 1), (855, 1), (860, 0), (865, 1), (870, 1), (875, 0), (880, 0), (885, 1), (890, 1), (895, 1), (900, 1), (905, 0), (910, 0), (915, 0), (920, 0), (925, 0), (930, 1), (935, 0), (940, 0), (945, 0), (950, 0), (955, 0), (960, 1), (965, 1), (970, 1), (975, 1), (980, 0), (985, 0), (990, 1), (995, 0), (1000, 1), (1005, 0), (1010, 0), (1015, 0), (1020, 1), (1025, 1)]
Va0_5  a0_5  0 PWL (0n 0.0v 4.745n 0.0v 4.755n 0.0v 9.745n 0.0v 9.755n 1.1v 14.745n 1.1v 14.755n 0.0v 19.745n 0.0v 19.755n 1.1v 24.745n 1.1v 24.755n 0.0v 29.745n 0.0v 29.755n 1.1v 34.745n 1.1v 34.755n 1.1v 39.745n 1.1v 39.755n 1.1v 44.745n 1.1v 44.755n 0.0v 49.745n 0.0v 49.755n 1.1v 54.745n 1.1v 54.755n 1.1v 59.745n 1.1v 59.755n 1.1v 64.745n 1.1v 64.755n 1.1v 69.745n 1.1v 69.755n 0.0v 74.745n 0.0v 74.755n 0.0v 79.745n 0.0v 79.755n 1.1v 84.745n 1.1v 84.755n 0.0v 89.745n 0.0v 89.755n 0.0v 94.745n 0.0v 94.755n 1.1v 99.745n 1.1v 99.755n 1.1v 104.745n 1.1v 104.755n 1.1v 109.745n 1.1v 109.755n 1.1v 114.745n 1.1v 114.755n 0.0v 119.745n 0.0v 119.755n 0.0v 124.745n 0.0v 124.755n 0.0v 129.745n 0.0v 129.755n 0.0v 134.745n 0.0v 134.755n 0.0v 139.745n 0.0v 139.755n 0.0v 144.745n 0.0v 144.755n 0.0v 149.745n 0.0v 149.755n 0.0v 154.745n 0.0v 154.755n 0.0v 159.745n 0.0v 159.755n 0.0v 164.745n 0.0v 164.755n 0.0v 169.745n 0.0v 169.755n 1.1v 174.745n 1.1v 174.755n 0.0v 179.745n 0.0v 179.755n 0.0v 184.745n 0.0v 184.755n 0.0v 189.745n 0.0v 189.755n 0.0v 194.745n 0.0v 194.755n 1.1v 199.745n 1.1v 199.755n 0.0v 204.745n 0.0v 204.755n 0.0v 209.745n 0.0v 209.755n 1.1v 214.745n 1.1v 214.755n 0.0v 219.745n 0.0v 219.755n 0.0v 224.745n 0.0v 224.755n 1.1v 229.745n 1.1v 229.755n 0.0v 234.745n 0.0v 234.755n 1.1v 239.745n 1.1v 239.755n 1.1v 244.745n 1.1v 244.755n 1.1v 249.745n 1.1v 249.755n 1.1v 254.745n 1.1v 254.755n 0.0v 259.745n 0.0v 259.755n 1.1v 264.745n 1.1v 264.755n 1.1v 269.745n 1.1v 269.755n 1.1v 274.745n 1.1v 274.755n 1.1v 279.745n 1.1v 279.755n 0.0v 284.745n 0.0v 284.755n 1.1v 289.745n 1.1v 289.755n 0.0v 294.745n 0.0v 294.755n 1.1v 299.745n 1.1v 299.755n 1.1v 304.745n 1.1v 304.755n 0.0v 309.745n 0.0v 309.755n 0.0v 314.745n 0.0v 314.755n 1.1v 319.745n 1.1v 319.755n 1.1v 324.745n 1.1v 324.755n 1.1v 329.745n 1.1v 329.755n 1.1v 334.745n 1.1v 334.755n 1.1v 339.745n 1.1v 339.755n 0.0v 344.745n 0.0v 344.755n 0.0v 349.745n 0.0v 349.755n 1.1v 354.745n 1.1v 354.755n 1.1v 359.745n 1.1v 359.755n 0.0v 364.745n 0.0v 364.755n 0.0v 369.745n 0.0v 369.755n 0.0v 374.745n 0.0v 374.755n 0.0v 379.745n 0.0v 379.755n 0.0v 384.745n 0.0v 384.755n 0.0v 389.745n 0.0v 389.755n 0.0v 394.745n 0.0v 394.755n 1.1v 399.745n 1.1v 399.755n 0.0v 404.745n 0.0v 404.755n 0.0v 409.745n 0.0v 409.755n 1.1v 414.745n 1.1v 414.755n 0.0v 419.745n 0.0v 419.755n 1.1v 424.745n 1.1v 424.755n 0.0v 429.745n 0.0v 429.755n 1.1v 434.745n 1.1v 434.755n 1.1v 439.745n 1.1v 439.755n 0.0v 444.745n 0.0v 444.755n 0.0v 449.745n 0.0v 449.755n 0.0v 454.745n 0.0v 454.755n 1.1v 459.745n 1.1v 459.755n 1.1v 464.745n 1.1v 464.755n 1.1v 469.745n 1.1v 469.755n 1.1v 474.745n 1.1v 474.755n 1.1v 479.745n 1.1v 479.755n 1.1v 484.745n 1.1v 484.755n 1.1v 489.745n 1.1v 489.755n 1.1v 494.745n 1.1v 494.755n 0.0v 499.745n 0.0v 499.755n 0.0v 504.745n 0.0v 504.755n 0.0v 509.745n 0.0v 509.755n 0.0v 514.745n 0.0v 514.755n 0.0v 519.745n 0.0v 519.755n 0.0v 524.745n 0.0v 524.755n 0.0v 529.745n 0.0v 529.755n 1.1v 534.745n 1.1v 534.755n 0.0v 539.745n 0.0v 539.755n 1.1v 544.745n 1.1v 544.755n 0.0v 549.745n 0.0v 549.755n 1.1v 554.745n 1.1v 554.755n 1.1v 559.745n 1.1v 559.755n 0.0v 564.745n 0.0v 564.755n 1.1v 569.745n 1.1v 569.755n 0.0v 574.745n 0.0v 574.755n 0.0v 579.745n 0.0v 579.755n 1.1v 584.745n 1.1v 584.755n 1.1v 589.745n 1.1v 589.755n 0.0v 594.745n 0.0v 594.755n 0.0v 599.745n 0.0v 599.755n 1.1v 604.745n 1.1v 604.755n 0.0v 609.745n 0.0v 609.755n 0.0v 614.745n 0.0v 614.755n 0.0v 619.745n 0.0v 619.755n 1.1v 624.745n 1.1v 624.755n 0.0v 629.745n 0.0v 629.755n 0.0v 634.745n 0.0v 634.755n 1.1v 639.745n 1.1v 639.755n 1.1v 644.745n 1.1v 644.755n 1.1v 649.745n 1.1v 649.755n 0.0v 654.745n 0.0v 654.755n 0.0v 659.745n 0.0v 659.755n 1.1v 664.745n 1.1v 664.755n 1.1v 669.745n 1.1v 669.755n 0.0v 674.745n 0.0v 674.755n 1.1v 679.745n 1.1v 679.755n 1.1v 684.745n 1.1v 684.755n 1.1v 689.745n 1.1v 689.755n 0.0v 694.745n 0.0v 694.755n 0.0v 699.745n 0.0v 699.755n 0.0v 704.745n 0.0v 704.755n 1.1v 709.745n 1.1v 709.755n 0.0v 714.745n 0.0v 714.755n 1.1v 719.745n 1.1v 719.755n 0.0v 724.745n 0.0v 724.755n 1.1v 729.745n 1.1v 729.755n 0.0v 734.745n 0.0v 734.755n 1.1v 739.745n 1.1v 739.755n 0.0v 744.745n 0.0v 744.755n 0.0v 749.745n 0.0v 749.755n 1.1v 754.745n 1.1v 754.755n 1.1v 759.745n 1.1v 759.755n 1.1v 764.745n 1.1v 764.755n 0.0v 769.745n 0.0v 769.755n 0.0v 774.745n 0.0v 774.755n 0.0v 779.745n 0.0v 779.755n 0.0v 784.745n 0.0v 784.755n 1.1v 789.745n 1.1v 789.755n 0.0v 794.745n 0.0v 794.755n 0.0v 799.745n 0.0v 799.755n 0.0v 804.745n 0.0v 804.755n 1.1v 809.745n 1.1v 809.755n 0.0v 814.745n 0.0v 814.755n 1.1v 819.745n 1.1v 819.755n 0.0v 824.745n 0.0v 824.755n 0.0v 829.745n 0.0v 829.755n 1.1v 834.745n 1.1v 834.755n 0.0v 839.745n 0.0v 839.755n 1.1v 844.745n 1.1v 844.755n 1.1v 849.745n 1.1v 849.755n 1.1v 854.745n 1.1v 854.755n 1.1v 859.745n 1.1v 859.755n 0.0v 864.745n 0.0v 864.755n 1.1v 869.745n 1.1v 869.755n 1.1v 874.745n 1.1v 874.755n 0.0v 879.745n 0.0v 879.755n 0.0v 884.745n 0.0v 884.755n 1.1v 889.745n 1.1v 889.755n 1.1v 894.745n 1.1v 894.755n 1.1v 899.745n 1.1v 899.755n 1.1v 904.745n 1.1v 904.755n 0.0v 909.745n 0.0v 909.755n 0.0v 914.745n 0.0v 914.755n 0.0v 919.745n 0.0v 919.755n 0.0v 924.745n 0.0v 924.755n 0.0v 929.745n 0.0v 929.755n 1.1v 934.745n 1.1v 934.755n 0.0v 939.745n 0.0v 939.755n 0.0v 944.745n 0.0v 944.755n 0.0v 949.745n 0.0v 949.755n 0.0v 954.745n 0.0v 954.755n 0.0v 959.745n 0.0v 959.755n 1.1v 964.745n 1.1v 964.755n 1.1v 969.745n 1.1v 969.755n 1.1v 974.745n 1.1v 974.755n 1.1v 979.745n 1.1v 979.755n 0.0v 984.745n 0.0v 984.755n 0.0v 989.745n 0.0v 989.755n 1.1v 994.745n 1.1v 994.755n 0.0v 999.745n 0.0v 999.755n 1.1v 1004.745n 1.1v 1004.755n 0.0v 1009.745n 0.0v 1009.755n 0.0v 1014.745n 0.0v 1014.755n 0.0v 1019.745n 0.0v 1019.755n 1.1v 1024.745n 1.1v 1024.755n 1.1v )
* (time, data): [(0, 0), (5, 0), (10, 1), (15, 0), (20, 1), (25, 0), (30, 1), (35, 1), (40, 1), (45, 0), (50, 1), (55, 1), (60, 1), (65, 1), (70, 0), (75, 0), (80, 1), (85, 0), (90, 0), (95, 1), (100, 1), (105, 1), (110, 1), (115, 0), (120, 0), (125, 0), (130, 0), (135, 0), (140, 0), (145, 0), (150, 0), (155, 0), (160, 0), (165, 0), (170, 1), (175, 0), (180, 0), (185, 0), (190, 0), (195, 1), (200, 0), (205, 0), (210, 1), (215, 0), (220, 0), (225, 1), (230, 0), (235, 1), (240, 1), (245, 1), (250, 1), (255, 0), (260, 1), (265, 1), (270, 1), (275, 1), (280, 0), (285, 1), (290, 0), (295, 1), (300, 1), (305, 0), (310, 0), (315, 1), (320, 1), (325, 1), (330, 1), (335, 1), (340, 0), (345, 0), (350, 1), (355, 1), (360, 0), (365, 0), (370, 0), (375, 0), (380, 0), (385, 0), (390, 0), (395, 1), (400, 0), (405, 0), (410, 1), (415, 0), (420, 1), (425, 0), (430, 1), (435, 1), (440, 0), (445, 0), (450, 0), (455, 1), (460, 1), (465, 1), (470, 1), (475, 1), (480, 1), (485, 1), (490, 1), (495, 0), (500, 0), (505, 0), (510, 0), (515, 0), (520, 0), (525, 0), (530, 1), (535, 0), (540, 1), (545, 0), (550, 1), (555, 1), (560, 0), (565, 1), (570, 0), (575, 0), (580, 1), (585, 1), (590, 0), (595, 0), (600, 1), (605, 0), (610, 0), (615, 0), (620, 1), (625, 0), (630, 0), (635, 1), (640, 1), (645, 1), (650, 0), (655, 0), (660, 1), (665, 1), (670, 0), (675, 1), (680, 1), (685, 1), (690, 0), (695, 0), (700, 0), (705, 1), (710, 0), (715, 1), (720, 0), (725, 1), (730, 0), (735, 1), (740, 0), (745, 0), (750, 1), (755, 1), (760, 1), (765, 0), (770, 0), (775, 0), (780, 0), (785, 1), (790, 0), (795, 0), (800, 0), (805, 1), (810, 0), (815, 1), (820, 0), (825, 0), (830, 1), (835, 0), (840, 1), (845, 1), (850, 1), (855, 1), (860, 0), (865, 1), (870, 1), (875, 0), (880, 0), (885, 1), (890, 1), (895, 1), (900, 1), (905, 0), (910, 0), (915, 0), (920, 0), (925, 0), (930, 1), (935, 0), (940, 0), (945, 0), (950, 0), (955, 0), (960, 1), (965, 1), (970, 1), (975, 1), (980, 0), (985, 0), (990, 1), (995, 0), (1000, 1), (1005, 0), (1010, 0), (1015, 0), (1020, 1), (1025, 1)]
Va0_6  a0_6  0 PWL (0n 0.0v 4.745n 0.0v 4.755n 0.0v 9.745n 0.0v 9.755n 1.1v 14.745n 1.1v 14.755n 0.0v 19.745n 0.0v 19.755n 1.1v 24.745n 1.1v 24.755n 0.0v 29.745n 0.0v 29.755n 1.1v 34.745n 1.1v 34.755n 1.1v 39.745n 1.1v 39.755n 1.1v 44.745n 1.1v 44.755n 0.0v 49.745n 0.0v 49.755n 1.1v 54.745n 1.1v 54.755n 1.1v 59.745n 1.1v 59.755n 1.1v 64.745n 1.1v 64.755n 1.1v 69.745n 1.1v 69.755n 0.0v 74.745n 0.0v 74.755n 0.0v 79.745n 0.0v 79.755n 1.1v 84.745n 1.1v 84.755n 0.0v 89.745n 0.0v 89.755n 0.0v 94.745n 0.0v 94.755n 1.1v 99.745n 1.1v 99.755n 1.1v 104.745n 1.1v 104.755n 1.1v 109.745n 1.1v 109.755n 1.1v 114.745n 1.1v 114.755n 0.0v 119.745n 0.0v 119.755n 0.0v 124.745n 0.0v 124.755n 0.0v 129.745n 0.0v 129.755n 0.0v 134.745n 0.0v 134.755n 0.0v 139.745n 0.0v 139.755n 0.0v 144.745n 0.0v 144.755n 0.0v 149.745n 0.0v 149.755n 0.0v 154.745n 0.0v 154.755n 0.0v 159.745n 0.0v 159.755n 0.0v 164.745n 0.0v 164.755n 0.0v 169.745n 0.0v 169.755n 1.1v 174.745n 1.1v 174.755n 0.0v 179.745n 0.0v 179.755n 0.0v 184.745n 0.0v 184.755n 0.0v 189.745n 0.0v 189.755n 0.0v 194.745n 0.0v 194.755n 1.1v 199.745n 1.1v 199.755n 0.0v 204.745n 0.0v 204.755n 0.0v 209.745n 0.0v 209.755n 1.1v 214.745n 1.1v 214.755n 0.0v 219.745n 0.0v 219.755n 0.0v 224.745n 0.0v 224.755n 1.1v 229.745n 1.1v 229.755n 0.0v 234.745n 0.0v 234.755n 1.1v 239.745n 1.1v 239.755n 1.1v 244.745n 1.1v 244.755n 1.1v 249.745n 1.1v 249.755n 1.1v 254.745n 1.1v 254.755n 0.0v 259.745n 0.0v 259.755n 1.1v 264.745n 1.1v 264.755n 1.1v 269.745n 1.1v 269.755n 1.1v 274.745n 1.1v 274.755n 1.1v 279.745n 1.1v 279.755n 0.0v 284.745n 0.0v 284.755n 1.1v 289.745n 1.1v 289.755n 0.0v 294.745n 0.0v 294.755n 1.1v 299.745n 1.1v 299.755n 1.1v 304.745n 1.1v 304.755n 0.0v 309.745n 0.0v 309.755n 0.0v 314.745n 0.0v 314.755n 1.1v 319.745n 1.1v 319.755n 1.1v 324.745n 1.1v 324.755n 1.1v 329.745n 1.1v 329.755n 1.1v 334.745n 1.1v 334.755n 1.1v 339.745n 1.1v 339.755n 0.0v 344.745n 0.0v 344.755n 0.0v 349.745n 0.0v 349.755n 1.1v 354.745n 1.1v 354.755n 1.1v 359.745n 1.1v 359.755n 0.0v 364.745n 0.0v 364.755n 0.0v 369.745n 0.0v 369.755n 0.0v 374.745n 0.0v 374.755n 0.0v 379.745n 0.0v 379.755n 0.0v 384.745n 0.0v 384.755n 0.0v 389.745n 0.0v 389.755n 0.0v 394.745n 0.0v 394.755n 1.1v 399.745n 1.1v 399.755n 0.0v 404.745n 0.0v 404.755n 0.0v 409.745n 0.0v 409.755n 1.1v 414.745n 1.1v 414.755n 0.0v 419.745n 0.0v 419.755n 1.1v 424.745n 1.1v 424.755n 0.0v 429.745n 0.0v 429.755n 1.1v 434.745n 1.1v 434.755n 1.1v 439.745n 1.1v 439.755n 0.0v 444.745n 0.0v 444.755n 0.0v 449.745n 0.0v 449.755n 0.0v 454.745n 0.0v 454.755n 1.1v 459.745n 1.1v 459.755n 1.1v 464.745n 1.1v 464.755n 1.1v 469.745n 1.1v 469.755n 1.1v 474.745n 1.1v 474.755n 1.1v 479.745n 1.1v 479.755n 1.1v 484.745n 1.1v 484.755n 1.1v 489.745n 1.1v 489.755n 1.1v 494.745n 1.1v 494.755n 0.0v 499.745n 0.0v 499.755n 0.0v 504.745n 0.0v 504.755n 0.0v 509.745n 0.0v 509.755n 0.0v 514.745n 0.0v 514.755n 0.0v 519.745n 0.0v 519.755n 0.0v 524.745n 0.0v 524.755n 0.0v 529.745n 0.0v 529.755n 1.1v 534.745n 1.1v 534.755n 0.0v 539.745n 0.0v 539.755n 1.1v 544.745n 1.1v 544.755n 0.0v 549.745n 0.0v 549.755n 1.1v 554.745n 1.1v 554.755n 1.1v 559.745n 1.1v 559.755n 0.0v 564.745n 0.0v 564.755n 1.1v 569.745n 1.1v 569.755n 0.0v 574.745n 0.0v 574.755n 0.0v 579.745n 0.0v 579.755n 1.1v 584.745n 1.1v 584.755n 1.1v 589.745n 1.1v 589.755n 0.0v 594.745n 0.0v 594.755n 0.0v 599.745n 0.0v 599.755n 1.1v 604.745n 1.1v 604.755n 0.0v 609.745n 0.0v 609.755n 0.0v 614.745n 0.0v 614.755n 0.0v 619.745n 0.0v 619.755n 1.1v 624.745n 1.1v 624.755n 0.0v 629.745n 0.0v 629.755n 0.0v 634.745n 0.0v 634.755n 1.1v 639.745n 1.1v 639.755n 1.1v 644.745n 1.1v 644.755n 1.1v 649.745n 1.1v 649.755n 0.0v 654.745n 0.0v 654.755n 0.0v 659.745n 0.0v 659.755n 1.1v 664.745n 1.1v 664.755n 1.1v 669.745n 1.1v 669.755n 0.0v 674.745n 0.0v 674.755n 1.1v 679.745n 1.1v 679.755n 1.1v 684.745n 1.1v 684.755n 1.1v 689.745n 1.1v 689.755n 0.0v 694.745n 0.0v 694.755n 0.0v 699.745n 0.0v 699.755n 0.0v 704.745n 0.0v 704.755n 1.1v 709.745n 1.1v 709.755n 0.0v 714.745n 0.0v 714.755n 1.1v 719.745n 1.1v 719.755n 0.0v 724.745n 0.0v 724.755n 1.1v 729.745n 1.1v 729.755n 0.0v 734.745n 0.0v 734.755n 1.1v 739.745n 1.1v 739.755n 0.0v 744.745n 0.0v 744.755n 0.0v 749.745n 0.0v 749.755n 1.1v 754.745n 1.1v 754.755n 1.1v 759.745n 1.1v 759.755n 1.1v 764.745n 1.1v 764.755n 0.0v 769.745n 0.0v 769.755n 0.0v 774.745n 0.0v 774.755n 0.0v 779.745n 0.0v 779.755n 0.0v 784.745n 0.0v 784.755n 1.1v 789.745n 1.1v 789.755n 0.0v 794.745n 0.0v 794.755n 0.0v 799.745n 0.0v 799.755n 0.0v 804.745n 0.0v 804.755n 1.1v 809.745n 1.1v 809.755n 0.0v 814.745n 0.0v 814.755n 1.1v 819.745n 1.1v 819.755n 0.0v 824.745n 0.0v 824.755n 0.0v 829.745n 0.0v 829.755n 1.1v 834.745n 1.1v 834.755n 0.0v 839.745n 0.0v 839.755n 1.1v 844.745n 1.1v 844.755n 1.1v 849.745n 1.1v 849.755n 1.1v 854.745n 1.1v 854.755n 1.1v 859.745n 1.1v 859.755n 0.0v 864.745n 0.0v 864.755n 1.1v 869.745n 1.1v 869.755n 1.1v 874.745n 1.1v 874.755n 0.0v 879.745n 0.0v 879.755n 0.0v 884.745n 0.0v 884.755n 1.1v 889.745n 1.1v 889.755n 1.1v 894.745n 1.1v 894.755n 1.1v 899.745n 1.1v 899.755n 1.1v 904.745n 1.1v 904.755n 0.0v 909.745n 0.0v 909.755n 0.0v 914.745n 0.0v 914.755n 0.0v 919.745n 0.0v 919.755n 0.0v 924.745n 0.0v 924.755n 0.0v 929.745n 0.0v 929.755n 1.1v 934.745n 1.1v 934.755n 0.0v 939.745n 0.0v 939.755n 0.0v 944.745n 0.0v 944.755n 0.0v 949.745n 0.0v 949.755n 0.0v 954.745n 0.0v 954.755n 0.0v 959.745n 0.0v 959.755n 1.1v 964.745n 1.1v 964.755n 1.1v 969.745n 1.1v 969.755n 1.1v 974.745n 1.1v 974.755n 1.1v 979.745n 1.1v 979.755n 0.0v 984.745n 0.0v 984.755n 0.0v 989.745n 0.0v 989.755n 1.1v 994.745n 1.1v 994.755n 0.0v 999.745n 0.0v 999.755n 1.1v 1004.745n 1.1v 1004.755n 0.0v 1009.745n 0.0v 1009.755n 0.0v 1014.745n 0.0v 1014.755n 0.0v 1019.745n 0.0v 1019.755n 1.1v 1024.745n 1.1v 1024.755n 1.1v )
* (time, data): [(0, 0), (5, 0), (10, 1), (15, 0), (20, 1), (25, 0), (30, 1), (35, 1), (40, 1), (45, 0), (50, 1), (55, 1), (60, 1), (65, 1), (70, 0), (75, 0), (80, 1), (85, 0), (90, 0), (95, 1), (100, 1), (105, 1), (110, 1), (115, 0), (120, 0), (125, 0), (130, 0), (135, 0), (140, 0), (145, 0), (150, 0), (155, 0), (160, 0), (165, 0), (170, 1), (175, 0), (180, 0), (185, 0), (190, 0), (195, 1), (200, 0), (205, 0), (210, 1), (215, 0), (220, 0), (225, 1), (230, 0), (235, 1), (240, 1), (245, 1), (250, 1), (255, 0), (260, 1), (265, 1), (270, 1), (275, 1), (280, 0), (285, 1), (290, 0), (295, 1), (300, 1), (305, 0), (310, 0), (315, 1), (320, 1), (325, 1), (330, 1), (335, 1), (340, 0), (345, 0), (350, 1), (355, 1), (360, 0), (365, 0), (370, 0), (375, 0), (380, 0), (385, 0), (390, 0), (395, 1), (400, 0), (405, 0), (410, 1), (415, 0), (420, 1), (425, 0), (430, 1), (435, 1), (440, 0), (445, 0), (450, 0), (455, 1), (460, 1), (465, 1), (470, 1), (475, 1), (480, 1), (485, 1), (490, 1), (495, 0), (500, 0), (505, 0), (510, 0), (515, 0), (520, 0), (525, 0), (530, 1), (535, 0), (540, 1), (545, 0), (550, 1), (555, 1), (560, 0), (565, 1), (570, 0), (575, 0), (580, 1), (585, 1), (590, 0), (595, 0), (600, 1), (605, 0), (610, 0), (615, 0), (620, 1), (625, 0), (630, 0), (635, 1), (640, 1), (645, 1), (650, 0), (655, 0), (660, 1), (665, 1), (670, 0), (675, 1), (680, 1), (685, 1), (690, 0), (695, 0), (700, 0), (705, 1), (710, 0), (715, 1), (720, 0), (725, 1), (730, 0), (735, 1), (740, 0), (745, 0), (750, 1), (755, 1), (760, 1), (765, 0), (770, 0), (775, 0), (780, 0), (785, 1), (790, 0), (795, 0), (800, 0), (805, 1), (810, 0), (815, 1), (820, 0), (825, 0), (830, 1), (835, 0), (840, 1), (845, 1), (850, 1), (855, 1), (860, 0), (865, 1), (870, 1), (875, 0), (880, 0), (885, 1), (890, 1), (895, 1), (900, 1), (905, 0), (910, 0), (915, 0), (920, 0), (925, 0), (930, 1), (935, 0), (940, 0), (945, 0), (950, 0), (955, 0), (960, 1), (965, 1), (970, 1), (975, 1), (980, 0), (985, 0), (990, 1), (995, 0), (1000, 1), (1005, 0), (1010, 0), (1015, 0), (1020, 1), (1025, 1)]
Va0_7  a0_7  0 PWL (0n 0.0v 4.745n 0.0v 4.755n 0.0v 9.745n 0.0v 9.755n 1.1v 14.745n 1.1v 14.755n 0.0v 19.745n 0.0v 19.755n 1.1v 24.745n 1.1v 24.755n 0.0v 29.745n 0.0v 29.755n 1.1v 34.745n 1.1v 34.755n 1.1v 39.745n 1.1v 39.755n 1.1v 44.745n 1.1v 44.755n 0.0v 49.745n 0.0v 49.755n 1.1v 54.745n 1.1v 54.755n 1.1v 59.745n 1.1v 59.755n 1.1v 64.745n 1.1v 64.755n 1.1v 69.745n 1.1v 69.755n 0.0v 74.745n 0.0v 74.755n 0.0v 79.745n 0.0v 79.755n 1.1v 84.745n 1.1v 84.755n 0.0v 89.745n 0.0v 89.755n 0.0v 94.745n 0.0v 94.755n 1.1v 99.745n 1.1v 99.755n 1.1v 104.745n 1.1v 104.755n 1.1v 109.745n 1.1v 109.755n 1.1v 114.745n 1.1v 114.755n 0.0v 119.745n 0.0v 119.755n 0.0v 124.745n 0.0v 124.755n 0.0v 129.745n 0.0v 129.755n 0.0v 134.745n 0.0v 134.755n 0.0v 139.745n 0.0v 139.755n 0.0v 144.745n 0.0v 144.755n 0.0v 149.745n 0.0v 149.755n 0.0v 154.745n 0.0v 154.755n 0.0v 159.745n 0.0v 159.755n 0.0v 164.745n 0.0v 164.755n 0.0v 169.745n 0.0v 169.755n 1.1v 174.745n 1.1v 174.755n 0.0v 179.745n 0.0v 179.755n 0.0v 184.745n 0.0v 184.755n 0.0v 189.745n 0.0v 189.755n 0.0v 194.745n 0.0v 194.755n 1.1v 199.745n 1.1v 199.755n 0.0v 204.745n 0.0v 204.755n 0.0v 209.745n 0.0v 209.755n 1.1v 214.745n 1.1v 214.755n 0.0v 219.745n 0.0v 219.755n 0.0v 224.745n 0.0v 224.755n 1.1v 229.745n 1.1v 229.755n 0.0v 234.745n 0.0v 234.755n 1.1v 239.745n 1.1v 239.755n 1.1v 244.745n 1.1v 244.755n 1.1v 249.745n 1.1v 249.755n 1.1v 254.745n 1.1v 254.755n 0.0v 259.745n 0.0v 259.755n 1.1v 264.745n 1.1v 264.755n 1.1v 269.745n 1.1v 269.755n 1.1v 274.745n 1.1v 274.755n 1.1v 279.745n 1.1v 279.755n 0.0v 284.745n 0.0v 284.755n 1.1v 289.745n 1.1v 289.755n 0.0v 294.745n 0.0v 294.755n 1.1v 299.745n 1.1v 299.755n 1.1v 304.745n 1.1v 304.755n 0.0v 309.745n 0.0v 309.755n 0.0v 314.745n 0.0v 314.755n 1.1v 319.745n 1.1v 319.755n 1.1v 324.745n 1.1v 324.755n 1.1v 329.745n 1.1v 329.755n 1.1v 334.745n 1.1v 334.755n 1.1v 339.745n 1.1v 339.755n 0.0v 344.745n 0.0v 344.755n 0.0v 349.745n 0.0v 349.755n 1.1v 354.745n 1.1v 354.755n 1.1v 359.745n 1.1v 359.755n 0.0v 364.745n 0.0v 364.755n 0.0v 369.745n 0.0v 369.755n 0.0v 374.745n 0.0v 374.755n 0.0v 379.745n 0.0v 379.755n 0.0v 384.745n 0.0v 384.755n 0.0v 389.745n 0.0v 389.755n 0.0v 394.745n 0.0v 394.755n 1.1v 399.745n 1.1v 399.755n 0.0v 404.745n 0.0v 404.755n 0.0v 409.745n 0.0v 409.755n 1.1v 414.745n 1.1v 414.755n 0.0v 419.745n 0.0v 419.755n 1.1v 424.745n 1.1v 424.755n 0.0v 429.745n 0.0v 429.755n 1.1v 434.745n 1.1v 434.755n 1.1v 439.745n 1.1v 439.755n 0.0v 444.745n 0.0v 444.755n 0.0v 449.745n 0.0v 449.755n 0.0v 454.745n 0.0v 454.755n 1.1v 459.745n 1.1v 459.755n 1.1v 464.745n 1.1v 464.755n 1.1v 469.745n 1.1v 469.755n 1.1v 474.745n 1.1v 474.755n 1.1v 479.745n 1.1v 479.755n 1.1v 484.745n 1.1v 484.755n 1.1v 489.745n 1.1v 489.755n 1.1v 494.745n 1.1v 494.755n 0.0v 499.745n 0.0v 499.755n 0.0v 504.745n 0.0v 504.755n 0.0v 509.745n 0.0v 509.755n 0.0v 514.745n 0.0v 514.755n 0.0v 519.745n 0.0v 519.755n 0.0v 524.745n 0.0v 524.755n 0.0v 529.745n 0.0v 529.755n 1.1v 534.745n 1.1v 534.755n 0.0v 539.745n 0.0v 539.755n 1.1v 544.745n 1.1v 544.755n 0.0v 549.745n 0.0v 549.755n 1.1v 554.745n 1.1v 554.755n 1.1v 559.745n 1.1v 559.755n 0.0v 564.745n 0.0v 564.755n 1.1v 569.745n 1.1v 569.755n 0.0v 574.745n 0.0v 574.755n 0.0v 579.745n 0.0v 579.755n 1.1v 584.745n 1.1v 584.755n 1.1v 589.745n 1.1v 589.755n 0.0v 594.745n 0.0v 594.755n 0.0v 599.745n 0.0v 599.755n 1.1v 604.745n 1.1v 604.755n 0.0v 609.745n 0.0v 609.755n 0.0v 614.745n 0.0v 614.755n 0.0v 619.745n 0.0v 619.755n 1.1v 624.745n 1.1v 624.755n 0.0v 629.745n 0.0v 629.755n 0.0v 634.745n 0.0v 634.755n 1.1v 639.745n 1.1v 639.755n 1.1v 644.745n 1.1v 644.755n 1.1v 649.745n 1.1v 649.755n 0.0v 654.745n 0.0v 654.755n 0.0v 659.745n 0.0v 659.755n 1.1v 664.745n 1.1v 664.755n 1.1v 669.745n 1.1v 669.755n 0.0v 674.745n 0.0v 674.755n 1.1v 679.745n 1.1v 679.755n 1.1v 684.745n 1.1v 684.755n 1.1v 689.745n 1.1v 689.755n 0.0v 694.745n 0.0v 694.755n 0.0v 699.745n 0.0v 699.755n 0.0v 704.745n 0.0v 704.755n 1.1v 709.745n 1.1v 709.755n 0.0v 714.745n 0.0v 714.755n 1.1v 719.745n 1.1v 719.755n 0.0v 724.745n 0.0v 724.755n 1.1v 729.745n 1.1v 729.755n 0.0v 734.745n 0.0v 734.755n 1.1v 739.745n 1.1v 739.755n 0.0v 744.745n 0.0v 744.755n 0.0v 749.745n 0.0v 749.755n 1.1v 754.745n 1.1v 754.755n 1.1v 759.745n 1.1v 759.755n 1.1v 764.745n 1.1v 764.755n 0.0v 769.745n 0.0v 769.755n 0.0v 774.745n 0.0v 774.755n 0.0v 779.745n 0.0v 779.755n 0.0v 784.745n 0.0v 784.755n 1.1v 789.745n 1.1v 789.755n 0.0v 794.745n 0.0v 794.755n 0.0v 799.745n 0.0v 799.755n 0.0v 804.745n 0.0v 804.755n 1.1v 809.745n 1.1v 809.755n 0.0v 814.745n 0.0v 814.755n 1.1v 819.745n 1.1v 819.755n 0.0v 824.745n 0.0v 824.755n 0.0v 829.745n 0.0v 829.755n 1.1v 834.745n 1.1v 834.755n 0.0v 839.745n 0.0v 839.755n 1.1v 844.745n 1.1v 844.755n 1.1v 849.745n 1.1v 849.755n 1.1v 854.745n 1.1v 854.755n 1.1v 859.745n 1.1v 859.755n 0.0v 864.745n 0.0v 864.755n 1.1v 869.745n 1.1v 869.755n 1.1v 874.745n 1.1v 874.755n 0.0v 879.745n 0.0v 879.755n 0.0v 884.745n 0.0v 884.755n 1.1v 889.745n 1.1v 889.755n 1.1v 894.745n 1.1v 894.755n 1.1v 899.745n 1.1v 899.755n 1.1v 904.745n 1.1v 904.755n 0.0v 909.745n 0.0v 909.755n 0.0v 914.745n 0.0v 914.755n 0.0v 919.745n 0.0v 919.755n 0.0v 924.745n 0.0v 924.755n 0.0v 929.745n 0.0v 929.755n 1.1v 934.745n 1.1v 934.755n 0.0v 939.745n 0.0v 939.755n 0.0v 944.745n 0.0v 944.755n 0.0v 949.745n 0.0v 949.755n 0.0v 954.745n 0.0v 954.755n 0.0v 959.745n 0.0v 959.755n 1.1v 964.745n 1.1v 964.755n 1.1v 969.745n 1.1v 969.755n 1.1v 974.745n 1.1v 974.755n 1.1v 979.745n 1.1v 979.755n 0.0v 984.745n 0.0v 984.755n 0.0v 989.745n 0.0v 989.755n 1.1v 994.745n 1.1v 994.755n 0.0v 999.745n 0.0v 999.755n 1.1v 1004.745n 1.1v 1004.755n 0.0v 1009.745n 0.0v 1009.755n 0.0v 1014.745n 0.0v 1014.755n 0.0v 1019.745n 0.0v 1019.755n 1.1v 1024.745n 1.1v 1024.755n 1.1v )
* (time, data): [(0, 0), (5, 0), (10, 1), (15, 0), (20, 1), (25, 0), (30, 1), (35, 1), (40, 1), (45, 0), (50, 1), (55, 1), (60, 1), (65, 1), (70, 0), (75, 0), (80, 1), (85, 0), (90, 0), (95, 1), (100, 1), (105, 1), (110, 1), (115, 0), (120, 0), (125, 0), (130, 0), (135, 0), (140, 0), (145, 0), (150, 0), (155, 0), (160, 0), (165, 0), (170, 1), (175, 0), (180, 0), (185, 0), (190, 0), (195, 1), (200, 0), (205, 0), (210, 1), (215, 0), (220, 0), (225, 1), (230, 0), (235, 1), (240, 1), (245, 1), (250, 1), (255, 0), (260, 1), (265, 1), (270, 1), (275, 1), (280, 0), (285, 1), (290, 0), (295, 1), (300, 1), (305, 0), (310, 0), (315, 1), (320, 1), (325, 1), (330, 1), (335, 1), (340, 0), (345, 0), (350, 1), (355, 1), (360, 0), (365, 0), (370, 0), (375, 0), (380, 0), (385, 0), (390, 0), (395, 1), (400, 0), (405, 0), (410, 1), (415, 0), (420, 1), (425, 0), (430, 1), (435, 1), (440, 0), (445, 0), (450, 0), (455, 1), (460, 1), (465, 1), (470, 1), (475, 1), (480, 1), (485, 1), (490, 1), (495, 0), (500, 0), (505, 0), (510, 0), (515, 0), (520, 0), (525, 0), (530, 1), (535, 0), (540, 1), (545, 0), (550, 1), (555, 1), (560, 0), (565, 1), (570, 0), (575, 0), (580, 1), (585, 1), (590, 0), (595, 0), (600, 1), (605, 0), (610, 0), (615, 0), (620, 1), (625, 0), (630, 0), (635, 1), (640, 1), (645, 1), (650, 0), (655, 0), (660, 1), (665, 1), (670, 0), (675, 1), (680, 1), (685, 1), (690, 0), (695, 0), (700, 0), (705, 1), (710, 0), (715, 1), (720, 0), (725, 1), (730, 0), (735, 1), (740, 0), (745, 0), (750, 1), (755, 1), (760, 1), (765, 0), (770, 0), (775, 0), (780, 0), (785, 1), (790, 0), (795, 0), (800, 0), (805, 1), (810, 0), (815, 1), (820, 0), (825, 0), (830, 1), (835, 0), (840, 1), (845, 1), (850, 1), (855, 1), (860, 0), (865, 1), (870, 1), (875, 0), (880, 0), (885, 1), (890, 1), (895, 1), (900, 1), (905, 0), (910, 0), (915, 0), (920, 0), (925, 0), (930, 1), (935, 0), (940, 0), (945, 0), (950, 0), (955, 0), (960, 1), (965, 1), (970, 1), (975, 1), (980, 0), (985, 0), (990, 1), (995, 0), (1000, 1), (1005, 0), (1010, 0), (1015, 0), (1020, 1), (1025, 1)]
Va0_8  a0_8  0 PWL (0n 0.0v 4.745n 0.0v 4.755n 0.0v 9.745n 0.0v 9.755n 1.1v 14.745n 1.1v 14.755n 0.0v 19.745n 0.0v 19.755n 1.1v 24.745n 1.1v 24.755n 0.0v 29.745n 0.0v 29.755n 1.1v 34.745n 1.1v 34.755n 1.1v 39.745n 1.1v 39.755n 1.1v 44.745n 1.1v 44.755n 0.0v 49.745n 0.0v 49.755n 1.1v 54.745n 1.1v 54.755n 1.1v 59.745n 1.1v 59.755n 1.1v 64.745n 1.1v 64.755n 1.1v 69.745n 1.1v 69.755n 0.0v 74.745n 0.0v 74.755n 0.0v 79.745n 0.0v 79.755n 1.1v 84.745n 1.1v 84.755n 0.0v 89.745n 0.0v 89.755n 0.0v 94.745n 0.0v 94.755n 1.1v 99.745n 1.1v 99.755n 1.1v 104.745n 1.1v 104.755n 1.1v 109.745n 1.1v 109.755n 1.1v 114.745n 1.1v 114.755n 0.0v 119.745n 0.0v 119.755n 0.0v 124.745n 0.0v 124.755n 0.0v 129.745n 0.0v 129.755n 0.0v 134.745n 0.0v 134.755n 0.0v 139.745n 0.0v 139.755n 0.0v 144.745n 0.0v 144.755n 0.0v 149.745n 0.0v 149.755n 0.0v 154.745n 0.0v 154.755n 0.0v 159.745n 0.0v 159.755n 0.0v 164.745n 0.0v 164.755n 0.0v 169.745n 0.0v 169.755n 1.1v 174.745n 1.1v 174.755n 0.0v 179.745n 0.0v 179.755n 0.0v 184.745n 0.0v 184.755n 0.0v 189.745n 0.0v 189.755n 0.0v 194.745n 0.0v 194.755n 1.1v 199.745n 1.1v 199.755n 0.0v 204.745n 0.0v 204.755n 0.0v 209.745n 0.0v 209.755n 1.1v 214.745n 1.1v 214.755n 0.0v 219.745n 0.0v 219.755n 0.0v 224.745n 0.0v 224.755n 1.1v 229.745n 1.1v 229.755n 0.0v 234.745n 0.0v 234.755n 1.1v 239.745n 1.1v 239.755n 1.1v 244.745n 1.1v 244.755n 1.1v 249.745n 1.1v 249.755n 1.1v 254.745n 1.1v 254.755n 0.0v 259.745n 0.0v 259.755n 1.1v 264.745n 1.1v 264.755n 1.1v 269.745n 1.1v 269.755n 1.1v 274.745n 1.1v 274.755n 1.1v 279.745n 1.1v 279.755n 0.0v 284.745n 0.0v 284.755n 1.1v 289.745n 1.1v 289.755n 0.0v 294.745n 0.0v 294.755n 1.1v 299.745n 1.1v 299.755n 1.1v 304.745n 1.1v 304.755n 0.0v 309.745n 0.0v 309.755n 0.0v 314.745n 0.0v 314.755n 1.1v 319.745n 1.1v 319.755n 1.1v 324.745n 1.1v 324.755n 1.1v 329.745n 1.1v 329.755n 1.1v 334.745n 1.1v 334.755n 1.1v 339.745n 1.1v 339.755n 0.0v 344.745n 0.0v 344.755n 0.0v 349.745n 0.0v 349.755n 1.1v 354.745n 1.1v 354.755n 1.1v 359.745n 1.1v 359.755n 0.0v 364.745n 0.0v 364.755n 0.0v 369.745n 0.0v 369.755n 0.0v 374.745n 0.0v 374.755n 0.0v 379.745n 0.0v 379.755n 0.0v 384.745n 0.0v 384.755n 0.0v 389.745n 0.0v 389.755n 0.0v 394.745n 0.0v 394.755n 1.1v 399.745n 1.1v 399.755n 0.0v 404.745n 0.0v 404.755n 0.0v 409.745n 0.0v 409.755n 1.1v 414.745n 1.1v 414.755n 0.0v 419.745n 0.0v 419.755n 1.1v 424.745n 1.1v 424.755n 0.0v 429.745n 0.0v 429.755n 1.1v 434.745n 1.1v 434.755n 1.1v 439.745n 1.1v 439.755n 0.0v 444.745n 0.0v 444.755n 0.0v 449.745n 0.0v 449.755n 0.0v 454.745n 0.0v 454.755n 1.1v 459.745n 1.1v 459.755n 1.1v 464.745n 1.1v 464.755n 1.1v 469.745n 1.1v 469.755n 1.1v 474.745n 1.1v 474.755n 1.1v 479.745n 1.1v 479.755n 1.1v 484.745n 1.1v 484.755n 1.1v 489.745n 1.1v 489.755n 1.1v 494.745n 1.1v 494.755n 0.0v 499.745n 0.0v 499.755n 0.0v 504.745n 0.0v 504.755n 0.0v 509.745n 0.0v 509.755n 0.0v 514.745n 0.0v 514.755n 0.0v 519.745n 0.0v 519.755n 0.0v 524.745n 0.0v 524.755n 0.0v 529.745n 0.0v 529.755n 1.1v 534.745n 1.1v 534.755n 0.0v 539.745n 0.0v 539.755n 1.1v 544.745n 1.1v 544.755n 0.0v 549.745n 0.0v 549.755n 1.1v 554.745n 1.1v 554.755n 1.1v 559.745n 1.1v 559.755n 0.0v 564.745n 0.0v 564.755n 1.1v 569.745n 1.1v 569.755n 0.0v 574.745n 0.0v 574.755n 0.0v 579.745n 0.0v 579.755n 1.1v 584.745n 1.1v 584.755n 1.1v 589.745n 1.1v 589.755n 0.0v 594.745n 0.0v 594.755n 0.0v 599.745n 0.0v 599.755n 1.1v 604.745n 1.1v 604.755n 0.0v 609.745n 0.0v 609.755n 0.0v 614.745n 0.0v 614.755n 0.0v 619.745n 0.0v 619.755n 1.1v 624.745n 1.1v 624.755n 0.0v 629.745n 0.0v 629.755n 0.0v 634.745n 0.0v 634.755n 1.1v 639.745n 1.1v 639.755n 1.1v 644.745n 1.1v 644.755n 1.1v 649.745n 1.1v 649.755n 0.0v 654.745n 0.0v 654.755n 0.0v 659.745n 0.0v 659.755n 1.1v 664.745n 1.1v 664.755n 1.1v 669.745n 1.1v 669.755n 0.0v 674.745n 0.0v 674.755n 1.1v 679.745n 1.1v 679.755n 1.1v 684.745n 1.1v 684.755n 1.1v 689.745n 1.1v 689.755n 0.0v 694.745n 0.0v 694.755n 0.0v 699.745n 0.0v 699.755n 0.0v 704.745n 0.0v 704.755n 1.1v 709.745n 1.1v 709.755n 0.0v 714.745n 0.0v 714.755n 1.1v 719.745n 1.1v 719.755n 0.0v 724.745n 0.0v 724.755n 1.1v 729.745n 1.1v 729.755n 0.0v 734.745n 0.0v 734.755n 1.1v 739.745n 1.1v 739.755n 0.0v 744.745n 0.0v 744.755n 0.0v 749.745n 0.0v 749.755n 1.1v 754.745n 1.1v 754.755n 1.1v 759.745n 1.1v 759.755n 1.1v 764.745n 1.1v 764.755n 0.0v 769.745n 0.0v 769.755n 0.0v 774.745n 0.0v 774.755n 0.0v 779.745n 0.0v 779.755n 0.0v 784.745n 0.0v 784.755n 1.1v 789.745n 1.1v 789.755n 0.0v 794.745n 0.0v 794.755n 0.0v 799.745n 0.0v 799.755n 0.0v 804.745n 0.0v 804.755n 1.1v 809.745n 1.1v 809.755n 0.0v 814.745n 0.0v 814.755n 1.1v 819.745n 1.1v 819.755n 0.0v 824.745n 0.0v 824.755n 0.0v 829.745n 0.0v 829.755n 1.1v 834.745n 1.1v 834.755n 0.0v 839.745n 0.0v 839.755n 1.1v 844.745n 1.1v 844.755n 1.1v 849.745n 1.1v 849.755n 1.1v 854.745n 1.1v 854.755n 1.1v 859.745n 1.1v 859.755n 0.0v 864.745n 0.0v 864.755n 1.1v 869.745n 1.1v 869.755n 1.1v 874.745n 1.1v 874.755n 0.0v 879.745n 0.0v 879.755n 0.0v 884.745n 0.0v 884.755n 1.1v 889.745n 1.1v 889.755n 1.1v 894.745n 1.1v 894.755n 1.1v 899.745n 1.1v 899.755n 1.1v 904.745n 1.1v 904.755n 0.0v 909.745n 0.0v 909.755n 0.0v 914.745n 0.0v 914.755n 0.0v 919.745n 0.0v 919.755n 0.0v 924.745n 0.0v 924.755n 0.0v 929.745n 0.0v 929.755n 1.1v 934.745n 1.1v 934.755n 0.0v 939.745n 0.0v 939.755n 0.0v 944.745n 0.0v 944.755n 0.0v 949.745n 0.0v 949.755n 0.0v 954.745n 0.0v 954.755n 0.0v 959.745n 0.0v 959.755n 1.1v 964.745n 1.1v 964.755n 1.1v 969.745n 1.1v 969.755n 1.1v 974.745n 1.1v 974.755n 1.1v 979.745n 1.1v 979.755n 0.0v 984.745n 0.0v 984.755n 0.0v 989.745n 0.0v 989.755n 1.1v 994.745n 1.1v 994.755n 0.0v 999.745n 0.0v 999.755n 1.1v 1004.745n 1.1v 1004.755n 0.0v 1009.745n 0.0v 1009.755n 0.0v 1014.745n 0.0v 1014.755n 0.0v 1019.745n 0.0v 1019.755n 1.1v 1024.745n 1.1v 1024.755n 1.1v )
* (time, data): [(0, 0), (5, 0), (10, 1), (15, 0), (20, 1), (25, 0), (30, 1), (35, 1), (40, 1), (45, 0), (50, 1), (55, 1), (60, 1), (65, 1), (70, 0), (75, 0), (80, 1), (85, 0), (90, 0), (95, 1), (100, 1), (105, 1), (110, 1), (115, 0), (120, 0), (125, 0), (130, 0), (135, 0), (140, 0), (145, 0), (150, 0), (155, 0), (160, 0), (165, 0), (170, 1), (175, 0), (180, 0), (185, 0), (190, 0), (195, 1), (200, 0), (205, 0), (210, 1), (215, 0), (220, 0), (225, 1), (230, 0), (235, 1), (240, 1), (245, 1), (250, 1), (255, 0), (260, 1), (265, 1), (270, 1), (275, 1), (280, 0), (285, 1), (290, 0), (295, 1), (300, 1), (305, 0), (310, 0), (315, 1), (320, 1), (325, 1), (330, 1), (335, 1), (340, 0), (345, 0), (350, 1), (355, 1), (360, 0), (365, 0), (370, 0), (375, 0), (380, 0), (385, 0), (390, 0), (395, 1), (400, 0), (405, 0), (410, 1), (415, 0), (420, 1), (425, 0), (430, 1), (435, 1), (440, 0), (445, 0), (450, 0), (455, 1), (460, 1), (465, 1), (470, 1), (475, 1), (480, 1), (485, 1), (490, 1), (495, 0), (500, 0), (505, 0), (510, 0), (515, 0), (520, 0), (525, 0), (530, 1), (535, 0), (540, 1), (545, 0), (550, 1), (555, 1), (560, 0), (565, 1), (570, 0), (575, 0), (580, 1), (585, 1), (590, 0), (595, 0), (600, 1), (605, 0), (610, 0), (615, 0), (620, 1), (625, 0), (630, 0), (635, 1), (640, 1), (645, 1), (650, 0), (655, 0), (660, 1), (665, 1), (670, 0), (675, 1), (680, 1), (685, 1), (690, 0), (695, 0), (700, 0), (705, 1), (710, 0), (715, 1), (720, 0), (725, 1), (730, 0), (735, 1), (740, 0), (745, 0), (750, 1), (755, 1), (760, 1), (765, 0), (770, 0), (775, 0), (780, 0), (785, 1), (790, 0), (795, 0), (800, 0), (805, 1), (810, 0), (815, 1), (820, 0), (825, 0), (830, 1), (835, 0), (840, 1), (845, 1), (850, 1), (855, 1), (860, 0), (865, 1), (870, 1), (875, 0), (880, 0), (885, 1), (890, 1), (895, 1), (900, 1), (905, 0), (910, 0), (915, 0), (920, 0), (925, 0), (930, 1), (935, 0), (940, 0), (945, 0), (950, 0), (955, 0), (960, 1), (965, 1), (970, 1), (975, 1), (980, 0), (985, 0), (990, 1), (995, 0), (1000, 1), (1005, 0), (1010, 0), (1015, 0), (1020, 1), (1025, 1)]
Va0_9  a0_9  0 PWL (0n 0.0v 4.745n 0.0v 4.755n 0.0v 9.745n 0.0v 9.755n 1.1v 14.745n 1.1v 14.755n 0.0v 19.745n 0.0v 19.755n 1.1v 24.745n 1.1v 24.755n 0.0v 29.745n 0.0v 29.755n 1.1v 34.745n 1.1v 34.755n 1.1v 39.745n 1.1v 39.755n 1.1v 44.745n 1.1v 44.755n 0.0v 49.745n 0.0v 49.755n 1.1v 54.745n 1.1v 54.755n 1.1v 59.745n 1.1v 59.755n 1.1v 64.745n 1.1v 64.755n 1.1v 69.745n 1.1v 69.755n 0.0v 74.745n 0.0v 74.755n 0.0v 79.745n 0.0v 79.755n 1.1v 84.745n 1.1v 84.755n 0.0v 89.745n 0.0v 89.755n 0.0v 94.745n 0.0v 94.755n 1.1v 99.745n 1.1v 99.755n 1.1v 104.745n 1.1v 104.755n 1.1v 109.745n 1.1v 109.755n 1.1v 114.745n 1.1v 114.755n 0.0v 119.745n 0.0v 119.755n 0.0v 124.745n 0.0v 124.755n 0.0v 129.745n 0.0v 129.755n 0.0v 134.745n 0.0v 134.755n 0.0v 139.745n 0.0v 139.755n 0.0v 144.745n 0.0v 144.755n 0.0v 149.745n 0.0v 149.755n 0.0v 154.745n 0.0v 154.755n 0.0v 159.745n 0.0v 159.755n 0.0v 164.745n 0.0v 164.755n 0.0v 169.745n 0.0v 169.755n 1.1v 174.745n 1.1v 174.755n 0.0v 179.745n 0.0v 179.755n 0.0v 184.745n 0.0v 184.755n 0.0v 189.745n 0.0v 189.755n 0.0v 194.745n 0.0v 194.755n 1.1v 199.745n 1.1v 199.755n 0.0v 204.745n 0.0v 204.755n 0.0v 209.745n 0.0v 209.755n 1.1v 214.745n 1.1v 214.755n 0.0v 219.745n 0.0v 219.755n 0.0v 224.745n 0.0v 224.755n 1.1v 229.745n 1.1v 229.755n 0.0v 234.745n 0.0v 234.755n 1.1v 239.745n 1.1v 239.755n 1.1v 244.745n 1.1v 244.755n 1.1v 249.745n 1.1v 249.755n 1.1v 254.745n 1.1v 254.755n 0.0v 259.745n 0.0v 259.755n 1.1v 264.745n 1.1v 264.755n 1.1v 269.745n 1.1v 269.755n 1.1v 274.745n 1.1v 274.755n 1.1v 279.745n 1.1v 279.755n 0.0v 284.745n 0.0v 284.755n 1.1v 289.745n 1.1v 289.755n 0.0v 294.745n 0.0v 294.755n 1.1v 299.745n 1.1v 299.755n 1.1v 304.745n 1.1v 304.755n 0.0v 309.745n 0.0v 309.755n 0.0v 314.745n 0.0v 314.755n 1.1v 319.745n 1.1v 319.755n 1.1v 324.745n 1.1v 324.755n 1.1v 329.745n 1.1v 329.755n 1.1v 334.745n 1.1v 334.755n 1.1v 339.745n 1.1v 339.755n 0.0v 344.745n 0.0v 344.755n 0.0v 349.745n 0.0v 349.755n 1.1v 354.745n 1.1v 354.755n 1.1v 359.745n 1.1v 359.755n 0.0v 364.745n 0.0v 364.755n 0.0v 369.745n 0.0v 369.755n 0.0v 374.745n 0.0v 374.755n 0.0v 379.745n 0.0v 379.755n 0.0v 384.745n 0.0v 384.755n 0.0v 389.745n 0.0v 389.755n 0.0v 394.745n 0.0v 394.755n 1.1v 399.745n 1.1v 399.755n 0.0v 404.745n 0.0v 404.755n 0.0v 409.745n 0.0v 409.755n 1.1v 414.745n 1.1v 414.755n 0.0v 419.745n 0.0v 419.755n 1.1v 424.745n 1.1v 424.755n 0.0v 429.745n 0.0v 429.755n 1.1v 434.745n 1.1v 434.755n 1.1v 439.745n 1.1v 439.755n 0.0v 444.745n 0.0v 444.755n 0.0v 449.745n 0.0v 449.755n 0.0v 454.745n 0.0v 454.755n 1.1v 459.745n 1.1v 459.755n 1.1v 464.745n 1.1v 464.755n 1.1v 469.745n 1.1v 469.755n 1.1v 474.745n 1.1v 474.755n 1.1v 479.745n 1.1v 479.755n 1.1v 484.745n 1.1v 484.755n 1.1v 489.745n 1.1v 489.755n 1.1v 494.745n 1.1v 494.755n 0.0v 499.745n 0.0v 499.755n 0.0v 504.745n 0.0v 504.755n 0.0v 509.745n 0.0v 509.755n 0.0v 514.745n 0.0v 514.755n 0.0v 519.745n 0.0v 519.755n 0.0v 524.745n 0.0v 524.755n 0.0v 529.745n 0.0v 529.755n 1.1v 534.745n 1.1v 534.755n 0.0v 539.745n 0.0v 539.755n 1.1v 544.745n 1.1v 544.755n 0.0v 549.745n 0.0v 549.755n 1.1v 554.745n 1.1v 554.755n 1.1v 559.745n 1.1v 559.755n 0.0v 564.745n 0.0v 564.755n 1.1v 569.745n 1.1v 569.755n 0.0v 574.745n 0.0v 574.755n 0.0v 579.745n 0.0v 579.755n 1.1v 584.745n 1.1v 584.755n 1.1v 589.745n 1.1v 589.755n 0.0v 594.745n 0.0v 594.755n 0.0v 599.745n 0.0v 599.755n 1.1v 604.745n 1.1v 604.755n 0.0v 609.745n 0.0v 609.755n 0.0v 614.745n 0.0v 614.755n 0.0v 619.745n 0.0v 619.755n 1.1v 624.745n 1.1v 624.755n 0.0v 629.745n 0.0v 629.755n 0.0v 634.745n 0.0v 634.755n 1.1v 639.745n 1.1v 639.755n 1.1v 644.745n 1.1v 644.755n 1.1v 649.745n 1.1v 649.755n 0.0v 654.745n 0.0v 654.755n 0.0v 659.745n 0.0v 659.755n 1.1v 664.745n 1.1v 664.755n 1.1v 669.745n 1.1v 669.755n 0.0v 674.745n 0.0v 674.755n 1.1v 679.745n 1.1v 679.755n 1.1v 684.745n 1.1v 684.755n 1.1v 689.745n 1.1v 689.755n 0.0v 694.745n 0.0v 694.755n 0.0v 699.745n 0.0v 699.755n 0.0v 704.745n 0.0v 704.755n 1.1v 709.745n 1.1v 709.755n 0.0v 714.745n 0.0v 714.755n 1.1v 719.745n 1.1v 719.755n 0.0v 724.745n 0.0v 724.755n 1.1v 729.745n 1.1v 729.755n 0.0v 734.745n 0.0v 734.755n 1.1v 739.745n 1.1v 739.755n 0.0v 744.745n 0.0v 744.755n 0.0v 749.745n 0.0v 749.755n 1.1v 754.745n 1.1v 754.755n 1.1v 759.745n 1.1v 759.755n 1.1v 764.745n 1.1v 764.755n 0.0v 769.745n 0.0v 769.755n 0.0v 774.745n 0.0v 774.755n 0.0v 779.745n 0.0v 779.755n 0.0v 784.745n 0.0v 784.755n 1.1v 789.745n 1.1v 789.755n 0.0v 794.745n 0.0v 794.755n 0.0v 799.745n 0.0v 799.755n 0.0v 804.745n 0.0v 804.755n 1.1v 809.745n 1.1v 809.755n 0.0v 814.745n 0.0v 814.755n 1.1v 819.745n 1.1v 819.755n 0.0v 824.745n 0.0v 824.755n 0.0v 829.745n 0.0v 829.755n 1.1v 834.745n 1.1v 834.755n 0.0v 839.745n 0.0v 839.755n 1.1v 844.745n 1.1v 844.755n 1.1v 849.745n 1.1v 849.755n 1.1v 854.745n 1.1v 854.755n 1.1v 859.745n 1.1v 859.755n 0.0v 864.745n 0.0v 864.755n 1.1v 869.745n 1.1v 869.755n 1.1v 874.745n 1.1v 874.755n 0.0v 879.745n 0.0v 879.755n 0.0v 884.745n 0.0v 884.755n 1.1v 889.745n 1.1v 889.755n 1.1v 894.745n 1.1v 894.755n 1.1v 899.745n 1.1v 899.755n 1.1v 904.745n 1.1v 904.755n 0.0v 909.745n 0.0v 909.755n 0.0v 914.745n 0.0v 914.755n 0.0v 919.745n 0.0v 919.755n 0.0v 924.745n 0.0v 924.755n 0.0v 929.745n 0.0v 929.755n 1.1v 934.745n 1.1v 934.755n 0.0v 939.745n 0.0v 939.755n 0.0v 944.745n 0.0v 944.755n 0.0v 949.745n 0.0v 949.755n 0.0v 954.745n 0.0v 954.755n 0.0v 959.745n 0.0v 959.755n 1.1v 964.745n 1.1v 964.755n 1.1v 969.745n 1.1v 969.755n 1.1v 974.745n 1.1v 974.755n 1.1v 979.745n 1.1v 979.755n 0.0v 984.745n 0.0v 984.755n 0.0v 989.745n 0.0v 989.755n 1.1v 994.745n 1.1v 994.755n 0.0v 999.745n 0.0v 999.755n 1.1v 1004.745n 1.1v 1004.755n 0.0v 1009.745n 0.0v 1009.755n 0.0v 1014.745n 0.0v 1014.755n 0.0v 1019.745n 0.0v 1019.755n 1.1v 1024.745n 1.1v 1024.755n 1.1v )
* (time, data): [(0, 0), (5, 0), (10, 1), (15, 0), (20, 1), (25, 0), (30, 1), (35, 1), (40, 1), (45, 0), (50, 1), (55, 1), (60, 1), (65, 1), (70, 0), (75, 0), (80, 1), (85, 0), (90, 0), (95, 1), (100, 1), (105, 1), (110, 1), (115, 0), (120, 0), (125, 0), (130, 0), (135, 0), (140, 0), (145, 0), (150, 0), (155, 0), (160, 0), (165, 0), (170, 1), (175, 0), (180, 0), (185, 0), (190, 0), (195, 1), (200, 0), (205, 0), (210, 1), (215, 0), (220, 0), (225, 1), (230, 0), (235, 1), (240, 1), (245, 1), (250, 1), (255, 0), (260, 1), (265, 1), (270, 1), (275, 1), (280, 0), (285, 1), (290, 0), (295, 1), (300, 1), (305, 0), (310, 0), (315, 1), (320, 1), (325, 1), (330, 1), (335, 1), (340, 0), (345, 0), (350, 1), (355, 1), (360, 0), (365, 0), (370, 0), (375, 0), (380, 0), (385, 0), (390, 0), (395, 1), (400, 0), (405, 0), (410, 1), (415, 0), (420, 1), (425, 0), (430, 1), (435, 1), (440, 0), (445, 0), (450, 0), (455, 1), (460, 1), (465, 1), (470, 1), (475, 1), (480, 1), (485, 1), (490, 1), (495, 0), (500, 0), (505, 0), (510, 0), (515, 0), (520, 0), (525, 0), (530, 1), (535, 0), (540, 1), (545, 0), (550, 1), (555, 1), (560, 0), (565, 1), (570, 0), (575, 0), (580, 1), (585, 1), (590, 0), (595, 0), (600, 1), (605, 0), (610, 0), (615, 0), (620, 1), (625, 0), (630, 0), (635, 1), (640, 1), (645, 1), (650, 0), (655, 0), (660, 1), (665, 1), (670, 0), (675, 1), (680, 1), (685, 1), (690, 0), (695, 0), (700, 0), (705, 1), (710, 0), (715, 1), (720, 0), (725, 1), (730, 0), (735, 1), (740, 0), (745, 0), (750, 1), (755, 1), (760, 1), (765, 0), (770, 0), (775, 0), (780, 0), (785, 1), (790, 0), (795, 0), (800, 0), (805, 1), (810, 0), (815, 1), (820, 0), (825, 0), (830, 1), (835, 0), (840, 1), (845, 1), (850, 1), (855, 1), (860, 0), (865, 1), (870, 1), (875, 0), (880, 0), (885, 1), (890, 1), (895, 1), (900, 1), (905, 0), (910, 0), (915, 0), (920, 0), (925, 0), (930, 1), (935, 0), (940, 0), (945, 0), (950, 0), (955, 0), (960, 1), (965, 1), (970, 1), (975, 1), (980, 0), (985, 0), (990, 1), (995, 0), (1000, 1), (1005, 0), (1010, 0), (1015, 0), (1020, 1), (1025, 1)]
Va0_10  a0_10  0 PWL (0n 0.0v 4.745n 0.0v 4.755n 0.0v 9.745n 0.0v 9.755n 1.1v 14.745n 1.1v 14.755n 0.0v 19.745n 0.0v 19.755n 1.1v 24.745n 1.1v 24.755n 0.0v 29.745n 0.0v 29.755n 1.1v 34.745n 1.1v 34.755n 1.1v 39.745n 1.1v 39.755n 1.1v 44.745n 1.1v 44.755n 0.0v 49.745n 0.0v 49.755n 1.1v 54.745n 1.1v 54.755n 1.1v 59.745n 1.1v 59.755n 1.1v 64.745n 1.1v 64.755n 1.1v 69.745n 1.1v 69.755n 0.0v 74.745n 0.0v 74.755n 0.0v 79.745n 0.0v 79.755n 1.1v 84.745n 1.1v 84.755n 0.0v 89.745n 0.0v 89.755n 0.0v 94.745n 0.0v 94.755n 1.1v 99.745n 1.1v 99.755n 1.1v 104.745n 1.1v 104.755n 1.1v 109.745n 1.1v 109.755n 1.1v 114.745n 1.1v 114.755n 0.0v 119.745n 0.0v 119.755n 0.0v 124.745n 0.0v 124.755n 0.0v 129.745n 0.0v 129.755n 0.0v 134.745n 0.0v 134.755n 0.0v 139.745n 0.0v 139.755n 0.0v 144.745n 0.0v 144.755n 0.0v 149.745n 0.0v 149.755n 0.0v 154.745n 0.0v 154.755n 0.0v 159.745n 0.0v 159.755n 0.0v 164.745n 0.0v 164.755n 0.0v 169.745n 0.0v 169.755n 1.1v 174.745n 1.1v 174.755n 0.0v 179.745n 0.0v 179.755n 0.0v 184.745n 0.0v 184.755n 0.0v 189.745n 0.0v 189.755n 0.0v 194.745n 0.0v 194.755n 1.1v 199.745n 1.1v 199.755n 0.0v 204.745n 0.0v 204.755n 0.0v 209.745n 0.0v 209.755n 1.1v 214.745n 1.1v 214.755n 0.0v 219.745n 0.0v 219.755n 0.0v 224.745n 0.0v 224.755n 1.1v 229.745n 1.1v 229.755n 0.0v 234.745n 0.0v 234.755n 1.1v 239.745n 1.1v 239.755n 1.1v 244.745n 1.1v 244.755n 1.1v 249.745n 1.1v 249.755n 1.1v 254.745n 1.1v 254.755n 0.0v 259.745n 0.0v 259.755n 1.1v 264.745n 1.1v 264.755n 1.1v 269.745n 1.1v 269.755n 1.1v 274.745n 1.1v 274.755n 1.1v 279.745n 1.1v 279.755n 0.0v 284.745n 0.0v 284.755n 1.1v 289.745n 1.1v 289.755n 0.0v 294.745n 0.0v 294.755n 1.1v 299.745n 1.1v 299.755n 1.1v 304.745n 1.1v 304.755n 0.0v 309.745n 0.0v 309.755n 0.0v 314.745n 0.0v 314.755n 1.1v 319.745n 1.1v 319.755n 1.1v 324.745n 1.1v 324.755n 1.1v 329.745n 1.1v 329.755n 1.1v 334.745n 1.1v 334.755n 1.1v 339.745n 1.1v 339.755n 0.0v 344.745n 0.0v 344.755n 0.0v 349.745n 0.0v 349.755n 1.1v 354.745n 1.1v 354.755n 1.1v 359.745n 1.1v 359.755n 0.0v 364.745n 0.0v 364.755n 0.0v 369.745n 0.0v 369.755n 0.0v 374.745n 0.0v 374.755n 0.0v 379.745n 0.0v 379.755n 0.0v 384.745n 0.0v 384.755n 0.0v 389.745n 0.0v 389.755n 0.0v 394.745n 0.0v 394.755n 1.1v 399.745n 1.1v 399.755n 0.0v 404.745n 0.0v 404.755n 0.0v 409.745n 0.0v 409.755n 1.1v 414.745n 1.1v 414.755n 0.0v 419.745n 0.0v 419.755n 1.1v 424.745n 1.1v 424.755n 0.0v 429.745n 0.0v 429.755n 1.1v 434.745n 1.1v 434.755n 1.1v 439.745n 1.1v 439.755n 0.0v 444.745n 0.0v 444.755n 0.0v 449.745n 0.0v 449.755n 0.0v 454.745n 0.0v 454.755n 1.1v 459.745n 1.1v 459.755n 1.1v 464.745n 1.1v 464.755n 1.1v 469.745n 1.1v 469.755n 1.1v 474.745n 1.1v 474.755n 1.1v 479.745n 1.1v 479.755n 1.1v 484.745n 1.1v 484.755n 1.1v 489.745n 1.1v 489.755n 1.1v 494.745n 1.1v 494.755n 0.0v 499.745n 0.0v 499.755n 0.0v 504.745n 0.0v 504.755n 0.0v 509.745n 0.0v 509.755n 0.0v 514.745n 0.0v 514.755n 0.0v 519.745n 0.0v 519.755n 0.0v 524.745n 0.0v 524.755n 0.0v 529.745n 0.0v 529.755n 1.1v 534.745n 1.1v 534.755n 0.0v 539.745n 0.0v 539.755n 1.1v 544.745n 1.1v 544.755n 0.0v 549.745n 0.0v 549.755n 1.1v 554.745n 1.1v 554.755n 1.1v 559.745n 1.1v 559.755n 0.0v 564.745n 0.0v 564.755n 1.1v 569.745n 1.1v 569.755n 0.0v 574.745n 0.0v 574.755n 0.0v 579.745n 0.0v 579.755n 1.1v 584.745n 1.1v 584.755n 1.1v 589.745n 1.1v 589.755n 0.0v 594.745n 0.0v 594.755n 0.0v 599.745n 0.0v 599.755n 1.1v 604.745n 1.1v 604.755n 0.0v 609.745n 0.0v 609.755n 0.0v 614.745n 0.0v 614.755n 0.0v 619.745n 0.0v 619.755n 1.1v 624.745n 1.1v 624.755n 0.0v 629.745n 0.0v 629.755n 0.0v 634.745n 0.0v 634.755n 1.1v 639.745n 1.1v 639.755n 1.1v 644.745n 1.1v 644.755n 1.1v 649.745n 1.1v 649.755n 0.0v 654.745n 0.0v 654.755n 0.0v 659.745n 0.0v 659.755n 1.1v 664.745n 1.1v 664.755n 1.1v 669.745n 1.1v 669.755n 0.0v 674.745n 0.0v 674.755n 1.1v 679.745n 1.1v 679.755n 1.1v 684.745n 1.1v 684.755n 1.1v 689.745n 1.1v 689.755n 0.0v 694.745n 0.0v 694.755n 0.0v 699.745n 0.0v 699.755n 0.0v 704.745n 0.0v 704.755n 1.1v 709.745n 1.1v 709.755n 0.0v 714.745n 0.0v 714.755n 1.1v 719.745n 1.1v 719.755n 0.0v 724.745n 0.0v 724.755n 1.1v 729.745n 1.1v 729.755n 0.0v 734.745n 0.0v 734.755n 1.1v 739.745n 1.1v 739.755n 0.0v 744.745n 0.0v 744.755n 0.0v 749.745n 0.0v 749.755n 1.1v 754.745n 1.1v 754.755n 1.1v 759.745n 1.1v 759.755n 1.1v 764.745n 1.1v 764.755n 0.0v 769.745n 0.0v 769.755n 0.0v 774.745n 0.0v 774.755n 0.0v 779.745n 0.0v 779.755n 0.0v 784.745n 0.0v 784.755n 1.1v 789.745n 1.1v 789.755n 0.0v 794.745n 0.0v 794.755n 0.0v 799.745n 0.0v 799.755n 0.0v 804.745n 0.0v 804.755n 1.1v 809.745n 1.1v 809.755n 0.0v 814.745n 0.0v 814.755n 1.1v 819.745n 1.1v 819.755n 0.0v 824.745n 0.0v 824.755n 0.0v 829.745n 0.0v 829.755n 1.1v 834.745n 1.1v 834.755n 0.0v 839.745n 0.0v 839.755n 1.1v 844.745n 1.1v 844.755n 1.1v 849.745n 1.1v 849.755n 1.1v 854.745n 1.1v 854.755n 1.1v 859.745n 1.1v 859.755n 0.0v 864.745n 0.0v 864.755n 1.1v 869.745n 1.1v 869.755n 1.1v 874.745n 1.1v 874.755n 0.0v 879.745n 0.0v 879.755n 0.0v 884.745n 0.0v 884.755n 1.1v 889.745n 1.1v 889.755n 1.1v 894.745n 1.1v 894.755n 1.1v 899.745n 1.1v 899.755n 1.1v 904.745n 1.1v 904.755n 0.0v 909.745n 0.0v 909.755n 0.0v 914.745n 0.0v 914.755n 0.0v 919.745n 0.0v 919.755n 0.0v 924.745n 0.0v 924.755n 0.0v 929.745n 0.0v 929.755n 1.1v 934.745n 1.1v 934.755n 0.0v 939.745n 0.0v 939.755n 0.0v 944.745n 0.0v 944.755n 0.0v 949.745n 0.0v 949.755n 0.0v 954.745n 0.0v 954.755n 0.0v 959.745n 0.0v 959.755n 1.1v 964.745n 1.1v 964.755n 1.1v 969.745n 1.1v 969.755n 1.1v 974.745n 1.1v 974.755n 1.1v 979.745n 1.1v 979.755n 0.0v 984.745n 0.0v 984.755n 0.0v 989.745n 0.0v 989.755n 1.1v 994.745n 1.1v 994.755n 0.0v 999.745n 0.0v 999.755n 1.1v 1004.745n 1.1v 1004.755n 0.0v 1009.745n 0.0v 1009.755n 0.0v 1014.745n 0.0v 1014.755n 0.0v 1019.745n 0.0v 1019.755n 1.1v 1024.745n 1.1v 1024.755n 1.1v )

 * Generation of control signals
* (time, data): [(0, 1), (5, 0), (10, 0), (15, 0), (20, 0), (25, 0), (30, 0), (35, 0), (40, 0), (45, 0), (50, 0), (55, 0), (60, 1), (65, 1), (70, 0), (75, 0), (80, 0), (85, 0), (90, 0), (95, 0), (100, 0), (105, 1), (110, 0), (115, 0), (120, 0), (125, 0), (130, 1), (135, 0), (140, 0), (145, 1), (150, 0), (155, 1), (160, 0), (165, 0), (170, 0), (175, 0), (180, 0), (185, 1), (190, 0), (195, 0), (200, 0), (205, 0), (210, 0), (215, 0), (220, 1), (225, 0), (230, 0), (235, 0), (240, 0), (245, 1), (250, 0), (255, 0), (260, 0), (265, 1), (270, 0), (275, 1), (280, 0), (285, 0), (290, 0), (295, 0), (300, 0), (305, 0), (310, 0), (315, 0), (320, 0), (325, 0), (330, 1), (335, 1), (340, 0), (345, 1), (350, 0), (355, 0), (360, 0), (365, 0), (370, 0), (375, 1), (380, 0), (385, 0), (390, 0), (395, 0), (400, 0), (405, 1), (410, 0), (415, 0), (420, 0), (425, 0), (430, 0), (435, 0), (440, 0), (445, 1), (450, 0), (455, 0), (460, 0), (465, 0), (470, 1), (475, 0), (480, 0), (485, 0), (490, 1), (495, 0), (500, 0), (505, 0), (510, 1), (515, 0), (520, 1), (525, 0), (530, 0), (535, 0), (540, 0), (545, 0), (550, 0), (555, 0), (560, 0), (565, 0), (570, 0), (575, 1), (580, 0), (585, 0), (590, 0), (595, 0), (600, 0), (605, 0), (610, 1), (615, 1), (620, 0), (625, 0), (630, 0), (635, 0), (640, 0), (645, 1), (650, 0), (655, 0), (660, 0), (665, 1), (670, 0), (675, 0), (680, 1), (685, 1), (690, 0), (695, 0), (700, 0), (705, 0), (710, 0), (715, 0), (720, 0), (725, 0), (730, 0), (735, 0), (740, 0), (745, 0), (750, 0), (755, 0), (760, 0), (765, 0), (770, 0), (775, 0), (780, 1), (785, 0), (790, 0), (795, 1), (800, 0), (805, 0), (810, 0), (815, 0), (820, 0), (825, 0), (830, 0), (835, 0), (840, 0), (845, 0), (850, 1), (855, 0), (860, 0), (865, 0), (870, 0), (875, 0), (880, 0), (885, 0), (890, 0), (895, 0), (900, 0), (905, 0), (910, 1), (915, 0), (920, 1), (925, 1), (930, 0), (935, 0), (940, 1), (945, 0), (950, 0), (955, 1), (960, 0), (965, 0), (970, 0), (975, 1), (980, 0), (985, 0), (990, 0), (995, 0), (1000, 0), (1005, 0), (1010, 0), (1015, 0), (1020, 0), (1025, 1)]
VCSB0 CSB0 0 PWL (0n 1.1v 4.745n 1.1v 4.755n 0.0v 9.745n 0.0v 9.755n 0.0v 14.745n 0.0v 14.755n 0.0v 19.745n 0.0v 19.755n 0.0v 24.745n 0.0v 24.755n 0.0v 29.745n 0.0v 29.755n 0.0v 34.745n 0.0v 34.755n 0.0v 39.745n 0.0v 39.755n 0.0v 44.745n 0.0v 44.755n 0.0v 49.745n 0.0v 49.755n 0.0v 54.745n 0.0v 54.755n 0.0v 59.745n 0.0v 59.755n 1.1v 64.745n 1.1v 64.755n 1.1v 69.745n 1.1v 69.755n 0.0v 74.745n 0.0v 74.755n 0.0v 79.745n 0.0v 79.755n 0.0v 84.745n 0.0v 84.755n 0.0v 89.745n 0.0v 89.755n 0.0v 94.745n 0.0v 94.755n 0.0v 99.745n 0.0v 99.755n 0.0v 104.745n 0.0v 104.755n 1.1v 109.745n 1.1v 109.755n 0.0v 114.745n 0.0v 114.755n 0.0v 119.745n 0.0v 119.755n 0.0v 124.745n 0.0v 124.755n 0.0v 129.745n 0.0v 129.755n 1.1v 134.745n 1.1v 134.755n 0.0v 139.745n 0.0v 139.755n 0.0v 144.745n 0.0v 144.755n 1.1v 149.745n 1.1v 149.755n 0.0v 154.745n 0.0v 154.755n 1.1v 159.745n 1.1v 159.755n 0.0v 164.745n 0.0v 164.755n 0.0v 169.745n 0.0v 169.755n 0.0v 174.745n 0.0v 174.755n 0.0v 179.745n 0.0v 179.755n 0.0v 184.745n 0.0v 184.755n 1.1v 189.745n 1.1v 189.755n 0.0v 194.745n 0.0v 194.755n 0.0v 199.745n 0.0v 199.755n 0.0v 204.745n 0.0v 204.755n 0.0v 209.745n 0.0v 209.755n 0.0v 214.745n 0.0v 214.755n 0.0v 219.745n 0.0v 219.755n 1.1v 224.745n 1.1v 224.755n 0.0v 229.745n 0.0v 229.755n 0.0v 234.745n 0.0v 234.755n 0.0v 239.745n 0.0v 239.755n 0.0v 244.745n 0.0v 244.755n 1.1v 249.745n 1.1v 249.755n 0.0v 254.745n 0.0v 254.755n 0.0v 259.745n 0.0v 259.755n 0.0v 264.745n 0.0v 264.755n 1.1v 269.745n 1.1v 269.755n 0.0v 274.745n 0.0v 274.755n 1.1v 279.745n 1.1v 279.755n 0.0v 284.745n 0.0v 284.755n 0.0v 289.745n 0.0v 289.755n 0.0v 294.745n 0.0v 294.755n 0.0v 299.745n 0.0v 299.755n 0.0v 304.745n 0.0v 304.755n 0.0v 309.745n 0.0v 309.755n 0.0v 314.745n 0.0v 314.755n 0.0v 319.745n 0.0v 319.755n 0.0v 324.745n 0.0v 324.755n 0.0v 329.745n 0.0v 329.755n 1.1v 334.745n 1.1v 334.755n 1.1v 339.745n 1.1v 339.755n 0.0v 344.745n 0.0v 344.755n 1.1v 349.745n 1.1v 349.755n 0.0v 354.745n 0.0v 354.755n 0.0v 359.745n 0.0v 359.755n 0.0v 364.745n 0.0v 364.755n 0.0v 369.745n 0.0v 369.755n 0.0v 374.745n 0.0v 374.755n 1.1v 379.745n 1.1v 379.755n 0.0v 384.745n 0.0v 384.755n 0.0v 389.745n 0.0v 389.755n 0.0v 394.745n 0.0v 394.755n 0.0v 399.745n 0.0v 399.755n 0.0v 404.745n 0.0v 404.755n 1.1v 409.745n 1.1v 409.755n 0.0v 414.745n 0.0v 414.755n 0.0v 419.745n 0.0v 419.755n 0.0v 424.745n 0.0v 424.755n 0.0v 429.745n 0.0v 429.755n 0.0v 434.745n 0.0v 434.755n 0.0v 439.745n 0.0v 439.755n 0.0v 444.745n 0.0v 444.755n 1.1v 449.745n 1.1v 449.755n 0.0v 454.745n 0.0v 454.755n 0.0v 459.745n 0.0v 459.755n 0.0v 464.745n 0.0v 464.755n 0.0v 469.745n 0.0v 469.755n 1.1v 474.745n 1.1v 474.755n 0.0v 479.745n 0.0v 479.755n 0.0v 484.745n 0.0v 484.755n 0.0v 489.745n 0.0v 489.755n 1.1v 494.745n 1.1v 494.755n 0.0v 499.745n 0.0v 499.755n 0.0v 504.745n 0.0v 504.755n 0.0v 509.745n 0.0v 509.755n 1.1v 514.745n 1.1v 514.755n 0.0v 519.745n 0.0v 519.755n 1.1v 524.745n 1.1v 524.755n 0.0v 529.745n 0.0v 529.755n 0.0v 534.745n 0.0v 534.755n 0.0v 539.745n 0.0v 539.755n 0.0v 544.745n 0.0v 544.755n 0.0v 549.745n 0.0v 549.755n 0.0v 554.745n 0.0v 554.755n 0.0v 559.745n 0.0v 559.755n 0.0v 564.745n 0.0v 564.755n 0.0v 569.745n 0.0v 569.755n 0.0v 574.745n 0.0v 574.755n 1.1v 579.745n 1.1v 579.755n 0.0v 584.745n 0.0v 584.755n 0.0v 589.745n 0.0v 589.755n 0.0v 594.745n 0.0v 594.755n 0.0v 599.745n 0.0v 599.755n 0.0v 604.745n 0.0v 604.755n 0.0v 609.745n 0.0v 609.755n 1.1v 614.745n 1.1v 614.755n 1.1v 619.745n 1.1v 619.755n 0.0v 624.745n 0.0v 624.755n 0.0v 629.745n 0.0v 629.755n 0.0v 634.745n 0.0v 634.755n 0.0v 639.745n 0.0v 639.755n 0.0v 644.745n 0.0v 644.755n 1.1v 649.745n 1.1v 649.755n 0.0v 654.745n 0.0v 654.755n 0.0v 659.745n 0.0v 659.755n 0.0v 664.745n 0.0v 664.755n 1.1v 669.745n 1.1v 669.755n 0.0v 674.745n 0.0v 674.755n 0.0v 679.745n 0.0v 679.755n 1.1v 684.745n 1.1v 684.755n 1.1v 689.745n 1.1v 689.755n 0.0v 694.745n 0.0v 694.755n 0.0v 699.745n 0.0v 699.755n 0.0v 704.745n 0.0v 704.755n 0.0v 709.745n 0.0v 709.755n 0.0v 714.745n 0.0v 714.755n 0.0v 719.745n 0.0v 719.755n 0.0v 724.745n 0.0v 724.755n 0.0v 729.745n 0.0v 729.755n 0.0v 734.745n 0.0v 734.755n 0.0v 739.745n 0.0v 739.755n 0.0v 744.745n 0.0v 744.755n 0.0v 749.745n 0.0v 749.755n 0.0v 754.745n 0.0v 754.755n 0.0v 759.745n 0.0v 759.755n 0.0v 764.745n 0.0v 764.755n 0.0v 769.745n 0.0v 769.755n 0.0v 774.745n 0.0v 774.755n 0.0v 779.745n 0.0v 779.755n 1.1v 784.745n 1.1v 784.755n 0.0v 789.745n 0.0v 789.755n 0.0v 794.745n 0.0v 794.755n 1.1v 799.745n 1.1v 799.755n 0.0v 804.745n 0.0v 804.755n 0.0v 809.745n 0.0v 809.755n 0.0v 814.745n 0.0v 814.755n 0.0v 819.745n 0.0v 819.755n 0.0v 824.745n 0.0v 824.755n 0.0v 829.745n 0.0v 829.755n 0.0v 834.745n 0.0v 834.755n 0.0v 839.745n 0.0v 839.755n 0.0v 844.745n 0.0v 844.755n 0.0v 849.745n 0.0v 849.755n 1.1v 854.745n 1.1v 854.755n 0.0v 859.745n 0.0v 859.755n 0.0v 864.745n 0.0v 864.755n 0.0v 869.745n 0.0v 869.755n 0.0v 874.745n 0.0v 874.755n 0.0v 879.745n 0.0v 879.755n 0.0v 884.745n 0.0v 884.755n 0.0v 889.745n 0.0v 889.755n 0.0v 894.745n 0.0v 894.755n 0.0v 899.745n 0.0v 899.755n 0.0v 904.745n 0.0v 904.755n 0.0v 909.745n 0.0v 909.755n 1.1v 914.745n 1.1v 914.755n 0.0v 919.745n 0.0v 919.755n 1.1v 924.745n 1.1v 924.755n 1.1v 929.745n 1.1v 929.755n 0.0v 934.745n 0.0v 934.755n 0.0v 939.745n 0.0v 939.755n 1.1v 944.745n 1.1v 944.755n 0.0v 949.745n 0.0v 949.755n 0.0v 954.745n 0.0v 954.755n 1.1v 959.745n 1.1v 959.755n 0.0v 964.745n 0.0v 964.755n 0.0v 969.745n 0.0v 969.755n 0.0v 974.745n 0.0v 974.755n 1.1v 979.745n 1.1v 979.755n 0.0v 984.745n 0.0v 984.755n 0.0v 989.745n 0.0v 989.755n 0.0v 994.745n 0.0v 994.755n 0.0v 999.745n 0.0v 999.755n 0.0v 1004.745n 0.0v 1004.755n 0.0v 1009.745n 0.0v 1009.755n 0.0v 1014.745n 0.0v 1014.755n 0.0v 1019.745n 0.0v 1019.755n 0.0v 1024.745n 0.0v 1024.755n 1.1v )
* (time, data): [(0, 1), (5, 0), (10, 0), (15, 0), (20, 1), (25, 1), (30, 1), (35, 0), (40, 1), (45, 0), (50, 0), (55, 0), (60, 1), (65, 1), (70, 1), (75, 0), (80, 0), (85, 1), (90, 1), (95, 1), (100, 1), (105, 1), (110, 1), (115, 0), (120, 1), (125, 1), (130, 1), (135, 0), (140, 0), (145, 1), (150, 0), (155, 1), (160, 1), (165, 0), (170, 1), (175, 0), (180, 0), (185, 1), (190, 1), (195, 0), (200, 1), (205, 1), (210, 0), (215, 0), (220, 1), (225, 1), (230, 0), (235, 1), (240, 1), (245, 1), (250, 1), (255, 1), (260, 0), (265, 1), (270, 0), (275, 1), (280, 1), (285, 1), (290, 1), (295, 0), (300, 1), (305, 1), (310, 1), (315, 0), (320, 0), (325, 0), (330, 1), (335, 1), (340, 1), (345, 1), (350, 0), (355, 1), (360, 0), (365, 0), (370, 0), (375, 1), (380, 0), (385, 1), (390, 1), (395, 1), (400, 0), (405, 1), (410, 0), (415, 1), (420, 1), (425, 1), (430, 1), (435, 0), (440, 0), (445, 1), (450, 1), (455, 0), (460, 0), (465, 1), (470, 1), (475, 0), (480, 1), (485, 0), (490, 1), (495, 0), (500, 1), (505, 0), (510, 1), (515, 0), (520, 1), (525, 1), (530, 1), (535, 1), (540, 0), (545, 0), (550, 0), (555, 0), (560, 1), (565, 1), (570, 1), (575, 1), (580, 0), (585, 0), (590, 1), (595, 0), (600, 1), (605, 0), (610, 1), (615, 1), (620, 0), (625, 1), (630, 0), (635, 0), (640, 0), (645, 1), (650, 0), (655, 1), (660, 1), (665, 1), (670, 1), (675, 1), (680, 1), (685, 1), (690, 1), (695, 1), (700, 0), (705, 0), (710, 1), (715, 1), (720, 0), (725, 1), (730, 0), (735, 1), (740, 1), (745, 1), (750, 1), (755, 0), (760, 1), (765, 0), (770, 1), (775, 1), (780, 1), (785, 0), (790, 1), (795, 1), (800, 1), (805, 0), (810, 1), (815, 0), (820, 1), (825, 0), (830, 0), (835, 0), (840, 1), (845, 1), (850, 1), (855, 1), (860, 0), (865, 0), (870, 0), (875, 1), (880, 1), (885, 1), (890, 1), (895, 1), (900, 1), (905, 0), (910, 1), (915, 1), (920, 1), (925, 1), (930, 0), (935, 0), (940, 1), (945, 0), (950, 0), (955, 1), (960, 1), (965, 1), (970, 1), (975, 1), (980, 1), (985, 0), (990, 0), (995, 1), (1000, 0), (1005, 1), (1010, 0), (1015, 1), (1020, 1), (1025, 1)]
VWEB0 WEB0 0 PWL (0n 1.1v 4.745n 1.1v 4.755n 0.0v 9.745n 0.0v 9.755n 0.0v 14.745n 0.0v 14.755n 0.0v 19.745n 0.0v 19.755n 1.1v 24.745n 1.1v 24.755n 1.1v 29.745n 1.1v 29.755n 1.1v 34.745n 1.1v 34.755n 0.0v 39.745n 0.0v 39.755n 1.1v 44.745n 1.1v 44.755n 0.0v 49.745n 0.0v 49.755n 0.0v 54.745n 0.0v 54.755n 0.0v 59.745n 0.0v 59.755n 1.1v 64.745n 1.1v 64.755n 1.1v 69.745n 1.1v 69.755n 1.1v 74.745n 1.1v 74.755n 0.0v 79.745n 0.0v 79.755n 0.0v 84.745n 0.0v 84.755n 1.1v 89.745n 1.1v 89.755n 1.1v 94.745n 1.1v 94.755n 1.1v 99.745n 1.1v 99.755n 1.1v 104.745n 1.1v 104.755n 1.1v 109.745n 1.1v 109.755n 1.1v 114.745n 1.1v 114.755n 0.0v 119.745n 0.0v 119.755n 1.1v 124.745n 1.1v 124.755n 1.1v 129.745n 1.1v 129.755n 1.1v 134.745n 1.1v 134.755n 0.0v 139.745n 0.0v 139.755n 0.0v 144.745n 0.0v 144.755n 1.1v 149.745n 1.1v 149.755n 0.0v 154.745n 0.0v 154.755n 1.1v 159.745n 1.1v 159.755n 1.1v 164.745n 1.1v 164.755n 0.0v 169.745n 0.0v 169.755n 1.1v 174.745n 1.1v 174.755n 0.0v 179.745n 0.0v 179.755n 0.0v 184.745n 0.0v 184.755n 1.1v 189.745n 1.1v 189.755n 1.1v 194.745n 1.1v 194.755n 0.0v 199.745n 0.0v 199.755n 1.1v 204.745n 1.1v 204.755n 1.1v 209.745n 1.1v 209.755n 0.0v 214.745n 0.0v 214.755n 0.0v 219.745n 0.0v 219.755n 1.1v 224.745n 1.1v 224.755n 1.1v 229.745n 1.1v 229.755n 0.0v 234.745n 0.0v 234.755n 1.1v 239.745n 1.1v 239.755n 1.1v 244.745n 1.1v 244.755n 1.1v 249.745n 1.1v 249.755n 1.1v 254.745n 1.1v 254.755n 1.1v 259.745n 1.1v 259.755n 0.0v 264.745n 0.0v 264.755n 1.1v 269.745n 1.1v 269.755n 0.0v 274.745n 0.0v 274.755n 1.1v 279.745n 1.1v 279.755n 1.1v 284.745n 1.1v 284.755n 1.1v 289.745n 1.1v 289.755n 1.1v 294.745n 1.1v 294.755n 0.0v 299.745n 0.0v 299.755n 1.1v 304.745n 1.1v 304.755n 1.1v 309.745n 1.1v 309.755n 1.1v 314.745n 1.1v 314.755n 0.0v 319.745n 0.0v 319.755n 0.0v 324.745n 0.0v 324.755n 0.0v 329.745n 0.0v 329.755n 1.1v 334.745n 1.1v 334.755n 1.1v 339.745n 1.1v 339.755n 1.1v 344.745n 1.1v 344.755n 1.1v 349.745n 1.1v 349.755n 0.0v 354.745n 0.0v 354.755n 1.1v 359.745n 1.1v 359.755n 0.0v 364.745n 0.0v 364.755n 0.0v 369.745n 0.0v 369.755n 0.0v 374.745n 0.0v 374.755n 1.1v 379.745n 1.1v 379.755n 0.0v 384.745n 0.0v 384.755n 1.1v 389.745n 1.1v 389.755n 1.1v 394.745n 1.1v 394.755n 1.1v 399.745n 1.1v 399.755n 0.0v 404.745n 0.0v 404.755n 1.1v 409.745n 1.1v 409.755n 0.0v 414.745n 0.0v 414.755n 1.1v 419.745n 1.1v 419.755n 1.1v 424.745n 1.1v 424.755n 1.1v 429.745n 1.1v 429.755n 1.1v 434.745n 1.1v 434.755n 0.0v 439.745n 0.0v 439.755n 0.0v 444.745n 0.0v 444.755n 1.1v 449.745n 1.1v 449.755n 1.1v 454.745n 1.1v 454.755n 0.0v 459.745n 0.0v 459.755n 0.0v 464.745n 0.0v 464.755n 1.1v 469.745n 1.1v 469.755n 1.1v 474.745n 1.1v 474.755n 0.0v 479.745n 0.0v 479.755n 1.1v 484.745n 1.1v 484.755n 0.0v 489.745n 0.0v 489.755n 1.1v 494.745n 1.1v 494.755n 0.0v 499.745n 0.0v 499.755n 1.1v 504.745n 1.1v 504.755n 0.0v 509.745n 0.0v 509.755n 1.1v 514.745n 1.1v 514.755n 0.0v 519.745n 0.0v 519.755n 1.1v 524.745n 1.1v 524.755n 1.1v 529.745n 1.1v 529.755n 1.1v 534.745n 1.1v 534.755n 1.1v 539.745n 1.1v 539.755n 0.0v 544.745n 0.0v 544.755n 0.0v 549.745n 0.0v 549.755n 0.0v 554.745n 0.0v 554.755n 0.0v 559.745n 0.0v 559.755n 1.1v 564.745n 1.1v 564.755n 1.1v 569.745n 1.1v 569.755n 1.1v 574.745n 1.1v 574.755n 1.1v 579.745n 1.1v 579.755n 0.0v 584.745n 0.0v 584.755n 0.0v 589.745n 0.0v 589.755n 1.1v 594.745n 1.1v 594.755n 0.0v 599.745n 0.0v 599.755n 1.1v 604.745n 1.1v 604.755n 0.0v 609.745n 0.0v 609.755n 1.1v 614.745n 1.1v 614.755n 1.1v 619.745n 1.1v 619.755n 0.0v 624.745n 0.0v 624.755n 1.1v 629.745n 1.1v 629.755n 0.0v 634.745n 0.0v 634.755n 0.0v 639.745n 0.0v 639.755n 0.0v 644.745n 0.0v 644.755n 1.1v 649.745n 1.1v 649.755n 0.0v 654.745n 0.0v 654.755n 1.1v 659.745n 1.1v 659.755n 1.1v 664.745n 1.1v 664.755n 1.1v 669.745n 1.1v 669.755n 1.1v 674.745n 1.1v 674.755n 1.1v 679.745n 1.1v 679.755n 1.1v 684.745n 1.1v 684.755n 1.1v 689.745n 1.1v 689.755n 1.1v 694.745n 1.1v 694.755n 1.1v 699.745n 1.1v 699.755n 0.0v 704.745n 0.0v 704.755n 0.0v 709.745n 0.0v 709.755n 1.1v 714.745n 1.1v 714.755n 1.1v 719.745n 1.1v 719.755n 0.0v 724.745n 0.0v 724.755n 1.1v 729.745n 1.1v 729.755n 0.0v 734.745n 0.0v 734.755n 1.1v 739.745n 1.1v 739.755n 1.1v 744.745n 1.1v 744.755n 1.1v 749.745n 1.1v 749.755n 1.1v 754.745n 1.1v 754.755n 0.0v 759.745n 0.0v 759.755n 1.1v 764.745n 1.1v 764.755n 0.0v 769.745n 0.0v 769.755n 1.1v 774.745n 1.1v 774.755n 1.1v 779.745n 1.1v 779.755n 1.1v 784.745n 1.1v 784.755n 0.0v 789.745n 0.0v 789.755n 1.1v 794.745n 1.1v 794.755n 1.1v 799.745n 1.1v 799.755n 1.1v 804.745n 1.1v 804.755n 0.0v 809.745n 0.0v 809.755n 1.1v 814.745n 1.1v 814.755n 0.0v 819.745n 0.0v 819.755n 1.1v 824.745n 1.1v 824.755n 0.0v 829.745n 0.0v 829.755n 0.0v 834.745n 0.0v 834.755n 0.0v 839.745n 0.0v 839.755n 1.1v 844.745n 1.1v 844.755n 1.1v 849.745n 1.1v 849.755n 1.1v 854.745n 1.1v 854.755n 1.1v 859.745n 1.1v 859.755n 0.0v 864.745n 0.0v 864.755n 0.0v 869.745n 0.0v 869.755n 0.0v 874.745n 0.0v 874.755n 1.1v 879.745n 1.1v 879.755n 1.1v 884.745n 1.1v 884.755n 1.1v 889.745n 1.1v 889.755n 1.1v 894.745n 1.1v 894.755n 1.1v 899.745n 1.1v 899.755n 1.1v 904.745n 1.1v 904.755n 0.0v 909.745n 0.0v 909.755n 1.1v 914.745n 1.1v 914.755n 1.1v 919.745n 1.1v 919.755n 1.1v 924.745n 1.1v 924.755n 1.1v 929.745n 1.1v 929.755n 0.0v 934.745n 0.0v 934.755n 0.0v 939.745n 0.0v 939.755n 1.1v 944.745n 1.1v 944.755n 0.0v 949.745n 0.0v 949.755n 0.0v 954.745n 0.0v 954.755n 1.1v 959.745n 1.1v 959.755n 1.1v 964.745n 1.1v 964.755n 1.1v 969.745n 1.1v 969.755n 1.1v 974.745n 1.1v 974.755n 1.1v 979.745n 1.1v 979.755n 1.1v 984.745n 1.1v 984.755n 0.0v 989.745n 0.0v 989.755n 0.0v 994.745n 0.0v 994.755n 1.1v 999.745n 1.1v 999.755n 0.0v 1004.745n 0.0v 1004.755n 1.1v 1009.745n 1.1v 1009.755n 0.0v 1014.745n 0.0v 1014.755n 1.1v 1019.745n 1.1v 1019.755n 1.1v 1024.745n 1.1v 1024.755n 1.1v )

* Generation of wmask signals
* (time, data): [(0, 0), (5, 1), (10, 1), (15, 1), (20, 1), (25, 1), (30, 1), (35, 0), (40, 0), (45, 0), (50, 0), (55, 0), (60, 0), (65, 0), (70, 0), (75, 1), (80, 0), (85, 0), (90, 0), (95, 0), (100, 0), (105, 0), (110, 0), (115, 0), (120, 0), (125, 0), (130, 0), (135, 1), (140, 0), (145, 0), (150, 1), (155, 1), (160, 1), (165, 1), (170, 1), (175, 0), (180, 1), (185, 1), (190, 1), (195, 1), (200, 1), (205, 1), (210, 1), (215, 1), (220, 1), (225, 1), (230, 1), (235, 1), (240, 1), (245, 1), (250, 1), (255, 1), (260, 1), (265, 1), (270, 0), (275, 0), (280, 0), (285, 0), (290, 0), (295, 1), (300, 1), (305, 1), (310, 1), (315, 1), (320, 1), (325, 0), (330, 0), (335, 0), (340, 0), (345, 0), (350, 0), (355, 0), (360, 1), (365, 0), (370, 1), (375, 1), (380, 0), (385, 0), (390, 0), (395, 0), (400, 1), (405, 1), (410, 0), (415, 0), (420, 0), (425, 0), (430, 0), (435, 1), (440, 0), (445, 0), (450, 0), (455, 1), (460, 1), (465, 1), (470, 1), (475, 0), (480, 0), (485, 0), (490, 0), (495, 0), (500, 0), (505, 0), (510, 0), (515, 1), (520, 1), (525, 1), (530, 1), (535, 1), (540, 1), (545, 1), (550, 1), (555, 1), (560, 1), (565, 1), (570, 1), (575, 1), (580, 1), (585, 1), (590, 1), (595, 1), (600, 1), (605, 1), (610, 1), (615, 1), (620, 1), (625, 1), (630, 1), (635, 1), (640, 0), (645, 0), (650, 1), (655, 1), (660, 1), (665, 1), (670, 1), (675, 1), (680, 1), (685, 1), (690, 1), (695, 1), (700, 1), (705, 1), (710, 1), (715, 1), (720, 1), (725, 1), (730, 1), (735, 1), (740, 1), (745, 1), (750, 1), (755, 1), (760, 1), (765, 1), (770, 1), (775, 1), (780, 1), (785, 1), (790, 1), (795, 1), (800, 1), (805, 0), (810, 0), (815, 0), (820, 0), (825, 1), (830, 0), (835, 1), (840, 1), (845, 1), (850, 1), (855, 1), (860, 1), (865, 1), (870, 0), (875, 0), (880, 0), (885, 0), (890, 0), (895, 0), (900, 0), (905, 1), (910, 1), (915, 1), (920, 1), (925, 1), (930, 1), (935, 0), (940, 0), (945, 0), (950, 1), (955, 1), (960, 1), (965, 1), (970, 1), (975, 1), (980, 1), (985, 1), (990, 1), (995, 1), (1000, 0), (1005, 0), (1010, 1), (1015, 1), (1020, 1), (1025, 1)]
VWMASK0_0  WMASK0_0  0 PWL (0n 0.0v 4.745n 0.0v 4.755n 1.1v 9.745n 1.1v 9.755n 1.1v 14.745n 1.1v 14.755n 1.1v 19.745n 1.1v 19.755n 1.1v 24.745n 1.1v 24.755n 1.1v 29.745n 1.1v 29.755n 1.1v 34.745n 1.1v 34.755n 0.0v 39.745n 0.0v 39.755n 0.0v 44.745n 0.0v 44.755n 0.0v 49.745n 0.0v 49.755n 0.0v 54.745n 0.0v 54.755n 0.0v 59.745n 0.0v 59.755n 0.0v 64.745n 0.0v 64.755n 0.0v 69.745n 0.0v 69.755n 0.0v 74.745n 0.0v 74.755n 1.1v 79.745n 1.1v 79.755n 0.0v 84.745n 0.0v 84.755n 0.0v 89.745n 0.0v 89.755n 0.0v 94.745n 0.0v 94.755n 0.0v 99.745n 0.0v 99.755n 0.0v 104.745n 0.0v 104.755n 0.0v 109.745n 0.0v 109.755n 0.0v 114.745n 0.0v 114.755n 0.0v 119.745n 0.0v 119.755n 0.0v 124.745n 0.0v 124.755n 0.0v 129.745n 0.0v 129.755n 0.0v 134.745n 0.0v 134.755n 1.1v 139.745n 1.1v 139.755n 0.0v 144.745n 0.0v 144.755n 0.0v 149.745n 0.0v 149.755n 1.1v 154.745n 1.1v 154.755n 1.1v 159.745n 1.1v 159.755n 1.1v 164.745n 1.1v 164.755n 1.1v 169.745n 1.1v 169.755n 1.1v 174.745n 1.1v 174.755n 0.0v 179.745n 0.0v 179.755n 1.1v 184.745n 1.1v 184.755n 1.1v 189.745n 1.1v 189.755n 1.1v 194.745n 1.1v 194.755n 1.1v 199.745n 1.1v 199.755n 1.1v 204.745n 1.1v 204.755n 1.1v 209.745n 1.1v 209.755n 1.1v 214.745n 1.1v 214.755n 1.1v 219.745n 1.1v 219.755n 1.1v 224.745n 1.1v 224.755n 1.1v 229.745n 1.1v 229.755n 1.1v 234.745n 1.1v 234.755n 1.1v 239.745n 1.1v 239.755n 1.1v 244.745n 1.1v 244.755n 1.1v 249.745n 1.1v 249.755n 1.1v 254.745n 1.1v 254.755n 1.1v 259.745n 1.1v 259.755n 1.1v 264.745n 1.1v 264.755n 1.1v 269.745n 1.1v 269.755n 0.0v 274.745n 0.0v 274.755n 0.0v 279.745n 0.0v 279.755n 0.0v 284.745n 0.0v 284.755n 0.0v 289.745n 0.0v 289.755n 0.0v 294.745n 0.0v 294.755n 1.1v 299.745n 1.1v 299.755n 1.1v 304.745n 1.1v 304.755n 1.1v 309.745n 1.1v 309.755n 1.1v 314.745n 1.1v 314.755n 1.1v 319.745n 1.1v 319.755n 1.1v 324.745n 1.1v 324.755n 0.0v 329.745n 0.0v 329.755n 0.0v 334.745n 0.0v 334.755n 0.0v 339.745n 0.0v 339.755n 0.0v 344.745n 0.0v 344.755n 0.0v 349.745n 0.0v 349.755n 0.0v 354.745n 0.0v 354.755n 0.0v 359.745n 0.0v 359.755n 1.1v 364.745n 1.1v 364.755n 0.0v 369.745n 0.0v 369.755n 1.1v 374.745n 1.1v 374.755n 1.1v 379.745n 1.1v 379.755n 0.0v 384.745n 0.0v 384.755n 0.0v 389.745n 0.0v 389.755n 0.0v 394.745n 0.0v 394.755n 0.0v 399.745n 0.0v 399.755n 1.1v 404.745n 1.1v 404.755n 1.1v 409.745n 1.1v 409.755n 0.0v 414.745n 0.0v 414.755n 0.0v 419.745n 0.0v 419.755n 0.0v 424.745n 0.0v 424.755n 0.0v 429.745n 0.0v 429.755n 0.0v 434.745n 0.0v 434.755n 1.1v 439.745n 1.1v 439.755n 0.0v 444.745n 0.0v 444.755n 0.0v 449.745n 0.0v 449.755n 0.0v 454.745n 0.0v 454.755n 1.1v 459.745n 1.1v 459.755n 1.1v 464.745n 1.1v 464.755n 1.1v 469.745n 1.1v 469.755n 1.1v 474.745n 1.1v 474.755n 0.0v 479.745n 0.0v 479.755n 0.0v 484.745n 0.0v 484.755n 0.0v 489.745n 0.0v 489.755n 0.0v 494.745n 0.0v 494.755n 0.0v 499.745n 0.0v 499.755n 0.0v 504.745n 0.0v 504.755n 0.0v 509.745n 0.0v 509.755n 0.0v 514.745n 0.0v 514.755n 1.1v 519.745n 1.1v 519.755n 1.1v 524.745n 1.1v 524.755n 1.1v 529.745n 1.1v 529.755n 1.1v 534.745n 1.1v 534.755n 1.1v 539.745n 1.1v 539.755n 1.1v 544.745n 1.1v 544.755n 1.1v 549.745n 1.1v 549.755n 1.1v 554.745n 1.1v 554.755n 1.1v 559.745n 1.1v 559.755n 1.1v 564.745n 1.1v 564.755n 1.1v 569.745n 1.1v 569.755n 1.1v 574.745n 1.1v 574.755n 1.1v 579.745n 1.1v 579.755n 1.1v 584.745n 1.1v 584.755n 1.1v 589.745n 1.1v 589.755n 1.1v 594.745n 1.1v 594.755n 1.1v 599.745n 1.1v 599.755n 1.1v 604.745n 1.1v 604.755n 1.1v 609.745n 1.1v 609.755n 1.1v 614.745n 1.1v 614.755n 1.1v 619.745n 1.1v 619.755n 1.1v 624.745n 1.1v 624.755n 1.1v 629.745n 1.1v 629.755n 1.1v 634.745n 1.1v 634.755n 1.1v 639.745n 1.1v 639.755n 0.0v 644.745n 0.0v 644.755n 0.0v 649.745n 0.0v 649.755n 1.1v 654.745n 1.1v 654.755n 1.1v 659.745n 1.1v 659.755n 1.1v 664.745n 1.1v 664.755n 1.1v 669.745n 1.1v 669.755n 1.1v 674.745n 1.1v 674.755n 1.1v 679.745n 1.1v 679.755n 1.1v 684.745n 1.1v 684.755n 1.1v 689.745n 1.1v 689.755n 1.1v 694.745n 1.1v 694.755n 1.1v 699.745n 1.1v 699.755n 1.1v 704.745n 1.1v 704.755n 1.1v 709.745n 1.1v 709.755n 1.1v 714.745n 1.1v 714.755n 1.1v 719.745n 1.1v 719.755n 1.1v 724.745n 1.1v 724.755n 1.1v 729.745n 1.1v 729.755n 1.1v 734.745n 1.1v 734.755n 1.1v 739.745n 1.1v 739.755n 1.1v 744.745n 1.1v 744.755n 1.1v 749.745n 1.1v 749.755n 1.1v 754.745n 1.1v 754.755n 1.1v 759.745n 1.1v 759.755n 1.1v 764.745n 1.1v 764.755n 1.1v 769.745n 1.1v 769.755n 1.1v 774.745n 1.1v 774.755n 1.1v 779.745n 1.1v 779.755n 1.1v 784.745n 1.1v 784.755n 1.1v 789.745n 1.1v 789.755n 1.1v 794.745n 1.1v 794.755n 1.1v 799.745n 1.1v 799.755n 1.1v 804.745n 1.1v 804.755n 0.0v 809.745n 0.0v 809.755n 0.0v 814.745n 0.0v 814.755n 0.0v 819.745n 0.0v 819.755n 0.0v 824.745n 0.0v 824.755n 1.1v 829.745n 1.1v 829.755n 0.0v 834.745n 0.0v 834.755n 1.1v 839.745n 1.1v 839.755n 1.1v 844.745n 1.1v 844.755n 1.1v 849.745n 1.1v 849.755n 1.1v 854.745n 1.1v 854.755n 1.1v 859.745n 1.1v 859.755n 1.1v 864.745n 1.1v 864.755n 1.1v 869.745n 1.1v 869.755n 0.0v 874.745n 0.0v 874.755n 0.0v 879.745n 0.0v 879.755n 0.0v 884.745n 0.0v 884.755n 0.0v 889.745n 0.0v 889.755n 0.0v 894.745n 0.0v 894.755n 0.0v 899.745n 0.0v 899.755n 0.0v 904.745n 0.0v 904.755n 1.1v 909.745n 1.1v 909.755n 1.1v 914.745n 1.1v 914.755n 1.1v 919.745n 1.1v 919.755n 1.1v 924.745n 1.1v 924.755n 1.1v 929.745n 1.1v 929.755n 1.1v 934.745n 1.1v 934.755n 0.0v 939.745n 0.0v 939.755n 0.0v 944.745n 0.0v 944.755n 0.0v 949.745n 0.0v 949.755n 1.1v 954.745n 1.1v 954.755n 1.1v 959.745n 1.1v 959.755n 1.1v 964.745n 1.1v 964.755n 1.1v 969.745n 1.1v 969.755n 1.1v 974.745n 1.1v 974.755n 1.1v 979.745n 1.1v 979.755n 1.1v 984.745n 1.1v 984.755n 1.1v 989.745n 1.1v 989.755n 1.1v 994.745n 1.1v 994.755n 1.1v 999.745n 1.1v 999.755n 0.0v 1004.745n 0.0v 1004.755n 0.0v 1009.745n 0.0v 1009.755n 1.1v 1014.745n 1.1v 1014.755n 1.1v 1019.745n 1.1v 1019.755n 1.1v 1024.745n 1.1v 1024.755n 1.1v )
* (time, data): [(0, 0), (5, 1), (10, 1), (15, 1), (20, 1), (25, 1), (30, 1), (35, 0), (40, 0), (45, 0), (50, 0), (55, 0), (60, 0), (65, 0), (70, 0), (75, 1), (80, 1), (85, 1), (90, 1), (95, 1), (100, 1), (105, 1), (110, 1), (115, 0), (120, 0), (125, 0), (130, 0), (135, 0), (140, 0), (145, 0), (150, 0), (155, 0), (160, 0), (165, 1), (170, 1), (175, 1), (180, 0), (185, 0), (190, 0), (195, 1), (200, 1), (205, 1), (210, 1), (215, 1), (220, 1), (225, 1), (230, 0), (235, 0), (240, 0), (245, 0), (250, 0), (255, 0), (260, 1), (265, 1), (270, 0), (275, 0), (280, 0), (285, 0), (290, 0), (295, 1), (300, 1), (305, 1), (310, 1), (315, 0), (320, 1), (325, 1), (330, 1), (335, 1), (340, 1), (345, 1), (350, 1), (355, 1), (360, 0), (365, 1), (370, 1), (375, 1), (380, 1), (385, 1), (390, 1), (395, 1), (400, 1), (405, 1), (410, 0), (415, 0), (420, 0), (425, 0), (430, 0), (435, 0), (440, 0), (445, 0), (450, 0), (455, 1), (460, 0), (465, 0), (470, 0), (475, 1), (480, 1), (485, 0), (490, 0), (495, 1), (500, 1), (505, 1), (510, 1), (515, 1), (520, 1), (525, 1), (530, 1), (535, 1), (540, 1), (545, 1), (550, 1), (555, 0), (560, 0), (565, 0), (570, 0), (575, 0), (580, 1), (585, 1), (590, 1), (595, 1), (600, 1), (605, 1), (610, 1), (615, 1), (620, 1), (625, 1), (630, 1), (635, 1), (640, 1), (645, 1), (650, 0), (655, 0), (660, 0), (665, 0), (670, 0), (675, 0), (680, 0), (685, 0), (690, 0), (695, 0), (700, 1), (705, 0), (710, 0), (715, 0), (720, 1), (725, 1), (730, 0), (735, 0), (740, 0), (745, 0), (750, 0), (755, 1), (760, 1), (765, 0), (770, 0), (775, 0), (780, 0), (785, 1), (790, 1), (795, 1), (800, 1), (805, 1), (810, 1), (815, 1), (820, 1), (825, 1), (830, 1), (835, 1), (840, 1), (845, 1), (850, 1), (855, 1), (860, 1), (865, 0), (870, 1), (875, 1), (880, 1), (885, 1), (890, 1), (895, 1), (900, 1), (905, 1), (910, 1), (915, 1), (920, 1), (925, 1), (930, 1), (935, 0), (940, 0), (945, 0), (950, 1), (955, 1), (960, 1), (965, 1), (970, 1), (975, 1), (980, 1), (985, 1), (990, 0), (995, 0), (1000, 0), (1005, 0), (1010, 0), (1015, 0), (1020, 0), (1025, 0)]
VWMASK0_1  WMASK0_1  0 PWL (0n 0.0v 4.745n 0.0v 4.755n 1.1v 9.745n 1.1v 9.755n 1.1v 14.745n 1.1v 14.755n 1.1v 19.745n 1.1v 19.755n 1.1v 24.745n 1.1v 24.755n 1.1v 29.745n 1.1v 29.755n 1.1v 34.745n 1.1v 34.755n 0.0v 39.745n 0.0v 39.755n 0.0v 44.745n 0.0v 44.755n 0.0v 49.745n 0.0v 49.755n 0.0v 54.745n 0.0v 54.755n 0.0v 59.745n 0.0v 59.755n 0.0v 64.745n 0.0v 64.755n 0.0v 69.745n 0.0v 69.755n 0.0v 74.745n 0.0v 74.755n 1.1v 79.745n 1.1v 79.755n 1.1v 84.745n 1.1v 84.755n 1.1v 89.745n 1.1v 89.755n 1.1v 94.745n 1.1v 94.755n 1.1v 99.745n 1.1v 99.755n 1.1v 104.745n 1.1v 104.755n 1.1v 109.745n 1.1v 109.755n 1.1v 114.745n 1.1v 114.755n 0.0v 119.745n 0.0v 119.755n 0.0v 124.745n 0.0v 124.755n 0.0v 129.745n 0.0v 129.755n 0.0v 134.745n 0.0v 134.755n 0.0v 139.745n 0.0v 139.755n 0.0v 144.745n 0.0v 144.755n 0.0v 149.745n 0.0v 149.755n 0.0v 154.745n 0.0v 154.755n 0.0v 159.745n 0.0v 159.755n 0.0v 164.745n 0.0v 164.755n 1.1v 169.745n 1.1v 169.755n 1.1v 174.745n 1.1v 174.755n 1.1v 179.745n 1.1v 179.755n 0.0v 184.745n 0.0v 184.755n 0.0v 189.745n 0.0v 189.755n 0.0v 194.745n 0.0v 194.755n 1.1v 199.745n 1.1v 199.755n 1.1v 204.745n 1.1v 204.755n 1.1v 209.745n 1.1v 209.755n 1.1v 214.745n 1.1v 214.755n 1.1v 219.745n 1.1v 219.755n 1.1v 224.745n 1.1v 224.755n 1.1v 229.745n 1.1v 229.755n 0.0v 234.745n 0.0v 234.755n 0.0v 239.745n 0.0v 239.755n 0.0v 244.745n 0.0v 244.755n 0.0v 249.745n 0.0v 249.755n 0.0v 254.745n 0.0v 254.755n 0.0v 259.745n 0.0v 259.755n 1.1v 264.745n 1.1v 264.755n 1.1v 269.745n 1.1v 269.755n 0.0v 274.745n 0.0v 274.755n 0.0v 279.745n 0.0v 279.755n 0.0v 284.745n 0.0v 284.755n 0.0v 289.745n 0.0v 289.755n 0.0v 294.745n 0.0v 294.755n 1.1v 299.745n 1.1v 299.755n 1.1v 304.745n 1.1v 304.755n 1.1v 309.745n 1.1v 309.755n 1.1v 314.745n 1.1v 314.755n 0.0v 319.745n 0.0v 319.755n 1.1v 324.745n 1.1v 324.755n 1.1v 329.745n 1.1v 329.755n 1.1v 334.745n 1.1v 334.755n 1.1v 339.745n 1.1v 339.755n 1.1v 344.745n 1.1v 344.755n 1.1v 349.745n 1.1v 349.755n 1.1v 354.745n 1.1v 354.755n 1.1v 359.745n 1.1v 359.755n 0.0v 364.745n 0.0v 364.755n 1.1v 369.745n 1.1v 369.755n 1.1v 374.745n 1.1v 374.755n 1.1v 379.745n 1.1v 379.755n 1.1v 384.745n 1.1v 384.755n 1.1v 389.745n 1.1v 389.755n 1.1v 394.745n 1.1v 394.755n 1.1v 399.745n 1.1v 399.755n 1.1v 404.745n 1.1v 404.755n 1.1v 409.745n 1.1v 409.755n 0.0v 414.745n 0.0v 414.755n 0.0v 419.745n 0.0v 419.755n 0.0v 424.745n 0.0v 424.755n 0.0v 429.745n 0.0v 429.755n 0.0v 434.745n 0.0v 434.755n 0.0v 439.745n 0.0v 439.755n 0.0v 444.745n 0.0v 444.755n 0.0v 449.745n 0.0v 449.755n 0.0v 454.745n 0.0v 454.755n 1.1v 459.745n 1.1v 459.755n 0.0v 464.745n 0.0v 464.755n 0.0v 469.745n 0.0v 469.755n 0.0v 474.745n 0.0v 474.755n 1.1v 479.745n 1.1v 479.755n 1.1v 484.745n 1.1v 484.755n 0.0v 489.745n 0.0v 489.755n 0.0v 494.745n 0.0v 494.755n 1.1v 499.745n 1.1v 499.755n 1.1v 504.745n 1.1v 504.755n 1.1v 509.745n 1.1v 509.755n 1.1v 514.745n 1.1v 514.755n 1.1v 519.745n 1.1v 519.755n 1.1v 524.745n 1.1v 524.755n 1.1v 529.745n 1.1v 529.755n 1.1v 534.745n 1.1v 534.755n 1.1v 539.745n 1.1v 539.755n 1.1v 544.745n 1.1v 544.755n 1.1v 549.745n 1.1v 549.755n 1.1v 554.745n 1.1v 554.755n 0.0v 559.745n 0.0v 559.755n 0.0v 564.745n 0.0v 564.755n 0.0v 569.745n 0.0v 569.755n 0.0v 574.745n 0.0v 574.755n 0.0v 579.745n 0.0v 579.755n 1.1v 584.745n 1.1v 584.755n 1.1v 589.745n 1.1v 589.755n 1.1v 594.745n 1.1v 594.755n 1.1v 599.745n 1.1v 599.755n 1.1v 604.745n 1.1v 604.755n 1.1v 609.745n 1.1v 609.755n 1.1v 614.745n 1.1v 614.755n 1.1v 619.745n 1.1v 619.755n 1.1v 624.745n 1.1v 624.755n 1.1v 629.745n 1.1v 629.755n 1.1v 634.745n 1.1v 634.755n 1.1v 639.745n 1.1v 639.755n 1.1v 644.745n 1.1v 644.755n 1.1v 649.745n 1.1v 649.755n 0.0v 654.745n 0.0v 654.755n 0.0v 659.745n 0.0v 659.755n 0.0v 664.745n 0.0v 664.755n 0.0v 669.745n 0.0v 669.755n 0.0v 674.745n 0.0v 674.755n 0.0v 679.745n 0.0v 679.755n 0.0v 684.745n 0.0v 684.755n 0.0v 689.745n 0.0v 689.755n 0.0v 694.745n 0.0v 694.755n 0.0v 699.745n 0.0v 699.755n 1.1v 704.745n 1.1v 704.755n 0.0v 709.745n 0.0v 709.755n 0.0v 714.745n 0.0v 714.755n 0.0v 719.745n 0.0v 719.755n 1.1v 724.745n 1.1v 724.755n 1.1v 729.745n 1.1v 729.755n 0.0v 734.745n 0.0v 734.755n 0.0v 739.745n 0.0v 739.755n 0.0v 744.745n 0.0v 744.755n 0.0v 749.745n 0.0v 749.755n 0.0v 754.745n 0.0v 754.755n 1.1v 759.745n 1.1v 759.755n 1.1v 764.745n 1.1v 764.755n 0.0v 769.745n 0.0v 769.755n 0.0v 774.745n 0.0v 774.755n 0.0v 779.745n 0.0v 779.755n 0.0v 784.745n 0.0v 784.755n 1.1v 789.745n 1.1v 789.755n 1.1v 794.745n 1.1v 794.755n 1.1v 799.745n 1.1v 799.755n 1.1v 804.745n 1.1v 804.755n 1.1v 809.745n 1.1v 809.755n 1.1v 814.745n 1.1v 814.755n 1.1v 819.745n 1.1v 819.755n 1.1v 824.745n 1.1v 824.755n 1.1v 829.745n 1.1v 829.755n 1.1v 834.745n 1.1v 834.755n 1.1v 839.745n 1.1v 839.755n 1.1v 844.745n 1.1v 844.755n 1.1v 849.745n 1.1v 849.755n 1.1v 854.745n 1.1v 854.755n 1.1v 859.745n 1.1v 859.755n 1.1v 864.745n 1.1v 864.755n 0.0v 869.745n 0.0v 869.755n 1.1v 874.745n 1.1v 874.755n 1.1v 879.745n 1.1v 879.755n 1.1v 884.745n 1.1v 884.755n 1.1v 889.745n 1.1v 889.755n 1.1v 894.745n 1.1v 894.755n 1.1v 899.745n 1.1v 899.755n 1.1v 904.745n 1.1v 904.755n 1.1v 909.745n 1.1v 909.755n 1.1v 914.745n 1.1v 914.755n 1.1v 919.745n 1.1v 919.755n 1.1v 924.745n 1.1v 924.755n 1.1v 929.745n 1.1v 929.755n 1.1v 934.745n 1.1v 934.755n 0.0v 939.745n 0.0v 939.755n 0.0v 944.745n 0.0v 944.755n 0.0v 949.745n 0.0v 949.755n 1.1v 954.745n 1.1v 954.755n 1.1v 959.745n 1.1v 959.755n 1.1v 964.745n 1.1v 964.755n 1.1v 969.745n 1.1v 969.755n 1.1v 974.745n 1.1v 974.755n 1.1v 979.745n 1.1v 979.755n 1.1v 984.745n 1.1v 984.755n 1.1v 989.745n 1.1v 989.755n 0.0v 994.745n 0.0v 994.755n 0.0v 999.745n 0.0v 999.755n 0.0v 1004.745n 0.0v 1004.755n 0.0v 1009.745n 0.0v 1009.755n 0.0v 1014.745n 0.0v 1014.755n 0.0v 1019.745n 0.0v 1019.755n 0.0v 1024.745n 0.0v 1024.755n 0.0v )
* (time, data): [(0, 0), (5, 1), (10, 1), (15, 1), (20, 1), (25, 1), (30, 1), (35, 1), (40, 1), (45, 1), (50, 0), (55, 1), (60, 1), (65, 1), (70, 1), (75, 1), (80, 0), (85, 0), (90, 0), (95, 0), (100, 0), (105, 0), (110, 0), (115, 1), (120, 1), (125, 1), (130, 1), (135, 0), (140, 0), (145, 0), (150, 1), (155, 1), (160, 1), (165, 0), (170, 0), (175, 0), (180, 1), (185, 1), (190, 1), (195, 1), (200, 1), (205, 1), (210, 1), (215, 1), (220, 1), (225, 1), (230, 0), (235, 0), (240, 0), (245, 0), (250, 0), (255, 0), (260, 1), (265, 1), (270, 1), (275, 1), (280, 1), (285, 1), (290, 1), (295, 1), (300, 1), (305, 1), (310, 1), (315, 1), (320, 1), (325, 0), (330, 0), (335, 0), (340, 0), (345, 0), (350, 0), (355, 0), (360, 1), (365, 0), (370, 1), (375, 1), (380, 0), (385, 0), (390, 0), (395, 0), (400, 1), (405, 1), (410, 1), (415, 1), (420, 1), (425, 1), (430, 1), (435, 1), (440, 1), (445, 1), (450, 1), (455, 1), (460, 0), (465, 0), (470, 0), (475, 1), (480, 1), (485, 1), (490, 1), (495, 1), (500, 1), (505, 1), (510, 1), (515, 1), (520, 1), (525, 1), (530, 1), (535, 1), (540, 1), (545, 1), (550, 1), (555, 1), (560, 1), (565, 1), (570, 1), (575, 1), (580, 1), (585, 1), (590, 1), (595, 1), (600, 1), (605, 1), (610, 1), (615, 1), (620, 0), (625, 0), (630, 1), (635, 1), (640, 0), (645, 0), (650, 1), (655, 1), (660, 1), (665, 1), (670, 1), (675, 1), (680, 1), (685, 1), (690, 1), (695, 1), (700, 1), (705, 1), (710, 1), (715, 1), (720, 1), (725, 1), (730, 1), (735, 1), (740, 1), (745, 1), (750, 1), (755, 1), (760, 1), (765, 0), (770, 0), (775, 0), (780, 0), (785, 1), (790, 1), (795, 1), (800, 1), (805, 0), (810, 0), (815, 1), (820, 1), (825, 1), (830, 1), (835, 1), (840, 1), (845, 1), (850, 1), (855, 1), (860, 1), (865, 1), (870, 0), (875, 0), (880, 0), (885, 0), (890, 0), (895, 0), (900, 0), (905, 1), (910, 1), (915, 1), (920, 1), (925, 1), (930, 1), (935, 1), (940, 1), (945, 0), (950, 1), (955, 1), (960, 1), (965, 1), (970, 1), (975, 1), (980, 1), (985, 1), (990, 0), (995, 0), (1000, 1), (1005, 1), (1010, 1), (1015, 1), (1020, 1), (1025, 1)]
VWMASK0_2  WMASK0_2  0 PWL (0n 0.0v 4.745n 0.0v 4.755n 1.1v 9.745n 1.1v 9.755n 1.1v 14.745n 1.1v 14.755n 1.1v 19.745n 1.1v 19.755n 1.1v 24.745n 1.1v 24.755n 1.1v 29.745n 1.1v 29.755n 1.1v 34.745n 1.1v 34.755n 1.1v 39.745n 1.1v 39.755n 1.1v 44.745n 1.1v 44.755n 1.1v 49.745n 1.1v 49.755n 0.0v 54.745n 0.0v 54.755n 1.1v 59.745n 1.1v 59.755n 1.1v 64.745n 1.1v 64.755n 1.1v 69.745n 1.1v 69.755n 1.1v 74.745n 1.1v 74.755n 1.1v 79.745n 1.1v 79.755n 0.0v 84.745n 0.0v 84.755n 0.0v 89.745n 0.0v 89.755n 0.0v 94.745n 0.0v 94.755n 0.0v 99.745n 0.0v 99.755n 0.0v 104.745n 0.0v 104.755n 0.0v 109.745n 0.0v 109.755n 0.0v 114.745n 0.0v 114.755n 1.1v 119.745n 1.1v 119.755n 1.1v 124.745n 1.1v 124.755n 1.1v 129.745n 1.1v 129.755n 1.1v 134.745n 1.1v 134.755n 0.0v 139.745n 0.0v 139.755n 0.0v 144.745n 0.0v 144.755n 0.0v 149.745n 0.0v 149.755n 1.1v 154.745n 1.1v 154.755n 1.1v 159.745n 1.1v 159.755n 1.1v 164.745n 1.1v 164.755n 0.0v 169.745n 0.0v 169.755n 0.0v 174.745n 0.0v 174.755n 0.0v 179.745n 0.0v 179.755n 1.1v 184.745n 1.1v 184.755n 1.1v 189.745n 1.1v 189.755n 1.1v 194.745n 1.1v 194.755n 1.1v 199.745n 1.1v 199.755n 1.1v 204.745n 1.1v 204.755n 1.1v 209.745n 1.1v 209.755n 1.1v 214.745n 1.1v 214.755n 1.1v 219.745n 1.1v 219.755n 1.1v 224.745n 1.1v 224.755n 1.1v 229.745n 1.1v 229.755n 0.0v 234.745n 0.0v 234.755n 0.0v 239.745n 0.0v 239.755n 0.0v 244.745n 0.0v 244.755n 0.0v 249.745n 0.0v 249.755n 0.0v 254.745n 0.0v 254.755n 0.0v 259.745n 0.0v 259.755n 1.1v 264.745n 1.1v 264.755n 1.1v 269.745n 1.1v 269.755n 1.1v 274.745n 1.1v 274.755n 1.1v 279.745n 1.1v 279.755n 1.1v 284.745n 1.1v 284.755n 1.1v 289.745n 1.1v 289.755n 1.1v 294.745n 1.1v 294.755n 1.1v 299.745n 1.1v 299.755n 1.1v 304.745n 1.1v 304.755n 1.1v 309.745n 1.1v 309.755n 1.1v 314.745n 1.1v 314.755n 1.1v 319.745n 1.1v 319.755n 1.1v 324.745n 1.1v 324.755n 0.0v 329.745n 0.0v 329.755n 0.0v 334.745n 0.0v 334.755n 0.0v 339.745n 0.0v 339.755n 0.0v 344.745n 0.0v 344.755n 0.0v 349.745n 0.0v 349.755n 0.0v 354.745n 0.0v 354.755n 0.0v 359.745n 0.0v 359.755n 1.1v 364.745n 1.1v 364.755n 0.0v 369.745n 0.0v 369.755n 1.1v 374.745n 1.1v 374.755n 1.1v 379.745n 1.1v 379.755n 0.0v 384.745n 0.0v 384.755n 0.0v 389.745n 0.0v 389.755n 0.0v 394.745n 0.0v 394.755n 0.0v 399.745n 0.0v 399.755n 1.1v 404.745n 1.1v 404.755n 1.1v 409.745n 1.1v 409.755n 1.1v 414.745n 1.1v 414.755n 1.1v 419.745n 1.1v 419.755n 1.1v 424.745n 1.1v 424.755n 1.1v 429.745n 1.1v 429.755n 1.1v 434.745n 1.1v 434.755n 1.1v 439.745n 1.1v 439.755n 1.1v 444.745n 1.1v 444.755n 1.1v 449.745n 1.1v 449.755n 1.1v 454.745n 1.1v 454.755n 1.1v 459.745n 1.1v 459.755n 0.0v 464.745n 0.0v 464.755n 0.0v 469.745n 0.0v 469.755n 0.0v 474.745n 0.0v 474.755n 1.1v 479.745n 1.1v 479.755n 1.1v 484.745n 1.1v 484.755n 1.1v 489.745n 1.1v 489.755n 1.1v 494.745n 1.1v 494.755n 1.1v 499.745n 1.1v 499.755n 1.1v 504.745n 1.1v 504.755n 1.1v 509.745n 1.1v 509.755n 1.1v 514.745n 1.1v 514.755n 1.1v 519.745n 1.1v 519.755n 1.1v 524.745n 1.1v 524.755n 1.1v 529.745n 1.1v 529.755n 1.1v 534.745n 1.1v 534.755n 1.1v 539.745n 1.1v 539.755n 1.1v 544.745n 1.1v 544.755n 1.1v 549.745n 1.1v 549.755n 1.1v 554.745n 1.1v 554.755n 1.1v 559.745n 1.1v 559.755n 1.1v 564.745n 1.1v 564.755n 1.1v 569.745n 1.1v 569.755n 1.1v 574.745n 1.1v 574.755n 1.1v 579.745n 1.1v 579.755n 1.1v 584.745n 1.1v 584.755n 1.1v 589.745n 1.1v 589.755n 1.1v 594.745n 1.1v 594.755n 1.1v 599.745n 1.1v 599.755n 1.1v 604.745n 1.1v 604.755n 1.1v 609.745n 1.1v 609.755n 1.1v 614.745n 1.1v 614.755n 1.1v 619.745n 1.1v 619.755n 0.0v 624.745n 0.0v 624.755n 0.0v 629.745n 0.0v 629.755n 1.1v 634.745n 1.1v 634.755n 1.1v 639.745n 1.1v 639.755n 0.0v 644.745n 0.0v 644.755n 0.0v 649.745n 0.0v 649.755n 1.1v 654.745n 1.1v 654.755n 1.1v 659.745n 1.1v 659.755n 1.1v 664.745n 1.1v 664.755n 1.1v 669.745n 1.1v 669.755n 1.1v 674.745n 1.1v 674.755n 1.1v 679.745n 1.1v 679.755n 1.1v 684.745n 1.1v 684.755n 1.1v 689.745n 1.1v 689.755n 1.1v 694.745n 1.1v 694.755n 1.1v 699.745n 1.1v 699.755n 1.1v 704.745n 1.1v 704.755n 1.1v 709.745n 1.1v 709.755n 1.1v 714.745n 1.1v 714.755n 1.1v 719.745n 1.1v 719.755n 1.1v 724.745n 1.1v 724.755n 1.1v 729.745n 1.1v 729.755n 1.1v 734.745n 1.1v 734.755n 1.1v 739.745n 1.1v 739.755n 1.1v 744.745n 1.1v 744.755n 1.1v 749.745n 1.1v 749.755n 1.1v 754.745n 1.1v 754.755n 1.1v 759.745n 1.1v 759.755n 1.1v 764.745n 1.1v 764.755n 0.0v 769.745n 0.0v 769.755n 0.0v 774.745n 0.0v 774.755n 0.0v 779.745n 0.0v 779.755n 0.0v 784.745n 0.0v 784.755n 1.1v 789.745n 1.1v 789.755n 1.1v 794.745n 1.1v 794.755n 1.1v 799.745n 1.1v 799.755n 1.1v 804.745n 1.1v 804.755n 0.0v 809.745n 0.0v 809.755n 0.0v 814.745n 0.0v 814.755n 1.1v 819.745n 1.1v 819.755n 1.1v 824.745n 1.1v 824.755n 1.1v 829.745n 1.1v 829.755n 1.1v 834.745n 1.1v 834.755n 1.1v 839.745n 1.1v 839.755n 1.1v 844.745n 1.1v 844.755n 1.1v 849.745n 1.1v 849.755n 1.1v 854.745n 1.1v 854.755n 1.1v 859.745n 1.1v 859.755n 1.1v 864.745n 1.1v 864.755n 1.1v 869.745n 1.1v 869.755n 0.0v 874.745n 0.0v 874.755n 0.0v 879.745n 0.0v 879.755n 0.0v 884.745n 0.0v 884.755n 0.0v 889.745n 0.0v 889.755n 0.0v 894.745n 0.0v 894.755n 0.0v 899.745n 0.0v 899.755n 0.0v 904.745n 0.0v 904.755n 1.1v 909.745n 1.1v 909.755n 1.1v 914.745n 1.1v 914.755n 1.1v 919.745n 1.1v 919.755n 1.1v 924.745n 1.1v 924.755n 1.1v 929.745n 1.1v 929.755n 1.1v 934.745n 1.1v 934.755n 1.1v 939.745n 1.1v 939.755n 1.1v 944.745n 1.1v 944.755n 0.0v 949.745n 0.0v 949.755n 1.1v 954.745n 1.1v 954.755n 1.1v 959.745n 1.1v 959.755n 1.1v 964.745n 1.1v 964.755n 1.1v 969.745n 1.1v 969.755n 1.1v 974.745n 1.1v 974.755n 1.1v 979.745n 1.1v 979.755n 1.1v 984.745n 1.1v 984.755n 1.1v 989.745n 1.1v 989.755n 0.0v 994.745n 0.0v 994.755n 0.0v 999.745n 0.0v 999.755n 1.1v 1004.745n 1.1v 1004.755n 1.1v 1009.745n 1.1v 1009.755n 1.1v 1014.745n 1.1v 1014.755n 1.1v 1019.745n 1.1v 1019.755n 1.1v 1024.745n 1.1v 1024.755n 1.1v )
* (time, data): [(0, 0), (5, 1), (10, 1), (15, 1), (20, 1), (25, 1), (30, 1), (35, 0), (40, 0), (45, 1), (50, 1), (55, 0), (60, 0), (65, 0), (70, 0), (75, 1), (80, 0), (85, 0), (90, 0), (95, 0), (100, 0), (105, 0), (110, 0), (115, 0), (120, 0), (125, 0), (130, 0), (135, 0), (140, 1), (145, 1), (150, 1), (155, 1), (160, 1), (165, 0), (170, 0), (175, 1), (180, 1), (185, 1), (190, 1), (195, 1), (200, 1), (205, 1), (210, 0), (215, 0), (220, 0), (225, 0), (230, 1), (235, 1), (240, 1), (245, 1), (250, 1), (255, 1), (260, 1), (265, 1), (270, 1), (275, 1), (280, 1), (285, 1), (290, 1), (295, 1), (300, 1), (305, 1), (310, 1), (315, 0), (320, 1), (325, 0), (330, 0), (335, 0), (340, 0), (345, 0), (350, 0), (355, 0), (360, 1), (365, 1), (370, 1), (375, 1), (380, 1), (385, 1), (390, 1), (395, 1), (400, 1), (405, 1), (410, 0), (415, 0), (420, 0), (425, 0), (430, 0), (435, 1), (440, 0), (445, 0), (450, 0), (455, 1), (460, 0), (465, 0), (470, 0), (475, 1), (480, 1), (485, 1), (490, 1), (495, 1), (500, 1), (505, 1), (510, 1), (515, 1), (520, 1), (525, 1), (530, 1), (535, 1), (540, 1), (545, 1), (550, 0), (555, 0), (560, 0), (565, 0), (570, 0), (575, 0), (580, 1), (585, 1), (590, 1), (595, 1), (600, 1), (605, 1), (610, 1), (615, 1), (620, 0), (625, 0), (630, 1), (635, 1), (640, 0), (645, 0), (650, 0), (655, 0), (660, 0), (665, 0), (670, 0), (675, 0), (680, 0), (685, 0), (690, 0), (695, 0), (700, 1), (705, 1), (710, 1), (715, 1), (720, 1), (725, 1), (730, 0), (735, 0), (740, 0), (745, 0), (750, 0), (755, 1), (760, 1), (765, 0), (770, 0), (775, 0), (780, 0), (785, 1), (790, 1), (795, 1), (800, 1), (805, 0), (810, 0), (815, 1), (820, 1), (825, 1), (830, 0), (835, 1), (840, 1), (845, 1), (850, 1), (855, 1), (860, 1), (865, 0), (870, 0), (875, 0), (880, 0), (885, 0), (890, 0), (895, 0), (900, 0), (905, 1), (910, 1), (915, 1), (920, 1), (925, 1), (930, 1), (935, 1), (940, 1), (945, 1), (950, 1), (955, 1), (960, 1), (965, 1), (970, 1), (975, 1), (980, 1), (985, 1), (990, 0), (995, 0), (1000, 1), (1005, 1), (1010, 0), (1015, 0), (1020, 0), (1025, 0)]
VWMASK0_3  WMASK0_3  0 PWL (0n 0.0v 4.745n 0.0v 4.755n 1.1v 9.745n 1.1v 9.755n 1.1v 14.745n 1.1v 14.755n 1.1v 19.745n 1.1v 19.755n 1.1v 24.745n 1.1v 24.755n 1.1v 29.745n 1.1v 29.755n 1.1v 34.745n 1.1v 34.755n 0.0v 39.745n 0.0v 39.755n 0.0v 44.745n 0.0v 44.755n 1.1v 49.745n 1.1v 49.755n 1.1v 54.745n 1.1v 54.755n 0.0v 59.745n 0.0v 59.755n 0.0v 64.745n 0.0v 64.755n 0.0v 69.745n 0.0v 69.755n 0.0v 74.745n 0.0v 74.755n 1.1v 79.745n 1.1v 79.755n 0.0v 84.745n 0.0v 84.755n 0.0v 89.745n 0.0v 89.755n 0.0v 94.745n 0.0v 94.755n 0.0v 99.745n 0.0v 99.755n 0.0v 104.745n 0.0v 104.755n 0.0v 109.745n 0.0v 109.755n 0.0v 114.745n 0.0v 114.755n 0.0v 119.745n 0.0v 119.755n 0.0v 124.745n 0.0v 124.755n 0.0v 129.745n 0.0v 129.755n 0.0v 134.745n 0.0v 134.755n 0.0v 139.745n 0.0v 139.755n 1.1v 144.745n 1.1v 144.755n 1.1v 149.745n 1.1v 149.755n 1.1v 154.745n 1.1v 154.755n 1.1v 159.745n 1.1v 159.755n 1.1v 164.745n 1.1v 164.755n 0.0v 169.745n 0.0v 169.755n 0.0v 174.745n 0.0v 174.755n 1.1v 179.745n 1.1v 179.755n 1.1v 184.745n 1.1v 184.755n 1.1v 189.745n 1.1v 189.755n 1.1v 194.745n 1.1v 194.755n 1.1v 199.745n 1.1v 199.755n 1.1v 204.745n 1.1v 204.755n 1.1v 209.745n 1.1v 209.755n 0.0v 214.745n 0.0v 214.755n 0.0v 219.745n 0.0v 219.755n 0.0v 224.745n 0.0v 224.755n 0.0v 229.745n 0.0v 229.755n 1.1v 234.745n 1.1v 234.755n 1.1v 239.745n 1.1v 239.755n 1.1v 244.745n 1.1v 244.755n 1.1v 249.745n 1.1v 249.755n 1.1v 254.745n 1.1v 254.755n 1.1v 259.745n 1.1v 259.755n 1.1v 264.745n 1.1v 264.755n 1.1v 269.745n 1.1v 269.755n 1.1v 274.745n 1.1v 274.755n 1.1v 279.745n 1.1v 279.755n 1.1v 284.745n 1.1v 284.755n 1.1v 289.745n 1.1v 289.755n 1.1v 294.745n 1.1v 294.755n 1.1v 299.745n 1.1v 299.755n 1.1v 304.745n 1.1v 304.755n 1.1v 309.745n 1.1v 309.755n 1.1v 314.745n 1.1v 314.755n 0.0v 319.745n 0.0v 319.755n 1.1v 324.745n 1.1v 324.755n 0.0v 329.745n 0.0v 329.755n 0.0v 334.745n 0.0v 334.755n 0.0v 339.745n 0.0v 339.755n 0.0v 344.745n 0.0v 344.755n 0.0v 349.745n 0.0v 349.755n 0.0v 354.745n 0.0v 354.755n 0.0v 359.745n 0.0v 359.755n 1.1v 364.745n 1.1v 364.755n 1.1v 369.745n 1.1v 369.755n 1.1v 374.745n 1.1v 374.755n 1.1v 379.745n 1.1v 379.755n 1.1v 384.745n 1.1v 384.755n 1.1v 389.745n 1.1v 389.755n 1.1v 394.745n 1.1v 394.755n 1.1v 399.745n 1.1v 399.755n 1.1v 404.745n 1.1v 404.755n 1.1v 409.745n 1.1v 409.755n 0.0v 414.745n 0.0v 414.755n 0.0v 419.745n 0.0v 419.755n 0.0v 424.745n 0.0v 424.755n 0.0v 429.745n 0.0v 429.755n 0.0v 434.745n 0.0v 434.755n 1.1v 439.745n 1.1v 439.755n 0.0v 444.745n 0.0v 444.755n 0.0v 449.745n 0.0v 449.755n 0.0v 454.745n 0.0v 454.755n 1.1v 459.745n 1.1v 459.755n 0.0v 464.745n 0.0v 464.755n 0.0v 469.745n 0.0v 469.755n 0.0v 474.745n 0.0v 474.755n 1.1v 479.745n 1.1v 479.755n 1.1v 484.745n 1.1v 484.755n 1.1v 489.745n 1.1v 489.755n 1.1v 494.745n 1.1v 494.755n 1.1v 499.745n 1.1v 499.755n 1.1v 504.745n 1.1v 504.755n 1.1v 509.745n 1.1v 509.755n 1.1v 514.745n 1.1v 514.755n 1.1v 519.745n 1.1v 519.755n 1.1v 524.745n 1.1v 524.755n 1.1v 529.745n 1.1v 529.755n 1.1v 534.745n 1.1v 534.755n 1.1v 539.745n 1.1v 539.755n 1.1v 544.745n 1.1v 544.755n 1.1v 549.745n 1.1v 549.755n 0.0v 554.745n 0.0v 554.755n 0.0v 559.745n 0.0v 559.755n 0.0v 564.745n 0.0v 564.755n 0.0v 569.745n 0.0v 569.755n 0.0v 574.745n 0.0v 574.755n 0.0v 579.745n 0.0v 579.755n 1.1v 584.745n 1.1v 584.755n 1.1v 589.745n 1.1v 589.755n 1.1v 594.745n 1.1v 594.755n 1.1v 599.745n 1.1v 599.755n 1.1v 604.745n 1.1v 604.755n 1.1v 609.745n 1.1v 609.755n 1.1v 614.745n 1.1v 614.755n 1.1v 619.745n 1.1v 619.755n 0.0v 624.745n 0.0v 624.755n 0.0v 629.745n 0.0v 629.755n 1.1v 634.745n 1.1v 634.755n 1.1v 639.745n 1.1v 639.755n 0.0v 644.745n 0.0v 644.755n 0.0v 649.745n 0.0v 649.755n 0.0v 654.745n 0.0v 654.755n 0.0v 659.745n 0.0v 659.755n 0.0v 664.745n 0.0v 664.755n 0.0v 669.745n 0.0v 669.755n 0.0v 674.745n 0.0v 674.755n 0.0v 679.745n 0.0v 679.755n 0.0v 684.745n 0.0v 684.755n 0.0v 689.745n 0.0v 689.755n 0.0v 694.745n 0.0v 694.755n 0.0v 699.745n 0.0v 699.755n 1.1v 704.745n 1.1v 704.755n 1.1v 709.745n 1.1v 709.755n 1.1v 714.745n 1.1v 714.755n 1.1v 719.745n 1.1v 719.755n 1.1v 724.745n 1.1v 724.755n 1.1v 729.745n 1.1v 729.755n 0.0v 734.745n 0.0v 734.755n 0.0v 739.745n 0.0v 739.755n 0.0v 744.745n 0.0v 744.755n 0.0v 749.745n 0.0v 749.755n 0.0v 754.745n 0.0v 754.755n 1.1v 759.745n 1.1v 759.755n 1.1v 764.745n 1.1v 764.755n 0.0v 769.745n 0.0v 769.755n 0.0v 774.745n 0.0v 774.755n 0.0v 779.745n 0.0v 779.755n 0.0v 784.745n 0.0v 784.755n 1.1v 789.745n 1.1v 789.755n 1.1v 794.745n 1.1v 794.755n 1.1v 799.745n 1.1v 799.755n 1.1v 804.745n 1.1v 804.755n 0.0v 809.745n 0.0v 809.755n 0.0v 814.745n 0.0v 814.755n 1.1v 819.745n 1.1v 819.755n 1.1v 824.745n 1.1v 824.755n 1.1v 829.745n 1.1v 829.755n 0.0v 834.745n 0.0v 834.755n 1.1v 839.745n 1.1v 839.755n 1.1v 844.745n 1.1v 844.755n 1.1v 849.745n 1.1v 849.755n 1.1v 854.745n 1.1v 854.755n 1.1v 859.745n 1.1v 859.755n 1.1v 864.745n 1.1v 864.755n 0.0v 869.745n 0.0v 869.755n 0.0v 874.745n 0.0v 874.755n 0.0v 879.745n 0.0v 879.755n 0.0v 884.745n 0.0v 884.755n 0.0v 889.745n 0.0v 889.755n 0.0v 894.745n 0.0v 894.755n 0.0v 899.745n 0.0v 899.755n 0.0v 904.745n 0.0v 904.755n 1.1v 909.745n 1.1v 909.755n 1.1v 914.745n 1.1v 914.755n 1.1v 919.745n 1.1v 919.755n 1.1v 924.745n 1.1v 924.755n 1.1v 929.745n 1.1v 929.755n 1.1v 934.745n 1.1v 934.755n 1.1v 939.745n 1.1v 939.755n 1.1v 944.745n 1.1v 944.755n 1.1v 949.745n 1.1v 949.755n 1.1v 954.745n 1.1v 954.755n 1.1v 959.745n 1.1v 959.755n 1.1v 964.745n 1.1v 964.755n 1.1v 969.745n 1.1v 969.755n 1.1v 974.745n 1.1v 974.755n 1.1v 979.745n 1.1v 979.755n 1.1v 984.745n 1.1v 984.755n 1.1v 989.745n 1.1v 989.755n 0.0v 994.745n 0.0v 994.755n 0.0v 999.745n 0.0v 999.755n 1.1v 1004.745n 1.1v 1004.755n 1.1v 1009.745n 1.1v 1009.755n 0.0v 1014.745n 0.0v 1014.755n 0.0v 1019.745n 0.0v 1019.755n 0.0v 1024.745n 0.0v 1024.755n 0.0v )
* PULSE: period=5
Vclk0 clk0 0 PULSE (0 1.1 4.995n 0.01n 0.01n 2.49n 5n)

 * Generation of dout measurements
* CHECK dout0_0 vdout0_0ck4 = 1.1 time = 25
* CHECK dout0_1 vdout0_1ck4 = 1.1 time = 25
* CHECK dout0_2 vdout0_2ck4 = 0 time = 25
* CHECK dout0_3 vdout0_3ck4 = 1.1 time = 25
* CHECK dout0_4 vdout0_4ck4 = 1.1 time = 25
* CHECK dout0_5 vdout0_5ck4 = 1.1 time = 25
* CHECK dout0_6 vdout0_6ck4 = 1.1 time = 25
* CHECK dout0_7 vdout0_7ck4 = 0 time = 25
* CHECK dout0_8 vdout0_8ck4 = 1.1 time = 25
* CHECK dout0_9 vdout0_9ck4 = 0 time = 25
* CHECK dout0_10 vdout0_10ck4 = 0 time = 25
* CHECK dout0_11 vdout0_11ck4 = 0 time = 25
* CHECK dout0_12 vdout0_12ck4 = 1.1 time = 25
* CHECK dout0_13 vdout0_13ck4 = 0 time = 25
* CHECK dout0_14 vdout0_14ck4 = 0 time = 25
* CHECK dout0_15 vdout0_15ck4 = 1.1 time = 25
* CHECK dout0_16 vdout0_16ck4 = 1.1 time = 25
* CHECK dout0_17 vdout0_17ck4 = 1.1 time = 25
* CHECK dout0_18 vdout0_18ck4 = 1.1 time = 25
* CHECK dout0_19 vdout0_19ck4 = 0 time = 25
* CHECK dout0_20 vdout0_20ck4 = 0 time = 25
* CHECK dout0_21 vdout0_21ck4 = 0 time = 25
* CHECK dout0_22 vdout0_22ck4 = 0 time = 25
* CHECK dout0_23 vdout0_23ck4 = 1.1 time = 25
* CHECK dout0_24 vdout0_24ck4 = 1.1 time = 25
* CHECK dout0_25 vdout0_25ck4 = 0 time = 25
* CHECK dout0_26 vdout0_26ck4 = 1.1 time = 25
* CHECK dout0_27 vdout0_27ck4 = 1.1 time = 25
* CHECK dout0_28 vdout0_28ck4 = 1.1 time = 25
* CHECK dout0_29 vdout0_29ck4 = 0 time = 25
* CHECK dout0_30 vdout0_30ck4 = 0 time = 25
* CHECK dout0_31 vdout0_31ck4 = 1.1 time = 25
* CHECK dout0_0 vdout0_0ck5 = 0 time = 30
* CHECK dout0_1 vdout0_1ck5 = 0 time = 30
* CHECK dout0_2 vdout0_2ck5 = 1.1 time = 30
* CHECK dout0_3 vdout0_3ck5 = 1.1 time = 30
* CHECK dout0_4 vdout0_4ck5 = 0 time = 30
* CHECK dout0_5 vdout0_5ck5 = 0 time = 30
* CHECK dout0_6 vdout0_6ck5 = 1.1 time = 30
* CHECK dout0_7 vdout0_7ck5 = 0 time = 30
* CHECK dout0_8 vdout0_8ck5 = 0 time = 30
* CHECK dout0_9 vdout0_9ck5 = 0 time = 30
* CHECK dout0_10 vdout0_10ck5 = 0 time = 30
* CHECK dout0_11 vdout0_11ck5 = 0 time = 30
* CHECK dout0_12 vdout0_12ck5 = 0 time = 30
* CHECK dout0_13 vdout0_13ck5 = 0 time = 30
* CHECK dout0_14 vdout0_14ck5 = 1.1 time = 30
* CHECK dout0_15 vdout0_15ck5 = 1.1 time = 30
* CHECK dout0_16 vdout0_16ck5 = 0 time = 30
* CHECK dout0_17 vdout0_17ck5 = 1.1 time = 30
* CHECK dout0_18 vdout0_18ck5 = 0 time = 30
* CHECK dout0_19 vdout0_19ck5 = 0 time = 30
* CHECK dout0_20 vdout0_20ck5 = 0 time = 30
* CHECK dout0_21 vdout0_21ck5 = 1.1 time = 30
* CHECK dout0_22 vdout0_22ck5 = 0 time = 30
* CHECK dout0_23 vdout0_23ck5 = 1.1 time = 30
* CHECK dout0_24 vdout0_24ck5 = 0 time = 30
* CHECK dout0_25 vdout0_25ck5 = 1.1 time = 30
* CHECK dout0_26 vdout0_26ck5 = 1.1 time = 30
* CHECK dout0_27 vdout0_27ck5 = 0 time = 30
* CHECK dout0_28 vdout0_28ck5 = 1.1 time = 30
* CHECK dout0_29 vdout0_29ck5 = 1.1 time = 30
* CHECK dout0_30 vdout0_30ck5 = 1.1 time = 30
* CHECK dout0_31 vdout0_31ck5 = 1.1 time = 30
* CHECK dout0_0 vdout0_0ck6 = 1.1 time = 35
* CHECK dout0_1 vdout0_1ck6 = 1.1 time = 35
* CHECK dout0_2 vdout0_2ck6 = 0 time = 35
* CHECK dout0_3 vdout0_3ck6 = 1.1 time = 35
* CHECK dout0_4 vdout0_4ck6 = 1.1 time = 35
* CHECK dout0_5 vdout0_5ck6 = 1.1 time = 35
* CHECK dout0_6 vdout0_6ck6 = 1.1 time = 35
* CHECK dout0_7 vdout0_7ck6 = 0 time = 35
* CHECK dout0_8 vdout0_8ck6 = 1.1 time = 35
* CHECK dout0_9 vdout0_9ck6 = 0 time = 35
* CHECK dout0_10 vdout0_10ck6 = 0 time = 35
* CHECK dout0_11 vdout0_11ck6 = 0 time = 35
* CHECK dout0_12 vdout0_12ck6 = 1.1 time = 35
* CHECK dout0_13 vdout0_13ck6 = 0 time = 35
* CHECK dout0_14 vdout0_14ck6 = 0 time = 35
* CHECK dout0_15 vdout0_15ck6 = 1.1 time = 35
* CHECK dout0_16 vdout0_16ck6 = 1.1 time = 35
* CHECK dout0_17 vdout0_17ck6 = 1.1 time = 35
* CHECK dout0_18 vdout0_18ck6 = 1.1 time = 35
* CHECK dout0_19 vdout0_19ck6 = 0 time = 35
* CHECK dout0_20 vdout0_20ck6 = 0 time = 35
* CHECK dout0_21 vdout0_21ck6 = 0 time = 35
* CHECK dout0_22 vdout0_22ck6 = 0 time = 35
* CHECK dout0_23 vdout0_23ck6 = 1.1 time = 35
* CHECK dout0_24 vdout0_24ck6 = 1.1 time = 35
* CHECK dout0_25 vdout0_25ck6 = 0 time = 35
* CHECK dout0_26 vdout0_26ck6 = 1.1 time = 35
* CHECK dout0_27 vdout0_27ck6 = 1.1 time = 35
* CHECK dout0_28 vdout0_28ck6 = 1.1 time = 35
* CHECK dout0_29 vdout0_29ck6 = 0 time = 35
* CHECK dout0_30 vdout0_30ck6 = 0 time = 35
* CHECK dout0_31 vdout0_31ck6 = 1.1 time = 35
* CHECK dout0_0 vdout0_0ck8 = 1.1 time = 45
* CHECK dout0_1 vdout0_1ck8 = 1.1 time = 45
* CHECK dout0_2 vdout0_2ck8 = 0 time = 45
* CHECK dout0_3 vdout0_3ck8 = 1.1 time = 45
* CHECK dout0_4 vdout0_4ck8 = 1.1 time = 45
* CHECK dout0_5 vdout0_5ck8 = 1.1 time = 45
* CHECK dout0_6 vdout0_6ck8 = 1.1 time = 45
* CHECK dout0_7 vdout0_7ck8 = 0 time = 45
* CHECK dout0_8 vdout0_8ck8 = 1.1 time = 45
* CHECK dout0_9 vdout0_9ck8 = 0 time = 45
* CHECK dout0_10 vdout0_10ck8 = 0 time = 45
* CHECK dout0_11 vdout0_11ck8 = 0 time = 45
* CHECK dout0_12 vdout0_12ck8 = 1.1 time = 45
* CHECK dout0_13 vdout0_13ck8 = 0 time = 45
* CHECK dout0_14 vdout0_14ck8 = 0 time = 45
* CHECK dout0_15 vdout0_15ck8 = 1.1 time = 45
* CHECK dout0_16 vdout0_16ck8 = 0 time = 45
* CHECK dout0_17 vdout0_17ck8 = 1.1 time = 45
* CHECK dout0_18 vdout0_18ck8 = 1.1 time = 45
* CHECK dout0_19 vdout0_19ck8 = 0 time = 45
* CHECK dout0_20 vdout0_20ck8 = 1.1 time = 45
* CHECK dout0_21 vdout0_21ck8 = 1.1 time = 45
* CHECK dout0_22 vdout0_22ck8 = 1.1 time = 45
* CHECK dout0_23 vdout0_23ck8 = 1.1 time = 45
* CHECK dout0_24 vdout0_24ck8 = 1.1 time = 45
* CHECK dout0_25 vdout0_25ck8 = 0 time = 45
* CHECK dout0_26 vdout0_26ck8 = 1.1 time = 45
* CHECK dout0_27 vdout0_27ck8 = 1.1 time = 45
* CHECK dout0_28 vdout0_28ck8 = 1.1 time = 45
* CHECK dout0_29 vdout0_29ck8 = 0 time = 45
* CHECK dout0_30 vdout0_30ck8 = 0 time = 45
* CHECK dout0_31 vdout0_31ck8 = 1.1 time = 45
* CHECK dout0_0 vdout0_0ck14 = 0 time = 75
* CHECK dout0_1 vdout0_1ck14 = 0 time = 75
* CHECK dout0_2 vdout0_2ck14 = 1.1 time = 75
* CHECK dout0_3 vdout0_3ck14 = 1.1 time = 75
* CHECK dout0_4 vdout0_4ck14 = 0 time = 75
* CHECK dout0_5 vdout0_5ck14 = 0 time = 75
* CHECK dout0_6 vdout0_6ck14 = 1.1 time = 75
* CHECK dout0_7 vdout0_7ck14 = 0 time = 75
* CHECK dout0_8 vdout0_8ck14 = 0 time = 75
* CHECK dout0_9 vdout0_9ck14 = 0 time = 75
* CHECK dout0_10 vdout0_10ck14 = 0 time = 75
* CHECK dout0_11 vdout0_11ck14 = 0 time = 75
* CHECK dout0_12 vdout0_12ck14 = 0 time = 75
* CHECK dout0_13 vdout0_13ck14 = 0 time = 75
* CHECK dout0_14 vdout0_14ck14 = 1.1 time = 75
* CHECK dout0_15 vdout0_15ck14 = 1.1 time = 75
* CHECK dout0_16 vdout0_16ck14 = 1.1 time = 75
* CHECK dout0_17 vdout0_17ck14 = 1.1 time = 75
* CHECK dout0_18 vdout0_18ck14 = 1.1 time = 75
* CHECK dout0_19 vdout0_19ck14 = 1.1 time = 75
* CHECK dout0_20 vdout0_20ck14 = 1.1 time = 75
* CHECK dout0_21 vdout0_21ck14 = 0 time = 75
* CHECK dout0_22 vdout0_22ck14 = 1.1 time = 75
* CHECK dout0_23 vdout0_23ck14 = 0 time = 75
* CHECK dout0_24 vdout0_24ck14 = 1.1 time = 75
* CHECK dout0_25 vdout0_25ck14 = 0 time = 75
* CHECK dout0_26 vdout0_26ck14 = 1.1 time = 75
* CHECK dout0_27 vdout0_27ck14 = 1.1 time = 75
* CHECK dout0_28 vdout0_28ck14 = 0 time = 75
* CHECK dout0_29 vdout0_29ck14 = 1.1 time = 75
* CHECK dout0_30 vdout0_30ck14 = 0 time = 75
* CHECK dout0_31 vdout0_31ck14 = 1.1 time = 75
* CHECK dout0_0 vdout0_0ck17 = 0 time = 90
* CHECK dout0_1 vdout0_1ck17 = 0 time = 90
* CHECK dout0_2 vdout0_2ck17 = 0 time = 90
* CHECK dout0_3 vdout0_3ck17 = 0 time = 90
* CHECK dout0_4 vdout0_4ck17 = 0 time = 90
* CHECK dout0_5 vdout0_5ck17 = 0 time = 90
* CHECK dout0_6 vdout0_6ck17 = 1.1 time = 90
* CHECK dout0_7 vdout0_7ck17 = 1.1 time = 90
* CHECK dout0_8 vdout0_8ck17 = 0 time = 90
* CHECK dout0_9 vdout0_9ck17 = 1.1 time = 90
* CHECK dout0_10 vdout0_10ck17 = 1.1 time = 90
* CHECK dout0_11 vdout0_11ck17 = 0 time = 90
* CHECK dout0_12 vdout0_12ck17 = 0 time = 90
* CHECK dout0_13 vdout0_13ck17 = 1.1 time = 90
* CHECK dout0_14 vdout0_14ck17 = 1.1 time = 90
* CHECK dout0_15 vdout0_15ck17 = 0 time = 90
* CHECK dout0_16 vdout0_16ck17 = 0 time = 90
* CHECK dout0_17 vdout0_17ck17 = 0 time = 90
* CHECK dout0_18 vdout0_18ck17 = 0 time = 90
* CHECK dout0_19 vdout0_19ck17 = 1.1 time = 90
* CHECK dout0_20 vdout0_20ck17 = 1.1 time = 90
* CHECK dout0_21 vdout0_21ck17 = 0 time = 90
* CHECK dout0_22 vdout0_22ck17 = 1.1 time = 90
* CHECK dout0_23 vdout0_23ck17 = 1.1 time = 90
* CHECK dout0_24 vdout0_24ck17 = 0 time = 90
* CHECK dout0_25 vdout0_25ck17 = 1.1 time = 90
* CHECK dout0_26 vdout0_26ck17 = 1.1 time = 90
* CHECK dout0_27 vdout0_27ck17 = 1.1 time = 90
* CHECK dout0_28 vdout0_28ck17 = 1.1 time = 90
* CHECK dout0_29 vdout0_29ck17 = 1.1 time = 90
* CHECK dout0_30 vdout0_30ck17 = 0 time = 90
* CHECK dout0_31 vdout0_31ck17 = 1.1 time = 90
* CHECK dout0_0 vdout0_0ck18 = 0 time = 95
* CHECK dout0_1 vdout0_1ck18 = 0 time = 95
* CHECK dout0_2 vdout0_2ck18 = 0 time = 95
* CHECK dout0_3 vdout0_3ck18 = 0 time = 95
* CHECK dout0_4 vdout0_4ck18 = 0 time = 95
* CHECK dout0_5 vdout0_5ck18 = 0 time = 95
* CHECK dout0_6 vdout0_6ck18 = 1.1 time = 95
* CHECK dout0_7 vdout0_7ck18 = 1.1 time = 95
* CHECK dout0_8 vdout0_8ck18 = 0 time = 95
* CHECK dout0_9 vdout0_9ck18 = 1.1 time = 95
* CHECK dout0_10 vdout0_10ck18 = 1.1 time = 95
* CHECK dout0_11 vdout0_11ck18 = 0 time = 95
* CHECK dout0_12 vdout0_12ck18 = 0 time = 95
* CHECK dout0_13 vdout0_13ck18 = 1.1 time = 95
* CHECK dout0_14 vdout0_14ck18 = 1.1 time = 95
* CHECK dout0_15 vdout0_15ck18 = 0 time = 95
* CHECK dout0_16 vdout0_16ck18 = 0 time = 95
* CHECK dout0_17 vdout0_17ck18 = 0 time = 95
* CHECK dout0_18 vdout0_18ck18 = 0 time = 95
* CHECK dout0_19 vdout0_19ck18 = 1.1 time = 95
* CHECK dout0_20 vdout0_20ck18 = 1.1 time = 95
* CHECK dout0_21 vdout0_21ck18 = 0 time = 95
* CHECK dout0_22 vdout0_22ck18 = 1.1 time = 95
* CHECK dout0_23 vdout0_23ck18 = 1.1 time = 95
* CHECK dout0_24 vdout0_24ck18 = 0 time = 95
* CHECK dout0_25 vdout0_25ck18 = 1.1 time = 95
* CHECK dout0_26 vdout0_26ck18 = 1.1 time = 95
* CHECK dout0_27 vdout0_27ck18 = 1.1 time = 95
* CHECK dout0_28 vdout0_28ck18 = 1.1 time = 95
* CHECK dout0_29 vdout0_29ck18 = 1.1 time = 95
* CHECK dout0_30 vdout0_30ck18 = 0 time = 95
* CHECK dout0_31 vdout0_31ck18 = 1.1 time = 95
* CHECK dout0_0 vdout0_0ck19 = 1.1 time = 100
* CHECK dout0_1 vdout0_1ck19 = 1.1 time = 100
* CHECK dout0_2 vdout0_2ck19 = 0 time = 100
* CHECK dout0_3 vdout0_3ck19 = 1.1 time = 100
* CHECK dout0_4 vdout0_4ck19 = 1.1 time = 100
* CHECK dout0_5 vdout0_5ck19 = 1.1 time = 100
* CHECK dout0_6 vdout0_6ck19 = 1.1 time = 100
* CHECK dout0_7 vdout0_7ck19 = 0 time = 100
* CHECK dout0_8 vdout0_8ck19 = 0 time = 100
* CHECK dout0_9 vdout0_9ck19 = 0 time = 100
* CHECK dout0_10 vdout0_10ck19 = 0 time = 100
* CHECK dout0_11 vdout0_11ck19 = 0 time = 100
* CHECK dout0_12 vdout0_12ck19 = 0 time = 100
* CHECK dout0_13 vdout0_13ck19 = 1.1 time = 100
* CHECK dout0_14 vdout0_14ck19 = 0 time = 100
* CHECK dout0_15 vdout0_15ck19 = 1.1 time = 100
* CHECK dout0_16 vdout0_16ck19 = 0 time = 100
* CHECK dout0_17 vdout0_17ck19 = 1.1 time = 100
* CHECK dout0_18 vdout0_18ck19 = 1.1 time = 100
* CHECK dout0_19 vdout0_19ck19 = 0 time = 100
* CHECK dout0_20 vdout0_20ck19 = 0 time = 100
* CHECK dout0_21 vdout0_21ck19 = 0 time = 100
* CHECK dout0_22 vdout0_22ck19 = 0 time = 100
* CHECK dout0_23 vdout0_23ck19 = 0 time = 100
* CHECK dout0_24 vdout0_24ck19 = 0 time = 100
* CHECK dout0_25 vdout0_25ck19 = 0 time = 100
* CHECK dout0_26 vdout0_26ck19 = 0 time = 100
* CHECK dout0_27 vdout0_27ck19 = 0 time = 100
* CHECK dout0_28 vdout0_28ck19 = 0 time = 100
* CHECK dout0_29 vdout0_29ck19 = 0 time = 100
* CHECK dout0_30 vdout0_30ck19 = 0 time = 100
* CHECK dout0_31 vdout0_31ck19 = 1.1 time = 100
* CHECK dout0_0 vdout0_0ck20 = 1.1 time = 105
* CHECK dout0_1 vdout0_1ck20 = 1.1 time = 105
* CHECK dout0_2 vdout0_2ck20 = 0 time = 105
* CHECK dout0_3 vdout0_3ck20 = 1.1 time = 105
* CHECK dout0_4 vdout0_4ck20 = 1.1 time = 105
* CHECK dout0_5 vdout0_5ck20 = 1.1 time = 105
* CHECK dout0_6 vdout0_6ck20 = 1.1 time = 105
* CHECK dout0_7 vdout0_7ck20 = 0 time = 105
* CHECK dout0_8 vdout0_8ck20 = 0 time = 105
* CHECK dout0_9 vdout0_9ck20 = 0 time = 105
* CHECK dout0_10 vdout0_10ck20 = 0 time = 105
* CHECK dout0_11 vdout0_11ck20 = 0 time = 105
* CHECK dout0_12 vdout0_12ck20 = 0 time = 105
* CHECK dout0_13 vdout0_13ck20 = 1.1 time = 105
* CHECK dout0_14 vdout0_14ck20 = 0 time = 105
* CHECK dout0_15 vdout0_15ck20 = 1.1 time = 105
* CHECK dout0_16 vdout0_16ck20 = 0 time = 105
* CHECK dout0_17 vdout0_17ck20 = 1.1 time = 105
* CHECK dout0_18 vdout0_18ck20 = 1.1 time = 105
* CHECK dout0_19 vdout0_19ck20 = 0 time = 105
* CHECK dout0_20 vdout0_20ck20 = 0 time = 105
* CHECK dout0_21 vdout0_21ck20 = 0 time = 105
* CHECK dout0_22 vdout0_22ck20 = 0 time = 105
* CHECK dout0_23 vdout0_23ck20 = 0 time = 105
* CHECK dout0_24 vdout0_24ck20 = 0 time = 105
* CHECK dout0_25 vdout0_25ck20 = 0 time = 105
* CHECK dout0_26 vdout0_26ck20 = 0 time = 105
* CHECK dout0_27 vdout0_27ck20 = 0 time = 105
* CHECK dout0_28 vdout0_28ck20 = 0 time = 105
* CHECK dout0_29 vdout0_29ck20 = 0 time = 105
* CHECK dout0_30 vdout0_30ck20 = 0 time = 105
* CHECK dout0_31 vdout0_31ck20 = 1.1 time = 105
* CHECK dout0_0 vdout0_0ck22 = 1.1 time = 115
* CHECK dout0_1 vdout0_1ck22 = 1.1 time = 115
* CHECK dout0_2 vdout0_2ck22 = 0 time = 115
* CHECK dout0_3 vdout0_3ck22 = 1.1 time = 115
* CHECK dout0_4 vdout0_4ck22 = 1.1 time = 115
* CHECK dout0_5 vdout0_5ck22 = 1.1 time = 115
* CHECK dout0_6 vdout0_6ck22 = 1.1 time = 115
* CHECK dout0_7 vdout0_7ck22 = 0 time = 115
* CHECK dout0_8 vdout0_8ck22 = 0 time = 115
* CHECK dout0_9 vdout0_9ck22 = 0 time = 115
* CHECK dout0_10 vdout0_10ck22 = 0 time = 115
* CHECK dout0_11 vdout0_11ck22 = 0 time = 115
* CHECK dout0_12 vdout0_12ck22 = 0 time = 115
* CHECK dout0_13 vdout0_13ck22 = 1.1 time = 115
* CHECK dout0_14 vdout0_14ck22 = 0 time = 115
* CHECK dout0_15 vdout0_15ck22 = 1.1 time = 115
* CHECK dout0_16 vdout0_16ck22 = 0 time = 115
* CHECK dout0_17 vdout0_17ck22 = 1.1 time = 115
* CHECK dout0_18 vdout0_18ck22 = 1.1 time = 115
* CHECK dout0_19 vdout0_19ck22 = 0 time = 115
* CHECK dout0_20 vdout0_20ck22 = 0 time = 115
* CHECK dout0_21 vdout0_21ck22 = 0 time = 115
* CHECK dout0_22 vdout0_22ck22 = 0 time = 115
* CHECK dout0_23 vdout0_23ck22 = 0 time = 115
* CHECK dout0_24 vdout0_24ck22 = 0 time = 115
* CHECK dout0_25 vdout0_25ck22 = 0 time = 115
* CHECK dout0_26 vdout0_26ck22 = 0 time = 115
* CHECK dout0_27 vdout0_27ck22 = 0 time = 115
* CHECK dout0_28 vdout0_28ck22 = 0 time = 115
* CHECK dout0_29 vdout0_29ck22 = 0 time = 115
* CHECK dout0_30 vdout0_30ck22 = 0 time = 115
* CHECK dout0_31 vdout0_31ck22 = 1.1 time = 115
* CHECK dout0_0 vdout0_0ck24 = 0 time = 125
* CHECK dout0_1 vdout0_1ck24 = 0 time = 125
* CHECK dout0_2 vdout0_2ck24 = 1.1 time = 125
* CHECK dout0_3 vdout0_3ck24 = 1.1 time = 125
* CHECK dout0_4 vdout0_4ck24 = 0 time = 125
* CHECK dout0_5 vdout0_5ck24 = 0 time = 125
* CHECK dout0_6 vdout0_6ck24 = 1.1 time = 125
* CHECK dout0_7 vdout0_7ck24 = 0 time = 125
* CHECK dout0_8 vdout0_8ck24 = 0 time = 125
* CHECK dout0_9 vdout0_9ck24 = 0 time = 125
* CHECK dout0_10 vdout0_10ck24 = 0 time = 125
* CHECK dout0_11 vdout0_11ck24 = 0 time = 125
* CHECK dout0_12 vdout0_12ck24 = 0 time = 125
* CHECK dout0_13 vdout0_13ck24 = 0 time = 125
* CHECK dout0_14 vdout0_14ck24 = 1.1 time = 125
* CHECK dout0_15 vdout0_15ck24 = 1.1 time = 125
* CHECK dout0_16 vdout0_16ck24 = 0 time = 125
* CHECK dout0_17 vdout0_17ck24 = 1.1 time = 125
* CHECK dout0_18 vdout0_18ck24 = 1.1 time = 125
* CHECK dout0_19 vdout0_19ck24 = 0 time = 125
* CHECK dout0_20 vdout0_20ck24 = 0 time = 125
* CHECK dout0_21 vdout0_21ck24 = 0 time = 125
* CHECK dout0_22 vdout0_22ck24 = 0 time = 125
* CHECK dout0_23 vdout0_23ck24 = 1.1 time = 125
* CHECK dout0_24 vdout0_24ck24 = 1.1 time = 125
* CHECK dout0_25 vdout0_25ck24 = 0 time = 125
* CHECK dout0_26 vdout0_26ck24 = 1.1 time = 125
* CHECK dout0_27 vdout0_27ck24 = 1.1 time = 125
* CHECK dout0_28 vdout0_28ck24 = 0 time = 125
* CHECK dout0_29 vdout0_29ck24 = 1.1 time = 125
* CHECK dout0_30 vdout0_30ck24 = 0 time = 125
* CHECK dout0_31 vdout0_31ck24 = 1.1 time = 125
* CHECK dout0_0 vdout0_0ck25 = 0 time = 130
* CHECK dout0_1 vdout0_1ck25 = 0 time = 130
* CHECK dout0_2 vdout0_2ck25 = 0 time = 130
* CHECK dout0_3 vdout0_3ck25 = 0 time = 130
* CHECK dout0_4 vdout0_4ck25 = 0 time = 130
* CHECK dout0_5 vdout0_5ck25 = 0 time = 130
* CHECK dout0_6 vdout0_6ck25 = 1.1 time = 130
* CHECK dout0_7 vdout0_7ck25 = 1.1 time = 130
* CHECK dout0_8 vdout0_8ck25 = 0 time = 130
* CHECK dout0_9 vdout0_9ck25 = 1.1 time = 130
* CHECK dout0_10 vdout0_10ck25 = 1.1 time = 130
* CHECK dout0_11 vdout0_11ck25 = 0 time = 130
* CHECK dout0_12 vdout0_12ck25 = 0 time = 130
* CHECK dout0_13 vdout0_13ck25 = 1.1 time = 130
* CHECK dout0_14 vdout0_14ck25 = 1.1 time = 130
* CHECK dout0_15 vdout0_15ck25 = 0 time = 130
* CHECK dout0_16 vdout0_16ck25 = 0 time = 130
* CHECK dout0_17 vdout0_17ck25 = 0 time = 130
* CHECK dout0_18 vdout0_18ck25 = 0 time = 130
* CHECK dout0_19 vdout0_19ck25 = 1.1 time = 130
* CHECK dout0_20 vdout0_20ck25 = 1.1 time = 130
* CHECK dout0_21 vdout0_21ck25 = 0 time = 130
* CHECK dout0_22 vdout0_22ck25 = 1.1 time = 130
* CHECK dout0_23 vdout0_23ck25 = 1.1 time = 130
* CHECK dout0_24 vdout0_24ck25 = 0 time = 130
* CHECK dout0_25 vdout0_25ck25 = 1.1 time = 130
* CHECK dout0_26 vdout0_26ck25 = 1.1 time = 130
* CHECK dout0_27 vdout0_27ck25 = 1.1 time = 130
* CHECK dout0_28 vdout0_28ck25 = 1.1 time = 130
* CHECK dout0_29 vdout0_29ck25 = 1.1 time = 130
* CHECK dout0_30 vdout0_30ck25 = 0 time = 130
* CHECK dout0_31 vdout0_31ck25 = 1.1 time = 130
* CHECK dout0_0 vdout0_0ck32 = 1.1 time = 165
* CHECK dout0_1 vdout0_1ck32 = 0 time = 165
* CHECK dout0_2 vdout0_2ck32 = 0 time = 165
* CHECK dout0_3 vdout0_3ck32 = 1.1 time = 165
* CHECK dout0_4 vdout0_4ck32 = 1.1 time = 165
* CHECK dout0_5 vdout0_5ck32 = 0 time = 165
* CHECK dout0_6 vdout0_6ck32 = 1.1 time = 165
* CHECK dout0_7 vdout0_7ck32 = 0 time = 165
* CHECK dout0_8 vdout0_8ck32 = 0 time = 165
* CHECK dout0_9 vdout0_9ck32 = 1.1 time = 165
* CHECK dout0_10 vdout0_10ck32 = 1.1 time = 165
* CHECK dout0_11 vdout0_11ck32 = 0 time = 165
* CHECK dout0_12 vdout0_12ck32 = 0 time = 165
* CHECK dout0_13 vdout0_13ck32 = 1.1 time = 165
* CHECK dout0_14 vdout0_14ck32 = 1.1 time = 165
* CHECK dout0_15 vdout0_15ck32 = 0 time = 165
* CHECK dout0_16 vdout0_16ck32 = 1.1 time = 165
* CHECK dout0_17 vdout0_17ck32 = 0 time = 165
* CHECK dout0_18 vdout0_18ck32 = 1.1 time = 165
* CHECK dout0_19 vdout0_19ck32 = 0 time = 165
* CHECK dout0_20 vdout0_20ck32 = 0 time = 165
* CHECK dout0_21 vdout0_21ck32 = 0 time = 165
* CHECK dout0_22 vdout0_22ck32 = 1.1 time = 165
* CHECK dout0_23 vdout0_23ck32 = 0 time = 165
* CHECK dout0_24 vdout0_24ck32 = 1.1 time = 165
* CHECK dout0_25 vdout0_25ck32 = 0 time = 165
* CHECK dout0_26 vdout0_26ck32 = 0 time = 165
* CHECK dout0_27 vdout0_27ck32 = 1.1 time = 165
* CHECK dout0_28 vdout0_28ck32 = 1.1 time = 165
* CHECK dout0_29 vdout0_29ck32 = 0 time = 165
* CHECK dout0_30 vdout0_30ck32 = 1.1 time = 165
* CHECK dout0_31 vdout0_31ck32 = 1.1 time = 165
* CHECK dout0_0 vdout0_0ck34 = 1.1 time = 175
* CHECK dout0_1 vdout0_1ck34 = 1.1 time = 175
* CHECK dout0_2 vdout0_2ck34 = 0 time = 175
* CHECK dout0_3 vdout0_3ck34 = 1.1 time = 175
* CHECK dout0_4 vdout0_4ck34 = 1.1 time = 175
* CHECK dout0_5 vdout0_5ck34 = 1.1 time = 175
* CHECK dout0_6 vdout0_6ck34 = 1.1 time = 175
* CHECK dout0_7 vdout0_7ck34 = 0 time = 175
* CHECK dout0_8 vdout0_8ck34 = 0 time = 175
* CHECK dout0_9 vdout0_9ck34 = 0 time = 175
* CHECK dout0_10 vdout0_10ck34 = 0 time = 175
* CHECK dout0_11 vdout0_11ck34 = 0 time = 175
* CHECK dout0_12 vdout0_12ck34 = 0 time = 175
* CHECK dout0_13 vdout0_13ck34 = 1.1 time = 175
* CHECK dout0_14 vdout0_14ck34 = 0 time = 175
* CHECK dout0_15 vdout0_15ck34 = 1.1 time = 175
* CHECK dout0_16 vdout0_16ck34 = 0 time = 175
* CHECK dout0_17 vdout0_17ck34 = 1.1 time = 175
* CHECK dout0_18 vdout0_18ck34 = 1.1 time = 175
* CHECK dout0_19 vdout0_19ck34 = 0 time = 175
* CHECK dout0_20 vdout0_20ck34 = 0 time = 175
* CHECK dout0_21 vdout0_21ck34 = 0 time = 175
* CHECK dout0_22 vdout0_22ck34 = 0 time = 175
* CHECK dout0_23 vdout0_23ck34 = 0 time = 175
* CHECK dout0_24 vdout0_24ck34 = 0 time = 175
* CHECK dout0_25 vdout0_25ck34 = 0 time = 175
* CHECK dout0_26 vdout0_26ck34 = 0 time = 175
* CHECK dout0_27 vdout0_27ck34 = 0 time = 175
* CHECK dout0_28 vdout0_28ck34 = 0 time = 175
* CHECK dout0_29 vdout0_29ck34 = 0 time = 175
* CHECK dout0_30 vdout0_30ck34 = 0 time = 175
* CHECK dout0_31 vdout0_31ck34 = 1.1 time = 175
* CHECK dout0_0 vdout0_0ck38 = 0 time = 195
* CHECK dout0_1 vdout0_1ck38 = 0 time = 195
* CHECK dout0_2 vdout0_2ck38 = 1.1 time = 195
* CHECK dout0_3 vdout0_3ck38 = 1.1 time = 195
* CHECK dout0_4 vdout0_4ck38 = 1.1 time = 195
* CHECK dout0_5 vdout0_5ck38 = 0 time = 195
* CHECK dout0_6 vdout0_6ck38 = 1.1 time = 195
* CHECK dout0_7 vdout0_7ck38 = 1.1 time = 195
* CHECK dout0_8 vdout0_8ck38 = 1.1 time = 195
* CHECK dout0_9 vdout0_9ck38 = 1.1 time = 195
* CHECK dout0_10 vdout0_10ck38 = 0 time = 195
* CHECK dout0_11 vdout0_11ck38 = 1.1 time = 195
* CHECK dout0_12 vdout0_12ck38 = 0 time = 195
* CHECK dout0_13 vdout0_13ck38 = 1.1 time = 195
* CHECK dout0_14 vdout0_14ck38 = 1.1 time = 195
* CHECK dout0_15 vdout0_15ck38 = 0 time = 195
* CHECK dout0_16 vdout0_16ck38 = 0 time = 195
* CHECK dout0_17 vdout0_17ck38 = 1.1 time = 195
* CHECK dout0_18 vdout0_18ck38 = 1.1 time = 195
* CHECK dout0_19 vdout0_19ck38 = 0 time = 195
* CHECK dout0_20 vdout0_20ck38 = 0 time = 195
* CHECK dout0_21 vdout0_21ck38 = 0 time = 195
* CHECK dout0_22 vdout0_22ck38 = 0 time = 195
* CHECK dout0_23 vdout0_23ck38 = 1.1 time = 195
* CHECK dout0_24 vdout0_24ck38 = 0 time = 195
* CHECK dout0_25 vdout0_25ck38 = 1.1 time = 195
* CHECK dout0_26 vdout0_26ck38 = 1.1 time = 195
* CHECK dout0_27 vdout0_27ck38 = 0 time = 195
* CHECK dout0_28 vdout0_28ck38 = 0 time = 195
* CHECK dout0_29 vdout0_29ck38 = 1.1 time = 195
* CHECK dout0_30 vdout0_30ck38 = 1.1 time = 195
* CHECK dout0_31 vdout0_31ck38 = 1.1 time = 195
* CHECK dout0_0 vdout0_0ck40 = 0 time = 205
* CHECK dout0_1 vdout0_1ck40 = 0 time = 205
* CHECK dout0_2 vdout0_2ck40 = 0 time = 205
* CHECK dout0_3 vdout0_3ck40 = 0 time = 205
* CHECK dout0_4 vdout0_4ck40 = 1.1 time = 205
* CHECK dout0_5 vdout0_5ck40 = 1.1 time = 205
* CHECK dout0_6 vdout0_6ck40 = 0 time = 205
* CHECK dout0_7 vdout0_7ck40 = 1.1 time = 205
* CHECK dout0_8 vdout0_8ck40 = 0 time = 205
* CHECK dout0_9 vdout0_9ck40 = 1.1 time = 205
* CHECK dout0_10 vdout0_10ck40 = 0 time = 205
* CHECK dout0_11 vdout0_11ck40 = 0 time = 205
* CHECK dout0_12 vdout0_12ck40 = 1.1 time = 205
* CHECK dout0_13 vdout0_13ck40 = 1.1 time = 205
* CHECK dout0_14 vdout0_14ck40 = 1.1 time = 205
* CHECK dout0_15 vdout0_15ck40 = 1.1 time = 205
* CHECK dout0_16 vdout0_16ck40 = 1.1 time = 205
* CHECK dout0_17 vdout0_17ck40 = 0 time = 205
* CHECK dout0_18 vdout0_18ck40 = 0 time = 205
* CHECK dout0_19 vdout0_19ck40 = 0 time = 205
* CHECK dout0_20 vdout0_20ck40 = 1.1 time = 205
* CHECK dout0_21 vdout0_21ck40 = 0 time = 205
* CHECK dout0_22 vdout0_22ck40 = 1.1 time = 205
* CHECK dout0_23 vdout0_23ck40 = 0 time = 205
* CHECK dout0_24 vdout0_24ck40 = 1.1 time = 205
* CHECK dout0_25 vdout0_25ck40 = 1.1 time = 205
* CHECK dout0_26 vdout0_26ck40 = 1.1 time = 205
* CHECK dout0_27 vdout0_27ck40 = 0 time = 205
* CHECK dout0_28 vdout0_28ck40 = 0 time = 205
* CHECK dout0_29 vdout0_29ck40 = 1.1 time = 205
* CHECK dout0_30 vdout0_30ck40 = 0 time = 205
* CHECK dout0_31 vdout0_31ck40 = 1.1 time = 205
* CHECK dout0_0 vdout0_0ck41 = 0 time = 210
* CHECK dout0_1 vdout0_1ck41 = 0 time = 210
* CHECK dout0_2 vdout0_2ck41 = 0 time = 210
* CHECK dout0_3 vdout0_3ck41 = 0 time = 210
* CHECK dout0_4 vdout0_4ck41 = 1.1 time = 210
* CHECK dout0_5 vdout0_5ck41 = 1.1 time = 210
* CHECK dout0_6 vdout0_6ck41 = 0 time = 210
* CHECK dout0_7 vdout0_7ck41 = 1.1 time = 210
* CHECK dout0_8 vdout0_8ck41 = 0 time = 210
* CHECK dout0_9 vdout0_9ck41 = 1.1 time = 210
* CHECK dout0_10 vdout0_10ck41 = 0 time = 210
* CHECK dout0_11 vdout0_11ck41 = 0 time = 210
* CHECK dout0_12 vdout0_12ck41 = 1.1 time = 210
* CHECK dout0_13 vdout0_13ck41 = 1.1 time = 210
* CHECK dout0_14 vdout0_14ck41 = 1.1 time = 210
* CHECK dout0_15 vdout0_15ck41 = 1.1 time = 210
* CHECK dout0_16 vdout0_16ck41 = 1.1 time = 210
* CHECK dout0_17 vdout0_17ck41 = 0 time = 210
* CHECK dout0_18 vdout0_18ck41 = 0 time = 210
* CHECK dout0_19 vdout0_19ck41 = 0 time = 210
* CHECK dout0_20 vdout0_20ck41 = 1.1 time = 210
* CHECK dout0_21 vdout0_21ck41 = 0 time = 210
* CHECK dout0_22 vdout0_22ck41 = 1.1 time = 210
* CHECK dout0_23 vdout0_23ck41 = 0 time = 210
* CHECK dout0_24 vdout0_24ck41 = 1.1 time = 210
* CHECK dout0_25 vdout0_25ck41 = 1.1 time = 210
* CHECK dout0_26 vdout0_26ck41 = 1.1 time = 210
* CHECK dout0_27 vdout0_27ck41 = 0 time = 210
* CHECK dout0_28 vdout0_28ck41 = 0 time = 210
* CHECK dout0_29 vdout0_29ck41 = 1.1 time = 210
* CHECK dout0_30 vdout0_30ck41 = 0 time = 210
* CHECK dout0_31 vdout0_31ck41 = 1.1 time = 210
* CHECK dout0_0 vdout0_0ck45 = 0 time = 230
* CHECK dout0_1 vdout0_1ck45 = 1.1 time = 230
* CHECK dout0_2 vdout0_2ck45 = 1.1 time = 230
* CHECK dout0_3 vdout0_3ck45 = 1.1 time = 230
* CHECK dout0_4 vdout0_4ck45 = 1.1 time = 230
* CHECK dout0_5 vdout0_5ck45 = 0 time = 230
* CHECK dout0_6 vdout0_6ck45 = 0 time = 230
* CHECK dout0_7 vdout0_7ck45 = 1.1 time = 230
* CHECK dout0_8 vdout0_8ck45 = 0 time = 230
* CHECK dout0_9 vdout0_9ck45 = 0 time = 230
* CHECK dout0_10 vdout0_10ck45 = 0 time = 230
* CHECK dout0_11 vdout0_11ck45 = 0 time = 230
* CHECK dout0_12 vdout0_12ck45 = 1.1 time = 230
* CHECK dout0_13 vdout0_13ck45 = 0 time = 230
* CHECK dout0_14 vdout0_14ck45 = 0 time = 230
* CHECK dout0_15 vdout0_15ck45 = 0 time = 230
* CHECK dout0_16 vdout0_16ck45 = 1.1 time = 230
* CHECK dout0_17 vdout0_17ck45 = 0 time = 230
* CHECK dout0_18 vdout0_18ck45 = 1.1 time = 230
* CHECK dout0_19 vdout0_19ck45 = 0 time = 230
* CHECK dout0_20 vdout0_20ck45 = 1.1 time = 230
* CHECK dout0_21 vdout0_21ck45 = 1.1 time = 230
* CHECK dout0_22 vdout0_22ck45 = 0 time = 230
* CHECK dout0_23 vdout0_23ck45 = 1.1 time = 230
* CHECK dout0_24 vdout0_24ck45 = 1.1 time = 230
* CHECK dout0_25 vdout0_25ck45 = 0 time = 230
* CHECK dout0_26 vdout0_26ck45 = 1.1 time = 230
* CHECK dout0_27 vdout0_27ck45 = 0 time = 230
* CHECK dout0_28 vdout0_28ck45 = 1.1 time = 230
* CHECK dout0_29 vdout0_29ck45 = 1.1 time = 230
* CHECK dout0_30 vdout0_30ck45 = 1.1 time = 230
* CHECK dout0_31 vdout0_31ck45 = 0 time = 230
* CHECK dout0_0 vdout0_0ck47 = 0 time = 240
* CHECK dout0_1 vdout0_1ck47 = 1.1 time = 240
* CHECK dout0_2 vdout0_2ck47 = 1.1 time = 240
* CHECK dout0_3 vdout0_3ck47 = 1.1 time = 240
* CHECK dout0_4 vdout0_4ck47 = 1.1 time = 240
* CHECK dout0_5 vdout0_5ck47 = 0 time = 240
* CHECK dout0_6 vdout0_6ck47 = 0 time = 240
* CHECK dout0_7 vdout0_7ck47 = 1.1 time = 240
* CHECK dout0_8 vdout0_8ck47 = 0 time = 240
* CHECK dout0_9 vdout0_9ck47 = 0 time = 240
* CHECK dout0_10 vdout0_10ck47 = 0 time = 240
* CHECK dout0_11 vdout0_11ck47 = 0 time = 240
* CHECK dout0_12 vdout0_12ck47 = 1.1 time = 240
* CHECK dout0_13 vdout0_13ck47 = 0 time = 240
* CHECK dout0_14 vdout0_14ck47 = 0 time = 240
* CHECK dout0_15 vdout0_15ck47 = 0 time = 240
* CHECK dout0_16 vdout0_16ck47 = 1.1 time = 240
* CHECK dout0_17 vdout0_17ck47 = 0 time = 240
* CHECK dout0_18 vdout0_18ck47 = 1.1 time = 240
* CHECK dout0_19 vdout0_19ck47 = 0 time = 240
* CHECK dout0_20 vdout0_20ck47 = 1.1 time = 240
* CHECK dout0_21 vdout0_21ck47 = 1.1 time = 240
* CHECK dout0_22 vdout0_22ck47 = 0 time = 240
* CHECK dout0_23 vdout0_23ck47 = 1.1 time = 240
* CHECK dout0_24 vdout0_24ck47 = 1.1 time = 240
* CHECK dout0_25 vdout0_25ck47 = 0 time = 240
* CHECK dout0_26 vdout0_26ck47 = 1.1 time = 240
* CHECK dout0_27 vdout0_27ck47 = 0 time = 240
* CHECK dout0_28 vdout0_28ck47 = 1.1 time = 240
* CHECK dout0_29 vdout0_29ck47 = 1.1 time = 240
* CHECK dout0_30 vdout0_30ck47 = 1.1 time = 240
* CHECK dout0_31 vdout0_31ck47 = 0 time = 240
* CHECK dout0_0 vdout0_0ck48 = 0 time = 245
* CHECK dout0_1 vdout0_1ck48 = 1.1 time = 245
* CHECK dout0_2 vdout0_2ck48 = 1.1 time = 245
* CHECK dout0_3 vdout0_3ck48 = 1.1 time = 245
* CHECK dout0_4 vdout0_4ck48 = 1.1 time = 245
* CHECK dout0_5 vdout0_5ck48 = 0 time = 245
* CHECK dout0_6 vdout0_6ck48 = 0 time = 245
* CHECK dout0_7 vdout0_7ck48 = 1.1 time = 245
* CHECK dout0_8 vdout0_8ck48 = 0 time = 245
* CHECK dout0_9 vdout0_9ck48 = 0 time = 245
* CHECK dout0_10 vdout0_10ck48 = 0 time = 245
* CHECK dout0_11 vdout0_11ck48 = 0 time = 245
* CHECK dout0_12 vdout0_12ck48 = 1.1 time = 245
* CHECK dout0_13 vdout0_13ck48 = 0 time = 245
* CHECK dout0_14 vdout0_14ck48 = 0 time = 245
* CHECK dout0_15 vdout0_15ck48 = 0 time = 245
* CHECK dout0_16 vdout0_16ck48 = 1.1 time = 245
* CHECK dout0_17 vdout0_17ck48 = 0 time = 245
* CHECK dout0_18 vdout0_18ck48 = 1.1 time = 245
* CHECK dout0_19 vdout0_19ck48 = 0 time = 245
* CHECK dout0_20 vdout0_20ck48 = 1.1 time = 245
* CHECK dout0_21 vdout0_21ck48 = 1.1 time = 245
* CHECK dout0_22 vdout0_22ck48 = 0 time = 245
* CHECK dout0_23 vdout0_23ck48 = 1.1 time = 245
* CHECK dout0_24 vdout0_24ck48 = 1.1 time = 245
* CHECK dout0_25 vdout0_25ck48 = 0 time = 245
* CHECK dout0_26 vdout0_26ck48 = 1.1 time = 245
* CHECK dout0_27 vdout0_27ck48 = 0 time = 245
* CHECK dout0_28 vdout0_28ck48 = 1.1 time = 245
* CHECK dout0_29 vdout0_29ck48 = 1.1 time = 245
* CHECK dout0_30 vdout0_30ck48 = 1.1 time = 245
* CHECK dout0_31 vdout0_31ck48 = 0 time = 245
* CHECK dout0_0 vdout0_0ck50 = 0 time = 255
* CHECK dout0_1 vdout0_1ck50 = 1.1 time = 255
* CHECK dout0_2 vdout0_2ck50 = 1.1 time = 255
* CHECK dout0_3 vdout0_3ck50 = 1.1 time = 255
* CHECK dout0_4 vdout0_4ck50 = 1.1 time = 255
* CHECK dout0_5 vdout0_5ck50 = 0 time = 255
* CHECK dout0_6 vdout0_6ck50 = 0 time = 255
* CHECK dout0_7 vdout0_7ck50 = 1.1 time = 255
* CHECK dout0_8 vdout0_8ck50 = 0 time = 255
* CHECK dout0_9 vdout0_9ck50 = 0 time = 255
* CHECK dout0_10 vdout0_10ck50 = 0 time = 255
* CHECK dout0_11 vdout0_11ck50 = 0 time = 255
* CHECK dout0_12 vdout0_12ck50 = 1.1 time = 255
* CHECK dout0_13 vdout0_13ck50 = 0 time = 255
* CHECK dout0_14 vdout0_14ck50 = 0 time = 255
* CHECK dout0_15 vdout0_15ck50 = 0 time = 255
* CHECK dout0_16 vdout0_16ck50 = 1.1 time = 255
* CHECK dout0_17 vdout0_17ck50 = 0 time = 255
* CHECK dout0_18 vdout0_18ck50 = 1.1 time = 255
* CHECK dout0_19 vdout0_19ck50 = 0 time = 255
* CHECK dout0_20 vdout0_20ck50 = 1.1 time = 255
* CHECK dout0_21 vdout0_21ck50 = 1.1 time = 255
* CHECK dout0_22 vdout0_22ck50 = 0 time = 255
* CHECK dout0_23 vdout0_23ck50 = 1.1 time = 255
* CHECK dout0_24 vdout0_24ck50 = 1.1 time = 255
* CHECK dout0_25 vdout0_25ck50 = 0 time = 255
* CHECK dout0_26 vdout0_26ck50 = 1.1 time = 255
* CHECK dout0_27 vdout0_27ck50 = 0 time = 255
* CHECK dout0_28 vdout0_28ck50 = 1.1 time = 255
* CHECK dout0_29 vdout0_29ck50 = 1.1 time = 255
* CHECK dout0_30 vdout0_30ck50 = 1.1 time = 255
* CHECK dout0_31 vdout0_31ck50 = 0 time = 255
* CHECK dout0_0 vdout0_0ck51 = 0 time = 260
* CHECK dout0_1 vdout0_1ck51 = 0 time = 260
* CHECK dout0_2 vdout0_2ck51 = 0 time = 260
* CHECK dout0_3 vdout0_3ck51 = 1.1 time = 260
* CHECK dout0_4 vdout0_4ck51 = 1.1 time = 260
* CHECK dout0_5 vdout0_5ck51 = 1.1 time = 260
* CHECK dout0_6 vdout0_6ck51 = 0 time = 260
* CHECK dout0_7 vdout0_7ck51 = 0 time = 260
* CHECK dout0_8 vdout0_8ck51 = 0 time = 260
* CHECK dout0_9 vdout0_9ck51 = 1.1 time = 260
* CHECK dout0_10 vdout0_10ck51 = 0 time = 260
* CHECK dout0_11 vdout0_11ck51 = 0 time = 260
* CHECK dout0_12 vdout0_12ck51 = 1.1 time = 260
* CHECK dout0_13 vdout0_13ck51 = 1.1 time = 260
* CHECK dout0_14 vdout0_14ck51 = 1.1 time = 260
* CHECK dout0_15 vdout0_15ck51 = 1.1 time = 260
* CHECK dout0_16 vdout0_16ck51 = 1.1 time = 260
* CHECK dout0_17 vdout0_17ck51 = 0 time = 260
* CHECK dout0_18 vdout0_18ck51 = 0 time = 260
* CHECK dout0_19 vdout0_19ck51 = 0 time = 260
* CHECK dout0_20 vdout0_20ck51 = 1.1 time = 260
* CHECK dout0_21 vdout0_21ck51 = 0 time = 260
* CHECK dout0_22 vdout0_22ck51 = 1.1 time = 260
* CHECK dout0_23 vdout0_23ck51 = 0 time = 260
* CHECK dout0_24 vdout0_24ck51 = 1.1 time = 260
* CHECK dout0_25 vdout0_25ck51 = 1.1 time = 260
* CHECK dout0_26 vdout0_26ck51 = 1.1 time = 260
* CHECK dout0_27 vdout0_27ck51 = 1.1 time = 260
* CHECK dout0_28 vdout0_28ck51 = 1.1 time = 260
* CHECK dout0_29 vdout0_29ck51 = 0 time = 260
* CHECK dout0_30 vdout0_30ck51 = 0 time = 260
* CHECK dout0_31 vdout0_31ck51 = 0 time = 260
* CHECK dout0_0 vdout0_0ck56 = 0 time = 285
* CHECK dout0_1 vdout0_1ck56 = 0 time = 285
* CHECK dout0_2 vdout0_2ck56 = 0 time = 285
* CHECK dout0_3 vdout0_3ck56 = 1.1 time = 285
* CHECK dout0_4 vdout0_4ck56 = 1.1 time = 285
* CHECK dout0_5 vdout0_5ck56 = 1.1 time = 285
* CHECK dout0_6 vdout0_6ck56 = 0 time = 285
* CHECK dout0_7 vdout0_7ck56 = 0 time = 285
* CHECK dout0_8 vdout0_8ck56 = 0 time = 285
* CHECK dout0_9 vdout0_9ck56 = 1.1 time = 285
* CHECK dout0_10 vdout0_10ck56 = 0 time = 285
* CHECK dout0_11 vdout0_11ck56 = 0 time = 285
* CHECK dout0_12 vdout0_12ck56 = 1.1 time = 285
* CHECK dout0_13 vdout0_13ck56 = 1.1 time = 285
* CHECK dout0_14 vdout0_14ck56 = 1.1 time = 285
* CHECK dout0_15 vdout0_15ck56 = 1.1 time = 285
* CHECK dout0_16 vdout0_16ck56 = 1.1 time = 285
* CHECK dout0_17 vdout0_17ck56 = 0 time = 285
* CHECK dout0_18 vdout0_18ck56 = 0 time = 285
* CHECK dout0_19 vdout0_19ck56 = 0 time = 285
* CHECK dout0_20 vdout0_20ck56 = 1.1 time = 285
* CHECK dout0_21 vdout0_21ck56 = 0 time = 285
* CHECK dout0_22 vdout0_22ck56 = 1.1 time = 285
* CHECK dout0_23 vdout0_23ck56 = 0 time = 285
* CHECK dout0_24 vdout0_24ck56 = 1.1 time = 285
* CHECK dout0_25 vdout0_25ck56 = 1.1 time = 285
* CHECK dout0_26 vdout0_26ck56 = 1.1 time = 285
* CHECK dout0_27 vdout0_27ck56 = 1.1 time = 285
* CHECK dout0_28 vdout0_28ck56 = 1.1 time = 285
* CHECK dout0_29 vdout0_29ck56 = 0 time = 285
* CHECK dout0_30 vdout0_30ck56 = 0 time = 285
* CHECK dout0_31 vdout0_31ck56 = 0 time = 285
* CHECK dout0_0 vdout0_0ck57 = 1.1 time = 290
* CHECK dout0_1 vdout0_1ck57 = 1.1 time = 290
* CHECK dout0_2 vdout0_2ck57 = 0 time = 290
* CHECK dout0_3 vdout0_3ck57 = 0 time = 290
* CHECK dout0_4 vdout0_4ck57 = 0 time = 290
* CHECK dout0_5 vdout0_5ck57 = 0 time = 290
* CHECK dout0_6 vdout0_6ck57 = 1.1 time = 290
* CHECK dout0_7 vdout0_7ck57 = 1.1 time = 290
* CHECK dout0_8 vdout0_8ck57 = 1.1 time = 290
* CHECK dout0_9 vdout0_9ck57 = 0 time = 290
* CHECK dout0_10 vdout0_10ck57 = 0 time = 290
* CHECK dout0_11 vdout0_11ck57 = 1.1 time = 290
* CHECK dout0_12 vdout0_12ck57 = 1.1 time = 290
* CHECK dout0_13 vdout0_13ck57 = 1.1 time = 290
* CHECK dout0_14 vdout0_14ck57 = 1.1 time = 290
* CHECK dout0_15 vdout0_15ck57 = 1.1 time = 290
* CHECK dout0_16 vdout0_16ck57 = 1.1 time = 290
* CHECK dout0_17 vdout0_17ck57 = 1.1 time = 290
* CHECK dout0_18 vdout0_18ck57 = 1.1 time = 290
* CHECK dout0_19 vdout0_19ck57 = 1.1 time = 290
* CHECK dout0_20 vdout0_20ck57 = 0 time = 290
* CHECK dout0_21 vdout0_21ck57 = 1.1 time = 290
* CHECK dout0_22 vdout0_22ck57 = 0 time = 290
* CHECK dout0_23 vdout0_23ck57 = 0 time = 290
* CHECK dout0_24 vdout0_24ck57 = 1.1 time = 290
* CHECK dout0_25 vdout0_25ck57 = 1.1 time = 290
* CHECK dout0_26 vdout0_26ck57 = 1.1 time = 290
* CHECK dout0_27 vdout0_27ck57 = 1.1 time = 290
* CHECK dout0_28 vdout0_28ck57 = 1.1 time = 290
* CHECK dout0_29 vdout0_29ck57 = 0 time = 290
* CHECK dout0_30 vdout0_30ck57 = 0 time = 290
* CHECK dout0_31 vdout0_31ck57 = 0 time = 290
* CHECK dout0_0 vdout0_0ck58 = 1.1 time = 295
* CHECK dout0_1 vdout0_1ck58 = 1.1 time = 295
* CHECK dout0_2 vdout0_2ck58 = 0 time = 295
* CHECK dout0_3 vdout0_3ck58 = 1.1 time = 295
* CHECK dout0_4 vdout0_4ck58 = 0 time = 295
* CHECK dout0_5 vdout0_5ck58 = 1.1 time = 295
* CHECK dout0_6 vdout0_6ck58 = 1.1 time = 295
* CHECK dout0_7 vdout0_7ck58 = 1.1 time = 295
* CHECK dout0_8 vdout0_8ck58 = 1.1 time = 295
* CHECK dout0_9 vdout0_9ck58 = 1.1 time = 295
* CHECK dout0_10 vdout0_10ck58 = 1.1 time = 295
* CHECK dout0_11 vdout0_11ck58 = 1.1 time = 295
* CHECK dout0_12 vdout0_12ck58 = 0 time = 295
* CHECK dout0_13 vdout0_13ck58 = 0 time = 295
* CHECK dout0_14 vdout0_14ck58 = 0 time = 295
* CHECK dout0_15 vdout0_15ck58 = 0 time = 295
* CHECK dout0_16 vdout0_16ck58 = 0 time = 295
* CHECK dout0_17 vdout0_17ck58 = 1.1 time = 295
* CHECK dout0_18 vdout0_18ck58 = 1.1 time = 295
* CHECK dout0_19 vdout0_19ck58 = 1.1 time = 295
* CHECK dout0_20 vdout0_20ck58 = 0 time = 295
* CHECK dout0_21 vdout0_21ck58 = 0 time = 295
* CHECK dout0_22 vdout0_22ck58 = 0 time = 295
* CHECK dout0_23 vdout0_23ck58 = 0 time = 295
* CHECK dout0_24 vdout0_24ck58 = 0 time = 295
* CHECK dout0_25 vdout0_25ck58 = 1.1 time = 295
* CHECK dout0_26 vdout0_26ck58 = 1.1 time = 295
* CHECK dout0_27 vdout0_27ck58 = 0 time = 295
* CHECK dout0_28 vdout0_28ck58 = 0 time = 295
* CHECK dout0_29 vdout0_29ck58 = 1.1 time = 295
* CHECK dout0_30 vdout0_30ck58 = 1.1 time = 295
* CHECK dout0_31 vdout0_31ck58 = 1.1 time = 295
* CHECK dout0_0 vdout0_0ck60 = 1.1 time = 305
* CHECK dout0_1 vdout0_1ck60 = 1.1 time = 305
* CHECK dout0_2 vdout0_2ck60 = 0 time = 305
* CHECK dout0_3 vdout0_3ck60 = 0 time = 305
* CHECK dout0_4 vdout0_4ck60 = 0 time = 305
* CHECK dout0_5 vdout0_5ck60 = 0 time = 305
* CHECK dout0_6 vdout0_6ck60 = 1.1 time = 305
* CHECK dout0_7 vdout0_7ck60 = 1.1 time = 305
* CHECK dout0_8 vdout0_8ck60 = 1.1 time = 305
* CHECK dout0_9 vdout0_9ck60 = 0 time = 305
* CHECK dout0_10 vdout0_10ck60 = 0 time = 305
* CHECK dout0_11 vdout0_11ck60 = 1.1 time = 305
* CHECK dout0_12 vdout0_12ck60 = 1.1 time = 305
* CHECK dout0_13 vdout0_13ck60 = 1.1 time = 305
* CHECK dout0_14 vdout0_14ck60 = 1.1 time = 305
* CHECK dout0_15 vdout0_15ck60 = 1.1 time = 305
* CHECK dout0_16 vdout0_16ck60 = 1.1 time = 305
* CHECK dout0_17 vdout0_17ck60 = 1.1 time = 305
* CHECK dout0_18 vdout0_18ck60 = 1.1 time = 305
* CHECK dout0_19 vdout0_19ck60 = 1.1 time = 305
* CHECK dout0_20 vdout0_20ck60 = 0 time = 305
* CHECK dout0_21 vdout0_21ck60 = 1.1 time = 305
* CHECK dout0_22 vdout0_22ck60 = 0 time = 305
* CHECK dout0_23 vdout0_23ck60 = 0 time = 305
* CHECK dout0_24 vdout0_24ck60 = 1.1 time = 305
* CHECK dout0_25 vdout0_25ck60 = 1.1 time = 305
* CHECK dout0_26 vdout0_26ck60 = 1.1 time = 305
* CHECK dout0_27 vdout0_27ck60 = 1.1 time = 305
* CHECK dout0_28 vdout0_28ck60 = 1.1 time = 305
* CHECK dout0_29 vdout0_29ck60 = 0 time = 305
* CHECK dout0_30 vdout0_30ck60 = 0 time = 305
* CHECK dout0_31 vdout0_31ck60 = 0 time = 305
* CHECK dout0_0 vdout0_0ck61 = 1.1 time = 310
* CHECK dout0_1 vdout0_1ck61 = 1.1 time = 310
* CHECK dout0_2 vdout0_2ck61 = 0 time = 310
* CHECK dout0_3 vdout0_3ck61 = 1.1 time = 310
* CHECK dout0_4 vdout0_4ck61 = 0 time = 310
* CHECK dout0_5 vdout0_5ck61 = 1.1 time = 310
* CHECK dout0_6 vdout0_6ck61 = 1.1 time = 310
* CHECK dout0_7 vdout0_7ck61 = 1.1 time = 310
* CHECK dout0_8 vdout0_8ck61 = 1.1 time = 310
* CHECK dout0_9 vdout0_9ck61 = 1.1 time = 310
* CHECK dout0_10 vdout0_10ck61 = 1.1 time = 310
* CHECK dout0_11 vdout0_11ck61 = 1.1 time = 310
* CHECK dout0_12 vdout0_12ck61 = 0 time = 310
* CHECK dout0_13 vdout0_13ck61 = 0 time = 310
* CHECK dout0_14 vdout0_14ck61 = 0 time = 310
* CHECK dout0_15 vdout0_15ck61 = 0 time = 310
* CHECK dout0_16 vdout0_16ck61 = 0 time = 310
* CHECK dout0_17 vdout0_17ck61 = 1.1 time = 310
* CHECK dout0_18 vdout0_18ck61 = 1.1 time = 310
* CHECK dout0_19 vdout0_19ck61 = 1.1 time = 310
* CHECK dout0_20 vdout0_20ck61 = 0 time = 310
* CHECK dout0_21 vdout0_21ck61 = 0 time = 310
* CHECK dout0_22 vdout0_22ck61 = 0 time = 310
* CHECK dout0_23 vdout0_23ck61 = 0 time = 310
* CHECK dout0_24 vdout0_24ck61 = 0 time = 310
* CHECK dout0_25 vdout0_25ck61 = 1.1 time = 310
* CHECK dout0_26 vdout0_26ck61 = 1.1 time = 310
* CHECK dout0_27 vdout0_27ck61 = 0 time = 310
* CHECK dout0_28 vdout0_28ck61 = 0 time = 310
* CHECK dout0_29 vdout0_29ck61 = 1.1 time = 310
* CHECK dout0_30 vdout0_30ck61 = 1.1 time = 310
* CHECK dout0_31 vdout0_31ck61 = 1.1 time = 310
* CHECK dout0_0 vdout0_0ck62 = 0 time = 315
* CHECK dout0_1 vdout0_1ck62 = 0 time = 315
* CHECK dout0_2 vdout0_2ck62 = 0 time = 315
* CHECK dout0_3 vdout0_3ck62 = 1.1 time = 315
* CHECK dout0_4 vdout0_4ck62 = 1.1 time = 315
* CHECK dout0_5 vdout0_5ck62 = 1.1 time = 315
* CHECK dout0_6 vdout0_6ck62 = 0 time = 315
* CHECK dout0_7 vdout0_7ck62 = 0 time = 315
* CHECK dout0_8 vdout0_8ck62 = 0 time = 315
* CHECK dout0_9 vdout0_9ck62 = 1.1 time = 315
* CHECK dout0_10 vdout0_10ck62 = 0 time = 315
* CHECK dout0_11 vdout0_11ck62 = 0 time = 315
* CHECK dout0_12 vdout0_12ck62 = 1.1 time = 315
* CHECK dout0_13 vdout0_13ck62 = 1.1 time = 315
* CHECK dout0_14 vdout0_14ck62 = 1.1 time = 315
* CHECK dout0_15 vdout0_15ck62 = 1.1 time = 315
* CHECK dout0_16 vdout0_16ck62 = 1.1 time = 315
* CHECK dout0_17 vdout0_17ck62 = 0 time = 315
* CHECK dout0_18 vdout0_18ck62 = 0 time = 315
* CHECK dout0_19 vdout0_19ck62 = 0 time = 315
* CHECK dout0_20 vdout0_20ck62 = 1.1 time = 315
* CHECK dout0_21 vdout0_21ck62 = 0 time = 315
* CHECK dout0_22 vdout0_22ck62 = 1.1 time = 315
* CHECK dout0_23 vdout0_23ck62 = 0 time = 315
* CHECK dout0_24 vdout0_24ck62 = 1.1 time = 315
* CHECK dout0_25 vdout0_25ck62 = 1.1 time = 315
* CHECK dout0_26 vdout0_26ck62 = 1.1 time = 315
* CHECK dout0_27 vdout0_27ck62 = 1.1 time = 315
* CHECK dout0_28 vdout0_28ck62 = 1.1 time = 315
* CHECK dout0_29 vdout0_29ck62 = 0 time = 315
* CHECK dout0_30 vdout0_30ck62 = 0 time = 315
* CHECK dout0_31 vdout0_31ck62 = 0 time = 315
* CHECK dout0_0 vdout0_0ck68 = 1.1 time = 345
* CHECK dout0_1 vdout0_1ck68 = 1.1 time = 345
* CHECK dout0_2 vdout0_2ck68 = 0 time = 345
* CHECK dout0_3 vdout0_3ck68 = 1.1 time = 345
* CHECK dout0_4 vdout0_4ck68 = 0 time = 345
* CHECK dout0_5 vdout0_5ck68 = 1.1 time = 345
* CHECK dout0_6 vdout0_6ck68 = 1.1 time = 345
* CHECK dout0_7 vdout0_7ck68 = 1.1 time = 345
* CHECK dout0_8 vdout0_8ck68 = 1.1 time = 345
* CHECK dout0_9 vdout0_9ck68 = 1.1 time = 345
* CHECK dout0_10 vdout0_10ck68 = 1.1 time = 345
* CHECK dout0_11 vdout0_11ck68 = 1.1 time = 345
* CHECK dout0_12 vdout0_12ck68 = 0 time = 345
* CHECK dout0_13 vdout0_13ck68 = 0 time = 345
* CHECK dout0_14 vdout0_14ck68 = 0 time = 345
* CHECK dout0_15 vdout0_15ck68 = 0 time = 345
* CHECK dout0_16 vdout0_16ck68 = 0 time = 345
* CHECK dout0_17 vdout0_17ck68 = 1.1 time = 345
* CHECK dout0_18 vdout0_18ck68 = 1.1 time = 345
* CHECK dout0_19 vdout0_19ck68 = 1.1 time = 345
* CHECK dout0_20 vdout0_20ck68 = 0 time = 345
* CHECK dout0_21 vdout0_21ck68 = 0 time = 345
* CHECK dout0_22 vdout0_22ck68 = 0 time = 345
* CHECK dout0_23 vdout0_23ck68 = 0 time = 345
* CHECK dout0_24 vdout0_24ck68 = 0 time = 345
* CHECK dout0_25 vdout0_25ck68 = 1.1 time = 345
* CHECK dout0_26 vdout0_26ck68 = 1.1 time = 345
* CHECK dout0_27 vdout0_27ck68 = 0 time = 345
* CHECK dout0_28 vdout0_28ck68 = 0 time = 345
* CHECK dout0_29 vdout0_29ck68 = 1.1 time = 345
* CHECK dout0_30 vdout0_30ck68 = 1.1 time = 345
* CHECK dout0_31 vdout0_31ck68 = 1.1 time = 345
* CHECK dout0_0 vdout0_0ck71 = 1.1 time = 360
* CHECK dout0_1 vdout0_1ck71 = 1.1 time = 360
* CHECK dout0_2 vdout0_2ck71 = 0 time = 360
* CHECK dout0_3 vdout0_3ck71 = 0 time = 360
* CHECK dout0_4 vdout0_4ck71 = 0 time = 360
* CHECK dout0_5 vdout0_5ck71 = 0 time = 360
* CHECK dout0_6 vdout0_6ck71 = 1.1 time = 360
* CHECK dout0_7 vdout0_7ck71 = 1.1 time = 360
* CHECK dout0_8 vdout0_8ck71 = 1.1 time = 360
* CHECK dout0_9 vdout0_9ck71 = 0 time = 360
* CHECK dout0_10 vdout0_10ck71 = 0 time = 360
* CHECK dout0_11 vdout0_11ck71 = 1.1 time = 360
* CHECK dout0_12 vdout0_12ck71 = 1.1 time = 360
* CHECK dout0_13 vdout0_13ck71 = 1.1 time = 360
* CHECK dout0_14 vdout0_14ck71 = 1.1 time = 360
* CHECK dout0_15 vdout0_15ck71 = 1.1 time = 360
* CHECK dout0_16 vdout0_16ck71 = 1.1 time = 360
* CHECK dout0_17 vdout0_17ck71 = 1.1 time = 360
* CHECK dout0_18 vdout0_18ck71 = 1.1 time = 360
* CHECK dout0_19 vdout0_19ck71 = 1.1 time = 360
* CHECK dout0_20 vdout0_20ck71 = 0 time = 360
* CHECK dout0_21 vdout0_21ck71 = 1.1 time = 360
* CHECK dout0_22 vdout0_22ck71 = 0 time = 360
* CHECK dout0_23 vdout0_23ck71 = 0 time = 360
* CHECK dout0_24 vdout0_24ck71 = 1.1 time = 360
* CHECK dout0_25 vdout0_25ck71 = 1.1 time = 360
* CHECK dout0_26 vdout0_26ck71 = 1.1 time = 360
* CHECK dout0_27 vdout0_27ck71 = 1.1 time = 360
* CHECK dout0_28 vdout0_28ck71 = 1.1 time = 360
* CHECK dout0_29 vdout0_29ck71 = 0 time = 360
* CHECK dout0_30 vdout0_30ck71 = 0 time = 360
* CHECK dout0_31 vdout0_31ck71 = 0 time = 360
* CHECK dout0_0 vdout0_0ck77 = 0 time = 390
* CHECK dout0_1 vdout0_1ck77 = 0 time = 390
* CHECK dout0_2 vdout0_2ck77 = 0 time = 390
* CHECK dout0_3 vdout0_3ck77 = 1.1 time = 390
* CHECK dout0_4 vdout0_4ck77 = 1.1 time = 390
* CHECK dout0_5 vdout0_5ck77 = 1.1 time = 390
* CHECK dout0_6 vdout0_6ck77 = 0 time = 390
* CHECK dout0_7 vdout0_7ck77 = 0 time = 390
* CHECK dout0_8 vdout0_8ck77 = 0 time = 390
* CHECK dout0_9 vdout0_9ck77 = 1.1 time = 390
* CHECK dout0_10 vdout0_10ck77 = 0 time = 390
* CHECK dout0_11 vdout0_11ck77 = 0 time = 390
* CHECK dout0_12 vdout0_12ck77 = 1.1 time = 390
* CHECK dout0_13 vdout0_13ck77 = 1.1 time = 390
* CHECK dout0_14 vdout0_14ck77 = 1.1 time = 390
* CHECK dout0_15 vdout0_15ck77 = 1.1 time = 390
* CHECK dout0_16 vdout0_16ck77 = 1.1 time = 390
* CHECK dout0_17 vdout0_17ck77 = 0 time = 390
* CHECK dout0_18 vdout0_18ck77 = 0 time = 390
* CHECK dout0_19 vdout0_19ck77 = 0 time = 390
* CHECK dout0_20 vdout0_20ck77 = 1.1 time = 390
* CHECK dout0_21 vdout0_21ck77 = 0 time = 390
* CHECK dout0_22 vdout0_22ck77 = 1.1 time = 390
* CHECK dout0_23 vdout0_23ck77 = 0 time = 390
* CHECK dout0_24 vdout0_24ck77 = 1.1 time = 390
* CHECK dout0_25 vdout0_25ck77 = 1.1 time = 390
* CHECK dout0_26 vdout0_26ck77 = 1.1 time = 390
* CHECK dout0_27 vdout0_27ck77 = 1.1 time = 390
* CHECK dout0_28 vdout0_28ck77 = 1.1 time = 390
* CHECK dout0_29 vdout0_29ck77 = 0 time = 390
* CHECK dout0_30 vdout0_30ck77 = 0 time = 390
* CHECK dout0_31 vdout0_31ck77 = 0 time = 390
* CHECK dout0_0 vdout0_0ck78 = 1.1 time = 395
* CHECK dout0_1 vdout0_1ck78 = 0 time = 395
* CHECK dout0_2 vdout0_2ck78 = 1.1 time = 395
* CHECK dout0_3 vdout0_3ck78 = 0 time = 395
* CHECK dout0_4 vdout0_4ck78 = 0 time = 395
* CHECK dout0_5 vdout0_5ck78 = 0 time = 395
* CHECK dout0_6 vdout0_6ck78 = 0 time = 395
* CHECK dout0_7 vdout0_7ck78 = 0 time = 395
* CHECK dout0_8 vdout0_8ck78 = 1.1 time = 395
* CHECK dout0_9 vdout0_9ck78 = 0 time = 395
* CHECK dout0_10 vdout0_10ck78 = 1.1 time = 395
* CHECK dout0_11 vdout0_11ck78 = 1.1 time = 395
* CHECK dout0_12 vdout0_12ck78 = 0 time = 395
* CHECK dout0_13 vdout0_13ck78 = 0 time = 395
* CHECK dout0_14 vdout0_14ck78 = 1.1 time = 395
* CHECK dout0_15 vdout0_15ck78 = 0 time = 395
* CHECK dout0_16 vdout0_16ck78 = 0 time = 395
* CHECK dout0_17 vdout0_17ck78 = 1.1 time = 395
* CHECK dout0_18 vdout0_18ck78 = 1.1 time = 395
* CHECK dout0_19 vdout0_19ck78 = 0 time = 395
* CHECK dout0_20 vdout0_20ck78 = 1.1 time = 395
* CHECK dout0_21 vdout0_21ck78 = 1.1 time = 395
* CHECK dout0_22 vdout0_22ck78 = 1.1 time = 395
* CHECK dout0_23 vdout0_23ck78 = 0 time = 395
* CHECK dout0_24 vdout0_24ck78 = 1.1 time = 395
* CHECK dout0_25 vdout0_25ck78 = 0 time = 395
* CHECK dout0_26 vdout0_26ck78 = 1.1 time = 395
* CHECK dout0_27 vdout0_27ck78 = 1.1 time = 395
* CHECK dout0_28 vdout0_28ck78 = 0 time = 395
* CHECK dout0_29 vdout0_29ck78 = 1.1 time = 395
* CHECK dout0_30 vdout0_30ck78 = 1.1 time = 395
* CHECK dout0_31 vdout0_31ck78 = 1.1 time = 395
* CHECK dout0_0 vdout0_0ck79 = 1.1 time = 400
* CHECK dout0_1 vdout0_1ck79 = 1.1 time = 400
* CHECK dout0_2 vdout0_2ck79 = 0 time = 400
* CHECK dout0_3 vdout0_3ck79 = 0 time = 400
* CHECK dout0_4 vdout0_4ck79 = 0 time = 400
* CHECK dout0_5 vdout0_5ck79 = 0 time = 400
* CHECK dout0_6 vdout0_6ck79 = 1.1 time = 400
* CHECK dout0_7 vdout0_7ck79 = 1.1 time = 400
* CHECK dout0_8 vdout0_8ck79 = 1.1 time = 400
* CHECK dout0_9 vdout0_9ck79 = 0 time = 400
* CHECK dout0_10 vdout0_10ck79 = 0 time = 400
* CHECK dout0_11 vdout0_11ck79 = 1.1 time = 400
* CHECK dout0_12 vdout0_12ck79 = 1.1 time = 400
* CHECK dout0_13 vdout0_13ck79 = 1.1 time = 400
* CHECK dout0_14 vdout0_14ck79 = 1.1 time = 400
* CHECK dout0_15 vdout0_15ck79 = 1.1 time = 400
* CHECK dout0_16 vdout0_16ck79 = 1.1 time = 400
* CHECK dout0_17 vdout0_17ck79 = 1.1 time = 400
* CHECK dout0_18 vdout0_18ck79 = 1.1 time = 400
* CHECK dout0_19 vdout0_19ck79 = 1.1 time = 400
* CHECK dout0_20 vdout0_20ck79 = 0 time = 400
* CHECK dout0_21 vdout0_21ck79 = 1.1 time = 400
* CHECK dout0_22 vdout0_22ck79 = 0 time = 400
* CHECK dout0_23 vdout0_23ck79 = 0 time = 400
* CHECK dout0_24 vdout0_24ck79 = 1.1 time = 400
* CHECK dout0_25 vdout0_25ck79 = 1.1 time = 400
* CHECK dout0_26 vdout0_26ck79 = 1.1 time = 400
* CHECK dout0_27 vdout0_27ck79 = 1.1 time = 400
* CHECK dout0_28 vdout0_28ck79 = 1.1 time = 400
* CHECK dout0_29 vdout0_29ck79 = 0 time = 400
* CHECK dout0_30 vdout0_30ck79 = 0 time = 400
* CHECK dout0_31 vdout0_31ck79 = 0 time = 400
* CHECK dout0_0 vdout0_0ck83 = 1.1 time = 420
* CHECK dout0_1 vdout0_1ck83 = 0 time = 420
* CHECK dout0_2 vdout0_2ck83 = 1.1 time = 420
* CHECK dout0_3 vdout0_3ck83 = 0 time = 420
* CHECK dout0_4 vdout0_4ck83 = 0 time = 420
* CHECK dout0_5 vdout0_5ck83 = 0 time = 420
* CHECK dout0_6 vdout0_6ck83 = 0 time = 420
* CHECK dout0_7 vdout0_7ck83 = 0 time = 420
* CHECK dout0_8 vdout0_8ck83 = 1.1 time = 420
* CHECK dout0_9 vdout0_9ck83 = 0 time = 420
* CHECK dout0_10 vdout0_10ck83 = 1.1 time = 420
* CHECK dout0_11 vdout0_11ck83 = 1.1 time = 420
* CHECK dout0_12 vdout0_12ck83 = 0 time = 420
* CHECK dout0_13 vdout0_13ck83 = 0 time = 420
* CHECK dout0_14 vdout0_14ck83 = 1.1 time = 420
* CHECK dout0_15 vdout0_15ck83 = 0 time = 420
* CHECK dout0_16 vdout0_16ck83 = 0 time = 420
* CHECK dout0_17 vdout0_17ck83 = 1.1 time = 420
* CHECK dout0_18 vdout0_18ck83 = 1.1 time = 420
* CHECK dout0_19 vdout0_19ck83 = 0 time = 420
* CHECK dout0_20 vdout0_20ck83 = 1.1 time = 420
* CHECK dout0_21 vdout0_21ck83 = 1.1 time = 420
* CHECK dout0_22 vdout0_22ck83 = 1.1 time = 420
* CHECK dout0_23 vdout0_23ck83 = 0 time = 420
* CHECK dout0_24 vdout0_24ck83 = 1.1 time = 420
* CHECK dout0_25 vdout0_25ck83 = 0 time = 420
* CHECK dout0_26 vdout0_26ck83 = 1.1 time = 420
* CHECK dout0_27 vdout0_27ck83 = 1.1 time = 420
* CHECK dout0_28 vdout0_28ck83 = 0 time = 420
* CHECK dout0_29 vdout0_29ck83 = 1.1 time = 420
* CHECK dout0_30 vdout0_30ck83 = 1.1 time = 420
* CHECK dout0_31 vdout0_31ck83 = 1.1 time = 420
* CHECK dout0_0 vdout0_0ck84 = 1.1 time = 425
* CHECK dout0_1 vdout0_1ck84 = 0 time = 425
* CHECK dout0_2 vdout0_2ck84 = 1.1 time = 425
* CHECK dout0_3 vdout0_3ck84 = 0 time = 425
* CHECK dout0_4 vdout0_4ck84 = 1.1 time = 425
* CHECK dout0_5 vdout0_5ck84 = 0 time = 425
* CHECK dout0_6 vdout0_6ck84 = 1.1 time = 425
* CHECK dout0_7 vdout0_7ck84 = 1.1 time = 425
* CHECK dout0_8 vdout0_8ck84 = 0 time = 425
* CHECK dout0_9 vdout0_9ck84 = 0 time = 425
* CHECK dout0_10 vdout0_10ck84 = 0 time = 425
* CHECK dout0_11 vdout0_11ck84 = 0 time = 425
* CHECK dout0_12 vdout0_12ck84 = 1.1 time = 425
* CHECK dout0_13 vdout0_13ck84 = 1.1 time = 425
* CHECK dout0_14 vdout0_14ck84 = 1.1 time = 425
* CHECK dout0_15 vdout0_15ck84 = 0 time = 425
* CHECK dout0_16 vdout0_16ck84 = 1.1 time = 425
* CHECK dout0_17 vdout0_17ck84 = 0 time = 425
* CHECK dout0_18 vdout0_18ck84 = 1.1 time = 425
* CHECK dout0_19 vdout0_19ck84 = 0 time = 425
* CHECK dout0_20 vdout0_20ck84 = 0 time = 425
* CHECK dout0_21 vdout0_21ck84 = 1.1 time = 425
* CHECK dout0_22 vdout0_22ck84 = 1.1 time = 425
* CHECK dout0_23 vdout0_23ck84 = 0 time = 425
* CHECK dout0_24 vdout0_24ck84 = 1.1 time = 425
* CHECK dout0_25 vdout0_25ck84 = 0 time = 425
* CHECK dout0_26 vdout0_26ck84 = 1.1 time = 425
* CHECK dout0_27 vdout0_27ck84 = 0 time = 425
* CHECK dout0_28 vdout0_28ck84 = 0 time = 425
* CHECK dout0_29 vdout0_29ck84 = 1.1 time = 425
* CHECK dout0_30 vdout0_30ck84 = 0 time = 425
* CHECK dout0_31 vdout0_31ck84 = 0 time = 425
* CHECK dout0_0 vdout0_0ck85 = 1.1 time = 430
* CHECK dout0_1 vdout0_1ck85 = 0 time = 430
* CHECK dout0_2 vdout0_2ck85 = 1.1 time = 430
* CHECK dout0_3 vdout0_3ck85 = 0 time = 430
* CHECK dout0_4 vdout0_4ck85 = 0 time = 430
* CHECK dout0_5 vdout0_5ck85 = 0 time = 430
* CHECK dout0_6 vdout0_6ck85 = 0 time = 430
* CHECK dout0_7 vdout0_7ck85 = 0 time = 430
* CHECK dout0_8 vdout0_8ck85 = 1.1 time = 430
* CHECK dout0_9 vdout0_9ck85 = 0 time = 430
* CHECK dout0_10 vdout0_10ck85 = 1.1 time = 430
* CHECK dout0_11 vdout0_11ck85 = 1.1 time = 430
* CHECK dout0_12 vdout0_12ck85 = 0 time = 430
* CHECK dout0_13 vdout0_13ck85 = 0 time = 430
* CHECK dout0_14 vdout0_14ck85 = 1.1 time = 430
* CHECK dout0_15 vdout0_15ck85 = 0 time = 430
* CHECK dout0_16 vdout0_16ck85 = 0 time = 430
* CHECK dout0_17 vdout0_17ck85 = 1.1 time = 430
* CHECK dout0_18 vdout0_18ck85 = 1.1 time = 430
* CHECK dout0_19 vdout0_19ck85 = 0 time = 430
* CHECK dout0_20 vdout0_20ck85 = 1.1 time = 430
* CHECK dout0_21 vdout0_21ck85 = 1.1 time = 430
* CHECK dout0_22 vdout0_22ck85 = 1.1 time = 430
* CHECK dout0_23 vdout0_23ck85 = 0 time = 430
* CHECK dout0_24 vdout0_24ck85 = 1.1 time = 430
* CHECK dout0_25 vdout0_25ck85 = 0 time = 430
* CHECK dout0_26 vdout0_26ck85 = 1.1 time = 430
* CHECK dout0_27 vdout0_27ck85 = 1.1 time = 430
* CHECK dout0_28 vdout0_28ck85 = 0 time = 430
* CHECK dout0_29 vdout0_29ck85 = 1.1 time = 430
* CHECK dout0_30 vdout0_30ck85 = 1.1 time = 430
* CHECK dout0_31 vdout0_31ck85 = 1.1 time = 430
* CHECK dout0_0 vdout0_0ck86 = 1.1 time = 435
* CHECK dout0_1 vdout0_1ck86 = 1.1 time = 435
* CHECK dout0_2 vdout0_2ck86 = 0 time = 435
* CHECK dout0_3 vdout0_3ck86 = 0 time = 435
* CHECK dout0_4 vdout0_4ck86 = 0 time = 435
* CHECK dout0_5 vdout0_5ck86 = 0 time = 435
* CHECK dout0_6 vdout0_6ck86 = 1.1 time = 435
* CHECK dout0_7 vdout0_7ck86 = 1.1 time = 435
* CHECK dout0_8 vdout0_8ck86 = 1.1 time = 435
* CHECK dout0_9 vdout0_9ck86 = 0 time = 435
* CHECK dout0_10 vdout0_10ck86 = 0 time = 435
* CHECK dout0_11 vdout0_11ck86 = 1.1 time = 435
* CHECK dout0_12 vdout0_12ck86 = 1.1 time = 435
* CHECK dout0_13 vdout0_13ck86 = 1.1 time = 435
* CHECK dout0_14 vdout0_14ck86 = 1.1 time = 435
* CHECK dout0_15 vdout0_15ck86 = 1.1 time = 435
* CHECK dout0_16 vdout0_16ck86 = 1.1 time = 435
* CHECK dout0_17 vdout0_17ck86 = 0 time = 435
* CHECK dout0_18 vdout0_18ck86 = 1.1 time = 435
* CHECK dout0_19 vdout0_19ck86 = 1.1 time = 435
* CHECK dout0_20 vdout0_20ck86 = 1.1 time = 435
* CHECK dout0_21 vdout0_21ck86 = 0 time = 435
* CHECK dout0_22 vdout0_22ck86 = 1.1 time = 435
* CHECK dout0_23 vdout0_23ck86 = 1.1 time = 435
* CHECK dout0_24 vdout0_24ck86 = 1.1 time = 435
* CHECK dout0_25 vdout0_25ck86 = 1.1 time = 435
* CHECK dout0_26 vdout0_26ck86 = 1.1 time = 435
* CHECK dout0_27 vdout0_27ck86 = 1.1 time = 435
* CHECK dout0_28 vdout0_28ck86 = 1.1 time = 435
* CHECK dout0_29 vdout0_29ck86 = 0 time = 435
* CHECK dout0_30 vdout0_30ck86 = 0 time = 435
* CHECK dout0_31 vdout0_31ck86 = 0 time = 435
* CHECK dout0_0 vdout0_0ck90 = 1.1 time = 455
* CHECK dout0_1 vdout0_1ck90 = 0 time = 455
* CHECK dout0_2 vdout0_2ck90 = 1.1 time = 455
* CHECK dout0_3 vdout0_3ck90 = 1.1 time = 455
* CHECK dout0_4 vdout0_4ck90 = 0 time = 455
* CHECK dout0_5 vdout0_5ck90 = 1.1 time = 455
* CHECK dout0_6 vdout0_6ck90 = 1.1 time = 455
* CHECK dout0_7 vdout0_7ck90 = 0 time = 455
* CHECK dout0_8 vdout0_8ck90 = 0 time = 455
* CHECK dout0_9 vdout0_9ck90 = 0 time = 455
* CHECK dout0_10 vdout0_10ck90 = 0 time = 455
* CHECK dout0_11 vdout0_11ck90 = 0 time = 455
* CHECK dout0_12 vdout0_12ck90 = 0 time = 455
* CHECK dout0_13 vdout0_13ck90 = 1.1 time = 455
* CHECK dout0_14 vdout0_14ck90 = 1.1 time = 455
* CHECK dout0_15 vdout0_15ck90 = 1.1 time = 455
* CHECK dout0_16 vdout0_16ck90 = 1.1 time = 455
* CHECK dout0_17 vdout0_17ck90 = 1.1 time = 455
* CHECK dout0_18 vdout0_18ck90 = 0 time = 455
* CHECK dout0_19 vdout0_19ck90 = 1.1 time = 455
* CHECK dout0_20 vdout0_20ck90 = 1.1 time = 455
* CHECK dout0_21 vdout0_21ck90 = 0 time = 455
* CHECK dout0_22 vdout0_22ck90 = 1.1 time = 455
* CHECK dout0_23 vdout0_23ck90 = 1.1 time = 455
* CHECK dout0_24 vdout0_24ck90 = 0 time = 455
* CHECK dout0_25 vdout0_25ck90 = 0 time = 455
* CHECK dout0_26 vdout0_26ck90 = 1.1 time = 455
* CHECK dout0_27 vdout0_27ck90 = 1.1 time = 455
* CHECK dout0_28 vdout0_28ck90 = 1.1 time = 455
* CHECK dout0_29 vdout0_29ck90 = 0 time = 455
* CHECK dout0_30 vdout0_30ck90 = 0 time = 455
* CHECK dout0_31 vdout0_31ck90 = 1.1 time = 455
* CHECK dout0_0 vdout0_0ck93 = 0 time = 470
* CHECK dout0_1 vdout0_1ck93 = 0 time = 470
* CHECK dout0_2 vdout0_2ck93 = 1.1 time = 470
* CHECK dout0_3 vdout0_3ck93 = 1.1 time = 470
* CHECK dout0_4 vdout0_4ck93 = 1.1 time = 470
* CHECK dout0_5 vdout0_5ck93 = 0 time = 470
* CHECK dout0_6 vdout0_6ck93 = 0 time = 470
* CHECK dout0_7 vdout0_7ck93 = 1.1 time = 470
* CHECK dout0_8 vdout0_8ck93 = 1.1 time = 470
* CHECK dout0_9 vdout0_9ck93 = 0 time = 470
* CHECK dout0_10 vdout0_10ck93 = 0 time = 470
* CHECK dout0_11 vdout0_11ck93 = 1.1 time = 470
* CHECK dout0_12 vdout0_12ck93 = 1.1 time = 470
* CHECK dout0_13 vdout0_13ck93 = 1.1 time = 470
* CHECK dout0_14 vdout0_14ck93 = 1.1 time = 470
* CHECK dout0_15 vdout0_15ck93 = 1.1 time = 470
* CHECK dout0_16 vdout0_16ck93 = 1.1 time = 470
* CHECK dout0_17 vdout0_17ck93 = 0 time = 470
* CHECK dout0_18 vdout0_18ck93 = 1.1 time = 470
* CHECK dout0_19 vdout0_19ck93 = 1.1 time = 470
* CHECK dout0_20 vdout0_20ck93 = 1.1 time = 470
* CHECK dout0_21 vdout0_21ck93 = 0 time = 470
* CHECK dout0_22 vdout0_22ck93 = 1.1 time = 470
* CHECK dout0_23 vdout0_23ck93 = 1.1 time = 470
* CHECK dout0_24 vdout0_24ck93 = 1.1 time = 470
* CHECK dout0_25 vdout0_25ck93 = 1.1 time = 470
* CHECK dout0_26 vdout0_26ck93 = 1.1 time = 470
* CHECK dout0_27 vdout0_27ck93 = 1.1 time = 470
* CHECK dout0_28 vdout0_28ck93 = 1.1 time = 470
* CHECK dout0_29 vdout0_29ck93 = 0 time = 470
* CHECK dout0_30 vdout0_30ck93 = 0 time = 470
* CHECK dout0_31 vdout0_31ck93 = 0 time = 470
* CHECK dout0_0 vdout0_0ck96 = 0 time = 485
* CHECK dout0_1 vdout0_1ck96 = 0 time = 485
* CHECK dout0_2 vdout0_2ck96 = 1.1 time = 485
* CHECK dout0_3 vdout0_3ck96 = 1.1 time = 485
* CHECK dout0_4 vdout0_4ck96 = 1.1 time = 485
* CHECK dout0_5 vdout0_5ck96 = 0 time = 485
* CHECK dout0_6 vdout0_6ck96 = 0 time = 485
* CHECK dout0_7 vdout0_7ck96 = 1.1 time = 485
* CHECK dout0_8 vdout0_8ck96 = 1.1 time = 485
* CHECK dout0_9 vdout0_9ck96 = 0 time = 485
* CHECK dout0_10 vdout0_10ck96 = 0 time = 485
* CHECK dout0_11 vdout0_11ck96 = 0 time = 485
* CHECK dout0_12 vdout0_12ck96 = 0 time = 485
* CHECK dout0_13 vdout0_13ck96 = 0 time = 485
* CHECK dout0_14 vdout0_14ck96 = 0 time = 485
* CHECK dout0_15 vdout0_15ck96 = 0 time = 485
* CHECK dout0_16 vdout0_16ck96 = 0 time = 485
* CHECK dout0_17 vdout0_17ck96 = 1.1 time = 485
* CHECK dout0_18 vdout0_18ck96 = 0 time = 485
* CHECK dout0_19 vdout0_19ck96 = 0 time = 485
* CHECK dout0_20 vdout0_20ck96 = 1.1 time = 485
* CHECK dout0_21 vdout0_21ck96 = 1.1 time = 485
* CHECK dout0_22 vdout0_22ck96 = 0 time = 485
* CHECK dout0_23 vdout0_23ck96 = 0 time = 485
* CHECK dout0_24 vdout0_24ck96 = 1.1 time = 485
* CHECK dout0_25 vdout0_25ck96 = 1.1 time = 485
* CHECK dout0_26 vdout0_26ck96 = 1.1 time = 485
* CHECK dout0_27 vdout0_27ck96 = 0 time = 485
* CHECK dout0_28 vdout0_28ck96 = 0 time = 485
* CHECK dout0_29 vdout0_29ck96 = 0 time = 485
* CHECK dout0_30 vdout0_30ck96 = 1.1 time = 485
* CHECK dout0_31 vdout0_31ck96 = 1.1 time = 485
* CHECK dout0_0 vdout0_0ck100 = 1.1 time = 505
* CHECK dout0_1 vdout0_1ck100 = 0 time = 505
* CHECK dout0_2 vdout0_2ck100 = 1.1 time = 505
* CHECK dout0_3 vdout0_3ck100 = 1.1 time = 505
* CHECK dout0_4 vdout0_4ck100 = 0 time = 505
* CHECK dout0_5 vdout0_5ck100 = 1.1 time = 505
* CHECK dout0_6 vdout0_6ck100 = 1.1 time = 505
* CHECK dout0_7 vdout0_7ck100 = 0 time = 505
* CHECK dout0_8 vdout0_8ck100 = 1.1 time = 505
* CHECK dout0_9 vdout0_9ck100 = 0 time = 505
* CHECK dout0_10 vdout0_10ck100 = 1.1 time = 505
* CHECK dout0_11 vdout0_11ck100 = 1.1 time = 505
* CHECK dout0_12 vdout0_12ck100 = 1.1 time = 505
* CHECK dout0_13 vdout0_13ck100 = 0 time = 505
* CHECK dout0_14 vdout0_14ck100 = 0 time = 505
* CHECK dout0_15 vdout0_15ck100 = 1.1 time = 505
* CHECK dout0_16 vdout0_16ck100 = 1.1 time = 505
* CHECK dout0_17 vdout0_17ck100 = 0 time = 505
* CHECK dout0_18 vdout0_18ck100 = 1.1 time = 505
* CHECK dout0_19 vdout0_19ck100 = 1.1 time = 505
* CHECK dout0_20 vdout0_20ck100 = 0 time = 505
* CHECK dout0_21 vdout0_21ck100 = 0 time = 505
* CHECK dout0_22 vdout0_22ck100 = 0 time = 505
* CHECK dout0_23 vdout0_23ck100 = 0 time = 505
* CHECK dout0_24 vdout0_24ck100 = 1.1 time = 505
* CHECK dout0_25 vdout0_25ck100 = 1.1 time = 505
* CHECK dout0_26 vdout0_26ck100 = 0 time = 505
* CHECK dout0_27 vdout0_27ck100 = 0 time = 505
* CHECK dout0_28 vdout0_28ck100 = 0 time = 505
* CHECK dout0_29 vdout0_29ck100 = 1.1 time = 505
* CHECK dout0_30 vdout0_30ck100 = 0 time = 505
* CHECK dout0_31 vdout0_31ck100 = 0 time = 505
* CHECK dout0_0 vdout0_0ck105 = 1.1 time = 530
* CHECK dout0_1 vdout0_1ck105 = 0 time = 530
* CHECK dout0_2 vdout0_2ck105 = 1.1 time = 530
* CHECK dout0_3 vdout0_3ck105 = 1.1 time = 530
* CHECK dout0_4 vdout0_4ck105 = 0 time = 530
* CHECK dout0_5 vdout0_5ck105 = 1.1 time = 530
* CHECK dout0_6 vdout0_6ck105 = 1.1 time = 530
* CHECK dout0_7 vdout0_7ck105 = 0 time = 530
* CHECK dout0_8 vdout0_8ck105 = 1.1 time = 530
* CHECK dout0_9 vdout0_9ck105 = 0 time = 530
* CHECK dout0_10 vdout0_10ck105 = 1.1 time = 530
* CHECK dout0_11 vdout0_11ck105 = 1.1 time = 530
* CHECK dout0_12 vdout0_12ck105 = 1.1 time = 530
* CHECK dout0_13 vdout0_13ck105 = 0 time = 530
* CHECK dout0_14 vdout0_14ck105 = 0 time = 530
* CHECK dout0_15 vdout0_15ck105 = 1.1 time = 530
* CHECK dout0_16 vdout0_16ck105 = 1.1 time = 530
* CHECK dout0_17 vdout0_17ck105 = 0 time = 530
* CHECK dout0_18 vdout0_18ck105 = 1.1 time = 530
* CHECK dout0_19 vdout0_19ck105 = 1.1 time = 530
* CHECK dout0_20 vdout0_20ck105 = 0 time = 530
* CHECK dout0_21 vdout0_21ck105 = 0 time = 530
* CHECK dout0_22 vdout0_22ck105 = 0 time = 530
* CHECK dout0_23 vdout0_23ck105 = 0 time = 530
* CHECK dout0_24 vdout0_24ck105 = 1.1 time = 530
* CHECK dout0_25 vdout0_25ck105 = 1.1 time = 530
* CHECK dout0_26 vdout0_26ck105 = 0 time = 530
* CHECK dout0_27 vdout0_27ck105 = 0 time = 530
* CHECK dout0_28 vdout0_28ck105 = 0 time = 530
* CHECK dout0_29 vdout0_29ck105 = 1.1 time = 530
* CHECK dout0_30 vdout0_30ck105 = 0 time = 530
* CHECK dout0_31 vdout0_31ck105 = 0 time = 530
* CHECK dout0_0 vdout0_0ck106 = 1.1 time = 535
* CHECK dout0_1 vdout0_1ck106 = 0 time = 535
* CHECK dout0_2 vdout0_2ck106 = 1.1 time = 535
* CHECK dout0_3 vdout0_3ck106 = 1.1 time = 535
* CHECK dout0_4 vdout0_4ck106 = 1.1 time = 535
* CHECK dout0_5 vdout0_5ck106 = 0 time = 535
* CHECK dout0_6 vdout0_6ck106 = 0 time = 535
* CHECK dout0_7 vdout0_7ck106 = 0 time = 535
* CHECK dout0_8 vdout0_8ck106 = 0 time = 535
* CHECK dout0_9 vdout0_9ck106 = 0 time = 535
* CHECK dout0_10 vdout0_10ck106 = 0 time = 535
* CHECK dout0_11 vdout0_11ck106 = 1.1 time = 535
* CHECK dout0_12 vdout0_12ck106 = 1.1 time = 535
* CHECK dout0_13 vdout0_13ck106 = 1.1 time = 535
* CHECK dout0_14 vdout0_14ck106 = 0 time = 535
* CHECK dout0_15 vdout0_15ck106 = 0 time = 535
* CHECK dout0_16 vdout0_16ck106 = 0 time = 535
* CHECK dout0_17 vdout0_17ck106 = 0 time = 535
* CHECK dout0_18 vdout0_18ck106 = 0 time = 535
* CHECK dout0_19 vdout0_19ck106 = 1.1 time = 535
* CHECK dout0_20 vdout0_20ck106 = 1.1 time = 535
* CHECK dout0_21 vdout0_21ck106 = 0 time = 535
* CHECK dout0_22 vdout0_22ck106 = 0 time = 535
* CHECK dout0_23 vdout0_23ck106 = 0 time = 535
* CHECK dout0_24 vdout0_24ck106 = 0 time = 535
* CHECK dout0_25 vdout0_25ck106 = 0 time = 535
* CHECK dout0_26 vdout0_26ck106 = 0 time = 535
* CHECK dout0_27 vdout0_27ck106 = 1.1 time = 535
* CHECK dout0_28 vdout0_28ck106 = 0 time = 535
* CHECK dout0_29 vdout0_29ck106 = 1.1 time = 535
* CHECK dout0_30 vdout0_30ck106 = 0 time = 535
* CHECK dout0_31 vdout0_31ck106 = 1.1 time = 535
* CHECK dout0_0 vdout0_0ck107 = 1.1 time = 540
* CHECK dout0_1 vdout0_1ck107 = 0 time = 540
* CHECK dout0_2 vdout0_2ck107 = 1.1 time = 540
* CHECK dout0_3 vdout0_3ck107 = 1.1 time = 540
* CHECK dout0_4 vdout0_4ck107 = 0 time = 540
* CHECK dout0_5 vdout0_5ck107 = 1.1 time = 540
* CHECK dout0_6 vdout0_6ck107 = 1.1 time = 540
* CHECK dout0_7 vdout0_7ck107 = 0 time = 540
* CHECK dout0_8 vdout0_8ck107 = 1.1 time = 540
* CHECK dout0_9 vdout0_9ck107 = 0 time = 540
* CHECK dout0_10 vdout0_10ck107 = 1.1 time = 540
* CHECK dout0_11 vdout0_11ck107 = 1.1 time = 540
* CHECK dout0_12 vdout0_12ck107 = 1.1 time = 540
* CHECK dout0_13 vdout0_13ck107 = 0 time = 540
* CHECK dout0_14 vdout0_14ck107 = 0 time = 540
* CHECK dout0_15 vdout0_15ck107 = 1.1 time = 540
* CHECK dout0_16 vdout0_16ck107 = 1.1 time = 540
* CHECK dout0_17 vdout0_17ck107 = 0 time = 540
* CHECK dout0_18 vdout0_18ck107 = 1.1 time = 540
* CHECK dout0_19 vdout0_19ck107 = 1.1 time = 540
* CHECK dout0_20 vdout0_20ck107 = 0 time = 540
* CHECK dout0_21 vdout0_21ck107 = 0 time = 540
* CHECK dout0_22 vdout0_22ck107 = 0 time = 540
* CHECK dout0_23 vdout0_23ck107 = 0 time = 540
* CHECK dout0_24 vdout0_24ck107 = 1.1 time = 540
* CHECK dout0_25 vdout0_25ck107 = 1.1 time = 540
* CHECK dout0_26 vdout0_26ck107 = 0 time = 540
* CHECK dout0_27 vdout0_27ck107 = 0 time = 540
* CHECK dout0_28 vdout0_28ck107 = 0 time = 540
* CHECK dout0_29 vdout0_29ck107 = 1.1 time = 540
* CHECK dout0_30 vdout0_30ck107 = 0 time = 540
* CHECK dout0_31 vdout0_31ck107 = 0 time = 540
* CHECK dout0_0 vdout0_0ck112 = 0 time = 565
* CHECK dout0_1 vdout0_1ck112 = 1.1 time = 565
* CHECK dout0_2 vdout0_2ck112 = 0 time = 565
* CHECK dout0_3 vdout0_3ck112 = 0 time = 565
* CHECK dout0_4 vdout0_4ck112 = 0 time = 565
* CHECK dout0_5 vdout0_5ck112 = 1.1 time = 565
* CHECK dout0_6 vdout0_6ck112 = 0 time = 565
* CHECK dout0_7 vdout0_7ck112 = 1.1 time = 565
* CHECK dout0_8 vdout0_8ck112 = 1.1 time = 565
* CHECK dout0_9 vdout0_9ck112 = 0 time = 565
* CHECK dout0_10 vdout0_10ck112 = 0 time = 565
* CHECK dout0_11 vdout0_11ck112 = 1.1 time = 565
* CHECK dout0_12 vdout0_12ck112 = 1.1 time = 565
* CHECK dout0_13 vdout0_13ck112 = 1.1 time = 565
* CHECK dout0_14 vdout0_14ck112 = 0 time = 565
* CHECK dout0_15 vdout0_15ck112 = 1.1 time = 565
* CHECK dout0_16 vdout0_16ck112 = 1.1 time = 565
* CHECK dout0_17 vdout0_17ck112 = 0 time = 565
* CHECK dout0_18 vdout0_18ck112 = 0 time = 565
* CHECK dout0_19 vdout0_19ck112 = 0 time = 565
* CHECK dout0_20 vdout0_20ck112 = 1.1 time = 565
* CHECK dout0_21 vdout0_21ck112 = 0 time = 565
* CHECK dout0_22 vdout0_22ck112 = 1.1 time = 565
* CHECK dout0_23 vdout0_23ck112 = 0 time = 565
* CHECK dout0_24 vdout0_24ck112 = 0 time = 565
* CHECK dout0_25 vdout0_25ck112 = 0 time = 565
* CHECK dout0_26 vdout0_26ck112 = 1.1 time = 565
* CHECK dout0_27 vdout0_27ck112 = 0 time = 565
* CHECK dout0_28 vdout0_28ck112 = 0 time = 565
* CHECK dout0_29 vdout0_29ck112 = 0 time = 565
* CHECK dout0_30 vdout0_30ck112 = 1.1 time = 565
* CHECK dout0_31 vdout0_31ck112 = 1.1 time = 565
* CHECK dout0_0 vdout0_0ck113 = 0 time = 570
* CHECK dout0_1 vdout0_1ck113 = 0 time = 570
* CHECK dout0_2 vdout0_2ck113 = 1.1 time = 570
* CHECK dout0_3 vdout0_3ck113 = 0 time = 570
* CHECK dout0_4 vdout0_4ck113 = 1.1 time = 570
* CHECK dout0_5 vdout0_5ck113 = 0 time = 570
* CHECK dout0_6 vdout0_6ck113 = 1.1 time = 570
* CHECK dout0_7 vdout0_7ck113 = 1.1 time = 570
* CHECK dout0_8 vdout0_8ck113 = 0 time = 570
* CHECK dout0_9 vdout0_9ck113 = 0 time = 570
* CHECK dout0_10 vdout0_10ck113 = 1.1 time = 570
* CHECK dout0_11 vdout0_11ck113 = 1.1 time = 570
* CHECK dout0_12 vdout0_12ck113 = 1.1 time = 570
* CHECK dout0_13 vdout0_13ck113 = 1.1 time = 570
* CHECK dout0_14 vdout0_14ck113 = 1.1 time = 570
* CHECK dout0_15 vdout0_15ck113 = 0 time = 570
* CHECK dout0_16 vdout0_16ck113 = 1.1 time = 570
* CHECK dout0_17 vdout0_17ck113 = 0 time = 570
* CHECK dout0_18 vdout0_18ck113 = 1.1 time = 570
* CHECK dout0_19 vdout0_19ck113 = 1.1 time = 570
* CHECK dout0_20 vdout0_20ck113 = 1.1 time = 570
* CHECK dout0_21 vdout0_21ck113 = 1.1 time = 570
* CHECK dout0_22 vdout0_22ck113 = 0 time = 570
* CHECK dout0_23 vdout0_23ck113 = 0 time = 570
* CHECK dout0_24 vdout0_24ck113 = 0 time = 570
* CHECK dout0_25 vdout0_25ck113 = 0 time = 570
* CHECK dout0_26 vdout0_26ck113 = 0 time = 570
* CHECK dout0_27 vdout0_27ck113 = 0 time = 570
* CHECK dout0_28 vdout0_28ck113 = 0 time = 570
* CHECK dout0_29 vdout0_29ck113 = 0 time = 570
* CHECK dout0_30 vdout0_30ck113 = 1.1 time = 570
* CHECK dout0_31 vdout0_31ck113 = 1.1 time = 570
* CHECK dout0_0 vdout0_0ck114 = 1.1 time = 575
* CHECK dout0_1 vdout0_1ck114 = 1.1 time = 575
* CHECK dout0_2 vdout0_2ck114 = 0 time = 575
* CHECK dout0_3 vdout0_3ck114 = 1.1 time = 575
* CHECK dout0_4 vdout0_4ck114 = 1.1 time = 575
* CHECK dout0_5 vdout0_5ck114 = 1.1 time = 575
* CHECK dout0_6 vdout0_6ck114 = 0 time = 575
* CHECK dout0_7 vdout0_7ck114 = 0 time = 575
* CHECK dout0_8 vdout0_8ck114 = 1.1 time = 575
* CHECK dout0_9 vdout0_9ck114 = 1.1 time = 575
* CHECK dout0_10 vdout0_10ck114 = 0 time = 575
* CHECK dout0_11 vdout0_11ck114 = 1.1 time = 575
* CHECK dout0_12 vdout0_12ck114 = 0 time = 575
* CHECK dout0_13 vdout0_13ck114 = 1.1 time = 575
* CHECK dout0_14 vdout0_14ck114 = 0 time = 575
* CHECK dout0_15 vdout0_15ck114 = 0 time = 575
* CHECK dout0_16 vdout0_16ck114 = 0 time = 575
* CHECK dout0_17 vdout0_17ck114 = 0 time = 575
* CHECK dout0_18 vdout0_18ck114 = 1.1 time = 575
* CHECK dout0_19 vdout0_19ck114 = 1.1 time = 575
* CHECK dout0_20 vdout0_20ck114 = 1.1 time = 575
* CHECK dout0_21 vdout0_21ck114 = 0 time = 575
* CHECK dout0_22 vdout0_22ck114 = 0 time = 575
* CHECK dout0_23 vdout0_23ck114 = 1.1 time = 575
* CHECK dout0_24 vdout0_24ck114 = 1.1 time = 575
* CHECK dout0_25 vdout0_25ck114 = 1.1 time = 575
* CHECK dout0_26 vdout0_26ck114 = 1.1 time = 575
* CHECK dout0_27 vdout0_27ck114 = 0 time = 575
* CHECK dout0_28 vdout0_28ck114 = 0 time = 575
* CHECK dout0_29 vdout0_29ck114 = 0 time = 575
* CHECK dout0_30 vdout0_30ck114 = 0 time = 575
* CHECK dout0_31 vdout0_31ck114 = 1.1 time = 575
* CHECK dout0_0 vdout0_0ck118 = 1.1 time = 595
* CHECK dout0_1 vdout0_1ck118 = 1.1 time = 595
* CHECK dout0_2 vdout0_2ck118 = 0 time = 595
* CHECK dout0_3 vdout0_3ck118 = 1.1 time = 595
* CHECK dout0_4 vdout0_4ck118 = 1.1 time = 595
* CHECK dout0_5 vdout0_5ck118 = 1.1 time = 595
* CHECK dout0_6 vdout0_6ck118 = 0 time = 595
* CHECK dout0_7 vdout0_7ck118 = 0 time = 595
* CHECK dout0_8 vdout0_8ck118 = 1.1 time = 595
* CHECK dout0_9 vdout0_9ck118 = 1.1 time = 595
* CHECK dout0_10 vdout0_10ck118 = 0 time = 595
* CHECK dout0_11 vdout0_11ck118 = 1.1 time = 595
* CHECK dout0_12 vdout0_12ck118 = 0 time = 595
* CHECK dout0_13 vdout0_13ck118 = 1.1 time = 595
* CHECK dout0_14 vdout0_14ck118 = 0 time = 595
* CHECK dout0_15 vdout0_15ck118 = 0 time = 595
* CHECK dout0_16 vdout0_16ck118 = 0 time = 595
* CHECK dout0_17 vdout0_17ck118 = 0 time = 595
* CHECK dout0_18 vdout0_18ck118 = 1.1 time = 595
* CHECK dout0_19 vdout0_19ck118 = 1.1 time = 595
* CHECK dout0_20 vdout0_20ck118 = 1.1 time = 595
* CHECK dout0_21 vdout0_21ck118 = 0 time = 595
* CHECK dout0_22 vdout0_22ck118 = 0 time = 595
* CHECK dout0_23 vdout0_23ck118 = 1.1 time = 595
* CHECK dout0_24 vdout0_24ck118 = 1.1 time = 595
* CHECK dout0_25 vdout0_25ck118 = 1.1 time = 595
* CHECK dout0_26 vdout0_26ck118 = 1.1 time = 595
* CHECK dout0_27 vdout0_27ck118 = 0 time = 595
* CHECK dout0_28 vdout0_28ck118 = 0 time = 595
* CHECK dout0_29 vdout0_29ck118 = 0 time = 595
* CHECK dout0_30 vdout0_30ck118 = 0 time = 595
* CHECK dout0_31 vdout0_31ck118 = 1.1 time = 595
* CHECK dout0_0 vdout0_0ck120 = 1.1 time = 605
* CHECK dout0_1 vdout0_1ck120 = 0 time = 605
* CHECK dout0_2 vdout0_2ck120 = 0 time = 605
* CHECK dout0_3 vdout0_3ck120 = 0 time = 605
* CHECK dout0_4 vdout0_4ck120 = 0 time = 605
* CHECK dout0_5 vdout0_5ck120 = 1.1 time = 605
* CHECK dout0_6 vdout0_6ck120 = 1.1 time = 605
* CHECK dout0_7 vdout0_7ck120 = 1.1 time = 605
* CHECK dout0_8 vdout0_8ck120 = 1.1 time = 605
* CHECK dout0_9 vdout0_9ck120 = 0 time = 605
* CHECK dout0_10 vdout0_10ck120 = 1.1 time = 605
* CHECK dout0_11 vdout0_11ck120 = 1.1 time = 605
* CHECK dout0_12 vdout0_12ck120 = 0 time = 605
* CHECK dout0_13 vdout0_13ck120 = 1.1 time = 605
* CHECK dout0_14 vdout0_14ck120 = 1.1 time = 605
* CHECK dout0_15 vdout0_15ck120 = 1.1 time = 605
* CHECK dout0_16 vdout0_16ck120 = 1.1 time = 605
* CHECK dout0_17 vdout0_17ck120 = 1.1 time = 605
* CHECK dout0_18 vdout0_18ck120 = 1.1 time = 605
* CHECK dout0_19 vdout0_19ck120 = 1.1 time = 605
* CHECK dout0_20 vdout0_20ck120 = 0 time = 605
* CHECK dout0_21 vdout0_21ck120 = 1.1 time = 605
* CHECK dout0_22 vdout0_22ck120 = 1.1 time = 605
* CHECK dout0_23 vdout0_23ck120 = 1.1 time = 605
* CHECK dout0_24 vdout0_24ck120 = 1.1 time = 605
* CHECK dout0_25 vdout0_25ck120 = 0 time = 605
* CHECK dout0_26 vdout0_26ck120 = 1.1 time = 605
* CHECK dout0_27 vdout0_27ck120 = 0 time = 605
* CHECK dout0_28 vdout0_28ck120 = 1.1 time = 605
* CHECK dout0_29 vdout0_29ck120 = 1.1 time = 605
* CHECK dout0_30 vdout0_30ck120 = 1.1 time = 605
* CHECK dout0_31 vdout0_31ck120 = 1.1 time = 605
* CHECK dout0_0 vdout0_0ck125 = 1.1 time = 630
* CHECK dout0_1 vdout0_1ck125 = 0 time = 630
* CHECK dout0_2 vdout0_2ck125 = 1.1 time = 630
* CHECK dout0_3 vdout0_3ck125 = 0 time = 630
* CHECK dout0_4 vdout0_4ck125 = 1.1 time = 630
* CHECK dout0_5 vdout0_5ck125 = 0 time = 630
* CHECK dout0_6 vdout0_6ck125 = 1.1 time = 630
* CHECK dout0_7 vdout0_7ck125 = 0 time = 630
* CHECK dout0_8 vdout0_8ck125 = 0 time = 630
* CHECK dout0_9 vdout0_9ck125 = 0 time = 630
* CHECK dout0_10 vdout0_10ck125 = 0 time = 630
* CHECK dout0_11 vdout0_11ck125 = 0 time = 630
* CHECK dout0_12 vdout0_12ck125 = 0 time = 630
* CHECK dout0_13 vdout0_13ck125 = 1.1 time = 630
* CHECK dout0_14 vdout0_14ck125 = 0 time = 630
* CHECK dout0_15 vdout0_15ck125 = 1.1 time = 630
* CHECK dout0_16 vdout0_16ck125 = 0 time = 630
* CHECK dout0_17 vdout0_17ck125 = 0 time = 630
* CHECK dout0_18 vdout0_18ck125 = 0 time = 630
* CHECK dout0_19 vdout0_19ck125 = 0 time = 630
* CHECK dout0_20 vdout0_20ck125 = 1.1 time = 630
* CHECK dout0_21 vdout0_21ck125 = 1.1 time = 630
* CHECK dout0_22 vdout0_22ck125 = 1.1 time = 630
* CHECK dout0_23 vdout0_23ck125 = 0 time = 630
* CHECK dout0_24 vdout0_24ck125 = 0 time = 630
* CHECK dout0_25 vdout0_25ck125 = 1.1 time = 630
* CHECK dout0_26 vdout0_26ck125 = 0 time = 630
* CHECK dout0_27 vdout0_27ck125 = 1.1 time = 630
* CHECK dout0_28 vdout0_28ck125 = 1.1 time = 630
* CHECK dout0_29 vdout0_29ck125 = 0 time = 630
* CHECK dout0_30 vdout0_30ck125 = 1.1 time = 630
* CHECK dout0_31 vdout0_31ck125 = 1.1 time = 630
* CHECK dout0_0 vdout0_0ck131 = 0 time = 660
* CHECK dout0_1 vdout0_1ck131 = 1.1 time = 660
* CHECK dout0_2 vdout0_2ck131 = 1.1 time = 660
* CHECK dout0_3 vdout0_3ck131 = 0 time = 660
* CHECK dout0_4 vdout0_4ck131 = 1.1 time = 660
* CHECK dout0_5 vdout0_5ck131 = 0 time = 660
* CHECK dout0_6 vdout0_6ck131 = 1.1 time = 660
* CHECK dout0_7 vdout0_7ck131 = 0 time = 660
* CHECK dout0_8 vdout0_8ck131 = 1.1 time = 660
* CHECK dout0_9 vdout0_9ck131 = 0 time = 660
* CHECK dout0_10 vdout0_10ck131 = 1.1 time = 660
* CHECK dout0_11 vdout0_11ck131 = 1.1 time = 660
* CHECK dout0_12 vdout0_12ck131 = 1.1 time = 660
* CHECK dout0_13 vdout0_13ck131 = 0 time = 660
* CHECK dout0_14 vdout0_14ck131 = 1.1 time = 660
* CHECK dout0_15 vdout0_15ck131 = 0 time = 660
* CHECK dout0_16 vdout0_16ck131 = 0 time = 660
* CHECK dout0_17 vdout0_17ck131 = 1.1 time = 660
* CHECK dout0_18 vdout0_18ck131 = 1.1 time = 660
* CHECK dout0_19 vdout0_19ck131 = 0 time = 660
* CHECK dout0_20 vdout0_20ck131 = 1.1 time = 660
* CHECK dout0_21 vdout0_21ck131 = 1.1 time = 660
* CHECK dout0_22 vdout0_22ck131 = 0 time = 660
* CHECK dout0_23 vdout0_23ck131 = 0 time = 660
* CHECK dout0_24 vdout0_24ck131 = 0 time = 660
* CHECK dout0_25 vdout0_25ck131 = 1.1 time = 660
* CHECK dout0_26 vdout0_26ck131 = 1.1 time = 660
* CHECK dout0_27 vdout0_27ck131 = 0 time = 660
* CHECK dout0_28 vdout0_28ck131 = 1.1 time = 660
* CHECK dout0_29 vdout0_29ck131 = 0 time = 660
* CHECK dout0_30 vdout0_30ck131 = 1.1 time = 660
* CHECK dout0_31 vdout0_31ck131 = 0 time = 660
* CHECK dout0_0 vdout0_0ck132 = 0 time = 665
* CHECK dout0_1 vdout0_1ck132 = 1.1 time = 665
* CHECK dout0_2 vdout0_2ck132 = 0 time = 665
* CHECK dout0_3 vdout0_3ck132 = 1.1 time = 665
* CHECK dout0_4 vdout0_4ck132 = 0 time = 665
* CHECK dout0_5 vdout0_5ck132 = 0 time = 665
* CHECK dout0_6 vdout0_6ck132 = 1.1 time = 665
* CHECK dout0_7 vdout0_7ck132 = 0 time = 665
* CHECK dout0_8 vdout0_8ck132 = 0 time = 665
* CHECK dout0_9 vdout0_9ck132 = 0 time = 665
* CHECK dout0_10 vdout0_10ck132 = 1.1 time = 665
* CHECK dout0_11 vdout0_11ck132 = 1.1 time = 665
* CHECK dout0_12 vdout0_12ck132 = 0 time = 665
* CHECK dout0_13 vdout0_13ck132 = 0 time = 665
* CHECK dout0_14 vdout0_14ck132 = 1.1 time = 665
* CHECK dout0_15 vdout0_15ck132 = 1.1 time = 665
* CHECK dout0_16 vdout0_16ck132 = 1.1 time = 665
* CHECK dout0_17 vdout0_17ck132 = 1.1 time = 665
* CHECK dout0_18 vdout0_18ck132 = 1.1 time = 665
* CHECK dout0_19 vdout0_19ck132 = 0 time = 665
* CHECK dout0_20 vdout0_20ck132 = 0 time = 665
* CHECK dout0_21 vdout0_21ck132 = 1.1 time = 665
* CHECK dout0_22 vdout0_22ck132 = 1.1 time = 665
* CHECK dout0_23 vdout0_23ck132 = 0 time = 665
* CHECK dout0_24 vdout0_24ck132 = 0 time = 665
* CHECK dout0_25 vdout0_25ck132 = 0 time = 665
* CHECK dout0_26 vdout0_26ck132 = 1.1 time = 665
* CHECK dout0_27 vdout0_27ck132 = 1.1 time = 665
* CHECK dout0_28 vdout0_28ck132 = 0 time = 665
* CHECK dout0_29 vdout0_29ck132 = 0 time = 665
* CHECK dout0_30 vdout0_30ck132 = 1.1 time = 665
* CHECK dout0_31 vdout0_31ck132 = 0 time = 665
* CHECK dout0_0 vdout0_0ck134 = 0 time = 675
* CHECK dout0_1 vdout0_1ck134 = 1.1 time = 675
* CHECK dout0_2 vdout0_2ck134 = 1.1 time = 675
* CHECK dout0_3 vdout0_3ck134 = 0 time = 675
* CHECK dout0_4 vdout0_4ck134 = 1.1 time = 675
* CHECK dout0_5 vdout0_5ck134 = 0 time = 675
* CHECK dout0_6 vdout0_6ck134 = 1.1 time = 675
* CHECK dout0_7 vdout0_7ck134 = 0 time = 675
* CHECK dout0_8 vdout0_8ck134 = 1.1 time = 675
* CHECK dout0_9 vdout0_9ck134 = 0 time = 675
* CHECK dout0_10 vdout0_10ck134 = 1.1 time = 675
* CHECK dout0_11 vdout0_11ck134 = 1.1 time = 675
* CHECK dout0_12 vdout0_12ck134 = 1.1 time = 675
* CHECK dout0_13 vdout0_13ck134 = 0 time = 675
* CHECK dout0_14 vdout0_14ck134 = 1.1 time = 675
* CHECK dout0_15 vdout0_15ck134 = 0 time = 675
* CHECK dout0_16 vdout0_16ck134 = 0 time = 675
* CHECK dout0_17 vdout0_17ck134 = 1.1 time = 675
* CHECK dout0_18 vdout0_18ck134 = 1.1 time = 675
* CHECK dout0_19 vdout0_19ck134 = 0 time = 675
* CHECK dout0_20 vdout0_20ck134 = 1.1 time = 675
* CHECK dout0_21 vdout0_21ck134 = 1.1 time = 675
* CHECK dout0_22 vdout0_22ck134 = 0 time = 675
* CHECK dout0_23 vdout0_23ck134 = 0 time = 675
* CHECK dout0_24 vdout0_24ck134 = 0 time = 675
* CHECK dout0_25 vdout0_25ck134 = 1.1 time = 675
* CHECK dout0_26 vdout0_26ck134 = 1.1 time = 675
* CHECK dout0_27 vdout0_27ck134 = 0 time = 675
* CHECK dout0_28 vdout0_28ck134 = 1.1 time = 675
* CHECK dout0_29 vdout0_29ck134 = 0 time = 675
* CHECK dout0_30 vdout0_30ck134 = 1.1 time = 675
* CHECK dout0_31 vdout0_31ck134 = 0 time = 675
* CHECK dout0_0 vdout0_0ck135 = 0 time = 680
* CHECK dout0_1 vdout0_1ck135 = 1.1 time = 680
* CHECK dout0_2 vdout0_2ck135 = 0 time = 680
* CHECK dout0_3 vdout0_3ck135 = 1.1 time = 680
* CHECK dout0_4 vdout0_4ck135 = 0 time = 680
* CHECK dout0_5 vdout0_5ck135 = 0 time = 680
* CHECK dout0_6 vdout0_6ck135 = 1.1 time = 680
* CHECK dout0_7 vdout0_7ck135 = 0 time = 680
* CHECK dout0_8 vdout0_8ck135 = 0 time = 680
* CHECK dout0_9 vdout0_9ck135 = 0 time = 680
* CHECK dout0_10 vdout0_10ck135 = 1.1 time = 680
* CHECK dout0_11 vdout0_11ck135 = 1.1 time = 680
* CHECK dout0_12 vdout0_12ck135 = 0 time = 680
* CHECK dout0_13 vdout0_13ck135 = 0 time = 680
* CHECK dout0_14 vdout0_14ck135 = 1.1 time = 680
* CHECK dout0_15 vdout0_15ck135 = 1.1 time = 680
* CHECK dout0_16 vdout0_16ck135 = 1.1 time = 680
* CHECK dout0_17 vdout0_17ck135 = 1.1 time = 680
* CHECK dout0_18 vdout0_18ck135 = 1.1 time = 680
* CHECK dout0_19 vdout0_19ck135 = 0 time = 680
* CHECK dout0_20 vdout0_20ck135 = 0 time = 680
* CHECK dout0_21 vdout0_21ck135 = 1.1 time = 680
* CHECK dout0_22 vdout0_22ck135 = 1.1 time = 680
* CHECK dout0_23 vdout0_23ck135 = 0 time = 680
* CHECK dout0_24 vdout0_24ck135 = 0 time = 680
* CHECK dout0_25 vdout0_25ck135 = 0 time = 680
* CHECK dout0_26 vdout0_26ck135 = 1.1 time = 680
* CHECK dout0_27 vdout0_27ck135 = 1.1 time = 680
* CHECK dout0_28 vdout0_28ck135 = 0 time = 680
* CHECK dout0_29 vdout0_29ck135 = 0 time = 680
* CHECK dout0_30 vdout0_30ck135 = 1.1 time = 680
* CHECK dout0_31 vdout0_31ck135 = 0 time = 680
* CHECK dout0_0 vdout0_0ck138 = 0 time = 695
* CHECK dout0_1 vdout0_1ck138 = 0 time = 695
* CHECK dout0_2 vdout0_2ck138 = 0 time = 695
* CHECK dout0_3 vdout0_3ck138 = 0 time = 695
* CHECK dout0_4 vdout0_4ck138 = 0 time = 695
* CHECK dout0_5 vdout0_5ck138 = 0 time = 695
* CHECK dout0_6 vdout0_6ck138 = 0 time = 695
* CHECK dout0_7 vdout0_7ck138 = 1.1 time = 695
* CHECK dout0_8 vdout0_8ck138 = 1.1 time = 695
* CHECK dout0_9 vdout0_9ck138 = 0 time = 695
* CHECK dout0_10 vdout0_10ck138 = 0 time = 695
* CHECK dout0_11 vdout0_11ck138 = 1.1 time = 695
* CHECK dout0_12 vdout0_12ck138 = 1.1 time = 695
* CHECK dout0_13 vdout0_13ck138 = 1.1 time = 695
* CHECK dout0_14 vdout0_14ck138 = 0 time = 695
* CHECK dout0_15 vdout0_15ck138 = 1.1 time = 695
* CHECK dout0_16 vdout0_16ck138 = 0 time = 695
* CHECK dout0_17 vdout0_17ck138 = 0 time = 695
* CHECK dout0_18 vdout0_18ck138 = 0 time = 695
* CHECK dout0_19 vdout0_19ck138 = 1.1 time = 695
* CHECK dout0_20 vdout0_20ck138 = 1.1 time = 695
* CHECK dout0_21 vdout0_21ck138 = 0 time = 695
* CHECK dout0_22 vdout0_22ck138 = 0 time = 695
* CHECK dout0_23 vdout0_23ck138 = 1.1 time = 695
* CHECK dout0_24 vdout0_24ck138 = 0 time = 695
* CHECK dout0_25 vdout0_25ck138 = 0 time = 695
* CHECK dout0_26 vdout0_26ck138 = 1.1 time = 695
* CHECK dout0_27 vdout0_27ck138 = 0 time = 695
* CHECK dout0_28 vdout0_28ck138 = 0 time = 695
* CHECK dout0_29 vdout0_29ck138 = 0 time = 695
* CHECK dout0_30 vdout0_30ck138 = 1.1 time = 695
* CHECK dout0_31 vdout0_31ck138 = 1.1 time = 695
* CHECK dout0_0 vdout0_0ck139 = 0 time = 700
* CHECK dout0_1 vdout0_1ck139 = 1.1 time = 700
* CHECK dout0_2 vdout0_2ck139 = 1.1 time = 700
* CHECK dout0_3 vdout0_3ck139 = 0 time = 700
* CHECK dout0_4 vdout0_4ck139 = 1.1 time = 700
* CHECK dout0_5 vdout0_5ck139 = 0 time = 700
* CHECK dout0_6 vdout0_6ck139 = 1.1 time = 700
* CHECK dout0_7 vdout0_7ck139 = 0 time = 700
* CHECK dout0_8 vdout0_8ck139 = 1.1 time = 700
* CHECK dout0_9 vdout0_9ck139 = 0 time = 700
* CHECK dout0_10 vdout0_10ck139 = 1.1 time = 700
* CHECK dout0_11 vdout0_11ck139 = 1.1 time = 700
* CHECK dout0_12 vdout0_12ck139 = 1.1 time = 700
* CHECK dout0_13 vdout0_13ck139 = 0 time = 700
* CHECK dout0_14 vdout0_14ck139 = 1.1 time = 700
* CHECK dout0_15 vdout0_15ck139 = 0 time = 700
* CHECK dout0_16 vdout0_16ck139 = 0 time = 700
* CHECK dout0_17 vdout0_17ck139 = 1.1 time = 700
* CHECK dout0_18 vdout0_18ck139 = 1.1 time = 700
* CHECK dout0_19 vdout0_19ck139 = 0 time = 700
* CHECK dout0_20 vdout0_20ck139 = 1.1 time = 700
* CHECK dout0_21 vdout0_21ck139 = 1.1 time = 700
* CHECK dout0_22 vdout0_22ck139 = 0 time = 700
* CHECK dout0_23 vdout0_23ck139 = 0 time = 700
* CHECK dout0_24 vdout0_24ck139 = 0 time = 700
* CHECK dout0_25 vdout0_25ck139 = 1.1 time = 700
* CHECK dout0_26 vdout0_26ck139 = 1.1 time = 700
* CHECK dout0_27 vdout0_27ck139 = 0 time = 700
* CHECK dout0_28 vdout0_28ck139 = 1.1 time = 700
* CHECK dout0_29 vdout0_29ck139 = 0 time = 700
* CHECK dout0_30 vdout0_30ck139 = 1.1 time = 700
* CHECK dout0_31 vdout0_31ck139 = 0 time = 700
* CHECK dout0_0 vdout0_0ck142 = 0 time = 715
* CHECK dout0_1 vdout0_1ck142 = 1.1 time = 715
* CHECK dout0_2 vdout0_2ck142 = 0 time = 715
* CHECK dout0_3 vdout0_3ck142 = 1.1 time = 715
* CHECK dout0_4 vdout0_4ck142 = 1.1 time = 715
* CHECK dout0_5 vdout0_5ck142 = 1.1 time = 715
* CHECK dout0_6 vdout0_6ck142 = 1.1 time = 715
* CHECK dout0_7 vdout0_7ck142 = 0 time = 715
* CHECK dout0_8 vdout0_8ck142 = 1.1 time = 715
* CHECK dout0_9 vdout0_9ck142 = 0 time = 715
* CHECK dout0_10 vdout0_10ck142 = 1.1 time = 715
* CHECK dout0_11 vdout0_11ck142 = 0 time = 715
* CHECK dout0_12 vdout0_12ck142 = 0 time = 715
* CHECK dout0_13 vdout0_13ck142 = 0 time = 715
* CHECK dout0_14 vdout0_14ck142 = 0 time = 715
* CHECK dout0_15 vdout0_15ck142 = 1.1 time = 715
* CHECK dout0_16 vdout0_16ck142 = 0 time = 715
* CHECK dout0_17 vdout0_17ck142 = 0 time = 715
* CHECK dout0_18 vdout0_18ck142 = 0 time = 715
* CHECK dout0_19 vdout0_19ck142 = 0 time = 715
* CHECK dout0_20 vdout0_20ck142 = 1.1 time = 715
* CHECK dout0_21 vdout0_21ck142 = 1.1 time = 715
* CHECK dout0_22 vdout0_22ck142 = 1.1 time = 715
* CHECK dout0_23 vdout0_23ck142 = 0 time = 715
* CHECK dout0_24 vdout0_24ck142 = 0 time = 715
* CHECK dout0_25 vdout0_25ck142 = 1.1 time = 715
* CHECK dout0_26 vdout0_26ck142 = 1.1 time = 715
* CHECK dout0_27 vdout0_27ck142 = 0 time = 715
* CHECK dout0_28 vdout0_28ck142 = 1.1 time = 715
* CHECK dout0_29 vdout0_29ck142 = 0 time = 715
* CHECK dout0_30 vdout0_30ck142 = 0 time = 715
* CHECK dout0_31 vdout0_31ck142 = 0 time = 715
* CHECK dout0_0 vdout0_0ck143 = 0 time = 720
* CHECK dout0_1 vdout0_1ck143 = 1.1 time = 720
* CHECK dout0_2 vdout0_2ck143 = 1.1 time = 720
* CHECK dout0_3 vdout0_3ck143 = 0 time = 720
* CHECK dout0_4 vdout0_4ck143 = 1.1 time = 720
* CHECK dout0_5 vdout0_5ck143 = 1.1 time = 720
* CHECK dout0_6 vdout0_6ck143 = 1.1 time = 720
* CHECK dout0_7 vdout0_7ck143 = 1.1 time = 720
* CHECK dout0_8 vdout0_8ck143 = 0 time = 720
* CHECK dout0_9 vdout0_9ck143 = 0 time = 720
* CHECK dout0_10 vdout0_10ck143 = 1.1 time = 720
* CHECK dout0_11 vdout0_11ck143 = 1.1 time = 720
* CHECK dout0_12 vdout0_12ck143 = 0 time = 720
* CHECK dout0_13 vdout0_13ck143 = 0 time = 720
* CHECK dout0_14 vdout0_14ck143 = 1.1 time = 720
* CHECK dout0_15 vdout0_15ck143 = 1.1 time = 720
* CHECK dout0_16 vdout0_16ck143 = 1.1 time = 720
* CHECK dout0_17 vdout0_17ck143 = 1.1 time = 720
* CHECK dout0_18 vdout0_18ck143 = 1.1 time = 720
* CHECK dout0_19 vdout0_19ck143 = 0 time = 720
* CHECK dout0_20 vdout0_20ck143 = 0 time = 720
* CHECK dout0_21 vdout0_21ck143 = 1.1 time = 720
* CHECK dout0_22 vdout0_22ck143 = 1.1 time = 720
* CHECK dout0_23 vdout0_23ck143 = 1.1 time = 720
* CHECK dout0_24 vdout0_24ck143 = 1.1 time = 720
* CHECK dout0_25 vdout0_25ck143 = 1.1 time = 720
* CHECK dout0_26 vdout0_26ck143 = 1.1 time = 720
* CHECK dout0_27 vdout0_27ck143 = 0 time = 720
* CHECK dout0_28 vdout0_28ck143 = 1.1 time = 720
* CHECK dout0_29 vdout0_29ck143 = 0 time = 720
* CHECK dout0_30 vdout0_30ck143 = 0 time = 720
* CHECK dout0_31 vdout0_31ck143 = 0 time = 720
* CHECK dout0_0 vdout0_0ck145 = 1.1 time = 730
* CHECK dout0_1 vdout0_1ck145 = 0 time = 730
* CHECK dout0_2 vdout0_2ck145 = 0 time = 730
* CHECK dout0_3 vdout0_3ck145 = 0 time = 730
* CHECK dout0_4 vdout0_4ck145 = 0 time = 730
* CHECK dout0_5 vdout0_5ck145 = 1.1 time = 730
* CHECK dout0_6 vdout0_6ck145 = 1.1 time = 730
* CHECK dout0_7 vdout0_7ck145 = 1.1 time = 730
* CHECK dout0_8 vdout0_8ck145 = 1.1 time = 730
* CHECK dout0_9 vdout0_9ck145 = 0 time = 730
* CHECK dout0_10 vdout0_10ck145 = 1.1 time = 730
* CHECK dout0_11 vdout0_11ck145 = 1.1 time = 730
* CHECK dout0_12 vdout0_12ck145 = 0 time = 730
* CHECK dout0_13 vdout0_13ck145 = 1.1 time = 730
* CHECK dout0_14 vdout0_14ck145 = 1.1 time = 730
* CHECK dout0_15 vdout0_15ck145 = 1.1 time = 730
* CHECK dout0_16 vdout0_16ck145 = 1.1 time = 730
* CHECK dout0_17 vdout0_17ck145 = 1.1 time = 730
* CHECK dout0_18 vdout0_18ck145 = 1.1 time = 730
* CHECK dout0_19 vdout0_19ck145 = 1.1 time = 730
* CHECK dout0_20 vdout0_20ck145 = 0 time = 730
* CHECK dout0_21 vdout0_21ck145 = 1.1 time = 730
* CHECK dout0_22 vdout0_22ck145 = 1.1 time = 730
* CHECK dout0_23 vdout0_23ck145 = 1.1 time = 730
* CHECK dout0_24 vdout0_24ck145 = 1.1 time = 730
* CHECK dout0_25 vdout0_25ck145 = 0 time = 730
* CHECK dout0_26 vdout0_26ck145 = 1.1 time = 730
* CHECK dout0_27 vdout0_27ck145 = 0 time = 730
* CHECK dout0_28 vdout0_28ck145 = 1.1 time = 730
* CHECK dout0_29 vdout0_29ck145 = 1.1 time = 730
* CHECK dout0_30 vdout0_30ck145 = 1.1 time = 730
* CHECK dout0_31 vdout0_31ck145 = 1.1 time = 730
* CHECK dout0_0 vdout0_0ck147 = 0 time = 740
* CHECK dout0_1 vdout0_1ck147 = 1.1 time = 740
* CHECK dout0_2 vdout0_2ck147 = 1.1 time = 740
* CHECK dout0_3 vdout0_3ck147 = 0 time = 740
* CHECK dout0_4 vdout0_4ck147 = 1.1 time = 740
* CHECK dout0_5 vdout0_5ck147 = 1.1 time = 740
* CHECK dout0_6 vdout0_6ck147 = 1.1 time = 740
* CHECK dout0_7 vdout0_7ck147 = 1.1 time = 740
* CHECK dout0_8 vdout0_8ck147 = 0 time = 740
* CHECK dout0_9 vdout0_9ck147 = 0 time = 740
* CHECK dout0_10 vdout0_10ck147 = 1.1 time = 740
* CHECK dout0_11 vdout0_11ck147 = 1.1 time = 740
* CHECK dout0_12 vdout0_12ck147 = 0 time = 740
* CHECK dout0_13 vdout0_13ck147 = 0 time = 740
* CHECK dout0_14 vdout0_14ck147 = 1.1 time = 740
* CHECK dout0_15 vdout0_15ck147 = 1.1 time = 740
* CHECK dout0_16 vdout0_16ck147 = 1.1 time = 740
* CHECK dout0_17 vdout0_17ck147 = 1.1 time = 740
* CHECK dout0_18 vdout0_18ck147 = 1.1 time = 740
* CHECK dout0_19 vdout0_19ck147 = 0 time = 740
* CHECK dout0_20 vdout0_20ck147 = 0 time = 740
* CHECK dout0_21 vdout0_21ck147 = 1.1 time = 740
* CHECK dout0_22 vdout0_22ck147 = 1.1 time = 740
* CHECK dout0_23 vdout0_23ck147 = 1.1 time = 740
* CHECK dout0_24 vdout0_24ck147 = 1.1 time = 740
* CHECK dout0_25 vdout0_25ck147 = 1.1 time = 740
* CHECK dout0_26 vdout0_26ck147 = 1.1 time = 740
* CHECK dout0_27 vdout0_27ck147 = 0 time = 740
* CHECK dout0_28 vdout0_28ck147 = 1.1 time = 740
* CHECK dout0_29 vdout0_29ck147 = 0 time = 740
* CHECK dout0_30 vdout0_30ck147 = 0 time = 740
* CHECK dout0_31 vdout0_31ck147 = 0 time = 740
* CHECK dout0_0 vdout0_0ck148 = 1.1 time = 745
* CHECK dout0_1 vdout0_1ck148 = 1.1 time = 745
* CHECK dout0_2 vdout0_2ck148 = 1.1 time = 745
* CHECK dout0_3 vdout0_3ck148 = 1.1 time = 745
* CHECK dout0_4 vdout0_4ck148 = 1.1 time = 745
* CHECK dout0_5 vdout0_5ck148 = 0 time = 745
* CHECK dout0_6 vdout0_6ck148 = 1.1 time = 745
* CHECK dout0_7 vdout0_7ck148 = 0 time = 745
* CHECK dout0_8 vdout0_8ck148 = 0 time = 745
* CHECK dout0_9 vdout0_9ck148 = 0 time = 745
* CHECK dout0_10 vdout0_10ck148 = 0 time = 745
* CHECK dout0_11 vdout0_11ck148 = 1.1 time = 745
* CHECK dout0_12 vdout0_12ck148 = 0 time = 745
* CHECK dout0_13 vdout0_13ck148 = 1.1 time = 745
* CHECK dout0_14 vdout0_14ck148 = 1.1 time = 745
* CHECK dout0_15 vdout0_15ck148 = 0 time = 745
* CHECK dout0_16 vdout0_16ck148 = 1.1 time = 745
* CHECK dout0_17 vdout0_17ck148 = 1.1 time = 745
* CHECK dout0_18 vdout0_18ck148 = 1.1 time = 745
* CHECK dout0_19 vdout0_19ck148 = 1.1 time = 745
* CHECK dout0_20 vdout0_20ck148 = 1.1 time = 745
* CHECK dout0_21 vdout0_21ck148 = 1.1 time = 745
* CHECK dout0_22 vdout0_22ck148 = 0 time = 745
* CHECK dout0_23 vdout0_23ck148 = 0 time = 745
* CHECK dout0_24 vdout0_24ck148 = 1.1 time = 745
* CHECK dout0_25 vdout0_25ck148 = 1.1 time = 745
* CHECK dout0_26 vdout0_26ck148 = 0 time = 745
* CHECK dout0_27 vdout0_27ck148 = 1.1 time = 745
* CHECK dout0_28 vdout0_28ck148 = 1.1 time = 745
* CHECK dout0_29 vdout0_29ck148 = 1.1 time = 745
* CHECK dout0_30 vdout0_30ck148 = 0 time = 745
* CHECK dout0_31 vdout0_31ck148 = 1.1 time = 745
* CHECK dout0_0 vdout0_0ck149 = 1.1 time = 750
* CHECK dout0_1 vdout0_1ck149 = 1.1 time = 750
* CHECK dout0_2 vdout0_2ck149 = 1.1 time = 750
* CHECK dout0_3 vdout0_3ck149 = 1.1 time = 750
* CHECK dout0_4 vdout0_4ck149 = 1.1 time = 750
* CHECK dout0_5 vdout0_5ck149 = 0 time = 750
* CHECK dout0_6 vdout0_6ck149 = 1.1 time = 750
* CHECK dout0_7 vdout0_7ck149 = 0 time = 750
* CHECK dout0_8 vdout0_8ck149 = 0 time = 750
* CHECK dout0_9 vdout0_9ck149 = 0 time = 750
* CHECK dout0_10 vdout0_10ck149 = 0 time = 750
* CHECK dout0_11 vdout0_11ck149 = 1.1 time = 750
* CHECK dout0_12 vdout0_12ck149 = 0 time = 750
* CHECK dout0_13 vdout0_13ck149 = 1.1 time = 750
* CHECK dout0_14 vdout0_14ck149 = 1.1 time = 750
* CHECK dout0_15 vdout0_15ck149 = 0 time = 750
* CHECK dout0_16 vdout0_16ck149 = 1.1 time = 750
* CHECK dout0_17 vdout0_17ck149 = 1.1 time = 750
* CHECK dout0_18 vdout0_18ck149 = 1.1 time = 750
* CHECK dout0_19 vdout0_19ck149 = 1.1 time = 750
* CHECK dout0_20 vdout0_20ck149 = 1.1 time = 750
* CHECK dout0_21 vdout0_21ck149 = 1.1 time = 750
* CHECK dout0_22 vdout0_22ck149 = 0 time = 750
* CHECK dout0_23 vdout0_23ck149 = 0 time = 750
* CHECK dout0_24 vdout0_24ck149 = 1.1 time = 750
* CHECK dout0_25 vdout0_25ck149 = 1.1 time = 750
* CHECK dout0_26 vdout0_26ck149 = 0 time = 750
* CHECK dout0_27 vdout0_27ck149 = 1.1 time = 750
* CHECK dout0_28 vdout0_28ck149 = 1.1 time = 750
* CHECK dout0_29 vdout0_29ck149 = 1.1 time = 750
* CHECK dout0_30 vdout0_30ck149 = 0 time = 750
* CHECK dout0_31 vdout0_31ck149 = 1.1 time = 750
* CHECK dout0_0 vdout0_0ck150 = 1.1 time = 755
* CHECK dout0_1 vdout0_1ck150 = 0 time = 755
* CHECK dout0_2 vdout0_2ck150 = 0 time = 755
* CHECK dout0_3 vdout0_3ck150 = 0 time = 755
* CHECK dout0_4 vdout0_4ck150 = 0 time = 755
* CHECK dout0_5 vdout0_5ck150 = 1.1 time = 755
* CHECK dout0_6 vdout0_6ck150 = 1.1 time = 755
* CHECK dout0_7 vdout0_7ck150 = 1.1 time = 755
* CHECK dout0_8 vdout0_8ck150 = 1.1 time = 755
* CHECK dout0_9 vdout0_9ck150 = 0 time = 755
* CHECK dout0_10 vdout0_10ck150 = 1.1 time = 755
* CHECK dout0_11 vdout0_11ck150 = 1.1 time = 755
* CHECK dout0_12 vdout0_12ck150 = 0 time = 755
* CHECK dout0_13 vdout0_13ck150 = 1.1 time = 755
* CHECK dout0_14 vdout0_14ck150 = 1.1 time = 755
* CHECK dout0_15 vdout0_15ck150 = 1.1 time = 755
* CHECK dout0_16 vdout0_16ck150 = 1.1 time = 755
* CHECK dout0_17 vdout0_17ck150 = 1.1 time = 755
* CHECK dout0_18 vdout0_18ck150 = 1.1 time = 755
* CHECK dout0_19 vdout0_19ck150 = 1.1 time = 755
* CHECK dout0_20 vdout0_20ck150 = 0 time = 755
* CHECK dout0_21 vdout0_21ck150 = 1.1 time = 755
* CHECK dout0_22 vdout0_22ck150 = 1.1 time = 755
* CHECK dout0_23 vdout0_23ck150 = 1.1 time = 755
* CHECK dout0_24 vdout0_24ck150 = 1.1 time = 755
* CHECK dout0_25 vdout0_25ck150 = 0 time = 755
* CHECK dout0_26 vdout0_26ck150 = 1.1 time = 755
* CHECK dout0_27 vdout0_27ck150 = 0 time = 755
* CHECK dout0_28 vdout0_28ck150 = 1.1 time = 755
* CHECK dout0_29 vdout0_29ck150 = 1.1 time = 755
* CHECK dout0_30 vdout0_30ck150 = 1.1 time = 755
* CHECK dout0_31 vdout0_31ck150 = 1.1 time = 755
* CHECK dout0_0 vdout0_0ck152 = 1.1 time = 765
* CHECK dout0_1 vdout0_1ck152 = 0 time = 765
* CHECK dout0_2 vdout0_2ck152 = 0 time = 765
* CHECK dout0_3 vdout0_3ck152 = 0 time = 765
* CHECK dout0_4 vdout0_4ck152 = 0 time = 765
* CHECK dout0_5 vdout0_5ck152 = 1.1 time = 765
* CHECK dout0_6 vdout0_6ck152 = 1.1 time = 765
* CHECK dout0_7 vdout0_7ck152 = 1.1 time = 765
* CHECK dout0_8 vdout0_8ck152 = 1.1 time = 765
* CHECK dout0_9 vdout0_9ck152 = 0 time = 765
* CHECK dout0_10 vdout0_10ck152 = 1.1 time = 765
* CHECK dout0_11 vdout0_11ck152 = 1.1 time = 765
* CHECK dout0_12 vdout0_12ck152 = 0 time = 765
* CHECK dout0_13 vdout0_13ck152 = 1.1 time = 765
* CHECK dout0_14 vdout0_14ck152 = 1.1 time = 765
* CHECK dout0_15 vdout0_15ck152 = 1.1 time = 765
* CHECK dout0_16 vdout0_16ck152 = 1.1 time = 765
* CHECK dout0_17 vdout0_17ck152 = 1.1 time = 765
* CHECK dout0_18 vdout0_18ck152 = 1.1 time = 765
* CHECK dout0_19 vdout0_19ck152 = 1.1 time = 765
* CHECK dout0_20 vdout0_20ck152 = 0 time = 765
* CHECK dout0_21 vdout0_21ck152 = 1.1 time = 765
* CHECK dout0_22 vdout0_22ck152 = 1.1 time = 765
* CHECK dout0_23 vdout0_23ck152 = 1.1 time = 765
* CHECK dout0_24 vdout0_24ck152 = 1.1 time = 765
* CHECK dout0_25 vdout0_25ck152 = 0 time = 765
* CHECK dout0_26 vdout0_26ck152 = 1.1 time = 765
* CHECK dout0_27 vdout0_27ck152 = 0 time = 765
* CHECK dout0_28 vdout0_28ck152 = 1.1 time = 765
* CHECK dout0_29 vdout0_29ck152 = 1.1 time = 765
* CHECK dout0_30 vdout0_30ck152 = 1.1 time = 765
* CHECK dout0_31 vdout0_31ck152 = 1.1 time = 765
* CHECK dout0_0 vdout0_0ck154 = 1.1 time = 775
* CHECK dout0_1 vdout0_1ck154 = 0 time = 775
* CHECK dout0_2 vdout0_2ck154 = 0 time = 775
* CHECK dout0_3 vdout0_3ck154 = 0 time = 775
* CHECK dout0_4 vdout0_4ck154 = 1.1 time = 775
* CHECK dout0_5 vdout0_5ck154 = 1.1 time = 775
* CHECK dout0_6 vdout0_6ck154 = 0 time = 775
* CHECK dout0_7 vdout0_7ck154 = 1.1 time = 775
* CHECK dout0_8 vdout0_8ck154 = 1.1 time = 775
* CHECK dout0_9 vdout0_9ck154 = 0 time = 775
* CHECK dout0_10 vdout0_10ck154 = 0 time = 775
* CHECK dout0_11 vdout0_11ck154 = 1.1 time = 775
* CHECK dout0_12 vdout0_12ck154 = 1.1 time = 775
* CHECK dout0_13 vdout0_13ck154 = 1.1 time = 775
* CHECK dout0_14 vdout0_14ck154 = 0 time = 775
* CHECK dout0_15 vdout0_15ck154 = 1.1 time = 775
* CHECK dout0_16 vdout0_16ck154 = 1.1 time = 775
* CHECK dout0_17 vdout0_17ck154 = 0 time = 775
* CHECK dout0_18 vdout0_18ck154 = 1.1 time = 775
* CHECK dout0_19 vdout0_19ck154 = 0 time = 775
* CHECK dout0_20 vdout0_20ck154 = 1.1 time = 775
* CHECK dout0_21 vdout0_21ck154 = 0 time = 775
* CHECK dout0_22 vdout0_22ck154 = 0 time = 775
* CHECK dout0_23 vdout0_23ck154 = 1.1 time = 775
* CHECK dout0_24 vdout0_24ck154 = 0 time = 775
* CHECK dout0_25 vdout0_25ck154 = 0 time = 775
* CHECK dout0_26 vdout0_26ck154 = 1.1 time = 775
* CHECK dout0_27 vdout0_27ck154 = 0 time = 775
* CHECK dout0_28 vdout0_28ck154 = 0 time = 775
* CHECK dout0_29 vdout0_29ck154 = 0 time = 775
* CHECK dout0_30 vdout0_30ck154 = 1.1 time = 775
* CHECK dout0_31 vdout0_31ck154 = 1.1 time = 775
* CHECK dout0_0 vdout0_0ck155 = 1.1 time = 780
* CHECK dout0_1 vdout0_1ck155 = 0 time = 780
* CHECK dout0_2 vdout0_2ck155 = 0 time = 780
* CHECK dout0_3 vdout0_3ck155 = 0 time = 780
* CHECK dout0_4 vdout0_4ck155 = 1.1 time = 780
* CHECK dout0_5 vdout0_5ck155 = 1.1 time = 780
* CHECK dout0_6 vdout0_6ck155 = 0 time = 780
* CHECK dout0_7 vdout0_7ck155 = 1.1 time = 780
* CHECK dout0_8 vdout0_8ck155 = 1.1 time = 780
* CHECK dout0_9 vdout0_9ck155 = 0 time = 780
* CHECK dout0_10 vdout0_10ck155 = 0 time = 780
* CHECK dout0_11 vdout0_11ck155 = 1.1 time = 780
* CHECK dout0_12 vdout0_12ck155 = 1.1 time = 780
* CHECK dout0_13 vdout0_13ck155 = 1.1 time = 780
* CHECK dout0_14 vdout0_14ck155 = 0 time = 780
* CHECK dout0_15 vdout0_15ck155 = 1.1 time = 780
* CHECK dout0_16 vdout0_16ck155 = 1.1 time = 780
* CHECK dout0_17 vdout0_17ck155 = 0 time = 780
* CHECK dout0_18 vdout0_18ck155 = 1.1 time = 780
* CHECK dout0_19 vdout0_19ck155 = 0 time = 780
* CHECK dout0_20 vdout0_20ck155 = 1.1 time = 780
* CHECK dout0_21 vdout0_21ck155 = 0 time = 780
* CHECK dout0_22 vdout0_22ck155 = 0 time = 780
* CHECK dout0_23 vdout0_23ck155 = 1.1 time = 780
* CHECK dout0_24 vdout0_24ck155 = 0 time = 780
* CHECK dout0_25 vdout0_25ck155 = 0 time = 780
* CHECK dout0_26 vdout0_26ck155 = 1.1 time = 780
* CHECK dout0_27 vdout0_27ck155 = 0 time = 780
* CHECK dout0_28 vdout0_28ck155 = 0 time = 780
* CHECK dout0_29 vdout0_29ck155 = 0 time = 780
* CHECK dout0_30 vdout0_30ck155 = 1.1 time = 780
* CHECK dout0_31 vdout0_31ck155 = 1.1 time = 780
* CHECK dout0_0 vdout0_0ck158 = 1.1 time = 795
* CHECK dout0_1 vdout0_1ck158 = 1.1 time = 795
* CHECK dout0_2 vdout0_2ck158 = 1.1 time = 795
* CHECK dout0_3 vdout0_3ck158 = 1.1 time = 795
* CHECK dout0_4 vdout0_4ck158 = 1.1 time = 795
* CHECK dout0_5 vdout0_5ck158 = 0 time = 795
* CHECK dout0_6 vdout0_6ck158 = 1.1 time = 795
* CHECK dout0_7 vdout0_7ck158 = 0 time = 795
* CHECK dout0_8 vdout0_8ck158 = 0 time = 795
* CHECK dout0_9 vdout0_9ck158 = 0 time = 795
* CHECK dout0_10 vdout0_10ck158 = 0 time = 795
* CHECK dout0_11 vdout0_11ck158 = 1.1 time = 795
* CHECK dout0_12 vdout0_12ck158 = 0 time = 795
* CHECK dout0_13 vdout0_13ck158 = 1.1 time = 795
* CHECK dout0_14 vdout0_14ck158 = 1.1 time = 795
* CHECK dout0_15 vdout0_15ck158 = 0 time = 795
* CHECK dout0_16 vdout0_16ck158 = 1.1 time = 795
* CHECK dout0_17 vdout0_17ck158 = 1.1 time = 795
* CHECK dout0_18 vdout0_18ck158 = 1.1 time = 795
* CHECK dout0_19 vdout0_19ck158 = 1.1 time = 795
* CHECK dout0_20 vdout0_20ck158 = 1.1 time = 795
* CHECK dout0_21 vdout0_21ck158 = 1.1 time = 795
* CHECK dout0_22 vdout0_22ck158 = 0 time = 795
* CHECK dout0_23 vdout0_23ck158 = 0 time = 795
* CHECK dout0_24 vdout0_24ck158 = 1.1 time = 795
* CHECK dout0_25 vdout0_25ck158 = 1.1 time = 795
* CHECK dout0_26 vdout0_26ck158 = 0 time = 795
* CHECK dout0_27 vdout0_27ck158 = 1.1 time = 795
* CHECK dout0_28 vdout0_28ck158 = 1.1 time = 795
* CHECK dout0_29 vdout0_29ck158 = 1.1 time = 795
* CHECK dout0_30 vdout0_30ck158 = 0 time = 795
* CHECK dout0_31 vdout0_31ck158 = 1.1 time = 795
* CHECK dout0_0 vdout0_0ck160 = 1.1 time = 805
* CHECK dout0_1 vdout0_1ck160 = 1.1 time = 805
* CHECK dout0_2 vdout0_2ck160 = 1.1 time = 805
* CHECK dout0_3 vdout0_3ck160 = 1.1 time = 805
* CHECK dout0_4 vdout0_4ck160 = 1.1 time = 805
* CHECK dout0_5 vdout0_5ck160 = 0 time = 805
* CHECK dout0_6 vdout0_6ck160 = 1.1 time = 805
* CHECK dout0_7 vdout0_7ck160 = 0 time = 805
* CHECK dout0_8 vdout0_8ck160 = 0 time = 805
* CHECK dout0_9 vdout0_9ck160 = 0 time = 805
* CHECK dout0_10 vdout0_10ck160 = 0 time = 805
* CHECK dout0_11 vdout0_11ck160 = 1.1 time = 805
* CHECK dout0_12 vdout0_12ck160 = 0 time = 805
* CHECK dout0_13 vdout0_13ck160 = 1.1 time = 805
* CHECK dout0_14 vdout0_14ck160 = 1.1 time = 805
* CHECK dout0_15 vdout0_15ck160 = 0 time = 805
* CHECK dout0_16 vdout0_16ck160 = 1.1 time = 805
* CHECK dout0_17 vdout0_17ck160 = 1.1 time = 805
* CHECK dout0_18 vdout0_18ck160 = 1.1 time = 805
* CHECK dout0_19 vdout0_19ck160 = 1.1 time = 805
* CHECK dout0_20 vdout0_20ck160 = 1.1 time = 805
* CHECK dout0_21 vdout0_21ck160 = 1.1 time = 805
* CHECK dout0_22 vdout0_22ck160 = 0 time = 805
* CHECK dout0_23 vdout0_23ck160 = 0 time = 805
* CHECK dout0_24 vdout0_24ck160 = 1.1 time = 805
* CHECK dout0_25 vdout0_25ck160 = 1.1 time = 805
* CHECK dout0_26 vdout0_26ck160 = 0 time = 805
* CHECK dout0_27 vdout0_27ck160 = 1.1 time = 805
* CHECK dout0_28 vdout0_28ck160 = 1.1 time = 805
* CHECK dout0_29 vdout0_29ck160 = 1.1 time = 805
* CHECK dout0_30 vdout0_30ck160 = 0 time = 805
* CHECK dout0_31 vdout0_31ck160 = 1.1 time = 805
* CHECK dout0_0 vdout0_0ck162 = 1.1 time = 815
* CHECK dout0_1 vdout0_1ck162 = 1.1 time = 815
* CHECK dout0_2 vdout0_2ck162 = 1.1 time = 815
* CHECK dout0_3 vdout0_3ck162 = 1.1 time = 815
* CHECK dout0_4 vdout0_4ck162 = 1.1 time = 815
* CHECK dout0_5 vdout0_5ck162 = 0 time = 815
* CHECK dout0_6 vdout0_6ck162 = 1.1 time = 815
* CHECK dout0_7 vdout0_7ck162 = 0 time = 815
* CHECK dout0_8 vdout0_8ck162 = 0 time = 815
* CHECK dout0_9 vdout0_9ck162 = 0 time = 815
* CHECK dout0_10 vdout0_10ck162 = 0 time = 815
* CHECK dout0_11 vdout0_11ck162 = 1.1 time = 815
* CHECK dout0_12 vdout0_12ck162 = 0 time = 815
* CHECK dout0_13 vdout0_13ck162 = 1.1 time = 815
* CHECK dout0_14 vdout0_14ck162 = 1.1 time = 815
* CHECK dout0_15 vdout0_15ck162 = 0 time = 815
* CHECK dout0_16 vdout0_16ck162 = 1.1 time = 815
* CHECK dout0_17 vdout0_17ck162 = 1.1 time = 815
* CHECK dout0_18 vdout0_18ck162 = 1.1 time = 815
* CHECK dout0_19 vdout0_19ck162 = 1.1 time = 815
* CHECK dout0_20 vdout0_20ck162 = 1.1 time = 815
* CHECK dout0_21 vdout0_21ck162 = 1.1 time = 815
* CHECK dout0_22 vdout0_22ck162 = 0 time = 815
* CHECK dout0_23 vdout0_23ck162 = 0 time = 815
* CHECK dout0_24 vdout0_24ck162 = 1.1 time = 815
* CHECK dout0_25 vdout0_25ck162 = 1.1 time = 815
* CHECK dout0_26 vdout0_26ck162 = 0 time = 815
* CHECK dout0_27 vdout0_27ck162 = 1.1 time = 815
* CHECK dout0_28 vdout0_28ck162 = 1.1 time = 815
* CHECK dout0_29 vdout0_29ck162 = 1.1 time = 815
* CHECK dout0_30 vdout0_30ck162 = 0 time = 815
* CHECK dout0_31 vdout0_31ck162 = 1.1 time = 815
* CHECK dout0_0 vdout0_0ck164 = 1.1 time = 825
* CHECK dout0_1 vdout0_1ck164 = 0 time = 825
* CHECK dout0_2 vdout0_2ck164 = 0 time = 825
* CHECK dout0_3 vdout0_3ck164 = 0 time = 825
* CHECK dout0_4 vdout0_4ck164 = 1.1 time = 825
* CHECK dout0_5 vdout0_5ck164 = 1.1 time = 825
* CHECK dout0_6 vdout0_6ck164 = 0 time = 825
* CHECK dout0_7 vdout0_7ck164 = 1.1 time = 825
* CHECK dout0_8 vdout0_8ck164 = 1.1 time = 825
* CHECK dout0_9 vdout0_9ck164 = 0 time = 825
* CHECK dout0_10 vdout0_10ck164 = 0 time = 825
* CHECK dout0_11 vdout0_11ck164 = 1.1 time = 825
* CHECK dout0_12 vdout0_12ck164 = 1.1 time = 825
* CHECK dout0_13 vdout0_13ck164 = 1.1 time = 825
* CHECK dout0_14 vdout0_14ck164 = 0 time = 825
* CHECK dout0_15 vdout0_15ck164 = 1.1 time = 825
* CHECK dout0_16 vdout0_16ck164 = 1.1 time = 825
* CHECK dout0_17 vdout0_17ck164 = 0 time = 825
* CHECK dout0_18 vdout0_18ck164 = 1.1 time = 825
* CHECK dout0_19 vdout0_19ck164 = 0 time = 825
* CHECK dout0_20 vdout0_20ck164 = 1.1 time = 825
* CHECK dout0_21 vdout0_21ck164 = 0 time = 825
* CHECK dout0_22 vdout0_22ck164 = 0 time = 825
* CHECK dout0_23 vdout0_23ck164 = 1.1 time = 825
* CHECK dout0_24 vdout0_24ck164 = 0 time = 825
* CHECK dout0_25 vdout0_25ck164 = 0 time = 825
* CHECK dout0_26 vdout0_26ck164 = 1.1 time = 825
* CHECK dout0_27 vdout0_27ck164 = 0 time = 825
* CHECK dout0_28 vdout0_28ck164 = 0 time = 825
* CHECK dout0_29 vdout0_29ck164 = 0 time = 825
* CHECK dout0_30 vdout0_30ck164 = 1.1 time = 825
* CHECK dout0_31 vdout0_31ck164 = 1.1 time = 825
* CHECK dout0_0 vdout0_0ck168 = 1.1 time = 845
* CHECK dout0_1 vdout0_1ck168 = 0 time = 845
* CHECK dout0_2 vdout0_2ck168 = 0 time = 845
* CHECK dout0_3 vdout0_3ck168 = 0 time = 845
* CHECK dout0_4 vdout0_4ck168 = 0 time = 845
* CHECK dout0_5 vdout0_5ck168 = 1.1 time = 845
* CHECK dout0_6 vdout0_6ck168 = 0 time = 845
* CHECK dout0_7 vdout0_7ck168 = 0 time = 845
* CHECK dout0_8 vdout0_8ck168 = 1.1 time = 845
* CHECK dout0_9 vdout0_9ck168 = 0 time = 845
* CHECK dout0_10 vdout0_10ck168 = 1.1 time = 845
* CHECK dout0_11 vdout0_11ck168 = 0 time = 845
* CHECK dout0_12 vdout0_12ck168 = 1.1 time = 845
* CHECK dout0_13 vdout0_13ck168 = 1.1 time = 845
* CHECK dout0_14 vdout0_14ck168 = 0 time = 845
* CHECK dout0_15 vdout0_15ck168 = 1.1 time = 845
* CHECK dout0_16 vdout0_16ck168 = 1.1 time = 845
* CHECK dout0_17 vdout0_17ck168 = 1.1 time = 845
* CHECK dout0_18 vdout0_18ck168 = 1.1 time = 845
* CHECK dout0_19 vdout0_19ck168 = 0 time = 845
* CHECK dout0_20 vdout0_20ck168 = 1.1 time = 845
* CHECK dout0_21 vdout0_21ck168 = 1.1 time = 845
* CHECK dout0_22 vdout0_22ck168 = 0 time = 845
* CHECK dout0_23 vdout0_23ck168 = 0 time = 845
* CHECK dout0_24 vdout0_24ck168 = 0 time = 845
* CHECK dout0_25 vdout0_25ck168 = 1.1 time = 845
* CHECK dout0_26 vdout0_26ck168 = 1.1 time = 845
* CHECK dout0_27 vdout0_27ck168 = 1.1 time = 845
* CHECK dout0_28 vdout0_28ck168 = 0 time = 845
* CHECK dout0_29 vdout0_29ck168 = 1.1 time = 845
* CHECK dout0_30 vdout0_30ck168 = 0 time = 845
* CHECK dout0_31 vdout0_31ck168 = 0 time = 845
* CHECK dout0_0 vdout0_0ck169 = 1.1 time = 850
* CHECK dout0_1 vdout0_1ck169 = 0 time = 850
* CHECK dout0_2 vdout0_2ck169 = 0 time = 850
* CHECK dout0_3 vdout0_3ck169 = 0 time = 850
* CHECK dout0_4 vdout0_4ck169 = 0 time = 850
* CHECK dout0_5 vdout0_5ck169 = 1.1 time = 850
* CHECK dout0_6 vdout0_6ck169 = 1.1 time = 850
* CHECK dout0_7 vdout0_7ck169 = 1.1 time = 850
* CHECK dout0_8 vdout0_8ck169 = 1.1 time = 850
* CHECK dout0_9 vdout0_9ck169 = 1.1 time = 850
* CHECK dout0_10 vdout0_10ck169 = 1.1 time = 850
* CHECK dout0_11 vdout0_11ck169 = 1.1 time = 850
* CHECK dout0_12 vdout0_12ck169 = 0 time = 850
* CHECK dout0_13 vdout0_13ck169 = 1.1 time = 850
* CHECK dout0_14 vdout0_14ck169 = 1.1 time = 850
* CHECK dout0_15 vdout0_15ck169 = 0 time = 850
* CHECK dout0_16 vdout0_16ck169 = 1.1 time = 850
* CHECK dout0_17 vdout0_17ck169 = 0 time = 850
* CHECK dout0_18 vdout0_18ck169 = 0 time = 850
* CHECK dout0_19 vdout0_19ck169 = 1.1 time = 850
* CHECK dout0_20 vdout0_20ck169 = 1.1 time = 850
* CHECK dout0_21 vdout0_21ck169 = 1.1 time = 850
* CHECK dout0_22 vdout0_22ck169 = 1.1 time = 850
* CHECK dout0_23 vdout0_23ck169 = 0 time = 850
* CHECK dout0_24 vdout0_24ck169 = 0 time = 850
* CHECK dout0_25 vdout0_25ck169 = 1.1 time = 850
* CHECK dout0_26 vdout0_26ck169 = 0 time = 850
* CHECK dout0_27 vdout0_27ck169 = 1.1 time = 850
* CHECK dout0_28 vdout0_28ck169 = 0 time = 850
* CHECK dout0_29 vdout0_29ck169 = 0 time = 850
* CHECK dout0_30 vdout0_30ck169 = 0 time = 850
* CHECK dout0_31 vdout0_31ck169 = 1.1 time = 850
* CHECK dout0_0 vdout0_0ck171 = 1.1 time = 860
* CHECK dout0_1 vdout0_1ck171 = 0 time = 860
* CHECK dout0_2 vdout0_2ck171 = 0 time = 860
* CHECK dout0_3 vdout0_3ck171 = 0 time = 860
* CHECK dout0_4 vdout0_4ck171 = 0 time = 860
* CHECK dout0_5 vdout0_5ck171 = 1.1 time = 860
* CHECK dout0_6 vdout0_6ck171 = 0 time = 860
* CHECK dout0_7 vdout0_7ck171 = 0 time = 860
* CHECK dout0_8 vdout0_8ck171 = 1.1 time = 860
* CHECK dout0_9 vdout0_9ck171 = 0 time = 860
* CHECK dout0_10 vdout0_10ck171 = 1.1 time = 860
* CHECK dout0_11 vdout0_11ck171 = 0 time = 860
* CHECK dout0_12 vdout0_12ck171 = 1.1 time = 860
* CHECK dout0_13 vdout0_13ck171 = 1.1 time = 860
* CHECK dout0_14 vdout0_14ck171 = 0 time = 860
* CHECK dout0_15 vdout0_15ck171 = 1.1 time = 860
* CHECK dout0_16 vdout0_16ck171 = 1.1 time = 860
* CHECK dout0_17 vdout0_17ck171 = 1.1 time = 860
* CHECK dout0_18 vdout0_18ck171 = 1.1 time = 860
* CHECK dout0_19 vdout0_19ck171 = 0 time = 860
* CHECK dout0_20 vdout0_20ck171 = 1.1 time = 860
* CHECK dout0_21 vdout0_21ck171 = 1.1 time = 860
* CHECK dout0_22 vdout0_22ck171 = 0 time = 860
* CHECK dout0_23 vdout0_23ck171 = 0 time = 860
* CHECK dout0_24 vdout0_24ck171 = 0 time = 860
* CHECK dout0_25 vdout0_25ck171 = 1.1 time = 860
* CHECK dout0_26 vdout0_26ck171 = 1.1 time = 860
* CHECK dout0_27 vdout0_27ck171 = 1.1 time = 860
* CHECK dout0_28 vdout0_28ck171 = 0 time = 860
* CHECK dout0_29 vdout0_29ck171 = 1.1 time = 860
* CHECK dout0_30 vdout0_30ck171 = 0 time = 860
* CHECK dout0_31 vdout0_31ck171 = 0 time = 860
* CHECK dout0_0 vdout0_0ck175 = 0 time = 880
* CHECK dout0_1 vdout0_1ck175 = 1.1 time = 880
* CHECK dout0_2 vdout0_2ck175 = 0 time = 880
* CHECK dout0_3 vdout0_3ck175 = 0 time = 880
* CHECK dout0_4 vdout0_4ck175 = 0 time = 880
* CHECK dout0_5 vdout0_5ck175 = 1.1 time = 880
* CHECK dout0_6 vdout0_6ck175 = 1.1 time = 880
* CHECK dout0_7 vdout0_7ck175 = 0 time = 880
* CHECK dout0_8 vdout0_8ck175 = 0 time = 880
* CHECK dout0_9 vdout0_9ck175 = 0 time = 880
* CHECK dout0_10 vdout0_10ck175 = 0 time = 880
* CHECK dout0_11 vdout0_11ck175 = 0 time = 880
* CHECK dout0_12 vdout0_12ck175 = 1.1 time = 880
* CHECK dout0_13 vdout0_13ck175 = 0 time = 880
* CHECK dout0_14 vdout0_14ck175 = 1.1 time = 880
* CHECK dout0_15 vdout0_15ck175 = 0 time = 880
* CHECK dout0_16 vdout0_16ck175 = 1.1 time = 880
* CHECK dout0_17 vdout0_17ck175 = 1.1 time = 880
* CHECK dout0_18 vdout0_18ck175 = 0 time = 880
* CHECK dout0_19 vdout0_19ck175 = 0 time = 880
* CHECK dout0_20 vdout0_20ck175 = 0 time = 880
* CHECK dout0_21 vdout0_21ck175 = 1.1 time = 880
* CHECK dout0_22 vdout0_22ck175 = 0 time = 880
* CHECK dout0_23 vdout0_23ck175 = 1.1 time = 880
* CHECK dout0_24 vdout0_24ck175 = 0 time = 880
* CHECK dout0_25 vdout0_25ck175 = 0 time = 880
* CHECK dout0_26 vdout0_26ck175 = 0 time = 880
* CHECK dout0_27 vdout0_27ck175 = 1.1 time = 880
* CHECK dout0_28 vdout0_28ck175 = 0 time = 880
* CHECK dout0_29 vdout0_29ck175 = 0 time = 880
* CHECK dout0_30 vdout0_30ck175 = 0 time = 880
* CHECK dout0_31 vdout0_31ck175 = 1.1 time = 880
* CHECK dout0_0 vdout0_0ck176 = 0 time = 885
* CHECK dout0_1 vdout0_1ck176 = 0 time = 885
* CHECK dout0_2 vdout0_2ck176 = 1.1 time = 885
* CHECK dout0_3 vdout0_3ck176 = 1.1 time = 885
* CHECK dout0_4 vdout0_4ck176 = 1.1 time = 885
* CHECK dout0_5 vdout0_5ck176 = 1.1 time = 885
* CHECK dout0_6 vdout0_6ck176 = 0 time = 885
* CHECK dout0_7 vdout0_7ck176 = 0 time = 885
* CHECK dout0_8 vdout0_8ck176 = 1.1 time = 885
* CHECK dout0_9 vdout0_9ck176 = 1.1 time = 885
* CHECK dout0_10 vdout0_10ck176 = 1.1 time = 885
* CHECK dout0_11 vdout0_11ck176 = 1.1 time = 885
* CHECK dout0_12 vdout0_12ck176 = 0 time = 885
* CHECK dout0_13 vdout0_13ck176 = 1.1 time = 885
* CHECK dout0_14 vdout0_14ck176 = 0 time = 885
* CHECK dout0_15 vdout0_15ck176 = 1.1 time = 885
* CHECK dout0_16 vdout0_16ck176 = 0 time = 885
* CHECK dout0_17 vdout0_17ck176 = 1.1 time = 885
* CHECK dout0_18 vdout0_18ck176 = 1.1 time = 885
* CHECK dout0_19 vdout0_19ck176 = 1.1 time = 885
* CHECK dout0_20 vdout0_20ck176 = 0 time = 885
* CHECK dout0_21 vdout0_21ck176 = 0 time = 885
* CHECK dout0_22 vdout0_22ck176 = 1.1 time = 885
* CHECK dout0_23 vdout0_23ck176 = 1.1 time = 885
* CHECK dout0_24 vdout0_24ck176 = 1.1 time = 885
* CHECK dout0_25 vdout0_25ck176 = 1.1 time = 885
* CHECK dout0_26 vdout0_26ck176 = 1.1 time = 885
* CHECK dout0_27 vdout0_27ck176 = 1.1 time = 885
* CHECK dout0_28 vdout0_28ck176 = 1.1 time = 885
* CHECK dout0_29 vdout0_29ck176 = 0 time = 885
* CHECK dout0_30 vdout0_30ck176 = 1.1 time = 885
* CHECK dout0_31 vdout0_31ck176 = 1.1 time = 885
* CHECK dout0_0 vdout0_0ck177 = 1.1 time = 890
* CHECK dout0_1 vdout0_1ck177 = 0 time = 890
* CHECK dout0_2 vdout0_2ck177 = 0 time = 890
* CHECK dout0_3 vdout0_3ck177 = 0 time = 890
* CHECK dout0_4 vdout0_4ck177 = 0 time = 890
* CHECK dout0_5 vdout0_5ck177 = 1.1 time = 890
* CHECK dout0_6 vdout0_6ck177 = 0 time = 890
* CHECK dout0_7 vdout0_7ck177 = 0 time = 890
* CHECK dout0_8 vdout0_8ck177 = 1.1 time = 890
* CHECK dout0_9 vdout0_9ck177 = 0 time = 890
* CHECK dout0_10 vdout0_10ck177 = 0 time = 890
* CHECK dout0_11 vdout0_11ck177 = 0 time = 890
* CHECK dout0_12 vdout0_12ck177 = 0 time = 890
* CHECK dout0_13 vdout0_13ck177 = 0 time = 890
* CHECK dout0_14 vdout0_14ck177 = 0 time = 890
* CHECK dout0_15 vdout0_15ck177 = 1.1 time = 890
* CHECK dout0_16 vdout0_16ck177 = 1.1 time = 890
* CHECK dout0_17 vdout0_17ck177 = 1.1 time = 890
* CHECK dout0_18 vdout0_18ck177 = 1.1 time = 890
* CHECK dout0_19 vdout0_19ck177 = 0 time = 890
* CHECK dout0_20 vdout0_20ck177 = 1.1 time = 890
* CHECK dout0_21 vdout0_21ck177 = 1.1 time = 890
* CHECK dout0_22 vdout0_22ck177 = 0 time = 890
* CHECK dout0_23 vdout0_23ck177 = 0 time = 890
* CHECK dout0_24 vdout0_24ck177 = 0 time = 890
* CHECK dout0_25 vdout0_25ck177 = 1.1 time = 890
* CHECK dout0_26 vdout0_26ck177 = 1.1 time = 890
* CHECK dout0_27 vdout0_27ck177 = 1.1 time = 890
* CHECK dout0_28 vdout0_28ck177 = 0 time = 890
* CHECK dout0_29 vdout0_29ck177 = 1.1 time = 890
* CHECK dout0_30 vdout0_30ck177 = 0 time = 890
* CHECK dout0_31 vdout0_31ck177 = 0 time = 890
* CHECK dout0_0 vdout0_0ck178 = 1.1 time = 895
* CHECK dout0_1 vdout0_1ck178 = 0 time = 895
* CHECK dout0_2 vdout0_2ck178 = 1.1 time = 895
* CHECK dout0_3 vdout0_3ck178 = 0 time = 895
* CHECK dout0_4 vdout0_4ck178 = 0 time = 895
* CHECK dout0_5 vdout0_5ck178 = 0 time = 895
* CHECK dout0_6 vdout0_6ck178 = 1.1 time = 895
* CHECK dout0_7 vdout0_7ck178 = 1.1 time = 895
* CHECK dout0_8 vdout0_8ck178 = 1.1 time = 895
* CHECK dout0_9 vdout0_9ck178 = 1.1 time = 895
* CHECK dout0_10 vdout0_10ck178 = 1.1 time = 895
* CHECK dout0_11 vdout0_11ck178 = 1.1 time = 895
* CHECK dout0_12 vdout0_12ck178 = 0 time = 895
* CHECK dout0_13 vdout0_13ck178 = 1.1 time = 895
* CHECK dout0_14 vdout0_14ck178 = 1.1 time = 895
* CHECK dout0_15 vdout0_15ck178 = 0 time = 895
* CHECK dout0_16 vdout0_16ck178 = 1.1 time = 895
* CHECK dout0_17 vdout0_17ck178 = 1.1 time = 895
* CHECK dout0_18 vdout0_18ck178 = 0 time = 895
* CHECK dout0_19 vdout0_19ck178 = 1.1 time = 895
* CHECK dout0_20 vdout0_20ck178 = 0 time = 895
* CHECK dout0_21 vdout0_21ck178 = 1.1 time = 895
* CHECK dout0_22 vdout0_22ck178 = 0 time = 895
* CHECK dout0_23 vdout0_23ck178 = 0 time = 895
* CHECK dout0_24 vdout0_24ck178 = 0 time = 895
* CHECK dout0_25 vdout0_25ck178 = 1.1 time = 895
* CHECK dout0_26 vdout0_26ck178 = 0 time = 895
* CHECK dout0_27 vdout0_27ck178 = 1.1 time = 895
* CHECK dout0_28 vdout0_28ck178 = 0 time = 895
* CHECK dout0_29 vdout0_29ck178 = 0 time = 895
* CHECK dout0_30 vdout0_30ck178 = 0 time = 895
* CHECK dout0_31 vdout0_31ck178 = 1.1 time = 895
* CHECK dout0_0 vdout0_0ck179 = 1.1 time = 900
* CHECK dout0_1 vdout0_1ck179 = 0 time = 900
* CHECK dout0_2 vdout0_2ck179 = 0 time = 900
* CHECK dout0_3 vdout0_3ck179 = 0 time = 900
* CHECK dout0_4 vdout0_4ck179 = 0 time = 900
* CHECK dout0_5 vdout0_5ck179 = 1.1 time = 900
* CHECK dout0_6 vdout0_6ck179 = 0 time = 900
* CHECK dout0_7 vdout0_7ck179 = 0 time = 900
* CHECK dout0_8 vdout0_8ck179 = 1.1 time = 900
* CHECK dout0_9 vdout0_9ck179 = 0 time = 900
* CHECK dout0_10 vdout0_10ck179 = 0 time = 900
* CHECK dout0_11 vdout0_11ck179 = 0 time = 900
* CHECK dout0_12 vdout0_12ck179 = 0 time = 900
* CHECK dout0_13 vdout0_13ck179 = 0 time = 900
* CHECK dout0_14 vdout0_14ck179 = 0 time = 900
* CHECK dout0_15 vdout0_15ck179 = 1.1 time = 900
* CHECK dout0_16 vdout0_16ck179 = 1.1 time = 900
* CHECK dout0_17 vdout0_17ck179 = 1.1 time = 900
* CHECK dout0_18 vdout0_18ck179 = 1.1 time = 900
* CHECK dout0_19 vdout0_19ck179 = 0 time = 900
* CHECK dout0_20 vdout0_20ck179 = 1.1 time = 900
* CHECK dout0_21 vdout0_21ck179 = 1.1 time = 900
* CHECK dout0_22 vdout0_22ck179 = 0 time = 900
* CHECK dout0_23 vdout0_23ck179 = 0 time = 900
* CHECK dout0_24 vdout0_24ck179 = 0 time = 900
* CHECK dout0_25 vdout0_25ck179 = 1.1 time = 900
* CHECK dout0_26 vdout0_26ck179 = 1.1 time = 900
* CHECK dout0_27 vdout0_27ck179 = 1.1 time = 900
* CHECK dout0_28 vdout0_28ck179 = 0 time = 900
* CHECK dout0_29 vdout0_29ck179 = 1.1 time = 900
* CHECK dout0_30 vdout0_30ck179 = 0 time = 900
* CHECK dout0_31 vdout0_31ck179 = 0 time = 900
* CHECK dout0_0 vdout0_0ck180 = 1.1 time = 905
* CHECK dout0_1 vdout0_1ck180 = 0 time = 905
* CHECK dout0_2 vdout0_2ck180 = 1.1 time = 905
* CHECK dout0_3 vdout0_3ck180 = 0 time = 905
* CHECK dout0_4 vdout0_4ck180 = 0 time = 905
* CHECK dout0_5 vdout0_5ck180 = 0 time = 905
* CHECK dout0_6 vdout0_6ck180 = 1.1 time = 905
* CHECK dout0_7 vdout0_7ck180 = 1.1 time = 905
* CHECK dout0_8 vdout0_8ck180 = 1.1 time = 905
* CHECK dout0_9 vdout0_9ck180 = 1.1 time = 905
* CHECK dout0_10 vdout0_10ck180 = 1.1 time = 905
* CHECK dout0_11 vdout0_11ck180 = 1.1 time = 905
* CHECK dout0_12 vdout0_12ck180 = 0 time = 905
* CHECK dout0_13 vdout0_13ck180 = 1.1 time = 905
* CHECK dout0_14 vdout0_14ck180 = 1.1 time = 905
* CHECK dout0_15 vdout0_15ck180 = 0 time = 905
* CHECK dout0_16 vdout0_16ck180 = 1.1 time = 905
* CHECK dout0_17 vdout0_17ck180 = 1.1 time = 905
* CHECK dout0_18 vdout0_18ck180 = 0 time = 905
* CHECK dout0_19 vdout0_19ck180 = 1.1 time = 905
* CHECK dout0_20 vdout0_20ck180 = 0 time = 905
* CHECK dout0_21 vdout0_21ck180 = 1.1 time = 905
* CHECK dout0_22 vdout0_22ck180 = 0 time = 905
* CHECK dout0_23 vdout0_23ck180 = 0 time = 905
* CHECK dout0_24 vdout0_24ck180 = 0 time = 905
* CHECK dout0_25 vdout0_25ck180 = 1.1 time = 905
* CHECK dout0_26 vdout0_26ck180 = 0 time = 905
* CHECK dout0_27 vdout0_27ck180 = 1.1 time = 905
* CHECK dout0_28 vdout0_28ck180 = 0 time = 905
* CHECK dout0_29 vdout0_29ck180 = 0 time = 905
* CHECK dout0_30 vdout0_30ck180 = 0 time = 905
* CHECK dout0_31 vdout0_31ck180 = 1.1 time = 905
* CHECK dout0_0 vdout0_0ck183 = 0 time = 920
* CHECK dout0_1 vdout0_1ck183 = 1.1 time = 920
* CHECK dout0_2 vdout0_2ck183 = 1.1 time = 920
* CHECK dout0_3 vdout0_3ck183 = 0 time = 920
* CHECK dout0_4 vdout0_4ck183 = 0 time = 920
* CHECK dout0_5 vdout0_5ck183 = 1.1 time = 920
* CHECK dout0_6 vdout0_6ck183 = 0 time = 920
* CHECK dout0_7 vdout0_7ck183 = 1.1 time = 920
* CHECK dout0_8 vdout0_8ck183 = 0 time = 920
* CHECK dout0_9 vdout0_9ck183 = 0 time = 920
* CHECK dout0_10 vdout0_10ck183 = 0 time = 920
* CHECK dout0_11 vdout0_11ck183 = 0 time = 920
* CHECK dout0_12 vdout0_12ck183 = 1.1 time = 920
* CHECK dout0_13 vdout0_13ck183 = 1.1 time = 920
* CHECK dout0_14 vdout0_14ck183 = 1.1 time = 920
* CHECK dout0_15 vdout0_15ck183 = 0 time = 920
* CHECK dout0_16 vdout0_16ck183 = 1.1 time = 920
* CHECK dout0_17 vdout0_17ck183 = 1.1 time = 920
* CHECK dout0_18 vdout0_18ck183 = 0 time = 920
* CHECK dout0_19 vdout0_19ck183 = 0 time = 920
* CHECK dout0_20 vdout0_20ck183 = 1.1 time = 920
* CHECK dout0_21 vdout0_21ck183 = 0 time = 920
* CHECK dout0_22 vdout0_22ck183 = 0 time = 920
* CHECK dout0_23 vdout0_23ck183 = 1.1 time = 920
* CHECK dout0_24 vdout0_24ck183 = 0 time = 920
* CHECK dout0_25 vdout0_25ck183 = 0 time = 920
* CHECK dout0_26 vdout0_26ck183 = 1.1 time = 920
* CHECK dout0_27 vdout0_27ck183 = 1.1 time = 920
* CHECK dout0_28 vdout0_28ck183 = 1.1 time = 920
* CHECK dout0_29 vdout0_29ck183 = 0 time = 920
* CHECK dout0_30 vdout0_30ck183 = 1.1 time = 920
* CHECK dout0_31 vdout0_31ck183 = 1.1 time = 920
* CHECK dout0_0 vdout0_0ck192 = 0 time = 965
* CHECK dout0_1 vdout0_1ck192 = 1.1 time = 965
* CHECK dout0_2 vdout0_2ck192 = 0 time = 965
* CHECK dout0_3 vdout0_3ck192 = 0 time = 965
* CHECK dout0_4 vdout0_4ck192 = 0 time = 965
* CHECK dout0_5 vdout0_5ck192 = 1.1 time = 965
* CHECK dout0_6 vdout0_6ck192 = 1.1 time = 965
* CHECK dout0_7 vdout0_7ck192 = 1.1 time = 965
* CHECK dout0_8 vdout0_8ck192 = 1.1 time = 965
* CHECK dout0_9 vdout0_9ck192 = 1.1 time = 965
* CHECK dout0_10 vdout0_10ck192 = 0 time = 965
* CHECK dout0_11 vdout0_11ck192 = 0 time = 965
* CHECK dout0_12 vdout0_12ck192 = 0 time = 965
* CHECK dout0_13 vdout0_13ck192 = 0 time = 965
* CHECK dout0_14 vdout0_14ck192 = 0 time = 965
* CHECK dout0_15 vdout0_15ck192 = 0 time = 965
* CHECK dout0_16 vdout0_16ck192 = 1.1 time = 965
* CHECK dout0_17 vdout0_17ck192 = 0 time = 965
* CHECK dout0_18 vdout0_18ck192 = 0 time = 965
* CHECK dout0_19 vdout0_19ck192 = 1.1 time = 965
* CHECK dout0_20 vdout0_20ck192 = 0 time = 965
* CHECK dout0_21 vdout0_21ck192 = 0 time = 965
* CHECK dout0_22 vdout0_22ck192 = 0 time = 965
* CHECK dout0_23 vdout0_23ck192 = 1.1 time = 965
* CHECK dout0_24 vdout0_24ck192 = 1.1 time = 965
* CHECK dout0_25 vdout0_25ck192 = 0 time = 965
* CHECK dout0_26 vdout0_26ck192 = 0 time = 965
* CHECK dout0_27 vdout0_27ck192 = 0 time = 965
* CHECK dout0_28 vdout0_28ck192 = 1.1 time = 965
* CHECK dout0_29 vdout0_29ck192 = 0 time = 965
* CHECK dout0_30 vdout0_30ck192 = 1.1 time = 965
* CHECK dout0_31 vdout0_31ck192 = 1.1 time = 965
* CHECK dout0_0 vdout0_0ck193 = 1.1 time = 970
* CHECK dout0_1 vdout0_1ck193 = 0 time = 970
* CHECK dout0_2 vdout0_2ck193 = 0 time = 970
* CHECK dout0_3 vdout0_3ck193 = 0 time = 970
* CHECK dout0_4 vdout0_4ck193 = 0 time = 970
* CHECK dout0_5 vdout0_5ck193 = 1.1 time = 970
* CHECK dout0_6 vdout0_6ck193 = 0 time = 970
* CHECK dout0_7 vdout0_7ck193 = 0 time = 970
* CHECK dout0_8 vdout0_8ck193 = 1.1 time = 970
* CHECK dout0_9 vdout0_9ck193 = 0 time = 970
* CHECK dout0_10 vdout0_10ck193 = 0 time = 970
* CHECK dout0_11 vdout0_11ck193 = 0 time = 970
* CHECK dout0_12 vdout0_12ck193 = 0 time = 970
* CHECK dout0_13 vdout0_13ck193 = 0 time = 970
* CHECK dout0_14 vdout0_14ck193 = 0 time = 970
* CHECK dout0_15 vdout0_15ck193 = 1.1 time = 970
* CHECK dout0_16 vdout0_16ck193 = 1.1 time = 970
* CHECK dout0_17 vdout0_17ck193 = 1.1 time = 970
* CHECK dout0_18 vdout0_18ck193 = 1.1 time = 970
* CHECK dout0_19 vdout0_19ck193 = 0 time = 970
* CHECK dout0_20 vdout0_20ck193 = 1.1 time = 970
* CHECK dout0_21 vdout0_21ck193 = 1.1 time = 970
* CHECK dout0_22 vdout0_22ck193 = 0 time = 970
* CHECK dout0_23 vdout0_23ck193 = 0 time = 970
* CHECK dout0_24 vdout0_24ck193 = 0 time = 970
* CHECK dout0_25 vdout0_25ck193 = 1.1 time = 970
* CHECK dout0_26 vdout0_26ck193 = 1.1 time = 970
* CHECK dout0_27 vdout0_27ck193 = 1.1 time = 970
* CHECK dout0_28 vdout0_28ck193 = 0 time = 970
* CHECK dout0_29 vdout0_29ck193 = 1.1 time = 970
* CHECK dout0_30 vdout0_30ck193 = 0 time = 970
* CHECK dout0_31 vdout0_31ck193 = 0 time = 970
* CHECK dout0_0 vdout0_0ck194 = 1.1 time = 975
* CHECK dout0_1 vdout0_1ck194 = 0 time = 975
* CHECK dout0_2 vdout0_2ck194 = 0 time = 975
* CHECK dout0_3 vdout0_3ck194 = 0 time = 975
* CHECK dout0_4 vdout0_4ck194 = 0 time = 975
* CHECK dout0_5 vdout0_5ck194 = 1.1 time = 975
* CHECK dout0_6 vdout0_6ck194 = 0 time = 975
* CHECK dout0_7 vdout0_7ck194 = 0 time = 975
* CHECK dout0_8 vdout0_8ck194 = 1.1 time = 975
* CHECK dout0_9 vdout0_9ck194 = 0 time = 975
* CHECK dout0_10 vdout0_10ck194 = 0 time = 975
* CHECK dout0_11 vdout0_11ck194 = 0 time = 975
* CHECK dout0_12 vdout0_12ck194 = 0 time = 975
* CHECK dout0_13 vdout0_13ck194 = 0 time = 975
* CHECK dout0_14 vdout0_14ck194 = 0 time = 975
* CHECK dout0_15 vdout0_15ck194 = 1.1 time = 975
* CHECK dout0_16 vdout0_16ck194 = 1.1 time = 975
* CHECK dout0_17 vdout0_17ck194 = 1.1 time = 975
* CHECK dout0_18 vdout0_18ck194 = 1.1 time = 975
* CHECK dout0_19 vdout0_19ck194 = 0 time = 975
* CHECK dout0_20 vdout0_20ck194 = 1.1 time = 975
* CHECK dout0_21 vdout0_21ck194 = 1.1 time = 975
* CHECK dout0_22 vdout0_22ck194 = 0 time = 975
* CHECK dout0_23 vdout0_23ck194 = 0 time = 975
* CHECK dout0_24 vdout0_24ck194 = 0 time = 975
* CHECK dout0_25 vdout0_25ck194 = 1.1 time = 975
* CHECK dout0_26 vdout0_26ck194 = 1.1 time = 975
* CHECK dout0_27 vdout0_27ck194 = 1.1 time = 975
* CHECK dout0_28 vdout0_28ck194 = 0 time = 975
* CHECK dout0_29 vdout0_29ck194 = 1.1 time = 975
* CHECK dout0_30 vdout0_30ck194 = 0 time = 975
* CHECK dout0_31 vdout0_31ck194 = 0 time = 975
* CHECK dout0_0 vdout0_0ck196 = 0 time = 985
* CHECK dout0_1 vdout0_1ck196 = 1.1 time = 985
* CHECK dout0_2 vdout0_2ck196 = 1.1 time = 985
* CHECK dout0_3 vdout0_3ck196 = 0 time = 985
* CHECK dout0_4 vdout0_4ck196 = 0 time = 985
* CHECK dout0_5 vdout0_5ck196 = 1.1 time = 985
* CHECK dout0_6 vdout0_6ck196 = 0 time = 985
* CHECK dout0_7 vdout0_7ck196 = 1.1 time = 985
* CHECK dout0_8 vdout0_8ck196 = 0 time = 985
* CHECK dout0_9 vdout0_9ck196 = 0 time = 985
* CHECK dout0_10 vdout0_10ck196 = 0 time = 985
* CHECK dout0_11 vdout0_11ck196 = 0 time = 985
* CHECK dout0_12 vdout0_12ck196 = 1.1 time = 985
* CHECK dout0_13 vdout0_13ck196 = 1.1 time = 985
* CHECK dout0_14 vdout0_14ck196 = 1.1 time = 985
* CHECK dout0_15 vdout0_15ck196 = 0 time = 985
* CHECK dout0_16 vdout0_16ck196 = 0 time = 985
* CHECK dout0_17 vdout0_17ck196 = 0 time = 985
* CHECK dout0_18 vdout0_18ck196 = 1.1 time = 985
* CHECK dout0_19 vdout0_19ck196 = 0 time = 985
* CHECK dout0_20 vdout0_20ck196 = 1.1 time = 985
* CHECK dout0_21 vdout0_21ck196 = 1.1 time = 985
* CHECK dout0_22 vdout0_22ck196 = 0 time = 985
* CHECK dout0_23 vdout0_23ck196 = 0 time = 985
* CHECK dout0_24 vdout0_24ck196 = 1.1 time = 985
* CHECK dout0_25 vdout0_25ck196 = 0 time = 985
* CHECK dout0_26 vdout0_26ck196 = 1.1 time = 985
* CHECK dout0_27 vdout0_27ck196 = 0 time = 985
* CHECK dout0_28 vdout0_28ck196 = 1.1 time = 985
* CHECK dout0_29 vdout0_29ck196 = 0 time = 985
* CHECK dout0_30 vdout0_30ck196 = 0 time = 985
* CHECK dout0_31 vdout0_31ck196 = 0 time = 985
* CHECK dout0_0 vdout0_0ck199 = 1.1 time = 1000
* CHECK dout0_1 vdout0_1ck199 = 1.1 time = 1000
* CHECK dout0_2 vdout0_2ck199 = 1.1 time = 1000
* CHECK dout0_3 vdout0_3ck199 = 0 time = 1000
* CHECK dout0_4 vdout0_4ck199 = 0 time = 1000
* CHECK dout0_5 vdout0_5ck199 = 0 time = 1000
* CHECK dout0_6 vdout0_6ck199 = 1.1 time = 1000
* CHECK dout0_7 vdout0_7ck199 = 0 time = 1000
* CHECK dout0_8 vdout0_8ck199 = 0 time = 1000
* CHECK dout0_9 vdout0_9ck199 = 1.1 time = 1000
* CHECK dout0_10 vdout0_10ck199 = 0 time = 1000
* CHECK dout0_11 vdout0_11ck199 = 1.1 time = 1000
* CHECK dout0_12 vdout0_12ck199 = 0 time = 1000
* CHECK dout0_13 vdout0_13ck199 = 1.1 time = 1000
* CHECK dout0_14 vdout0_14ck199 = 0 time = 1000
* CHECK dout0_15 vdout0_15ck199 = 0 time = 1000
* CHECK dout0_16 vdout0_16ck199 = 0 time = 1000
* CHECK dout0_17 vdout0_17ck199 = 1.1 time = 1000
* CHECK dout0_18 vdout0_18ck199 = 1.1 time = 1000
* CHECK dout0_19 vdout0_19ck199 = 1.1 time = 1000
* CHECK dout0_20 vdout0_20ck199 = 1.1 time = 1000
* CHECK dout0_21 vdout0_21ck199 = 0 time = 1000
* CHECK dout0_22 vdout0_22ck199 = 1.1 time = 1000
* CHECK dout0_23 vdout0_23ck199 = 0 time = 1000
* CHECK dout0_24 vdout0_24ck199 = 1.1 time = 1000
* CHECK dout0_25 vdout0_25ck199 = 0 time = 1000
* CHECK dout0_26 vdout0_26ck199 = 1.1 time = 1000
* CHECK dout0_27 vdout0_27ck199 = 0 time = 1000
* CHECK dout0_28 vdout0_28ck199 = 0 time = 1000
* CHECK dout0_29 vdout0_29ck199 = 1.1 time = 1000
* CHECK dout0_30 vdout0_30ck199 = 1.1 time = 1000
* CHECK dout0_31 vdout0_31ck199 = 0 time = 1000
* CHECK dout0_0 vdout0_0ck201 = 1.1 time = 1010
* CHECK dout0_1 vdout0_1ck201 = 1.1 time = 1010
* CHECK dout0_2 vdout0_2ck201 = 1.1 time = 1010
* CHECK dout0_3 vdout0_3ck201 = 0 time = 1010
* CHECK dout0_4 vdout0_4ck201 = 0 time = 1010
* CHECK dout0_5 vdout0_5ck201 = 0 time = 1010
* CHECK dout0_6 vdout0_6ck201 = 1.1 time = 1010
* CHECK dout0_7 vdout0_7ck201 = 0 time = 1010
* CHECK dout0_8 vdout0_8ck201 = 0 time = 1010
* CHECK dout0_9 vdout0_9ck201 = 1.1 time = 1010
* CHECK dout0_10 vdout0_10ck201 = 0 time = 1010
* CHECK dout0_11 vdout0_11ck201 = 1.1 time = 1010
* CHECK dout0_12 vdout0_12ck201 = 0 time = 1010
* CHECK dout0_13 vdout0_13ck201 = 1.1 time = 1010
* CHECK dout0_14 vdout0_14ck201 = 0 time = 1010
* CHECK dout0_15 vdout0_15ck201 = 0 time = 1010
* CHECK dout0_16 vdout0_16ck201 = 0 time = 1010
* CHECK dout0_17 vdout0_17ck201 = 1.1 time = 1010
* CHECK dout0_18 vdout0_18ck201 = 1.1 time = 1010
* CHECK dout0_19 vdout0_19ck201 = 1.1 time = 1010
* CHECK dout0_20 vdout0_20ck201 = 1.1 time = 1010
* CHECK dout0_21 vdout0_21ck201 = 0 time = 1010
* CHECK dout0_22 vdout0_22ck201 = 1.1 time = 1010
* CHECK dout0_23 vdout0_23ck201 = 0 time = 1010
* CHECK dout0_24 vdout0_24ck201 = 1.1 time = 1010
* CHECK dout0_25 vdout0_25ck201 = 0 time = 1010
* CHECK dout0_26 vdout0_26ck201 = 1.1 time = 1010
* CHECK dout0_27 vdout0_27ck201 = 0 time = 1010
* CHECK dout0_28 vdout0_28ck201 = 0 time = 1010
* CHECK dout0_29 vdout0_29ck201 = 1.1 time = 1010
* CHECK dout0_30 vdout0_30ck201 = 1.1 time = 1010
* CHECK dout0_31 vdout0_31ck201 = 0 time = 1010
* CHECK dout0_0 vdout0_0ck203 = 0 time = 1020
* CHECK dout0_1 vdout0_1ck203 = 0 time = 1020
* CHECK dout0_2 vdout0_2ck203 = 1.1 time = 1020
* CHECK dout0_3 vdout0_3ck203 = 0 time = 1020
* CHECK dout0_4 vdout0_4ck203 = 1.1 time = 1020
* CHECK dout0_5 vdout0_5ck203 = 1.1 time = 1020
* CHECK dout0_6 vdout0_6ck203 = 0 time = 1020
* CHECK dout0_7 vdout0_7ck203 = 1.1 time = 1020
* CHECK dout0_8 vdout0_8ck203 = 0 time = 1020
* CHECK dout0_9 vdout0_9ck203 = 0 time = 1020
* CHECK dout0_10 vdout0_10ck203 = 0 time = 1020
* CHECK dout0_11 vdout0_11ck203 = 0 time = 1020
* CHECK dout0_12 vdout0_12ck203 = 0 time = 1020
* CHECK dout0_13 vdout0_13ck203 = 1.1 time = 1020
* CHECK dout0_14 vdout0_14ck203 = 0 time = 1020
* CHECK dout0_15 vdout0_15ck203 = 1.1 time = 1020
* CHECK dout0_16 vdout0_16ck203 = 1.1 time = 1020
* CHECK dout0_17 vdout0_17ck203 = 0 time = 1020
* CHECK dout0_18 vdout0_18ck203 = 0 time = 1020
* CHECK dout0_19 vdout0_19ck203 = 0 time = 1020
* CHECK dout0_20 vdout0_20ck203 = 1.1 time = 1020
* CHECK dout0_21 vdout0_21ck203 = 0 time = 1020
* CHECK dout0_22 vdout0_22ck203 = 0 time = 1020
* CHECK dout0_23 vdout0_23ck203 = 0 time = 1020
* CHECK dout0_24 vdout0_24ck203 = 1.1 time = 1020
* CHECK dout0_25 vdout0_25ck203 = 1.1 time = 1020
* CHECK dout0_26 vdout0_26ck203 = 1.1 time = 1020
* CHECK dout0_27 vdout0_27ck203 = 1.1 time = 1020
* CHECK dout0_28 vdout0_28ck203 = 1.1 time = 1020
* CHECK dout0_29 vdout0_29ck203 = 0 time = 1020
* CHECK dout0_30 vdout0_30ck203 = 1.1 time = 1020
* CHECK dout0_31 vdout0_31ck203 = 0 time = 1020
* CHECK dout0_0 vdout0_0ck204 = 1.1 time = 1025
* CHECK dout0_1 vdout0_1ck204 = 0 time = 1025
* CHECK dout0_2 vdout0_2ck204 = 0 time = 1025
* CHECK dout0_3 vdout0_3ck204 = 0 time = 1025
* CHECK dout0_4 vdout0_4ck204 = 0 time = 1025
* CHECK dout0_5 vdout0_5ck204 = 1.1 time = 1025
* CHECK dout0_6 vdout0_6ck204 = 0 time = 1025
* CHECK dout0_7 vdout0_7ck204 = 0 time = 1025
* CHECK dout0_8 vdout0_8ck204 = 1.1 time = 1025
* CHECK dout0_9 vdout0_9ck204 = 0 time = 1025
* CHECK dout0_10 vdout0_10ck204 = 0 time = 1025
* CHECK dout0_11 vdout0_11ck204 = 0 time = 1025
* CHECK dout0_12 vdout0_12ck204 = 0 time = 1025
* CHECK dout0_13 vdout0_13ck204 = 0 time = 1025
* CHECK dout0_14 vdout0_14ck204 = 0 time = 1025
* CHECK dout0_15 vdout0_15ck204 = 1.1 time = 1025
* CHECK dout0_16 vdout0_16ck204 = 1.1 time = 1025
* CHECK dout0_17 vdout0_17ck204 = 1.1 time = 1025
* CHECK dout0_18 vdout0_18ck204 = 1.1 time = 1025
* CHECK dout0_19 vdout0_19ck204 = 0 time = 1025
* CHECK dout0_20 vdout0_20ck204 = 1.1 time = 1025
* CHECK dout0_21 vdout0_21ck204 = 1.1 time = 1025
* CHECK dout0_22 vdout0_22ck204 = 0 time = 1025
* CHECK dout0_23 vdout0_23ck204 = 0 time = 1025
* CHECK dout0_24 vdout0_24ck204 = 0 time = 1025
* CHECK dout0_25 vdout0_25ck204 = 1.1 time = 1025
* CHECK dout0_26 vdout0_26ck204 = 1.1 time = 1025
* CHECK dout0_27 vdout0_27ck204 = 1.1 time = 1025
* CHECK dout0_28 vdout0_28ck204 = 0 time = 1025
* CHECK dout0_29 vdout0_29ck204 = 1.1 time = 1025
* CHECK dout0_30 vdout0_30ck204 = 0 time = 1025
* CHECK dout0_31 vdout0_31ck204 = 0 time = 1025
.include /home/kuoping/Projects/jv32/syn/lib/openram/./functional_meas.sp
* probe is used for hspice/xa, while plot is used in ngspice
*.probe V(*)
*.plot V(*)
.end
