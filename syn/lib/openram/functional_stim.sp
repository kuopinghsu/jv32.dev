* Functional test stimulus file for 5ns period

* TT process corner
.include "/home/kuoping/opt/OpenRAM/technology/freepdk45/models/tran_models/models_nom/PMOS_VTG.inc"
.include "/home/kuoping/opt/OpenRAM/technology/freepdk45/models/tran_models/models_nom/NMOS_VTG.inc"
.include "/tmp/openram_kuoping_42926_temp/sram.sp"

* Global Power Supplies
Vvdd vdd 0 1.1

*Nodes gnd and 0 are the same global ground node in ngspice/hspice/xa. Otherwise, this source may be needed.
*Vgnd gnd 0 0.0

* Instantiation of the SRAM
Xsram_1rw_2048x32 din0_0 din0_1 din0_2 din0_3 din0_4 din0_5 din0_6 din0_7 din0_8 din0_9 din0_10 din0_11 din0_12 din0_13 din0_14 din0_15 din0_16 din0_17 din0_18 din0_19 din0_20 din0_21 din0_22 din0_23 din0_24 din0_25 din0_26 din0_27 din0_28 din0_29 din0_30 din0_31 a0_0 a0_1 a0_2 a0_3 a0_4 a0_5 a0_6 a0_7 a0_8 a0_9 a0_10 CSB0 WEB0 clk0 WMASK0_0 WMASK0_1 WMASK0_2 WMASK0_3 dout0_0 dout0_1 dout0_2 dout0_3 dout0_4 dout0_5 dout0_6 dout0_7 dout0_8 dout0_9 dout0_10 dout0_11 dout0_12 dout0_13 dout0_14 dout0_15 dout0_16 dout0_17 dout0_18 dout0_19 dout0_20 dout0_21 dout0_22 dout0_23 dout0_24 dout0_25 dout0_26 dout0_27 dout0_28 dout0_29 dout0_30 dout0_31 vdd gnd sram_1rw_2048x32

* SRAM output loads
CD00 dout0_0  0 0.8364f
CD01 dout0_1  0 0.8364f
CD02 dout0_2  0 0.8364f
CD03 dout0_3  0 0.8364f
CD04 dout0_4  0 0.8364f
CD05 dout0_5  0 0.8364f
CD06 dout0_6  0 0.8364f
CD07 dout0_7  0 0.8364f
CD08 dout0_8  0 0.8364f
CD09 dout0_9  0 0.8364f
CD010 dout0_10  0 0.8364f
CD011 dout0_11  0 0.8364f
CD012 dout0_12  0 0.8364f
CD013 dout0_13  0 0.8364f
CD014 dout0_14  0 0.8364f
CD015 dout0_15  0 0.8364f
CD016 dout0_16  0 0.8364f
CD017 dout0_17  0 0.8364f
CD018 dout0_18  0 0.8364f
CD019 dout0_19  0 0.8364f
CD020 dout0_20  0 0.8364f
CD021 dout0_21  0 0.8364f
CD022 dout0_22  0 0.8364f
CD023 dout0_23  0 0.8364f
CD024 dout0_24  0 0.8364f
CD025 dout0_25  0 0.8364f
CD026 dout0_26  0 0.8364f
CD027 dout0_27  0 0.8364f
CD028 dout0_28  0 0.8364f
CD029 dout0_29  0 0.8364f
CD030 dout0_30  0 0.8364f
CD031 dout0_31  0 0.8364f

* Important signals for debug
* bl:	xsram:xbank0:bl_0_0
* br:	xsram:xbank0:br_0_0
* s_en:	xsram:s_en
* q:	xsram:xbank0:xbitcell_array:xbitcell_array:xbit_r0_c0.Q
* qbar:	xsram:xbank0:xbitcell_array:xbitcell_array:xbit_r0_c0.Q_bar

* Sequence of operations
*	Idle during cycle 0 (0ns - 5ns)
*	Writing 00000001000100100101010010001010  to  address 11111111110 (from port 0) during cycle 1 (5ns - 10ns)
*	Writing 10011010000001011110010000100010  to  address 11111111110 (from port 0) during cycle 2 (10ns - 15ns)
*	Writing 10110011000101110001100011000011  to  address 00000000000 (from port 0) during cycle 3 (15ns - 20ns)
*	Reading 10110011000101110001100011000011 from address 00000000000 (from port 0) during cycle 4 (20ns - 25ns)
*	Reading 10110011000101110001100011000011 from address 00000000000 (from port 0) during cycle 5 (25ns - 30ns)
*	Reading 10110011000101110001100011000011 from address 00000000000 (from port 0) during cycle 9 (45ns - 50ns)
*	Writing 10101101000111010101011111100101  to  address 00000000000 (from port 0) during cycle 10 (50ns - 55ns)
*	Reading 10101101000111010101011111100101 from address 00000000000 (from port 0) during cycle 12 (60ns - 65ns)
*	Reading 10011010000001011110010000100010 from address 11111111110 (from port 0) during cycle 13 (65ns - 70ns)
*	Writing 01111001100111000011100010100010  to  address 00000000000 (from port 0) during cycle 14 (70ns - 75ns)
*	Reading 01111001100111000011100010100010 from address 00000000000 (from port 0) during cycle 16 (80ns - 85ns)
*	Writing (partial) 11101110100011100110111101100011  to  address 11111111110 with mask bit 1010 (from port 0) during cycle 17 (85ns - 90ns)
*	Writing 01001101000001101000011110111000  to  address 00000000000 (from port 0) during cycle 20 (100ns - 105ns)
*	Reading 01001101000001101000011110111000 from address 00000000000 (from port 0) during cycle 21 (105ns - 110ns)
*	Writing (partial) 00111111001101111010111000000111  to  address 00000000000 with mask bit 0010 (from port 0) during cycle 23 (115ns - 120ns)
*	Reading 01001101000001101010111010111000 from address 00000000000 (from port 0) during cycle 24 (120ns - 125ns)
*	Reading 01001101000001101010111010111000 from address 00000000000 (from port 0) during cycle 26 (130ns - 135ns)
*	Writing 11110000110011100101001010000010  to  address 00000000000 (from port 0) during cycle 28 (140ns - 145ns)
*	Writing (partial) 01000110100110110001011000101100  to  address 11111111110 with mask bit 1101 (from port 0) during cycle 29 (145ns - 150ns)
*	Reading 11110000110011100101001010000010 from address 00000000000 (from port 0) during cycle 31 (155ns - 160ns)
*	Reading 11110000110011100101001010000010 from address 00000000000 (from port 0) during cycle 32 (160ns - 165ns)
*	Reading 11110000110011100101001010000010 from address 00000000000 (from port 0) during cycle 33 (165ns - 170ns)
*	Reading 01000110100110110110111100101100 from address 11111111110 (from port 0) during cycle 34 (170ns - 175ns)
*	Reading 11110000110011100101001010000010 from address 00000000000 (from port 0) during cycle 35 (175ns - 180ns)
*	Writing (partial) 11010101001010001100110111110001  to  address 00000000000 with mask bit 1101 (from port 0) during cycle 36 (180ns - 185ns)
*	Reading 11010101001010000101001011110001 from address 00000000000 (from port 0) during cycle 37 (185ns - 190ns)
*	Reading 11010101001010000101001011110001 from address 00000000000 (from port 0) during cycle 38 (190ns - 195ns)
*	Writing (partial) 00110010100100010000111110100110  to  address 00000000000 with mask bit 1101 (from port 0) during cycle 41 (205ns - 210ns)
*	Writing (partial) 01000011000000100010010000111101  to  address 11111111110 with mask bit 0011 (from port 0) during cycle 42 (210ns - 215ns)
*	Reading 01000110100110110010010000111101 from address 11111111110 (from port 0) during cycle 43 (215ns - 220ns)
*	Writing (partial) 10000011110001000101111011010110  to  address 00000000000 with mask bit 0010 (from port 0) during cycle 44 (220ns - 225ns)
*	Reading 01000110100110110010010000111101 from address 11111111110 (from port 0) during cycle 46 (230ns - 235ns)
*	Reading 01000110100110110010010000111101 from address 11111111110 (from port 0) during cycle 47 (235ns - 240ns)
*	Writing 11101101011111110110111101111000  to  address 00000000000 (from port 0) during cycle 48 (240ns - 245ns)
*	Reading 01000110100110110010010000111101 from address 11111111110 (from port 0) during cycle 49 (245ns - 250ns)
*	Reading 01000110100110110010010000111101 from address 11111111110 (from port 0) during cycle 50 (250ns - 255ns)
*	Reading 01000110100110110010010000111101 from address 11111111110 (from port 0) during cycle 51 (255ns - 260ns)
*	Reading 11101101011111110110111101111000 from address 00000000000 (from port 0) during cycle 52 (260ns - 265ns)
*	Writing (partial) 11111000110100110010111111111001  to  address 11111111110 with mask bit 1010 (from port 0) during cycle 54 (270ns - 275ns)
*	Reading 11101101011111110110111101111000 from address 00000000000 (from port 0) during cycle 55 (275ns - 280ns)
*	Writing (partial) 01111011100110110001001110111000  to  address 00000000000 with mask bit 0011 (from port 0) during cycle 56 (280ns - 285ns)
*	Writing (partial) 10001111001111110010011110110011  to  address 00000000000 with mask bit 0010 (from port 0) during cycle 58 (290ns - 295ns)
*	Writing (partial) 10000011010100011010000001011001  to  address 00000000000 with mask bit 0111 (from port 0) during cycle 59 (295ns - 300ns)
*	Writing (partial) 10000000001011011110111100100110  to  address 11111111110 with mask bit 1000 (from port 0) during cycle 60 (300ns - 305ns)
*	Reading 11101101010100011010000001011001 from address 00000000000 (from port 0) during cycle 62 (310ns - 315ns)
*	Writing 01101100011001110101101101010011  to  address 00000000000 (from port 0) during cycle 63 (315ns - 320ns)
*	Writing (partial) 01011101111110011101110101000101  to  address 11111111110 with mask bit 1011 (from port 0) during cycle 64 (320ns - 325ns)
*	Writing (partial) 01110011111010001011101000110100  to  address 11111111110 with mask bit 0100 (from port 0) during cycle 65 (325ns - 330ns)
*	Writing (partial) 01011000001010001011110110001001  to  address 11111111110 with mask bit 1000 (from port 0) during cycle 66 (330ns - 335ns)
*	Writing (partial) 10011011111111101111011111100101  to  address 00000000000 with mask bit 0011 (from port 0) during cycle 67 (335ns - 340ns)
*	Writing (partial) 11100111000110100101101100110010  to  address 00000000000 with mask bit 1110 (from port 0) during cycle 68 (340ns - 345ns)
*	Reading 11100111000110100101101111100101 from address 00000000000 (from port 0) during cycle 70 (350ns - 355ns)
*	Reading 01011000111010001101110101000101 from address 11111111110 (from port 0) during cycle 71 (355ns - 360ns)
*	Reading 01011000111010001101110101000101 from address 11111111110 (from port 0) during cycle 72 (360ns - 365ns)
*	Reading 01011000111010001101110101000101 from address 11111111110 (from port 0) during cycle 73 (365ns - 370ns)
*	Reading 01011000111010001101110101000101 from address 11111111110 (from port 0) during cycle 76 (380ns - 385ns)
*	Writing 11101000110100011101110110111001  to  address 11111111110 (from port 0) during cycle 77 (385ns - 390ns)
*	Writing (partial) 11101001101011110011011001010001  to  address 00000000000 with mask bit 0101 (from port 0) during cycle 79 (395ns - 400ns)
*	Reading 11101000110100011101110110111001 from address 11111111110 (from port 0) during cycle 80 (400ns - 405ns)
*	Writing 11001100111101100100001100100111  to  address 00000000000 (from port 0) during cycle 81 (405ns - 410ns)
*	Writing 10110110000100110001010101101011  to  address 00000000000 (from port 0) during cycle 82 (410ns - 415ns)
*	Reading 10110110000100110001010101101011 from address 00000000000 (from port 0) during cycle 83 (415ns - 420ns)
*	Reading 10110110000100110001010101101011 from address 00000000000 (from port 0) during cycle 84 (420ns - 425ns)
*	Writing (partial) 01111100000001010110011100000001  to  address 11111111110 with mask bit 0001 (from port 0) during cycle 85 (425ns - 430ns)
*	Writing 00010100110100011000101001101100  to  address 00000000000 (from port 0) during cycle 87 (435ns - 440ns)
*	Reading 11101000110100011101110100000001 from address 11111111110 (from port 0) during cycle 88 (440ns - 445ns)
*	Writing 10110011111110100011110011001001  to  address 11111111110 (from port 0) during cycle 89 (445ns - 450ns)
*	Writing (partial) 00101010101010111110101111101100  to  address 11111111110 with mask bit 0010 (from port 0) during cycle 90 (450ns - 455ns)
*	Writing 01011001101110101011000111111010  to  address 11111111110 (from port 0) during cycle 91 (455ns - 460ns)
*	Reading 01011001101110101011000111111010 from address 11111111110 (from port 0) during cycle 93 (465ns - 470ns)
*	Reading 01011001101110101011000111111010 from address 11111111110 (from port 0) during cycle 94 (470ns - 475ns)
*	Writing 00111011001010010111101100100100  to  address 00000000000 (from port 0) during cycle 98 (490ns - 495ns)
*	Reading 00111011001010010111101100100100 from address 00000000000 (from port 0) during cycle 99 (495ns - 500ns)
*	Reading 00111011001010010111101100100100 from address 00000000000 (from port 0) during cycle 100 (500ns - 505ns)
*	Reading 00111011001010010111101100100100 from address 00000000000 (from port 0) during cycle 101 (505ns - 510ns)
*	Writing (partial) 11110011010110100000100000100011  to  address 00000000000 with mask bit 0111 (from port 0) during cycle 102 (510ns - 515ns)
*	Writing 00110101001110110100000101110001  to  address 00000000000 (from port 0) during cycle 103 (515ns - 520ns)
*	Reading 00110101001110110100000101110001 from address 00000000000 (from port 0) during cycle 104 (520ns - 525ns)
*	Reading 00110101001110110100000101110001 from address 00000000000 (from port 0) during cycle 105 (525ns - 530ns)
*	Writing 00110111001111101100101001101010  to  address 11111111110 (from port 0) during cycle 107 (535ns - 540ns)
*	Writing 00100010010101101111000110111100  to  address 00000000000 (from port 0) during cycle 108 (540ns - 545ns)
*	Writing (partial) 00101111010110110101000110000011  to  address 00000000000 with mask bit 0101 (from port 0) during cycle 109 (545ns - 550ns)
*	Writing (partial) 10110101010111000010011111010001  to  address 11111111110 with mask bit 0111 (from port 0) during cycle 110 (550ns - 555ns)
*	Reading 00110111010111000010011111010001 from address 11111111110 (from port 0) during cycle 112 (560ns - 565ns)
*	Reading 00100010010110111111000110000011 from address 00000000000 (from port 0) during cycle 113 (565ns - 570ns)
*	Writing (partial) 00011011011010101100101101010100  to  address 00000000000 with mask bit 1000 (from port 0) during cycle 114 (570ns - 575ns)
*	Writing (partial) 01100011111010000101101000001001  to  address 00000000000 with mask bit 0110 (from port 0) during cycle 115 (575ns - 580ns)
*	Writing (partial) 10101000101011010000100011111110  to  address 11111111110 with mask bit 1010 (from port 0) during cycle 116 (580ns - 585ns)
*	Writing 00010111101000001000110101011111  to  address 11111111110 (from port 0) during cycle 117 (585ns - 590ns)
*	Writing (partial) 10100110100110011100011101110101  to  address 11111111110 with mask bit 1010 (from port 0) during cycle 118 (590ns - 595ns)
*	Writing 00100111111010001001101000101100  to  address 11111111110 (from port 0) during cycle 119 (595ns - 600ns)
*	Writing 00000101011110110001001101011101  to  address 11111111110 (from port 0) during cycle 120 (600ns - 605ns)
*	Writing (partial) 01111100101110101110111001111001  to  address 11111111110 with mask bit 1001 (from port 0) during cycle 121 (605ns - 610ns)
*	Reading 00011011111010000101101010000011 from address 00000000000 (from port 0) during cycle 122 (610ns - 615ns)
*	Writing (partial) 00110011001110011101011001001001  to  address 00000000000 with mask bit 1101 (from port 0) during cycle 123 (615ns - 620ns)
*	Writing (partial) 10011010101100101101101101110111  to  address 00000000000 with mask bit 0001 (from port 0) during cycle 125 (625ns - 630ns)
*	Reading 01111100011110110001001101111001 from address 11111111110 (from port 0) during cycle 126 (630ns - 635ns)
*	Reading 00110011001110010101101001110111 from address 00000000000 (from port 0) during cycle 127 (635ns - 640ns)
*	Writing (partial) 00000001011010000100010111010001  to  address 11111111110 with mask bit 0011 (from port 0) during cycle 129 (645ns - 650ns)
*	Reading 00110011001110010101101001110111 from address 00000000000 (from port 0) during cycle 130 (650ns - 655ns)
*	Reading 01111100011110110100010111010001 from address 11111111110 (from port 0) during cycle 131 (655ns - 660ns)
*	Reading 00110011001110010101101001110111 from address 00000000000 (from port 0) during cycle 132 (660ns - 665ns)
*	Writing (partial) 11111110000001010101011101000000  to  address 00000000000 with mask bit 0110 (from port 0) during cycle 133 (665ns - 670ns)
*	Writing (partial) 01111011110000111000100111110001  to  address 11111111110 with mask bit 0110 (from port 0) during cycle 134 (670ns - 675ns)
*	Writing (partial) 01001100111000101010100000111001  to  address 11111111110 with mask bit 1100 (from port 0) during cycle 138 (690ns - 695ns)
*	Writing (partial) 10011101011101010000010111111110  to  address 11111111110 with mask bit 0111 (from port 0) during cycle 139 (695ns - 700ns)
*	Writing (partial) 11010010001101001100110010001101  to  address 11111111110 with mask bit 0110 (from port 0) during cycle 140 (700ns - 705ns)
*	Writing 11111101101001101100001101111101  to  address 00000000000 (from port 0) during cycle 141 (705ns - 710ns)
*	Writing (partial) 00101011010111100100010011001000  to  address 00000000000 with mask bit 1110 (from port 0) during cycle 142 (710ns - 715ns)
*	Reading 00101011010111100100010001111101 from address 00000000000 (from port 0) during cycle 143 (715ns - 720ns)
*	Reading 00101011010111100100010001111101 from address 00000000000 (from port 0) during cycle 144 (720ns - 725ns)
*	Reading 00101011010111100100010001111101 from address 00000000000 (from port 0) during cycle 145 (725ns - 730ns)
*	Reading 00101011010111100100010001111101 from address 00000000000 (from port 0) during cycle 146 (730ns - 735ns)
*	Writing (partial) 11101111011111000011011010110001  to  address 00000000000 with mask bit 0110 (from port 0) during cycle 147 (735ns - 740ns)
*	Writing (partial) 00010010011000100010010001111110  to  address 00000000000 with mask bit 0110 (from port 0) during cycle 149 (745ns - 750ns)
*	Writing (partial) 00011110010100001011111111101010  to  address 11111111110 with mask bit 1010 (from port 0) during cycle 151 (755ns - 760ns)
*	Reading 00011110001101001011111111111110 from address 11111111110 (from port 0) during cycle 152 (760ns - 765ns)
*	Writing (partial) 10101110100001010111101101100000  to  address 11111111110 with mask bit 0001 (from port 0) during cycle 153 (765ns - 770ns)
*	Reading 00101011011000100010010001111101 from address 00000000000 (from port 0) during cycle 154 (770ns - 775ns)
*	Reading 00011110001101001011111101100000 from address 11111111110 (from port 0) during cycle 155 (775ns - 780ns)
*	Reading 00011110001101001011111101100000 from address 11111111110 (from port 0) during cycle 156 (780ns - 785ns)
*	Writing (partial) 10101010110001011110010001010100  to  address 11111111110 with mask bit 0010 (from port 0) during cycle 157 (785ns - 790ns)
*	Reading 00011110001101001110010001100000 from address 11111111110 (from port 0) during cycle 158 (790ns - 795ns)
*	Reading 00101011011000100010010001111101 from address 00000000000 (from port 0) during cycle 161 (805ns - 810ns)
*	Writing (partial) 10011010110001010010010101111010  to  address 00000000000 with mask bit 1001 (from port 0) during cycle 162 (810ns - 815ns)
*	Writing 00001110100111011101010110011010  to  address 00000000000 (from port 0) during cycle 163 (815ns - 820ns)
*	Writing 11110011111111001100011011111110  to  address 00000000000 (from port 0) during cycle 164 (820ns - 825ns)
*	Reading 11110011111111001100011011111110 from address 00000000000 (from port 0) during cycle 166 (830ns - 835ns)
*	Writing 11100011110010101100001001101000  to  address 11111111110 (from port 0) during cycle 167 (835ns - 840ns)
*	Reading 11100011110010101100001001101000 from address 11111111110 (from port 0) during cycle 169 (845ns - 850ns)
*	Reading 11100011110010101100001001101000 from address 11111111110 (from port 0) during cycle 171 (855ns - 860ns)
*	Writing 01010011000001100101111001101101  to  address 11111111110 (from port 0) during cycle 172 (860ns - 865ns)
*	Reading 01010011000001100101111001101101 from address 11111111110 (from port 0) during cycle 174 (870ns - 875ns)
*	Reading 11110011111111001100011011111110 from address 00000000000 (from port 0) during cycle 175 (875ns - 880ns)
*	Reading 11110011111111001100011011111110 from address 00000000000 (from port 0) during cycle 176 (880ns - 885ns)
*	Reading 01010011000001100101111001101101 from address 11111111110 (from port 0) during cycle 177 (885ns - 890ns)
*	Writing 11000011001101000100011000010011  to  address 00000000000 (from port 0) during cycle 178 (890ns - 895ns)
*	Writing (partial) 11100110001110010100011101111111  to  address 11111111110 with mask bit 0110 (from port 0) during cycle 180 (900ns - 905ns)
*	Writing 10101111001110000111100100100001  to  address 11111111110 (from port 0) during cycle 181 (905ns - 910ns)
*	Writing 11000010101101000001011111101011  to  address 00000000000 (from port 0) during cycle 182 (910ns - 915ns)
*	Writing 00010101111111110111111010000001  to  address 11111111110 (from port 0) during cycle 184 (920ns - 925ns)
*	Reading 00010101111111110111111010000001 from address 11111111110 (from port 0) during cycle 185 (925ns - 930ns)
*	Writing (partial) 10001100101000110100010101011111  to  address 00000000000 with mask bit 0111 (from port 0) during cycle 186 (930ns - 935ns)
*	Writing 01111000101011011111000100101001  to  address 00000000000 (from port 0) during cycle 187 (935ns - 940ns)
*	Writing 01001101100010111111000010010010  to  address 00000000000 (from port 0) during cycle 188 (940ns - 945ns)
*	Reading 01001101100010111111000010010010 from address 00000000000 (from port 0) during cycle 189 (945ns - 950ns)
*	Writing 11111001010000101101011111111111  to  address 11111111110 (from port 0) during cycle 190 (950ns - 955ns)
*	Writing (partial) 10111010000111010100011011101011  to  address 00000000000 with mask bit 1001 (from port 0) during cycle 191 (955ns - 960ns)
*	Writing 11001000110110001011001110001001  to  address 11111111110 (from port 0) during cycle 192 (960ns - 965ns)
*	Writing (partial) 01001011111100110111110100110010  to  address 11111111110 with mask bit 1010 (from port 0) during cycle 193 (965ns - 970ns)
*	Writing 11110010010011001111110011001111  to  address 11111111110 (from port 0) during cycle 194 (970ns - 975ns)
*	Reading 11110010010011001111110011001111 from address 11111111110 (from port 0) during cycle 195 (975ns - 980ns)
*	Reading 10111010100010111111000011101011 from address 00000000000 (from port 0) during cycle 196 (980ns - 985ns)
*	Writing 10110111110000100000101111100111  to  address 11111111110 (from port 0) during cycle 197 (985ns - 990ns)
*	Writing 00010001111010000001011101011001  to  address 00000000000 (from port 0) during cycle 198 (990ns - 995ns)
*	Writing (partial) 00011011001110010000010110100111  to  address 11111111110 with mask bit 1110 (from port 0) during cycle 199 (995ns - 1000ns)
*	Writing 01100100111001010011100101100100  to  address 00000000000 (from port 0) during cycle 200 (1000ns - 1005ns)
*	Reading 00011011001110010000010111100111 from address 11111111110 (from port 0) during cycle 201 (1005ns - 1010ns)
*	Writing 00110011001001110000001101000000  to  address 00000000000 (from port 0) during cycle 202 (1010ns - 1015ns)
*	Reading 00011011001110010000010111100111 from address 11111111110 (from port 0) during cycle 203 (1015ns - 1020ns)
*	Reading 00011011001110010000010111100111 from address 11111111110 (from port 0) during cycle 204 (1020ns - 1025ns)
*	Idle during cycle 205 (1025ns - 1030ns)

* Generation of data and address signals
* (time, data): [(0, 0), (5, 0), (10, 0), (15, 1), (20, 1), (25, 1), (30, 1), (35, 1), (40, 1), (45, 1), (50, 1), (55, 1), (60, 1), (65, 1), (70, 0), (75, 0), (80, 0), (85, 1), (90, 1), (95, 1), (100, 0), (105, 0), (110, 0), (115, 1), (120, 1), (125, 1), (130, 1), (135, 1), (140, 0), (145, 0), (150, 0), (155, 0), (160, 0), (165, 0), (170, 0), (175, 0), (180, 1), (185, 1), (190, 1), (195, 1), (200, 1), (205, 0), (210, 1), (215, 1), (220, 0), (225, 0), (230, 0), (235, 0), (240, 0), (245, 0), (250, 0), (255, 0), (260, 0), (265, 0), (270, 1), (275, 1), (280, 0), (285, 0), (290, 1), (295, 1), (300, 0), (305, 0), (310, 0), (315, 1), (320, 1), (325, 0), (330, 1), (335, 1), (340, 0), (345, 0), (350, 0), (355, 0), (360, 0), (365, 0), (370, 0), (375, 0), (380, 0), (385, 1), (390, 1), (395, 1), (400, 1), (405, 1), (410, 1), (415, 1), (420, 1), (425, 1), (430, 1), (435, 0), (440, 0), (445, 1), (450, 0), (455, 0), (460, 0), (465, 0), (470, 0), (475, 0), (480, 0), (485, 0), (490, 0), (495, 0), (500, 0), (505, 0), (510, 1), (515, 1), (520, 1), (525, 1), (530, 1), (535, 0), (540, 0), (545, 1), (550, 1), (555, 1), (560, 1), (565, 1), (570, 0), (575, 1), (580, 0), (585, 1), (590, 1), (595, 0), (600, 1), (605, 1), (610, 1), (615, 1), (620, 1), (625, 1), (630, 1), (635, 1), (640, 1), (645, 1), (650, 1), (655, 1), (660, 1), (665, 0), (670, 1), (675, 1), (680, 1), (685, 1), (690, 1), (695, 0), (700, 1), (705, 1), (710, 0), (715, 0), (720, 0), (725, 0), (730, 0), (735, 1), (740, 1), (745, 0), (750, 0), (755, 0), (760, 0), (765, 0), (770, 0), (775, 0), (780, 0), (785, 0), (790, 0), (795, 0), (800, 0), (805, 0), (810, 0), (815, 0), (820, 0), (825, 0), (830, 0), (835, 0), (840, 0), (845, 0), (850, 0), (855, 0), (860, 1), (865, 1), (870, 1), (875, 1), (880, 1), (885, 1), (890, 1), (895, 1), (900, 1), (905, 1), (910, 1), (915, 1), (920, 1), (925, 1), (930, 1), (935, 1), (940, 0), (945, 0), (950, 1), (955, 1), (960, 1), (965, 0), (970, 1), (975, 1), (980, 1), (985, 1), (990, 1), (995, 1), (1000, 0), (1005, 0), (1010, 0), (1015, 0), (1020, 0), (1025, 0)]
Vdin0_0  din0_0  0 PWL (0n 0.0v 4.745n 0.0v 4.755n 0.0v 9.745n 0.0v 9.755n 0.0v 14.745n 0.0v 14.755n 1.1v 19.745n 1.1v 19.755n 1.1v 24.745n 1.1v 24.755n 1.1v 29.745n 1.1v 29.755n 1.1v 34.745n 1.1v 34.755n 1.1v 39.745n 1.1v 39.755n 1.1v 44.745n 1.1v 44.755n 1.1v 49.745n 1.1v 49.755n 1.1v 54.745n 1.1v 54.755n 1.1v 59.745n 1.1v 59.755n 1.1v 64.745n 1.1v 64.755n 1.1v 69.745n 1.1v 69.755n 0.0v 74.745n 0.0v 74.755n 0.0v 79.745n 0.0v 79.755n 0.0v 84.745n 0.0v 84.755n 1.1v 89.745n 1.1v 89.755n 1.1v 94.745n 1.1v 94.755n 1.1v 99.745n 1.1v 99.755n 0.0v 104.745n 0.0v 104.755n 0.0v 109.745n 0.0v 109.755n 0.0v 114.745n 0.0v 114.755n 1.1v 119.745n 1.1v 119.755n 1.1v 124.745n 1.1v 124.755n 1.1v 129.745n 1.1v 129.755n 1.1v 134.745n 1.1v 134.755n 1.1v 139.745n 1.1v 139.755n 0.0v 144.745n 0.0v 144.755n 0.0v 149.745n 0.0v 149.755n 0.0v 154.745n 0.0v 154.755n 0.0v 159.745n 0.0v 159.755n 0.0v 164.745n 0.0v 164.755n 0.0v 169.745n 0.0v 169.755n 0.0v 174.745n 0.0v 174.755n 0.0v 179.745n 0.0v 179.755n 1.1v 184.745n 1.1v 184.755n 1.1v 189.745n 1.1v 189.755n 1.1v 194.745n 1.1v 194.755n 1.1v 199.745n 1.1v 199.755n 1.1v 204.745n 1.1v 204.755n 0.0v 209.745n 0.0v 209.755n 1.1v 214.745n 1.1v 214.755n 1.1v 219.745n 1.1v 219.755n 0.0v 224.745n 0.0v 224.755n 0.0v 229.745n 0.0v 229.755n 0.0v 234.745n 0.0v 234.755n 0.0v 239.745n 0.0v 239.755n 0.0v 244.745n 0.0v 244.755n 0.0v 249.745n 0.0v 249.755n 0.0v 254.745n 0.0v 254.755n 0.0v 259.745n 0.0v 259.755n 0.0v 264.745n 0.0v 264.755n 0.0v 269.745n 0.0v 269.755n 1.1v 274.745n 1.1v 274.755n 1.1v 279.745n 1.1v 279.755n 0.0v 284.745n 0.0v 284.755n 0.0v 289.745n 0.0v 289.755n 1.1v 294.745n 1.1v 294.755n 1.1v 299.745n 1.1v 299.755n 0.0v 304.745n 0.0v 304.755n 0.0v 309.745n 0.0v 309.755n 0.0v 314.745n 0.0v 314.755n 1.1v 319.745n 1.1v 319.755n 1.1v 324.745n 1.1v 324.755n 0.0v 329.745n 0.0v 329.755n 1.1v 334.745n 1.1v 334.755n 1.1v 339.745n 1.1v 339.755n 0.0v 344.745n 0.0v 344.755n 0.0v 349.745n 0.0v 349.755n 0.0v 354.745n 0.0v 354.755n 0.0v 359.745n 0.0v 359.755n 0.0v 364.745n 0.0v 364.755n 0.0v 369.745n 0.0v 369.755n 0.0v 374.745n 0.0v 374.755n 0.0v 379.745n 0.0v 379.755n 0.0v 384.745n 0.0v 384.755n 1.1v 389.745n 1.1v 389.755n 1.1v 394.745n 1.1v 394.755n 1.1v 399.745n 1.1v 399.755n 1.1v 404.745n 1.1v 404.755n 1.1v 409.745n 1.1v 409.755n 1.1v 414.745n 1.1v 414.755n 1.1v 419.745n 1.1v 419.755n 1.1v 424.745n 1.1v 424.755n 1.1v 429.745n 1.1v 429.755n 1.1v 434.745n 1.1v 434.755n 0.0v 439.745n 0.0v 439.755n 0.0v 444.745n 0.0v 444.755n 1.1v 449.745n 1.1v 449.755n 0.0v 454.745n 0.0v 454.755n 0.0v 459.745n 0.0v 459.755n 0.0v 464.745n 0.0v 464.755n 0.0v 469.745n 0.0v 469.755n 0.0v 474.745n 0.0v 474.755n 0.0v 479.745n 0.0v 479.755n 0.0v 484.745n 0.0v 484.755n 0.0v 489.745n 0.0v 489.755n 0.0v 494.745n 0.0v 494.755n 0.0v 499.745n 0.0v 499.755n 0.0v 504.745n 0.0v 504.755n 0.0v 509.745n 0.0v 509.755n 1.1v 514.745n 1.1v 514.755n 1.1v 519.745n 1.1v 519.755n 1.1v 524.745n 1.1v 524.755n 1.1v 529.745n 1.1v 529.755n 1.1v 534.745n 1.1v 534.755n 0.0v 539.745n 0.0v 539.755n 0.0v 544.745n 0.0v 544.755n 1.1v 549.745n 1.1v 549.755n 1.1v 554.745n 1.1v 554.755n 1.1v 559.745n 1.1v 559.755n 1.1v 564.745n 1.1v 564.755n 1.1v 569.745n 1.1v 569.755n 0.0v 574.745n 0.0v 574.755n 1.1v 579.745n 1.1v 579.755n 0.0v 584.745n 0.0v 584.755n 1.1v 589.745n 1.1v 589.755n 1.1v 594.745n 1.1v 594.755n 0.0v 599.745n 0.0v 599.755n 1.1v 604.745n 1.1v 604.755n 1.1v 609.745n 1.1v 609.755n 1.1v 614.745n 1.1v 614.755n 1.1v 619.745n 1.1v 619.755n 1.1v 624.745n 1.1v 624.755n 1.1v 629.745n 1.1v 629.755n 1.1v 634.745n 1.1v 634.755n 1.1v 639.745n 1.1v 639.755n 1.1v 644.745n 1.1v 644.755n 1.1v 649.745n 1.1v 649.755n 1.1v 654.745n 1.1v 654.755n 1.1v 659.745n 1.1v 659.755n 1.1v 664.745n 1.1v 664.755n 0.0v 669.745n 0.0v 669.755n 1.1v 674.745n 1.1v 674.755n 1.1v 679.745n 1.1v 679.755n 1.1v 684.745n 1.1v 684.755n 1.1v 689.745n 1.1v 689.755n 1.1v 694.745n 1.1v 694.755n 0.0v 699.745n 0.0v 699.755n 1.1v 704.745n 1.1v 704.755n 1.1v 709.745n 1.1v 709.755n 0.0v 714.745n 0.0v 714.755n 0.0v 719.745n 0.0v 719.755n 0.0v 724.745n 0.0v 724.755n 0.0v 729.745n 0.0v 729.755n 0.0v 734.745n 0.0v 734.755n 1.1v 739.745n 1.1v 739.755n 1.1v 744.745n 1.1v 744.755n 0.0v 749.745n 0.0v 749.755n 0.0v 754.745n 0.0v 754.755n 0.0v 759.745n 0.0v 759.755n 0.0v 764.745n 0.0v 764.755n 0.0v 769.745n 0.0v 769.755n 0.0v 774.745n 0.0v 774.755n 0.0v 779.745n 0.0v 779.755n 0.0v 784.745n 0.0v 784.755n 0.0v 789.745n 0.0v 789.755n 0.0v 794.745n 0.0v 794.755n 0.0v 799.745n 0.0v 799.755n 0.0v 804.745n 0.0v 804.755n 0.0v 809.745n 0.0v 809.755n 0.0v 814.745n 0.0v 814.755n 0.0v 819.745n 0.0v 819.755n 0.0v 824.745n 0.0v 824.755n 0.0v 829.745n 0.0v 829.755n 0.0v 834.745n 0.0v 834.755n 0.0v 839.745n 0.0v 839.755n 0.0v 844.745n 0.0v 844.755n 0.0v 849.745n 0.0v 849.755n 0.0v 854.745n 0.0v 854.755n 0.0v 859.745n 0.0v 859.755n 1.1v 864.745n 1.1v 864.755n 1.1v 869.745n 1.1v 869.755n 1.1v 874.745n 1.1v 874.755n 1.1v 879.745n 1.1v 879.755n 1.1v 884.745n 1.1v 884.755n 1.1v 889.745n 1.1v 889.755n 1.1v 894.745n 1.1v 894.755n 1.1v 899.745n 1.1v 899.755n 1.1v 904.745n 1.1v 904.755n 1.1v 909.745n 1.1v 909.755n 1.1v 914.745n 1.1v 914.755n 1.1v 919.745n 1.1v 919.755n 1.1v 924.745n 1.1v 924.755n 1.1v 929.745n 1.1v 929.755n 1.1v 934.745n 1.1v 934.755n 1.1v 939.745n 1.1v 939.755n 0.0v 944.745n 0.0v 944.755n 0.0v 949.745n 0.0v 949.755n 1.1v 954.745n 1.1v 954.755n 1.1v 959.745n 1.1v 959.755n 1.1v 964.745n 1.1v 964.755n 0.0v 969.745n 0.0v 969.755n 1.1v 974.745n 1.1v 974.755n 1.1v 979.745n 1.1v 979.755n 1.1v 984.745n 1.1v 984.755n 1.1v 989.745n 1.1v 989.755n 1.1v 994.745n 1.1v 994.755n 1.1v 999.745n 1.1v 999.755n 0.0v 1004.745n 0.0v 1004.755n 0.0v 1009.745n 0.0v 1009.755n 0.0v 1014.745n 0.0v 1014.755n 0.0v 1019.745n 0.0v 1019.755n 0.0v 1024.745n 0.0v 1024.755n 0.0v )
* (time, data): [(0, 0), (5, 1), (10, 1), (15, 1), (20, 1), (25, 1), (30, 1), (35, 1), (40, 1), (45, 1), (50, 0), (55, 0), (60, 0), (65, 0), (70, 1), (75, 1), (80, 1), (85, 1), (90, 1), (95, 1), (100, 0), (105, 0), (110, 0), (115, 1), (120, 1), (125, 1), (130, 1), (135, 1), (140, 1), (145, 0), (150, 0), (155, 0), (160, 0), (165, 0), (170, 0), (175, 0), (180, 0), (185, 0), (190, 0), (195, 0), (200, 0), (205, 1), (210, 0), (215, 0), (220, 1), (225, 1), (230, 1), (235, 1), (240, 0), (245, 0), (250, 0), (255, 0), (260, 0), (265, 0), (270, 0), (275, 0), (280, 0), (285, 0), (290, 1), (295, 0), (300, 1), (305, 1), (310, 1), (315, 1), (320, 0), (325, 0), (330, 0), (335, 0), (340, 1), (345, 1), (350, 1), (355, 1), (360, 1), (365, 1), (370, 1), (375, 1), (380, 1), (385, 0), (390, 0), (395, 0), (400, 0), (405, 1), (410, 1), (415, 1), (420, 1), (425, 0), (430, 0), (435, 0), (440, 0), (445, 0), (450, 0), (455, 1), (460, 1), (465, 1), (470, 1), (475, 1), (480, 1), (485, 1), (490, 0), (495, 0), (500, 0), (505, 0), (510, 1), (515, 0), (520, 0), (525, 0), (530, 0), (535, 1), (540, 0), (545, 1), (550, 0), (555, 0), (560, 0), (565, 0), (570, 0), (575, 0), (580, 1), (585, 1), (590, 0), (595, 0), (600, 0), (605, 0), (610, 0), (615, 0), (620, 0), (625, 1), (630, 1), (635, 1), (640, 1), (645, 0), (650, 0), (655, 0), (660, 0), (665, 0), (670, 0), (675, 0), (680, 0), (685, 0), (690, 0), (695, 1), (700, 0), (705, 0), (710, 0), (715, 0), (720, 0), (725, 0), (730, 0), (735, 0), (740, 0), (745, 1), (750, 1), (755, 1), (760, 1), (765, 0), (770, 0), (775, 0), (780, 0), (785, 0), (790, 0), (795, 0), (800, 0), (805, 0), (810, 1), (815, 1), (820, 1), (825, 1), (830, 1), (835, 0), (840, 0), (845, 0), (850, 0), (855, 0), (860, 0), (865, 0), (870, 0), (875, 0), (880, 0), (885, 0), (890, 1), (895, 1), (900, 1), (905, 0), (910, 1), (915, 1), (920, 0), (925, 0), (930, 1), (935, 0), (940, 1), (945, 1), (950, 1), (955, 1), (960, 0), (965, 1), (970, 1), (975, 1), (980, 1), (985, 1), (990, 0), (995, 1), (1000, 0), (1005, 0), (1010, 0), (1015, 0), (1020, 0), (1025, 0)]
Vdin0_1  din0_1  0 PWL (0n 0.0v 4.745n 0.0v 4.755n 1.1v 9.745n 1.1v 9.755n 1.1v 14.745n 1.1v 14.755n 1.1v 19.745n 1.1v 19.755n 1.1v 24.745n 1.1v 24.755n 1.1v 29.745n 1.1v 29.755n 1.1v 34.745n 1.1v 34.755n 1.1v 39.745n 1.1v 39.755n 1.1v 44.745n 1.1v 44.755n 1.1v 49.745n 1.1v 49.755n 0.0v 54.745n 0.0v 54.755n 0.0v 59.745n 0.0v 59.755n 0.0v 64.745n 0.0v 64.755n 0.0v 69.745n 0.0v 69.755n 1.1v 74.745n 1.1v 74.755n 1.1v 79.745n 1.1v 79.755n 1.1v 84.745n 1.1v 84.755n 1.1v 89.745n 1.1v 89.755n 1.1v 94.745n 1.1v 94.755n 1.1v 99.745n 1.1v 99.755n 0.0v 104.745n 0.0v 104.755n 0.0v 109.745n 0.0v 109.755n 0.0v 114.745n 0.0v 114.755n 1.1v 119.745n 1.1v 119.755n 1.1v 124.745n 1.1v 124.755n 1.1v 129.745n 1.1v 129.755n 1.1v 134.745n 1.1v 134.755n 1.1v 139.745n 1.1v 139.755n 1.1v 144.745n 1.1v 144.755n 0.0v 149.745n 0.0v 149.755n 0.0v 154.745n 0.0v 154.755n 0.0v 159.745n 0.0v 159.755n 0.0v 164.745n 0.0v 164.755n 0.0v 169.745n 0.0v 169.755n 0.0v 174.745n 0.0v 174.755n 0.0v 179.745n 0.0v 179.755n 0.0v 184.745n 0.0v 184.755n 0.0v 189.745n 0.0v 189.755n 0.0v 194.745n 0.0v 194.755n 0.0v 199.745n 0.0v 199.755n 0.0v 204.745n 0.0v 204.755n 1.1v 209.745n 1.1v 209.755n 0.0v 214.745n 0.0v 214.755n 0.0v 219.745n 0.0v 219.755n 1.1v 224.745n 1.1v 224.755n 1.1v 229.745n 1.1v 229.755n 1.1v 234.745n 1.1v 234.755n 1.1v 239.745n 1.1v 239.755n 0.0v 244.745n 0.0v 244.755n 0.0v 249.745n 0.0v 249.755n 0.0v 254.745n 0.0v 254.755n 0.0v 259.745n 0.0v 259.755n 0.0v 264.745n 0.0v 264.755n 0.0v 269.745n 0.0v 269.755n 0.0v 274.745n 0.0v 274.755n 0.0v 279.745n 0.0v 279.755n 0.0v 284.745n 0.0v 284.755n 0.0v 289.745n 0.0v 289.755n 1.1v 294.745n 1.1v 294.755n 0.0v 299.745n 0.0v 299.755n 1.1v 304.745n 1.1v 304.755n 1.1v 309.745n 1.1v 309.755n 1.1v 314.745n 1.1v 314.755n 1.1v 319.745n 1.1v 319.755n 0.0v 324.745n 0.0v 324.755n 0.0v 329.745n 0.0v 329.755n 0.0v 334.745n 0.0v 334.755n 0.0v 339.745n 0.0v 339.755n 1.1v 344.745n 1.1v 344.755n 1.1v 349.745n 1.1v 349.755n 1.1v 354.745n 1.1v 354.755n 1.1v 359.745n 1.1v 359.755n 1.1v 364.745n 1.1v 364.755n 1.1v 369.745n 1.1v 369.755n 1.1v 374.745n 1.1v 374.755n 1.1v 379.745n 1.1v 379.755n 1.1v 384.745n 1.1v 384.755n 0.0v 389.745n 0.0v 389.755n 0.0v 394.745n 0.0v 394.755n 0.0v 399.745n 0.0v 399.755n 0.0v 404.745n 0.0v 404.755n 1.1v 409.745n 1.1v 409.755n 1.1v 414.745n 1.1v 414.755n 1.1v 419.745n 1.1v 419.755n 1.1v 424.745n 1.1v 424.755n 0.0v 429.745n 0.0v 429.755n 0.0v 434.745n 0.0v 434.755n 0.0v 439.745n 0.0v 439.755n 0.0v 444.745n 0.0v 444.755n 0.0v 449.745n 0.0v 449.755n 0.0v 454.745n 0.0v 454.755n 1.1v 459.745n 1.1v 459.755n 1.1v 464.745n 1.1v 464.755n 1.1v 469.745n 1.1v 469.755n 1.1v 474.745n 1.1v 474.755n 1.1v 479.745n 1.1v 479.755n 1.1v 484.745n 1.1v 484.755n 1.1v 489.745n 1.1v 489.755n 0.0v 494.745n 0.0v 494.755n 0.0v 499.745n 0.0v 499.755n 0.0v 504.745n 0.0v 504.755n 0.0v 509.745n 0.0v 509.755n 1.1v 514.745n 1.1v 514.755n 0.0v 519.745n 0.0v 519.755n 0.0v 524.745n 0.0v 524.755n 0.0v 529.745n 0.0v 529.755n 0.0v 534.745n 0.0v 534.755n 1.1v 539.745n 1.1v 539.755n 0.0v 544.745n 0.0v 544.755n 1.1v 549.745n 1.1v 549.755n 0.0v 554.745n 0.0v 554.755n 0.0v 559.745n 0.0v 559.755n 0.0v 564.745n 0.0v 564.755n 0.0v 569.745n 0.0v 569.755n 0.0v 574.745n 0.0v 574.755n 0.0v 579.745n 0.0v 579.755n 1.1v 584.745n 1.1v 584.755n 1.1v 589.745n 1.1v 589.755n 0.0v 594.745n 0.0v 594.755n 0.0v 599.745n 0.0v 599.755n 0.0v 604.745n 0.0v 604.755n 0.0v 609.745n 0.0v 609.755n 0.0v 614.745n 0.0v 614.755n 0.0v 619.745n 0.0v 619.755n 0.0v 624.745n 0.0v 624.755n 1.1v 629.745n 1.1v 629.755n 1.1v 634.745n 1.1v 634.755n 1.1v 639.745n 1.1v 639.755n 1.1v 644.745n 1.1v 644.755n 0.0v 649.745n 0.0v 649.755n 0.0v 654.745n 0.0v 654.755n 0.0v 659.745n 0.0v 659.755n 0.0v 664.745n 0.0v 664.755n 0.0v 669.745n 0.0v 669.755n 0.0v 674.745n 0.0v 674.755n 0.0v 679.745n 0.0v 679.755n 0.0v 684.745n 0.0v 684.755n 0.0v 689.745n 0.0v 689.755n 0.0v 694.745n 0.0v 694.755n 1.1v 699.745n 1.1v 699.755n 0.0v 704.745n 0.0v 704.755n 0.0v 709.745n 0.0v 709.755n 0.0v 714.745n 0.0v 714.755n 0.0v 719.745n 0.0v 719.755n 0.0v 724.745n 0.0v 724.755n 0.0v 729.745n 0.0v 729.755n 0.0v 734.745n 0.0v 734.755n 0.0v 739.745n 0.0v 739.755n 0.0v 744.745n 0.0v 744.755n 1.1v 749.745n 1.1v 749.755n 1.1v 754.745n 1.1v 754.755n 1.1v 759.745n 1.1v 759.755n 1.1v 764.745n 1.1v 764.755n 0.0v 769.745n 0.0v 769.755n 0.0v 774.745n 0.0v 774.755n 0.0v 779.745n 0.0v 779.755n 0.0v 784.745n 0.0v 784.755n 0.0v 789.745n 0.0v 789.755n 0.0v 794.745n 0.0v 794.755n 0.0v 799.745n 0.0v 799.755n 0.0v 804.745n 0.0v 804.755n 0.0v 809.745n 0.0v 809.755n 1.1v 814.745n 1.1v 814.755n 1.1v 819.745n 1.1v 819.755n 1.1v 824.745n 1.1v 824.755n 1.1v 829.745n 1.1v 829.755n 1.1v 834.745n 1.1v 834.755n 0.0v 839.745n 0.0v 839.755n 0.0v 844.745n 0.0v 844.755n 0.0v 849.745n 0.0v 849.755n 0.0v 854.745n 0.0v 854.755n 0.0v 859.745n 0.0v 859.755n 0.0v 864.745n 0.0v 864.755n 0.0v 869.745n 0.0v 869.755n 0.0v 874.745n 0.0v 874.755n 0.0v 879.745n 0.0v 879.755n 0.0v 884.745n 0.0v 884.755n 0.0v 889.745n 0.0v 889.755n 1.1v 894.745n 1.1v 894.755n 1.1v 899.745n 1.1v 899.755n 1.1v 904.745n 1.1v 904.755n 0.0v 909.745n 0.0v 909.755n 1.1v 914.745n 1.1v 914.755n 1.1v 919.745n 1.1v 919.755n 0.0v 924.745n 0.0v 924.755n 0.0v 929.745n 0.0v 929.755n 1.1v 934.745n 1.1v 934.755n 0.0v 939.745n 0.0v 939.755n 1.1v 944.745n 1.1v 944.755n 1.1v 949.745n 1.1v 949.755n 1.1v 954.745n 1.1v 954.755n 1.1v 959.745n 1.1v 959.755n 0.0v 964.745n 0.0v 964.755n 1.1v 969.745n 1.1v 969.755n 1.1v 974.745n 1.1v 974.755n 1.1v 979.745n 1.1v 979.755n 1.1v 984.745n 1.1v 984.755n 1.1v 989.745n 1.1v 989.755n 0.0v 994.745n 0.0v 994.755n 1.1v 999.745n 1.1v 999.755n 0.0v 1004.745n 0.0v 1004.755n 0.0v 1009.745n 0.0v 1009.755n 0.0v 1014.745n 0.0v 1014.755n 0.0v 1019.745n 0.0v 1019.755n 0.0v 1024.745n 0.0v 1024.755n 0.0v )
* (time, data): [(0, 0), (5, 0), (10, 0), (15, 0), (20, 0), (25, 0), (30, 0), (35, 0), (40, 0), (45, 0), (50, 1), (55, 1), (60, 1), (65, 1), (70, 0), (75, 0), (80, 0), (85, 0), (90, 0), (95, 0), (100, 0), (105, 0), (110, 0), (115, 1), (120, 1), (125, 1), (130, 1), (135, 1), (140, 0), (145, 1), (150, 1), (155, 1), (160, 1), (165, 1), (170, 1), (175, 1), (180, 0), (185, 0), (190, 0), (195, 0), (200, 0), (205, 1), (210, 1), (215, 1), (220, 1), (225, 1), (230, 1), (235, 1), (240, 0), (245, 0), (250, 0), (255, 0), (260, 0), (265, 0), (270, 0), (275, 0), (280, 0), (285, 0), (290, 0), (295, 0), (300, 1), (305, 1), (310, 1), (315, 0), (320, 1), (325, 1), (330, 0), (335, 1), (340, 0), (345, 0), (350, 0), (355, 0), (360, 0), (365, 0), (370, 0), (375, 0), (380, 0), (385, 0), (390, 0), (395, 0), (400, 0), (405, 1), (410, 0), (415, 0), (420, 0), (425, 0), (430, 0), (435, 1), (440, 1), (445, 0), (450, 1), (455, 0), (460, 0), (465, 0), (470, 0), (475, 0), (480, 0), (485, 0), (490, 1), (495, 1), (500, 1), (505, 1), (510, 0), (515, 0), (520, 0), (525, 0), (530, 0), (535, 0), (540, 1), (545, 0), (550, 0), (555, 0), (560, 0), (565, 0), (570, 1), (575, 0), (580, 1), (585, 1), (590, 1), (595, 1), (600, 1), (605, 0), (610, 0), (615, 0), (620, 0), (625, 1), (630, 1), (635, 1), (640, 1), (645, 0), (650, 0), (655, 0), (660, 0), (665, 0), (670, 0), (675, 0), (680, 0), (685, 0), (690, 0), (695, 1), (700, 1), (705, 1), (710, 0), (715, 0), (720, 0), (725, 0), (730, 0), (735, 0), (740, 0), (745, 1), (750, 1), (755, 0), (760, 0), (765, 0), (770, 0), (775, 0), (780, 0), (785, 1), (790, 1), (795, 1), (800, 1), (805, 1), (810, 0), (815, 0), (820, 1), (825, 1), (830, 1), (835, 0), (840, 0), (845, 0), (850, 0), (855, 0), (860, 1), (865, 1), (870, 1), (875, 1), (880, 1), (885, 1), (890, 0), (895, 0), (900, 1), (905, 0), (910, 0), (915, 0), (920, 0), (925, 0), (930, 1), (935, 0), (940, 0), (945, 0), (950, 1), (955, 0), (960, 0), (965, 0), (970, 1), (975, 1), (980, 1), (985, 1), (990, 0), (995, 1), (1000, 1), (1005, 1), (1010, 0), (1015, 0), (1020, 0), (1025, 0)]
Vdin0_2  din0_2  0 PWL (0n 0.0v 4.745n 0.0v 4.755n 0.0v 9.745n 0.0v 9.755n 0.0v 14.745n 0.0v 14.755n 0.0v 19.745n 0.0v 19.755n 0.0v 24.745n 0.0v 24.755n 0.0v 29.745n 0.0v 29.755n 0.0v 34.745n 0.0v 34.755n 0.0v 39.745n 0.0v 39.755n 0.0v 44.745n 0.0v 44.755n 0.0v 49.745n 0.0v 49.755n 1.1v 54.745n 1.1v 54.755n 1.1v 59.745n 1.1v 59.755n 1.1v 64.745n 1.1v 64.755n 1.1v 69.745n 1.1v 69.755n 0.0v 74.745n 0.0v 74.755n 0.0v 79.745n 0.0v 79.755n 0.0v 84.745n 0.0v 84.755n 0.0v 89.745n 0.0v 89.755n 0.0v 94.745n 0.0v 94.755n 0.0v 99.745n 0.0v 99.755n 0.0v 104.745n 0.0v 104.755n 0.0v 109.745n 0.0v 109.755n 0.0v 114.745n 0.0v 114.755n 1.1v 119.745n 1.1v 119.755n 1.1v 124.745n 1.1v 124.755n 1.1v 129.745n 1.1v 129.755n 1.1v 134.745n 1.1v 134.755n 1.1v 139.745n 1.1v 139.755n 0.0v 144.745n 0.0v 144.755n 1.1v 149.745n 1.1v 149.755n 1.1v 154.745n 1.1v 154.755n 1.1v 159.745n 1.1v 159.755n 1.1v 164.745n 1.1v 164.755n 1.1v 169.745n 1.1v 169.755n 1.1v 174.745n 1.1v 174.755n 1.1v 179.745n 1.1v 179.755n 0.0v 184.745n 0.0v 184.755n 0.0v 189.745n 0.0v 189.755n 0.0v 194.745n 0.0v 194.755n 0.0v 199.745n 0.0v 199.755n 0.0v 204.745n 0.0v 204.755n 1.1v 209.745n 1.1v 209.755n 1.1v 214.745n 1.1v 214.755n 1.1v 219.745n 1.1v 219.755n 1.1v 224.745n 1.1v 224.755n 1.1v 229.745n 1.1v 229.755n 1.1v 234.745n 1.1v 234.755n 1.1v 239.745n 1.1v 239.755n 0.0v 244.745n 0.0v 244.755n 0.0v 249.745n 0.0v 249.755n 0.0v 254.745n 0.0v 254.755n 0.0v 259.745n 0.0v 259.755n 0.0v 264.745n 0.0v 264.755n 0.0v 269.745n 0.0v 269.755n 0.0v 274.745n 0.0v 274.755n 0.0v 279.745n 0.0v 279.755n 0.0v 284.745n 0.0v 284.755n 0.0v 289.745n 0.0v 289.755n 0.0v 294.745n 0.0v 294.755n 0.0v 299.745n 0.0v 299.755n 1.1v 304.745n 1.1v 304.755n 1.1v 309.745n 1.1v 309.755n 1.1v 314.745n 1.1v 314.755n 0.0v 319.745n 0.0v 319.755n 1.1v 324.745n 1.1v 324.755n 1.1v 329.745n 1.1v 329.755n 0.0v 334.745n 0.0v 334.755n 1.1v 339.745n 1.1v 339.755n 0.0v 344.745n 0.0v 344.755n 0.0v 349.745n 0.0v 349.755n 0.0v 354.745n 0.0v 354.755n 0.0v 359.745n 0.0v 359.755n 0.0v 364.745n 0.0v 364.755n 0.0v 369.745n 0.0v 369.755n 0.0v 374.745n 0.0v 374.755n 0.0v 379.745n 0.0v 379.755n 0.0v 384.745n 0.0v 384.755n 0.0v 389.745n 0.0v 389.755n 0.0v 394.745n 0.0v 394.755n 0.0v 399.745n 0.0v 399.755n 0.0v 404.745n 0.0v 404.755n 1.1v 409.745n 1.1v 409.755n 0.0v 414.745n 0.0v 414.755n 0.0v 419.745n 0.0v 419.755n 0.0v 424.745n 0.0v 424.755n 0.0v 429.745n 0.0v 429.755n 0.0v 434.745n 0.0v 434.755n 1.1v 439.745n 1.1v 439.755n 1.1v 444.745n 1.1v 444.755n 0.0v 449.745n 0.0v 449.755n 1.1v 454.745n 1.1v 454.755n 0.0v 459.745n 0.0v 459.755n 0.0v 464.745n 0.0v 464.755n 0.0v 469.745n 0.0v 469.755n 0.0v 474.745n 0.0v 474.755n 0.0v 479.745n 0.0v 479.755n 0.0v 484.745n 0.0v 484.755n 0.0v 489.745n 0.0v 489.755n 1.1v 494.745n 1.1v 494.755n 1.1v 499.745n 1.1v 499.755n 1.1v 504.745n 1.1v 504.755n 1.1v 509.745n 1.1v 509.755n 0.0v 514.745n 0.0v 514.755n 0.0v 519.745n 0.0v 519.755n 0.0v 524.745n 0.0v 524.755n 0.0v 529.745n 0.0v 529.755n 0.0v 534.745n 0.0v 534.755n 0.0v 539.745n 0.0v 539.755n 1.1v 544.745n 1.1v 544.755n 0.0v 549.745n 0.0v 549.755n 0.0v 554.745n 0.0v 554.755n 0.0v 559.745n 0.0v 559.755n 0.0v 564.745n 0.0v 564.755n 0.0v 569.745n 0.0v 569.755n 1.1v 574.745n 1.1v 574.755n 0.0v 579.745n 0.0v 579.755n 1.1v 584.745n 1.1v 584.755n 1.1v 589.745n 1.1v 589.755n 1.1v 594.745n 1.1v 594.755n 1.1v 599.745n 1.1v 599.755n 1.1v 604.745n 1.1v 604.755n 0.0v 609.745n 0.0v 609.755n 0.0v 614.745n 0.0v 614.755n 0.0v 619.745n 0.0v 619.755n 0.0v 624.745n 0.0v 624.755n 1.1v 629.745n 1.1v 629.755n 1.1v 634.745n 1.1v 634.755n 1.1v 639.745n 1.1v 639.755n 1.1v 644.745n 1.1v 644.755n 0.0v 649.745n 0.0v 649.755n 0.0v 654.745n 0.0v 654.755n 0.0v 659.745n 0.0v 659.755n 0.0v 664.745n 0.0v 664.755n 0.0v 669.745n 0.0v 669.755n 0.0v 674.745n 0.0v 674.755n 0.0v 679.745n 0.0v 679.755n 0.0v 684.745n 0.0v 684.755n 0.0v 689.745n 0.0v 689.755n 0.0v 694.745n 0.0v 694.755n 1.1v 699.745n 1.1v 699.755n 1.1v 704.745n 1.1v 704.755n 1.1v 709.745n 1.1v 709.755n 0.0v 714.745n 0.0v 714.755n 0.0v 719.745n 0.0v 719.755n 0.0v 724.745n 0.0v 724.755n 0.0v 729.745n 0.0v 729.755n 0.0v 734.745n 0.0v 734.755n 0.0v 739.745n 0.0v 739.755n 0.0v 744.745n 0.0v 744.755n 1.1v 749.745n 1.1v 749.755n 1.1v 754.745n 1.1v 754.755n 0.0v 759.745n 0.0v 759.755n 0.0v 764.745n 0.0v 764.755n 0.0v 769.745n 0.0v 769.755n 0.0v 774.745n 0.0v 774.755n 0.0v 779.745n 0.0v 779.755n 0.0v 784.745n 0.0v 784.755n 1.1v 789.745n 1.1v 789.755n 1.1v 794.745n 1.1v 794.755n 1.1v 799.745n 1.1v 799.755n 1.1v 804.745n 1.1v 804.755n 1.1v 809.745n 1.1v 809.755n 0.0v 814.745n 0.0v 814.755n 0.0v 819.745n 0.0v 819.755n 1.1v 824.745n 1.1v 824.755n 1.1v 829.745n 1.1v 829.755n 1.1v 834.745n 1.1v 834.755n 0.0v 839.745n 0.0v 839.755n 0.0v 844.745n 0.0v 844.755n 0.0v 849.745n 0.0v 849.755n 0.0v 854.745n 0.0v 854.755n 0.0v 859.745n 0.0v 859.755n 1.1v 864.745n 1.1v 864.755n 1.1v 869.745n 1.1v 869.755n 1.1v 874.745n 1.1v 874.755n 1.1v 879.745n 1.1v 879.755n 1.1v 884.745n 1.1v 884.755n 1.1v 889.745n 1.1v 889.755n 0.0v 894.745n 0.0v 894.755n 0.0v 899.745n 0.0v 899.755n 1.1v 904.745n 1.1v 904.755n 0.0v 909.745n 0.0v 909.755n 0.0v 914.745n 0.0v 914.755n 0.0v 919.745n 0.0v 919.755n 0.0v 924.745n 0.0v 924.755n 0.0v 929.745n 0.0v 929.755n 1.1v 934.745n 1.1v 934.755n 0.0v 939.745n 0.0v 939.755n 0.0v 944.745n 0.0v 944.755n 0.0v 949.745n 0.0v 949.755n 1.1v 954.745n 1.1v 954.755n 0.0v 959.745n 0.0v 959.755n 0.0v 964.745n 0.0v 964.755n 0.0v 969.745n 0.0v 969.755n 1.1v 974.745n 1.1v 974.755n 1.1v 979.745n 1.1v 979.755n 1.1v 984.745n 1.1v 984.755n 1.1v 989.745n 1.1v 989.755n 0.0v 994.745n 0.0v 994.755n 1.1v 999.745n 1.1v 999.755n 1.1v 1004.745n 1.1v 1004.755n 1.1v 1009.745n 1.1v 1009.755n 0.0v 1014.745n 0.0v 1014.755n 0.0v 1019.745n 0.0v 1019.755n 0.0v 1024.745n 0.0v 1024.755n 0.0v )
* (time, data): [(0, 0), (5, 1), (10, 0), (15, 0), (20, 0), (25, 0), (30, 0), (35, 0), (40, 0), (45, 0), (50, 0), (55, 0), (60, 0), (65, 0), (70, 0), (75, 0), (80, 0), (85, 0), (90, 0), (95, 0), (100, 1), (105, 1), (110, 1), (115, 0), (120, 0), (125, 0), (130, 0), (135, 0), (140, 0), (145, 1), (150, 1), (155, 1), (160, 1), (165, 1), (170, 1), (175, 1), (180, 0), (185, 0), (190, 0), (195, 0), (200, 0), (205, 0), (210, 1), (215, 1), (220, 0), (225, 0), (230, 0), (235, 0), (240, 1), (245, 1), (250, 1), (255, 1), (260, 1), (265, 1), (270, 1), (275, 1), (280, 1), (285, 1), (290, 0), (295, 1), (300, 0), (305, 0), (310, 0), (315, 0), (320, 0), (325, 0), (330, 1), (335, 0), (340, 0), (345, 0), (350, 0), (355, 0), (360, 0), (365, 0), (370, 0), (375, 0), (380, 0), (385, 1), (390, 1), (395, 0), (400, 0), (405, 0), (410, 1), (415, 1), (420, 1), (425, 0), (430, 0), (435, 1), (440, 1), (445, 1), (450, 1), (455, 1), (460, 1), (465, 1), (470, 1), (475, 1), (480, 1), (485, 1), (490, 0), (495, 0), (500, 0), (505, 0), (510, 0), (515, 0), (520, 0), (525, 0), (530, 0), (535, 1), (540, 1), (545, 0), (550, 0), (555, 0), (560, 0), (565, 0), (570, 0), (575, 1), (580, 1), (585, 1), (590, 0), (595, 1), (600, 1), (605, 1), (610, 1), (615, 1), (620, 1), (625, 0), (630, 0), (635, 0), (640, 0), (645, 0), (650, 0), (655, 0), (660, 0), (665, 0), (670, 0), (675, 0), (680, 0), (685, 0), (690, 1), (695, 1), (700, 1), (705, 1), (710, 1), (715, 1), (720, 1), (725, 1), (730, 1), (735, 0), (740, 0), (745, 1), (750, 1), (755, 1), (760, 1), (765, 0), (770, 0), (775, 0), (780, 0), (785, 0), (790, 0), (795, 0), (800, 0), (805, 0), (810, 1), (815, 1), (820, 1), (825, 1), (830, 1), (835, 1), (840, 1), (845, 1), (850, 1), (855, 1), (860, 1), (865, 1), (870, 1), (875, 1), (880, 1), (885, 1), (890, 0), (895, 0), (900, 1), (905, 0), (910, 1), (915, 1), (920, 0), (925, 0), (930, 1), (935, 1), (940, 0), (945, 0), (950, 1), (955, 1), (960, 1), (965, 0), (970, 1), (975, 1), (980, 1), (985, 0), (990, 1), (995, 0), (1000, 0), (1005, 0), (1010, 0), (1015, 0), (1020, 0), (1025, 0)]
Vdin0_3  din0_3  0 PWL (0n 0.0v 4.745n 0.0v 4.755n 1.1v 9.745n 1.1v 9.755n 0.0v 14.745n 0.0v 14.755n 0.0v 19.745n 0.0v 19.755n 0.0v 24.745n 0.0v 24.755n 0.0v 29.745n 0.0v 29.755n 0.0v 34.745n 0.0v 34.755n 0.0v 39.745n 0.0v 39.755n 0.0v 44.745n 0.0v 44.755n 0.0v 49.745n 0.0v 49.755n 0.0v 54.745n 0.0v 54.755n 0.0v 59.745n 0.0v 59.755n 0.0v 64.745n 0.0v 64.755n 0.0v 69.745n 0.0v 69.755n 0.0v 74.745n 0.0v 74.755n 0.0v 79.745n 0.0v 79.755n 0.0v 84.745n 0.0v 84.755n 0.0v 89.745n 0.0v 89.755n 0.0v 94.745n 0.0v 94.755n 0.0v 99.745n 0.0v 99.755n 1.1v 104.745n 1.1v 104.755n 1.1v 109.745n 1.1v 109.755n 1.1v 114.745n 1.1v 114.755n 0.0v 119.745n 0.0v 119.755n 0.0v 124.745n 0.0v 124.755n 0.0v 129.745n 0.0v 129.755n 0.0v 134.745n 0.0v 134.755n 0.0v 139.745n 0.0v 139.755n 0.0v 144.745n 0.0v 144.755n 1.1v 149.745n 1.1v 149.755n 1.1v 154.745n 1.1v 154.755n 1.1v 159.745n 1.1v 159.755n 1.1v 164.745n 1.1v 164.755n 1.1v 169.745n 1.1v 169.755n 1.1v 174.745n 1.1v 174.755n 1.1v 179.745n 1.1v 179.755n 0.0v 184.745n 0.0v 184.755n 0.0v 189.745n 0.0v 189.755n 0.0v 194.745n 0.0v 194.755n 0.0v 199.745n 0.0v 199.755n 0.0v 204.745n 0.0v 204.755n 0.0v 209.745n 0.0v 209.755n 1.1v 214.745n 1.1v 214.755n 1.1v 219.745n 1.1v 219.755n 0.0v 224.745n 0.0v 224.755n 0.0v 229.745n 0.0v 229.755n 0.0v 234.745n 0.0v 234.755n 0.0v 239.745n 0.0v 239.755n 1.1v 244.745n 1.1v 244.755n 1.1v 249.745n 1.1v 249.755n 1.1v 254.745n 1.1v 254.755n 1.1v 259.745n 1.1v 259.755n 1.1v 264.745n 1.1v 264.755n 1.1v 269.745n 1.1v 269.755n 1.1v 274.745n 1.1v 274.755n 1.1v 279.745n 1.1v 279.755n 1.1v 284.745n 1.1v 284.755n 1.1v 289.745n 1.1v 289.755n 0.0v 294.745n 0.0v 294.755n 1.1v 299.745n 1.1v 299.755n 0.0v 304.745n 0.0v 304.755n 0.0v 309.745n 0.0v 309.755n 0.0v 314.745n 0.0v 314.755n 0.0v 319.745n 0.0v 319.755n 0.0v 324.745n 0.0v 324.755n 0.0v 329.745n 0.0v 329.755n 1.1v 334.745n 1.1v 334.755n 0.0v 339.745n 0.0v 339.755n 0.0v 344.745n 0.0v 344.755n 0.0v 349.745n 0.0v 349.755n 0.0v 354.745n 0.0v 354.755n 0.0v 359.745n 0.0v 359.755n 0.0v 364.745n 0.0v 364.755n 0.0v 369.745n 0.0v 369.755n 0.0v 374.745n 0.0v 374.755n 0.0v 379.745n 0.0v 379.755n 0.0v 384.745n 0.0v 384.755n 1.1v 389.745n 1.1v 389.755n 1.1v 394.745n 1.1v 394.755n 0.0v 399.745n 0.0v 399.755n 0.0v 404.745n 0.0v 404.755n 0.0v 409.745n 0.0v 409.755n 1.1v 414.745n 1.1v 414.755n 1.1v 419.745n 1.1v 419.755n 1.1v 424.745n 1.1v 424.755n 0.0v 429.745n 0.0v 429.755n 0.0v 434.745n 0.0v 434.755n 1.1v 439.745n 1.1v 439.755n 1.1v 444.745n 1.1v 444.755n 1.1v 449.745n 1.1v 449.755n 1.1v 454.745n 1.1v 454.755n 1.1v 459.745n 1.1v 459.755n 1.1v 464.745n 1.1v 464.755n 1.1v 469.745n 1.1v 469.755n 1.1v 474.745n 1.1v 474.755n 1.1v 479.745n 1.1v 479.755n 1.1v 484.745n 1.1v 484.755n 1.1v 489.745n 1.1v 489.755n 0.0v 494.745n 0.0v 494.755n 0.0v 499.745n 0.0v 499.755n 0.0v 504.745n 0.0v 504.755n 0.0v 509.745n 0.0v 509.755n 0.0v 514.745n 0.0v 514.755n 0.0v 519.745n 0.0v 519.755n 0.0v 524.745n 0.0v 524.755n 0.0v 529.745n 0.0v 529.755n 0.0v 534.745n 0.0v 534.755n 1.1v 539.745n 1.1v 539.755n 1.1v 544.745n 1.1v 544.755n 0.0v 549.745n 0.0v 549.755n 0.0v 554.745n 0.0v 554.755n 0.0v 559.745n 0.0v 559.755n 0.0v 564.745n 0.0v 564.755n 0.0v 569.745n 0.0v 569.755n 0.0v 574.745n 0.0v 574.755n 1.1v 579.745n 1.1v 579.755n 1.1v 584.745n 1.1v 584.755n 1.1v 589.745n 1.1v 589.755n 0.0v 594.745n 0.0v 594.755n 1.1v 599.745n 1.1v 599.755n 1.1v 604.745n 1.1v 604.755n 1.1v 609.745n 1.1v 609.755n 1.1v 614.745n 1.1v 614.755n 1.1v 619.745n 1.1v 619.755n 1.1v 624.745n 1.1v 624.755n 0.0v 629.745n 0.0v 629.755n 0.0v 634.745n 0.0v 634.755n 0.0v 639.745n 0.0v 639.755n 0.0v 644.745n 0.0v 644.755n 0.0v 649.745n 0.0v 649.755n 0.0v 654.745n 0.0v 654.755n 0.0v 659.745n 0.0v 659.755n 0.0v 664.745n 0.0v 664.755n 0.0v 669.745n 0.0v 669.755n 0.0v 674.745n 0.0v 674.755n 0.0v 679.745n 0.0v 679.755n 0.0v 684.745n 0.0v 684.755n 0.0v 689.745n 0.0v 689.755n 1.1v 694.745n 1.1v 694.755n 1.1v 699.745n 1.1v 699.755n 1.1v 704.745n 1.1v 704.755n 1.1v 709.745n 1.1v 709.755n 1.1v 714.745n 1.1v 714.755n 1.1v 719.745n 1.1v 719.755n 1.1v 724.745n 1.1v 724.755n 1.1v 729.745n 1.1v 729.755n 1.1v 734.745n 1.1v 734.755n 0.0v 739.745n 0.0v 739.755n 0.0v 744.745n 0.0v 744.755n 1.1v 749.745n 1.1v 749.755n 1.1v 754.745n 1.1v 754.755n 1.1v 759.745n 1.1v 759.755n 1.1v 764.745n 1.1v 764.755n 0.0v 769.745n 0.0v 769.755n 0.0v 774.745n 0.0v 774.755n 0.0v 779.745n 0.0v 779.755n 0.0v 784.745n 0.0v 784.755n 0.0v 789.745n 0.0v 789.755n 0.0v 794.745n 0.0v 794.755n 0.0v 799.745n 0.0v 799.755n 0.0v 804.745n 0.0v 804.755n 0.0v 809.745n 0.0v 809.755n 1.1v 814.745n 1.1v 814.755n 1.1v 819.745n 1.1v 819.755n 1.1v 824.745n 1.1v 824.755n 1.1v 829.745n 1.1v 829.755n 1.1v 834.745n 1.1v 834.755n 1.1v 839.745n 1.1v 839.755n 1.1v 844.745n 1.1v 844.755n 1.1v 849.745n 1.1v 849.755n 1.1v 854.745n 1.1v 854.755n 1.1v 859.745n 1.1v 859.755n 1.1v 864.745n 1.1v 864.755n 1.1v 869.745n 1.1v 869.755n 1.1v 874.745n 1.1v 874.755n 1.1v 879.745n 1.1v 879.755n 1.1v 884.745n 1.1v 884.755n 1.1v 889.745n 1.1v 889.755n 0.0v 894.745n 0.0v 894.755n 0.0v 899.745n 0.0v 899.755n 1.1v 904.745n 1.1v 904.755n 0.0v 909.745n 0.0v 909.755n 1.1v 914.745n 1.1v 914.755n 1.1v 919.745n 1.1v 919.755n 0.0v 924.745n 0.0v 924.755n 0.0v 929.745n 0.0v 929.755n 1.1v 934.745n 1.1v 934.755n 1.1v 939.745n 1.1v 939.755n 0.0v 944.745n 0.0v 944.755n 0.0v 949.745n 0.0v 949.755n 1.1v 954.745n 1.1v 954.755n 1.1v 959.745n 1.1v 959.755n 1.1v 964.745n 1.1v 964.755n 0.0v 969.745n 0.0v 969.755n 1.1v 974.745n 1.1v 974.755n 1.1v 979.745n 1.1v 979.755n 1.1v 984.745n 1.1v 984.755n 0.0v 989.745n 0.0v 989.755n 1.1v 994.745n 1.1v 994.755n 0.0v 999.745n 0.0v 999.755n 0.0v 1004.745n 0.0v 1004.755n 0.0v 1009.745n 0.0v 1009.755n 0.0v 1014.745n 0.0v 1014.755n 0.0v 1019.745n 0.0v 1019.755n 0.0v 1024.745n 0.0v 1024.755n 0.0v )
* (time, data): [(0, 0), (5, 0), (10, 0), (15, 0), (20, 0), (25, 0), (30, 0), (35, 0), (40, 0), (45, 0), (50, 0), (55, 0), (60, 0), (65, 0), (70, 0), (75, 0), (80, 0), (85, 0), (90, 0), (95, 0), (100, 1), (105, 1), (110, 1), (115, 0), (120, 0), (125, 0), (130, 0), (135, 0), (140, 0), (145, 0), (150, 0), (155, 0), (160, 0), (165, 0), (170, 0), (175, 0), (180, 1), (185, 1), (190, 1), (195, 1), (200, 1), (205, 0), (210, 1), (215, 1), (220, 1), (225, 1), (230, 1), (235, 1), (240, 1), (245, 1), (250, 1), (255, 1), (260, 1), (265, 1), (270, 1), (275, 1), (280, 1), (285, 1), (290, 1), (295, 1), (300, 0), (305, 0), (310, 0), (315, 1), (320, 0), (325, 1), (330, 0), (335, 0), (340, 1), (345, 1), (350, 1), (355, 1), (360, 1), (365, 1), (370, 1), (375, 1), (380, 1), (385, 1), (390, 1), (395, 1), (400, 1), (405, 0), (410, 0), (415, 0), (420, 0), (425, 0), (430, 0), (435, 0), (440, 0), (445, 0), (450, 0), (455, 1), (460, 1), (465, 1), (470, 1), (475, 1), (480, 1), (485, 1), (490, 0), (495, 0), (500, 0), (505, 0), (510, 0), (515, 1), (520, 1), (525, 1), (530, 1), (535, 0), (540, 1), (545, 0), (550, 1), (555, 1), (560, 1), (565, 1), (570, 1), (575, 0), (580, 1), (585, 1), (590, 1), (595, 0), (600, 1), (605, 1), (610, 1), (615, 0), (620, 0), (625, 1), (630, 1), (635, 1), (640, 1), (645, 1), (650, 1), (655, 1), (660, 1), (665, 0), (670, 1), (675, 1), (680, 1), (685, 1), (690, 1), (695, 1), (700, 0), (705, 1), (710, 0), (715, 0), (720, 0), (725, 0), (730, 0), (735, 1), (740, 1), (745, 1), (750, 1), (755, 0), (760, 0), (765, 0), (770, 0), (775, 0), (780, 0), (785, 1), (790, 1), (795, 1), (800, 1), (805, 1), (810, 1), (815, 1), (820, 1), (825, 1), (830, 1), (835, 0), (840, 0), (845, 0), (850, 0), (855, 0), (860, 0), (865, 0), (870, 0), (875, 0), (880, 0), (885, 0), (890, 1), (895, 1), (900, 1), (905, 0), (910, 0), (915, 0), (920, 0), (925, 0), (930, 1), (935, 0), (940, 1), (945, 1), (950, 1), (955, 0), (960, 0), (965, 1), (970, 0), (975, 0), (980, 0), (985, 0), (990, 1), (995, 0), (1000, 0), (1005, 0), (1010, 0), (1015, 0), (1020, 0), (1025, 0)]
Vdin0_4  din0_4  0 PWL (0n 0.0v 4.745n 0.0v 4.755n 0.0v 9.745n 0.0v 9.755n 0.0v 14.745n 0.0v 14.755n 0.0v 19.745n 0.0v 19.755n 0.0v 24.745n 0.0v 24.755n 0.0v 29.745n 0.0v 29.755n 0.0v 34.745n 0.0v 34.755n 0.0v 39.745n 0.0v 39.755n 0.0v 44.745n 0.0v 44.755n 0.0v 49.745n 0.0v 49.755n 0.0v 54.745n 0.0v 54.755n 0.0v 59.745n 0.0v 59.755n 0.0v 64.745n 0.0v 64.755n 0.0v 69.745n 0.0v 69.755n 0.0v 74.745n 0.0v 74.755n 0.0v 79.745n 0.0v 79.755n 0.0v 84.745n 0.0v 84.755n 0.0v 89.745n 0.0v 89.755n 0.0v 94.745n 0.0v 94.755n 0.0v 99.745n 0.0v 99.755n 1.1v 104.745n 1.1v 104.755n 1.1v 109.745n 1.1v 109.755n 1.1v 114.745n 1.1v 114.755n 0.0v 119.745n 0.0v 119.755n 0.0v 124.745n 0.0v 124.755n 0.0v 129.745n 0.0v 129.755n 0.0v 134.745n 0.0v 134.755n 0.0v 139.745n 0.0v 139.755n 0.0v 144.745n 0.0v 144.755n 0.0v 149.745n 0.0v 149.755n 0.0v 154.745n 0.0v 154.755n 0.0v 159.745n 0.0v 159.755n 0.0v 164.745n 0.0v 164.755n 0.0v 169.745n 0.0v 169.755n 0.0v 174.745n 0.0v 174.755n 0.0v 179.745n 0.0v 179.755n 1.1v 184.745n 1.1v 184.755n 1.1v 189.745n 1.1v 189.755n 1.1v 194.745n 1.1v 194.755n 1.1v 199.745n 1.1v 199.755n 1.1v 204.745n 1.1v 204.755n 0.0v 209.745n 0.0v 209.755n 1.1v 214.745n 1.1v 214.755n 1.1v 219.745n 1.1v 219.755n 1.1v 224.745n 1.1v 224.755n 1.1v 229.745n 1.1v 229.755n 1.1v 234.745n 1.1v 234.755n 1.1v 239.745n 1.1v 239.755n 1.1v 244.745n 1.1v 244.755n 1.1v 249.745n 1.1v 249.755n 1.1v 254.745n 1.1v 254.755n 1.1v 259.745n 1.1v 259.755n 1.1v 264.745n 1.1v 264.755n 1.1v 269.745n 1.1v 269.755n 1.1v 274.745n 1.1v 274.755n 1.1v 279.745n 1.1v 279.755n 1.1v 284.745n 1.1v 284.755n 1.1v 289.745n 1.1v 289.755n 1.1v 294.745n 1.1v 294.755n 1.1v 299.745n 1.1v 299.755n 0.0v 304.745n 0.0v 304.755n 0.0v 309.745n 0.0v 309.755n 0.0v 314.745n 0.0v 314.755n 1.1v 319.745n 1.1v 319.755n 0.0v 324.745n 0.0v 324.755n 1.1v 329.745n 1.1v 329.755n 0.0v 334.745n 0.0v 334.755n 0.0v 339.745n 0.0v 339.755n 1.1v 344.745n 1.1v 344.755n 1.1v 349.745n 1.1v 349.755n 1.1v 354.745n 1.1v 354.755n 1.1v 359.745n 1.1v 359.755n 1.1v 364.745n 1.1v 364.755n 1.1v 369.745n 1.1v 369.755n 1.1v 374.745n 1.1v 374.755n 1.1v 379.745n 1.1v 379.755n 1.1v 384.745n 1.1v 384.755n 1.1v 389.745n 1.1v 389.755n 1.1v 394.745n 1.1v 394.755n 1.1v 399.745n 1.1v 399.755n 1.1v 404.745n 1.1v 404.755n 0.0v 409.745n 0.0v 409.755n 0.0v 414.745n 0.0v 414.755n 0.0v 419.745n 0.0v 419.755n 0.0v 424.745n 0.0v 424.755n 0.0v 429.745n 0.0v 429.755n 0.0v 434.745n 0.0v 434.755n 0.0v 439.745n 0.0v 439.755n 0.0v 444.745n 0.0v 444.755n 0.0v 449.745n 0.0v 449.755n 0.0v 454.745n 0.0v 454.755n 1.1v 459.745n 1.1v 459.755n 1.1v 464.745n 1.1v 464.755n 1.1v 469.745n 1.1v 469.755n 1.1v 474.745n 1.1v 474.755n 1.1v 479.745n 1.1v 479.755n 1.1v 484.745n 1.1v 484.755n 1.1v 489.745n 1.1v 489.755n 0.0v 494.745n 0.0v 494.755n 0.0v 499.745n 0.0v 499.755n 0.0v 504.745n 0.0v 504.755n 0.0v 509.745n 0.0v 509.755n 0.0v 514.745n 0.0v 514.755n 1.1v 519.745n 1.1v 519.755n 1.1v 524.745n 1.1v 524.755n 1.1v 529.745n 1.1v 529.755n 1.1v 534.745n 1.1v 534.755n 0.0v 539.745n 0.0v 539.755n 1.1v 544.745n 1.1v 544.755n 0.0v 549.745n 0.0v 549.755n 1.1v 554.745n 1.1v 554.755n 1.1v 559.745n 1.1v 559.755n 1.1v 564.745n 1.1v 564.755n 1.1v 569.745n 1.1v 569.755n 1.1v 574.745n 1.1v 574.755n 0.0v 579.745n 0.0v 579.755n 1.1v 584.745n 1.1v 584.755n 1.1v 589.745n 1.1v 589.755n 1.1v 594.745n 1.1v 594.755n 0.0v 599.745n 0.0v 599.755n 1.1v 604.745n 1.1v 604.755n 1.1v 609.745n 1.1v 609.755n 1.1v 614.745n 1.1v 614.755n 0.0v 619.745n 0.0v 619.755n 0.0v 624.745n 0.0v 624.755n 1.1v 629.745n 1.1v 629.755n 1.1v 634.745n 1.1v 634.755n 1.1v 639.745n 1.1v 639.755n 1.1v 644.745n 1.1v 644.755n 1.1v 649.745n 1.1v 649.755n 1.1v 654.745n 1.1v 654.755n 1.1v 659.745n 1.1v 659.755n 1.1v 664.745n 1.1v 664.755n 0.0v 669.745n 0.0v 669.755n 1.1v 674.745n 1.1v 674.755n 1.1v 679.745n 1.1v 679.755n 1.1v 684.745n 1.1v 684.755n 1.1v 689.745n 1.1v 689.755n 1.1v 694.745n 1.1v 694.755n 1.1v 699.745n 1.1v 699.755n 0.0v 704.745n 0.0v 704.755n 1.1v 709.745n 1.1v 709.755n 0.0v 714.745n 0.0v 714.755n 0.0v 719.745n 0.0v 719.755n 0.0v 724.745n 0.0v 724.755n 0.0v 729.745n 0.0v 729.755n 0.0v 734.745n 0.0v 734.755n 1.1v 739.745n 1.1v 739.755n 1.1v 744.745n 1.1v 744.755n 1.1v 749.745n 1.1v 749.755n 1.1v 754.745n 1.1v 754.755n 0.0v 759.745n 0.0v 759.755n 0.0v 764.745n 0.0v 764.755n 0.0v 769.745n 0.0v 769.755n 0.0v 774.745n 0.0v 774.755n 0.0v 779.745n 0.0v 779.755n 0.0v 784.745n 0.0v 784.755n 1.1v 789.745n 1.1v 789.755n 1.1v 794.745n 1.1v 794.755n 1.1v 799.745n 1.1v 799.755n 1.1v 804.745n 1.1v 804.755n 1.1v 809.745n 1.1v 809.755n 1.1v 814.745n 1.1v 814.755n 1.1v 819.745n 1.1v 819.755n 1.1v 824.745n 1.1v 824.755n 1.1v 829.745n 1.1v 829.755n 1.1v 834.745n 1.1v 834.755n 0.0v 839.745n 0.0v 839.755n 0.0v 844.745n 0.0v 844.755n 0.0v 849.745n 0.0v 849.755n 0.0v 854.745n 0.0v 854.755n 0.0v 859.745n 0.0v 859.755n 0.0v 864.745n 0.0v 864.755n 0.0v 869.745n 0.0v 869.755n 0.0v 874.745n 0.0v 874.755n 0.0v 879.745n 0.0v 879.755n 0.0v 884.745n 0.0v 884.755n 0.0v 889.745n 0.0v 889.755n 1.1v 894.745n 1.1v 894.755n 1.1v 899.745n 1.1v 899.755n 1.1v 904.745n 1.1v 904.755n 0.0v 909.745n 0.0v 909.755n 0.0v 914.745n 0.0v 914.755n 0.0v 919.745n 0.0v 919.755n 0.0v 924.745n 0.0v 924.755n 0.0v 929.745n 0.0v 929.755n 1.1v 934.745n 1.1v 934.755n 0.0v 939.745n 0.0v 939.755n 1.1v 944.745n 1.1v 944.755n 1.1v 949.745n 1.1v 949.755n 1.1v 954.745n 1.1v 954.755n 0.0v 959.745n 0.0v 959.755n 0.0v 964.745n 0.0v 964.755n 1.1v 969.745n 1.1v 969.755n 0.0v 974.745n 0.0v 974.755n 0.0v 979.745n 0.0v 979.755n 0.0v 984.745n 0.0v 984.755n 0.0v 989.745n 0.0v 989.755n 1.1v 994.745n 1.1v 994.755n 0.0v 999.745n 0.0v 999.755n 0.0v 1004.745n 0.0v 1004.755n 0.0v 1009.745n 0.0v 1009.755n 0.0v 1014.745n 0.0v 1014.755n 0.0v 1019.745n 0.0v 1019.755n 0.0v 1024.745n 0.0v 1024.755n 0.0v )
* (time, data): [(0, 0), (5, 0), (10, 1), (15, 0), (20, 0), (25, 0), (30, 0), (35, 0), (40, 0), (45, 0), (50, 1), (55, 1), (60, 1), (65, 1), (70, 1), (75, 1), (80, 1), (85, 1), (90, 1), (95, 1), (100, 1), (105, 1), (110, 1), (115, 0), (120, 0), (125, 0), (130, 0), (135, 0), (140, 0), (145, 1), (150, 1), (155, 1), (160, 1), (165, 1), (170, 1), (175, 1), (180, 1), (185, 1), (190, 1), (195, 1), (200, 1), (205, 1), (210, 1), (215, 1), (220, 0), (225, 0), (230, 0), (235, 0), (240, 1), (245, 1), (250, 1), (255, 1), (260, 1), (265, 1), (270, 1), (275, 1), (280, 1), (285, 1), (290, 1), (295, 0), (300, 1), (305, 1), (310, 1), (315, 0), (320, 0), (325, 1), (330, 0), (335, 1), (340, 1), (345, 1), (350, 1), (355, 1), (360, 1), (365, 1), (370, 1), (375, 1), (380, 1), (385, 1), (390, 1), (395, 0), (400, 0), (405, 1), (410, 1), (415, 1), (420, 1), (425, 0), (430, 0), (435, 1), (440, 1), (445, 0), (450, 1), (455, 1), (460, 1), (465, 1), (470, 1), (475, 1), (480, 1), (485, 1), (490, 1), (495, 1), (500, 1), (505, 1), (510, 1), (515, 1), (520, 1), (525, 1), (530, 1), (535, 1), (540, 1), (545, 0), (550, 0), (555, 0), (560, 0), (565, 0), (570, 0), (575, 0), (580, 1), (585, 0), (590, 1), (595, 1), (600, 0), (605, 1), (610, 1), (615, 0), (620, 0), (625, 1), (630, 1), (635, 1), (640, 1), (645, 0), (650, 0), (655, 0), (660, 0), (665, 0), (670, 1), (675, 1), (680, 1), (685, 1), (690, 1), (695, 1), (700, 0), (705, 1), (710, 0), (715, 0), (720, 0), (725, 0), (730, 0), (735, 1), (740, 1), (745, 1), (750, 1), (755, 1), (760, 1), (765, 1), (770, 1), (775, 1), (780, 1), (785, 0), (790, 0), (795, 0), (800, 0), (805, 0), (810, 1), (815, 0), (820, 1), (825, 1), (830, 1), (835, 1), (840, 1), (845, 1), (850, 1), (855, 1), (860, 1), (865, 1), (870, 1), (875, 1), (880, 1), (885, 1), (890, 0), (895, 0), (900, 1), (905, 1), (910, 1), (915, 1), (920, 0), (925, 0), (930, 0), (935, 1), (940, 0), (945, 0), (950, 1), (955, 1), (960, 0), (965, 1), (970, 0), (975, 0), (980, 0), (985, 1), (990, 0), (995, 1), (1000, 1), (1005, 1), (1010, 0), (1015, 0), (1020, 0), (1025, 0)]
Vdin0_5  din0_5  0 PWL (0n 0.0v 4.745n 0.0v 4.755n 0.0v 9.745n 0.0v 9.755n 1.1v 14.745n 1.1v 14.755n 0.0v 19.745n 0.0v 19.755n 0.0v 24.745n 0.0v 24.755n 0.0v 29.745n 0.0v 29.755n 0.0v 34.745n 0.0v 34.755n 0.0v 39.745n 0.0v 39.755n 0.0v 44.745n 0.0v 44.755n 0.0v 49.745n 0.0v 49.755n 1.1v 54.745n 1.1v 54.755n 1.1v 59.745n 1.1v 59.755n 1.1v 64.745n 1.1v 64.755n 1.1v 69.745n 1.1v 69.755n 1.1v 74.745n 1.1v 74.755n 1.1v 79.745n 1.1v 79.755n 1.1v 84.745n 1.1v 84.755n 1.1v 89.745n 1.1v 89.755n 1.1v 94.745n 1.1v 94.755n 1.1v 99.745n 1.1v 99.755n 1.1v 104.745n 1.1v 104.755n 1.1v 109.745n 1.1v 109.755n 1.1v 114.745n 1.1v 114.755n 0.0v 119.745n 0.0v 119.755n 0.0v 124.745n 0.0v 124.755n 0.0v 129.745n 0.0v 129.755n 0.0v 134.745n 0.0v 134.755n 0.0v 139.745n 0.0v 139.755n 0.0v 144.745n 0.0v 144.755n 1.1v 149.745n 1.1v 149.755n 1.1v 154.745n 1.1v 154.755n 1.1v 159.745n 1.1v 159.755n 1.1v 164.745n 1.1v 164.755n 1.1v 169.745n 1.1v 169.755n 1.1v 174.745n 1.1v 174.755n 1.1v 179.745n 1.1v 179.755n 1.1v 184.745n 1.1v 184.755n 1.1v 189.745n 1.1v 189.755n 1.1v 194.745n 1.1v 194.755n 1.1v 199.745n 1.1v 199.755n 1.1v 204.745n 1.1v 204.755n 1.1v 209.745n 1.1v 209.755n 1.1v 214.745n 1.1v 214.755n 1.1v 219.745n 1.1v 219.755n 0.0v 224.745n 0.0v 224.755n 0.0v 229.745n 0.0v 229.755n 0.0v 234.745n 0.0v 234.755n 0.0v 239.745n 0.0v 239.755n 1.1v 244.745n 1.1v 244.755n 1.1v 249.745n 1.1v 249.755n 1.1v 254.745n 1.1v 254.755n 1.1v 259.745n 1.1v 259.755n 1.1v 264.745n 1.1v 264.755n 1.1v 269.745n 1.1v 269.755n 1.1v 274.745n 1.1v 274.755n 1.1v 279.745n 1.1v 279.755n 1.1v 284.745n 1.1v 284.755n 1.1v 289.745n 1.1v 289.755n 1.1v 294.745n 1.1v 294.755n 0.0v 299.745n 0.0v 299.755n 1.1v 304.745n 1.1v 304.755n 1.1v 309.745n 1.1v 309.755n 1.1v 314.745n 1.1v 314.755n 0.0v 319.745n 0.0v 319.755n 0.0v 324.745n 0.0v 324.755n 1.1v 329.745n 1.1v 329.755n 0.0v 334.745n 0.0v 334.755n 1.1v 339.745n 1.1v 339.755n 1.1v 344.745n 1.1v 344.755n 1.1v 349.745n 1.1v 349.755n 1.1v 354.745n 1.1v 354.755n 1.1v 359.745n 1.1v 359.755n 1.1v 364.745n 1.1v 364.755n 1.1v 369.745n 1.1v 369.755n 1.1v 374.745n 1.1v 374.755n 1.1v 379.745n 1.1v 379.755n 1.1v 384.745n 1.1v 384.755n 1.1v 389.745n 1.1v 389.755n 1.1v 394.745n 1.1v 394.755n 0.0v 399.745n 0.0v 399.755n 0.0v 404.745n 0.0v 404.755n 1.1v 409.745n 1.1v 409.755n 1.1v 414.745n 1.1v 414.755n 1.1v 419.745n 1.1v 419.755n 1.1v 424.745n 1.1v 424.755n 0.0v 429.745n 0.0v 429.755n 0.0v 434.745n 0.0v 434.755n 1.1v 439.745n 1.1v 439.755n 1.1v 444.745n 1.1v 444.755n 0.0v 449.745n 0.0v 449.755n 1.1v 454.745n 1.1v 454.755n 1.1v 459.745n 1.1v 459.755n 1.1v 464.745n 1.1v 464.755n 1.1v 469.745n 1.1v 469.755n 1.1v 474.745n 1.1v 474.755n 1.1v 479.745n 1.1v 479.755n 1.1v 484.745n 1.1v 484.755n 1.1v 489.745n 1.1v 489.755n 1.1v 494.745n 1.1v 494.755n 1.1v 499.745n 1.1v 499.755n 1.1v 504.745n 1.1v 504.755n 1.1v 509.745n 1.1v 509.755n 1.1v 514.745n 1.1v 514.755n 1.1v 519.745n 1.1v 519.755n 1.1v 524.745n 1.1v 524.755n 1.1v 529.745n 1.1v 529.755n 1.1v 534.745n 1.1v 534.755n 1.1v 539.745n 1.1v 539.755n 1.1v 544.745n 1.1v 544.755n 0.0v 549.745n 0.0v 549.755n 0.0v 554.745n 0.0v 554.755n 0.0v 559.745n 0.0v 559.755n 0.0v 564.745n 0.0v 564.755n 0.0v 569.745n 0.0v 569.755n 0.0v 574.745n 0.0v 574.755n 0.0v 579.745n 0.0v 579.755n 1.1v 584.745n 1.1v 584.755n 0.0v 589.745n 0.0v 589.755n 1.1v 594.745n 1.1v 594.755n 1.1v 599.745n 1.1v 599.755n 0.0v 604.745n 0.0v 604.755n 1.1v 609.745n 1.1v 609.755n 1.1v 614.745n 1.1v 614.755n 0.0v 619.745n 0.0v 619.755n 0.0v 624.745n 0.0v 624.755n 1.1v 629.745n 1.1v 629.755n 1.1v 634.745n 1.1v 634.755n 1.1v 639.745n 1.1v 639.755n 1.1v 644.745n 1.1v 644.755n 0.0v 649.745n 0.0v 649.755n 0.0v 654.745n 0.0v 654.755n 0.0v 659.745n 0.0v 659.755n 0.0v 664.745n 0.0v 664.755n 0.0v 669.745n 0.0v 669.755n 1.1v 674.745n 1.1v 674.755n 1.1v 679.745n 1.1v 679.755n 1.1v 684.745n 1.1v 684.755n 1.1v 689.745n 1.1v 689.755n 1.1v 694.745n 1.1v 694.755n 1.1v 699.745n 1.1v 699.755n 0.0v 704.745n 0.0v 704.755n 1.1v 709.745n 1.1v 709.755n 0.0v 714.745n 0.0v 714.755n 0.0v 719.745n 0.0v 719.755n 0.0v 724.745n 0.0v 724.755n 0.0v 729.745n 0.0v 729.755n 0.0v 734.745n 0.0v 734.755n 1.1v 739.745n 1.1v 739.755n 1.1v 744.745n 1.1v 744.755n 1.1v 749.745n 1.1v 749.755n 1.1v 754.745n 1.1v 754.755n 1.1v 759.745n 1.1v 759.755n 1.1v 764.745n 1.1v 764.755n 1.1v 769.745n 1.1v 769.755n 1.1v 774.745n 1.1v 774.755n 1.1v 779.745n 1.1v 779.755n 1.1v 784.745n 1.1v 784.755n 0.0v 789.745n 0.0v 789.755n 0.0v 794.745n 0.0v 794.755n 0.0v 799.745n 0.0v 799.755n 0.0v 804.745n 0.0v 804.755n 0.0v 809.745n 0.0v 809.755n 1.1v 814.745n 1.1v 814.755n 0.0v 819.745n 0.0v 819.755n 1.1v 824.745n 1.1v 824.755n 1.1v 829.745n 1.1v 829.755n 1.1v 834.745n 1.1v 834.755n 1.1v 839.745n 1.1v 839.755n 1.1v 844.745n 1.1v 844.755n 1.1v 849.745n 1.1v 849.755n 1.1v 854.745n 1.1v 854.755n 1.1v 859.745n 1.1v 859.755n 1.1v 864.745n 1.1v 864.755n 1.1v 869.745n 1.1v 869.755n 1.1v 874.745n 1.1v 874.755n 1.1v 879.745n 1.1v 879.755n 1.1v 884.745n 1.1v 884.755n 1.1v 889.745n 1.1v 889.755n 0.0v 894.745n 0.0v 894.755n 0.0v 899.745n 0.0v 899.755n 1.1v 904.745n 1.1v 904.755n 1.1v 909.745n 1.1v 909.755n 1.1v 914.745n 1.1v 914.755n 1.1v 919.745n 1.1v 919.755n 0.0v 924.745n 0.0v 924.755n 0.0v 929.745n 0.0v 929.755n 0.0v 934.745n 0.0v 934.755n 1.1v 939.745n 1.1v 939.755n 0.0v 944.745n 0.0v 944.755n 0.0v 949.745n 0.0v 949.755n 1.1v 954.745n 1.1v 954.755n 1.1v 959.745n 1.1v 959.755n 0.0v 964.745n 0.0v 964.755n 1.1v 969.745n 1.1v 969.755n 0.0v 974.745n 0.0v 974.755n 0.0v 979.745n 0.0v 979.755n 0.0v 984.745n 0.0v 984.755n 1.1v 989.745n 1.1v 989.755n 0.0v 994.745n 0.0v 994.755n 1.1v 999.745n 1.1v 999.755n 1.1v 1004.745n 1.1v 1004.755n 1.1v 1009.745n 1.1v 1009.755n 0.0v 1014.745n 0.0v 1014.755n 0.0v 1019.745n 0.0v 1019.755n 0.0v 1024.745n 0.0v 1024.755n 0.0v )
* (time, data): [(0, 0), (5, 0), (10, 0), (15, 1), (20, 1), (25, 1), (30, 1), (35, 1), (40, 1), (45, 1), (50, 1), (55, 1), (60, 1), (65, 1), (70, 0), (75, 0), (80, 0), (85, 1), (90, 1), (95, 1), (100, 0), (105, 0), (110, 0), (115, 0), (120, 0), (125, 0), (130, 0), (135, 0), (140, 0), (145, 0), (150, 0), (155, 0), (160, 0), (165, 0), (170, 0), (175, 0), (180, 1), (185, 1), (190, 1), (195, 1), (200, 1), (205, 0), (210, 0), (215, 0), (220, 1), (225, 1), (230, 1), (235, 1), (240, 1), (245, 1), (250, 1), (255, 1), (260, 1), (265, 1), (270, 1), (275, 1), (280, 0), (285, 0), (290, 0), (295, 1), (300, 0), (305, 0), (310, 0), (315, 1), (320, 1), (325, 0), (330, 0), (335, 1), (340, 0), (345, 0), (350, 0), (355, 0), (360, 0), (365, 0), (370, 0), (375, 0), (380, 0), (385, 0), (390, 0), (395, 1), (400, 1), (405, 0), (410, 1), (415, 1), (420, 1), (425, 0), (430, 0), (435, 1), (440, 1), (445, 1), (450, 1), (455, 1), (460, 1), (465, 1), (470, 1), (475, 1), (480, 1), (485, 1), (490, 0), (495, 0), (500, 0), (505, 0), (510, 0), (515, 1), (520, 1), (525, 1), (530, 1), (535, 1), (540, 0), (545, 0), (550, 1), (555, 1), (560, 1), (565, 1), (570, 1), (575, 0), (580, 1), (585, 1), (590, 1), (595, 0), (600, 1), (605, 1), (610, 1), (615, 1), (620, 1), (625, 1), (630, 1), (635, 1), (640, 1), (645, 1), (650, 1), (655, 1), (660, 1), (665, 1), (670, 1), (675, 1), (680, 1), (685, 1), (690, 0), (695, 1), (700, 0), (705, 1), (710, 1), (715, 1), (720, 1), (725, 1), (730, 1), (735, 0), (740, 0), (745, 1), (750, 1), (755, 1), (760, 1), (765, 1), (770, 1), (775, 1), (780, 1), (785, 1), (790, 1), (795, 1), (800, 1), (805, 1), (810, 1), (815, 0), (820, 1), (825, 1), (830, 1), (835, 1), (840, 1), (845, 1), (850, 1), (855, 1), (860, 1), (865, 1), (870, 1), (875, 1), (880, 1), (885, 1), (890, 0), (895, 0), (900, 1), (905, 0), (910, 1), (915, 1), (920, 0), (925, 0), (930, 1), (935, 0), (940, 0), (945, 0), (950, 1), (955, 1), (960, 0), (965, 0), (970, 1), (975, 1), (980, 1), (985, 1), (990, 1), (995, 0), (1000, 1), (1005, 1), (1010, 1), (1015, 1), (1020, 1), (1025, 1)]
Vdin0_6  din0_6  0 PWL (0n 0.0v 4.745n 0.0v 4.755n 0.0v 9.745n 0.0v 9.755n 0.0v 14.745n 0.0v 14.755n 1.1v 19.745n 1.1v 19.755n 1.1v 24.745n 1.1v 24.755n 1.1v 29.745n 1.1v 29.755n 1.1v 34.745n 1.1v 34.755n 1.1v 39.745n 1.1v 39.755n 1.1v 44.745n 1.1v 44.755n 1.1v 49.745n 1.1v 49.755n 1.1v 54.745n 1.1v 54.755n 1.1v 59.745n 1.1v 59.755n 1.1v 64.745n 1.1v 64.755n 1.1v 69.745n 1.1v 69.755n 0.0v 74.745n 0.0v 74.755n 0.0v 79.745n 0.0v 79.755n 0.0v 84.745n 0.0v 84.755n 1.1v 89.745n 1.1v 89.755n 1.1v 94.745n 1.1v 94.755n 1.1v 99.745n 1.1v 99.755n 0.0v 104.745n 0.0v 104.755n 0.0v 109.745n 0.0v 109.755n 0.0v 114.745n 0.0v 114.755n 0.0v 119.745n 0.0v 119.755n 0.0v 124.745n 0.0v 124.755n 0.0v 129.745n 0.0v 129.755n 0.0v 134.745n 0.0v 134.755n 0.0v 139.745n 0.0v 139.755n 0.0v 144.745n 0.0v 144.755n 0.0v 149.745n 0.0v 149.755n 0.0v 154.745n 0.0v 154.755n 0.0v 159.745n 0.0v 159.755n 0.0v 164.745n 0.0v 164.755n 0.0v 169.745n 0.0v 169.755n 0.0v 174.745n 0.0v 174.755n 0.0v 179.745n 0.0v 179.755n 1.1v 184.745n 1.1v 184.755n 1.1v 189.745n 1.1v 189.755n 1.1v 194.745n 1.1v 194.755n 1.1v 199.745n 1.1v 199.755n 1.1v 204.745n 1.1v 204.755n 0.0v 209.745n 0.0v 209.755n 0.0v 214.745n 0.0v 214.755n 0.0v 219.745n 0.0v 219.755n 1.1v 224.745n 1.1v 224.755n 1.1v 229.745n 1.1v 229.755n 1.1v 234.745n 1.1v 234.755n 1.1v 239.745n 1.1v 239.755n 1.1v 244.745n 1.1v 244.755n 1.1v 249.745n 1.1v 249.755n 1.1v 254.745n 1.1v 254.755n 1.1v 259.745n 1.1v 259.755n 1.1v 264.745n 1.1v 264.755n 1.1v 269.745n 1.1v 269.755n 1.1v 274.745n 1.1v 274.755n 1.1v 279.745n 1.1v 279.755n 0.0v 284.745n 0.0v 284.755n 0.0v 289.745n 0.0v 289.755n 0.0v 294.745n 0.0v 294.755n 1.1v 299.745n 1.1v 299.755n 0.0v 304.745n 0.0v 304.755n 0.0v 309.745n 0.0v 309.755n 0.0v 314.745n 0.0v 314.755n 1.1v 319.745n 1.1v 319.755n 1.1v 324.745n 1.1v 324.755n 0.0v 329.745n 0.0v 329.755n 0.0v 334.745n 0.0v 334.755n 1.1v 339.745n 1.1v 339.755n 0.0v 344.745n 0.0v 344.755n 0.0v 349.745n 0.0v 349.755n 0.0v 354.745n 0.0v 354.755n 0.0v 359.745n 0.0v 359.755n 0.0v 364.745n 0.0v 364.755n 0.0v 369.745n 0.0v 369.755n 0.0v 374.745n 0.0v 374.755n 0.0v 379.745n 0.0v 379.755n 0.0v 384.745n 0.0v 384.755n 0.0v 389.745n 0.0v 389.755n 0.0v 394.745n 0.0v 394.755n 1.1v 399.745n 1.1v 399.755n 1.1v 404.745n 1.1v 404.755n 0.0v 409.745n 0.0v 409.755n 1.1v 414.745n 1.1v 414.755n 1.1v 419.745n 1.1v 419.755n 1.1v 424.745n 1.1v 424.755n 0.0v 429.745n 0.0v 429.755n 0.0v 434.745n 0.0v 434.755n 1.1v 439.745n 1.1v 439.755n 1.1v 444.745n 1.1v 444.755n 1.1v 449.745n 1.1v 449.755n 1.1v 454.745n 1.1v 454.755n 1.1v 459.745n 1.1v 459.755n 1.1v 464.745n 1.1v 464.755n 1.1v 469.745n 1.1v 469.755n 1.1v 474.745n 1.1v 474.755n 1.1v 479.745n 1.1v 479.755n 1.1v 484.745n 1.1v 484.755n 1.1v 489.745n 1.1v 489.755n 0.0v 494.745n 0.0v 494.755n 0.0v 499.745n 0.0v 499.755n 0.0v 504.745n 0.0v 504.755n 0.0v 509.745n 0.0v 509.755n 0.0v 514.745n 0.0v 514.755n 1.1v 519.745n 1.1v 519.755n 1.1v 524.745n 1.1v 524.755n 1.1v 529.745n 1.1v 529.755n 1.1v 534.745n 1.1v 534.755n 1.1v 539.745n 1.1v 539.755n 0.0v 544.745n 0.0v 544.755n 0.0v 549.745n 0.0v 549.755n 1.1v 554.745n 1.1v 554.755n 1.1v 559.745n 1.1v 559.755n 1.1v 564.745n 1.1v 564.755n 1.1v 569.745n 1.1v 569.755n 1.1v 574.745n 1.1v 574.755n 0.0v 579.745n 0.0v 579.755n 1.1v 584.745n 1.1v 584.755n 1.1v 589.745n 1.1v 589.755n 1.1v 594.745n 1.1v 594.755n 0.0v 599.745n 0.0v 599.755n 1.1v 604.745n 1.1v 604.755n 1.1v 609.745n 1.1v 609.755n 1.1v 614.745n 1.1v 614.755n 1.1v 619.745n 1.1v 619.755n 1.1v 624.745n 1.1v 624.755n 1.1v 629.745n 1.1v 629.755n 1.1v 634.745n 1.1v 634.755n 1.1v 639.745n 1.1v 639.755n 1.1v 644.745n 1.1v 644.755n 1.1v 649.745n 1.1v 649.755n 1.1v 654.745n 1.1v 654.755n 1.1v 659.745n 1.1v 659.755n 1.1v 664.745n 1.1v 664.755n 1.1v 669.745n 1.1v 669.755n 1.1v 674.745n 1.1v 674.755n 1.1v 679.745n 1.1v 679.755n 1.1v 684.745n 1.1v 684.755n 1.1v 689.745n 1.1v 689.755n 0.0v 694.745n 0.0v 694.755n 1.1v 699.745n 1.1v 699.755n 0.0v 704.745n 0.0v 704.755n 1.1v 709.745n 1.1v 709.755n 1.1v 714.745n 1.1v 714.755n 1.1v 719.745n 1.1v 719.755n 1.1v 724.745n 1.1v 724.755n 1.1v 729.745n 1.1v 729.755n 1.1v 734.745n 1.1v 734.755n 0.0v 739.745n 0.0v 739.755n 0.0v 744.745n 0.0v 744.755n 1.1v 749.745n 1.1v 749.755n 1.1v 754.745n 1.1v 754.755n 1.1v 759.745n 1.1v 759.755n 1.1v 764.745n 1.1v 764.755n 1.1v 769.745n 1.1v 769.755n 1.1v 774.745n 1.1v 774.755n 1.1v 779.745n 1.1v 779.755n 1.1v 784.745n 1.1v 784.755n 1.1v 789.745n 1.1v 789.755n 1.1v 794.745n 1.1v 794.755n 1.1v 799.745n 1.1v 799.755n 1.1v 804.745n 1.1v 804.755n 1.1v 809.745n 1.1v 809.755n 1.1v 814.745n 1.1v 814.755n 0.0v 819.745n 0.0v 819.755n 1.1v 824.745n 1.1v 824.755n 1.1v 829.745n 1.1v 829.755n 1.1v 834.745n 1.1v 834.755n 1.1v 839.745n 1.1v 839.755n 1.1v 844.745n 1.1v 844.755n 1.1v 849.745n 1.1v 849.755n 1.1v 854.745n 1.1v 854.755n 1.1v 859.745n 1.1v 859.755n 1.1v 864.745n 1.1v 864.755n 1.1v 869.745n 1.1v 869.755n 1.1v 874.745n 1.1v 874.755n 1.1v 879.745n 1.1v 879.755n 1.1v 884.745n 1.1v 884.755n 1.1v 889.745n 1.1v 889.755n 0.0v 894.745n 0.0v 894.755n 0.0v 899.745n 0.0v 899.755n 1.1v 904.745n 1.1v 904.755n 0.0v 909.745n 0.0v 909.755n 1.1v 914.745n 1.1v 914.755n 1.1v 919.745n 1.1v 919.755n 0.0v 924.745n 0.0v 924.755n 0.0v 929.745n 0.0v 929.755n 1.1v 934.745n 1.1v 934.755n 0.0v 939.745n 0.0v 939.755n 0.0v 944.745n 0.0v 944.755n 0.0v 949.745n 0.0v 949.755n 1.1v 954.745n 1.1v 954.755n 1.1v 959.745n 1.1v 959.755n 0.0v 964.745n 0.0v 964.755n 0.0v 969.745n 0.0v 969.755n 1.1v 974.745n 1.1v 974.755n 1.1v 979.745n 1.1v 979.755n 1.1v 984.745n 1.1v 984.755n 1.1v 989.745n 1.1v 989.755n 1.1v 994.745n 1.1v 994.755n 0.0v 999.745n 0.0v 999.755n 1.1v 1004.745n 1.1v 1004.755n 1.1v 1009.745n 1.1v 1009.755n 1.1v 1014.745n 1.1v 1014.755n 1.1v 1019.745n 1.1v 1019.755n 1.1v 1024.745n 1.1v 1024.755n 1.1v )
* (time, data): [(0, 0), (5, 1), (10, 0), (15, 1), (20, 1), (25, 1), (30, 1), (35, 1), (40, 1), (45, 1), (50, 1), (55, 1), (60, 1), (65, 1), (70, 1), (75, 1), (80, 1), (85, 0), (90, 0), (95, 0), (100, 1), (105, 1), (110, 1), (115, 0), (120, 0), (125, 0), (130, 0), (135, 0), (140, 1), (145, 0), (150, 0), (155, 0), (160, 0), (165, 0), (170, 0), (175, 0), (180, 1), (185, 1), (190, 1), (195, 1), (200, 1), (205, 1), (210, 0), (215, 0), (220, 1), (225, 1), (230, 1), (235, 1), (240, 0), (245, 0), (250, 0), (255, 0), (260, 0), (265, 0), (270, 1), (275, 1), (280, 1), (285, 1), (290, 1), (295, 0), (300, 0), (305, 0), (310, 0), (315, 0), (320, 0), (325, 0), (330, 1), (335, 1), (340, 0), (345, 0), (350, 0), (355, 0), (360, 0), (365, 0), (370, 0), (375, 0), (380, 0), (385, 1), (390, 1), (395, 0), (400, 0), (405, 0), (410, 0), (415, 0), (420, 0), (425, 0), (430, 0), (435, 0), (440, 0), (445, 1), (450, 1), (455, 1), (460, 1), (465, 1), (470, 1), (475, 1), (480, 1), (485, 1), (490, 0), (495, 0), (500, 0), (505, 0), (510, 0), (515, 0), (520, 0), (525, 0), (530, 0), (535, 0), (540, 1), (545, 1), (550, 1), (555, 1), (560, 1), (565, 1), (570, 0), (575, 0), (580, 1), (585, 0), (590, 0), (595, 0), (600, 0), (605, 0), (610, 0), (615, 0), (620, 0), (625, 0), (630, 0), (635, 0), (640, 0), (645, 1), (650, 1), (655, 1), (660, 1), (665, 0), (670, 1), (675, 1), (680, 1), (685, 1), (690, 0), (695, 1), (700, 1), (705, 0), (710, 1), (715, 1), (720, 1), (725, 1), (730, 1), (735, 1), (740, 1), (745, 0), (750, 0), (755, 1), (760, 1), (765, 0), (770, 0), (775, 0), (780, 0), (785, 0), (790, 0), (795, 0), (800, 0), (805, 0), (810, 0), (815, 1), (820, 1), (825, 1), (830, 1), (835, 0), (840, 0), (845, 0), (850, 0), (855, 0), (860, 0), (865, 0), (870, 0), (875, 0), (880, 0), (885, 0), (890, 0), (895, 0), (900, 0), (905, 0), (910, 1), (915, 1), (920, 1), (925, 1), (930, 0), (935, 0), (940, 1), (945, 1), (950, 1), (955, 1), (960, 1), (965, 0), (970, 1), (975, 1), (980, 1), (985, 1), (990, 0), (995, 1), (1000, 0), (1005, 0), (1010, 0), (1015, 0), (1020, 0), (1025, 0)]
Vdin0_7  din0_7  0 PWL (0n 0.0v 4.745n 0.0v 4.755n 1.1v 9.745n 1.1v 9.755n 0.0v 14.745n 0.0v 14.755n 1.1v 19.745n 1.1v 19.755n 1.1v 24.745n 1.1v 24.755n 1.1v 29.745n 1.1v 29.755n 1.1v 34.745n 1.1v 34.755n 1.1v 39.745n 1.1v 39.755n 1.1v 44.745n 1.1v 44.755n 1.1v 49.745n 1.1v 49.755n 1.1v 54.745n 1.1v 54.755n 1.1v 59.745n 1.1v 59.755n 1.1v 64.745n 1.1v 64.755n 1.1v 69.745n 1.1v 69.755n 1.1v 74.745n 1.1v 74.755n 1.1v 79.745n 1.1v 79.755n 1.1v 84.745n 1.1v 84.755n 0.0v 89.745n 0.0v 89.755n 0.0v 94.745n 0.0v 94.755n 0.0v 99.745n 0.0v 99.755n 1.1v 104.745n 1.1v 104.755n 1.1v 109.745n 1.1v 109.755n 1.1v 114.745n 1.1v 114.755n 0.0v 119.745n 0.0v 119.755n 0.0v 124.745n 0.0v 124.755n 0.0v 129.745n 0.0v 129.755n 0.0v 134.745n 0.0v 134.755n 0.0v 139.745n 0.0v 139.755n 1.1v 144.745n 1.1v 144.755n 0.0v 149.745n 0.0v 149.755n 0.0v 154.745n 0.0v 154.755n 0.0v 159.745n 0.0v 159.755n 0.0v 164.745n 0.0v 164.755n 0.0v 169.745n 0.0v 169.755n 0.0v 174.745n 0.0v 174.755n 0.0v 179.745n 0.0v 179.755n 1.1v 184.745n 1.1v 184.755n 1.1v 189.745n 1.1v 189.755n 1.1v 194.745n 1.1v 194.755n 1.1v 199.745n 1.1v 199.755n 1.1v 204.745n 1.1v 204.755n 1.1v 209.745n 1.1v 209.755n 0.0v 214.745n 0.0v 214.755n 0.0v 219.745n 0.0v 219.755n 1.1v 224.745n 1.1v 224.755n 1.1v 229.745n 1.1v 229.755n 1.1v 234.745n 1.1v 234.755n 1.1v 239.745n 1.1v 239.755n 0.0v 244.745n 0.0v 244.755n 0.0v 249.745n 0.0v 249.755n 0.0v 254.745n 0.0v 254.755n 0.0v 259.745n 0.0v 259.755n 0.0v 264.745n 0.0v 264.755n 0.0v 269.745n 0.0v 269.755n 1.1v 274.745n 1.1v 274.755n 1.1v 279.745n 1.1v 279.755n 1.1v 284.745n 1.1v 284.755n 1.1v 289.745n 1.1v 289.755n 1.1v 294.745n 1.1v 294.755n 0.0v 299.745n 0.0v 299.755n 0.0v 304.745n 0.0v 304.755n 0.0v 309.745n 0.0v 309.755n 0.0v 314.745n 0.0v 314.755n 0.0v 319.745n 0.0v 319.755n 0.0v 324.745n 0.0v 324.755n 0.0v 329.745n 0.0v 329.755n 1.1v 334.745n 1.1v 334.755n 1.1v 339.745n 1.1v 339.755n 0.0v 344.745n 0.0v 344.755n 0.0v 349.745n 0.0v 349.755n 0.0v 354.745n 0.0v 354.755n 0.0v 359.745n 0.0v 359.755n 0.0v 364.745n 0.0v 364.755n 0.0v 369.745n 0.0v 369.755n 0.0v 374.745n 0.0v 374.755n 0.0v 379.745n 0.0v 379.755n 0.0v 384.745n 0.0v 384.755n 1.1v 389.745n 1.1v 389.755n 1.1v 394.745n 1.1v 394.755n 0.0v 399.745n 0.0v 399.755n 0.0v 404.745n 0.0v 404.755n 0.0v 409.745n 0.0v 409.755n 0.0v 414.745n 0.0v 414.755n 0.0v 419.745n 0.0v 419.755n 0.0v 424.745n 0.0v 424.755n 0.0v 429.745n 0.0v 429.755n 0.0v 434.745n 0.0v 434.755n 0.0v 439.745n 0.0v 439.755n 0.0v 444.745n 0.0v 444.755n 1.1v 449.745n 1.1v 449.755n 1.1v 454.745n 1.1v 454.755n 1.1v 459.745n 1.1v 459.755n 1.1v 464.745n 1.1v 464.755n 1.1v 469.745n 1.1v 469.755n 1.1v 474.745n 1.1v 474.755n 1.1v 479.745n 1.1v 479.755n 1.1v 484.745n 1.1v 484.755n 1.1v 489.745n 1.1v 489.755n 0.0v 494.745n 0.0v 494.755n 0.0v 499.745n 0.0v 499.755n 0.0v 504.745n 0.0v 504.755n 0.0v 509.745n 0.0v 509.755n 0.0v 514.745n 0.0v 514.755n 0.0v 519.745n 0.0v 519.755n 0.0v 524.745n 0.0v 524.755n 0.0v 529.745n 0.0v 529.755n 0.0v 534.745n 0.0v 534.755n 0.0v 539.745n 0.0v 539.755n 1.1v 544.745n 1.1v 544.755n 1.1v 549.745n 1.1v 549.755n 1.1v 554.745n 1.1v 554.755n 1.1v 559.745n 1.1v 559.755n 1.1v 564.745n 1.1v 564.755n 1.1v 569.745n 1.1v 569.755n 0.0v 574.745n 0.0v 574.755n 0.0v 579.745n 0.0v 579.755n 1.1v 584.745n 1.1v 584.755n 0.0v 589.745n 0.0v 589.755n 0.0v 594.745n 0.0v 594.755n 0.0v 599.745n 0.0v 599.755n 0.0v 604.745n 0.0v 604.755n 0.0v 609.745n 0.0v 609.755n 0.0v 614.745n 0.0v 614.755n 0.0v 619.745n 0.0v 619.755n 0.0v 624.745n 0.0v 624.755n 0.0v 629.745n 0.0v 629.755n 0.0v 634.745n 0.0v 634.755n 0.0v 639.745n 0.0v 639.755n 0.0v 644.745n 0.0v 644.755n 1.1v 649.745n 1.1v 649.755n 1.1v 654.745n 1.1v 654.755n 1.1v 659.745n 1.1v 659.755n 1.1v 664.745n 1.1v 664.755n 0.0v 669.745n 0.0v 669.755n 1.1v 674.745n 1.1v 674.755n 1.1v 679.745n 1.1v 679.755n 1.1v 684.745n 1.1v 684.755n 1.1v 689.745n 1.1v 689.755n 0.0v 694.745n 0.0v 694.755n 1.1v 699.745n 1.1v 699.755n 1.1v 704.745n 1.1v 704.755n 0.0v 709.745n 0.0v 709.755n 1.1v 714.745n 1.1v 714.755n 1.1v 719.745n 1.1v 719.755n 1.1v 724.745n 1.1v 724.755n 1.1v 729.745n 1.1v 729.755n 1.1v 734.745n 1.1v 734.755n 1.1v 739.745n 1.1v 739.755n 1.1v 744.745n 1.1v 744.755n 0.0v 749.745n 0.0v 749.755n 0.0v 754.745n 0.0v 754.755n 1.1v 759.745n 1.1v 759.755n 1.1v 764.745n 1.1v 764.755n 0.0v 769.745n 0.0v 769.755n 0.0v 774.745n 0.0v 774.755n 0.0v 779.745n 0.0v 779.755n 0.0v 784.745n 0.0v 784.755n 0.0v 789.745n 0.0v 789.755n 0.0v 794.745n 0.0v 794.755n 0.0v 799.745n 0.0v 799.755n 0.0v 804.745n 0.0v 804.755n 0.0v 809.745n 0.0v 809.755n 0.0v 814.745n 0.0v 814.755n 1.1v 819.745n 1.1v 819.755n 1.1v 824.745n 1.1v 824.755n 1.1v 829.745n 1.1v 829.755n 1.1v 834.745n 1.1v 834.755n 0.0v 839.745n 0.0v 839.755n 0.0v 844.745n 0.0v 844.755n 0.0v 849.745n 0.0v 849.755n 0.0v 854.745n 0.0v 854.755n 0.0v 859.745n 0.0v 859.755n 0.0v 864.745n 0.0v 864.755n 0.0v 869.745n 0.0v 869.755n 0.0v 874.745n 0.0v 874.755n 0.0v 879.745n 0.0v 879.755n 0.0v 884.745n 0.0v 884.755n 0.0v 889.745n 0.0v 889.755n 0.0v 894.745n 0.0v 894.755n 0.0v 899.745n 0.0v 899.755n 0.0v 904.745n 0.0v 904.755n 0.0v 909.745n 0.0v 909.755n 1.1v 914.745n 1.1v 914.755n 1.1v 919.745n 1.1v 919.755n 1.1v 924.745n 1.1v 924.755n 1.1v 929.745n 1.1v 929.755n 0.0v 934.745n 0.0v 934.755n 0.0v 939.745n 0.0v 939.755n 1.1v 944.745n 1.1v 944.755n 1.1v 949.745n 1.1v 949.755n 1.1v 954.745n 1.1v 954.755n 1.1v 959.745n 1.1v 959.755n 1.1v 964.745n 1.1v 964.755n 0.0v 969.745n 0.0v 969.755n 1.1v 974.745n 1.1v 974.755n 1.1v 979.745n 1.1v 979.755n 1.1v 984.745n 1.1v 984.755n 1.1v 989.745n 1.1v 989.755n 0.0v 994.745n 0.0v 994.755n 1.1v 999.745n 1.1v 999.755n 0.0v 1004.745n 0.0v 1004.755n 0.0v 1009.745n 0.0v 1009.755n 0.0v 1014.745n 0.0v 1014.755n 0.0v 1019.745n 0.0v 1019.755n 0.0v 1024.745n 0.0v 1024.755n 0.0v )
* (time, data): [(0, 0), (5, 0), (10, 0), (15, 0), (20, 0), (25, 0), (30, 0), (35, 0), (40, 0), (45, 0), (50, 1), (55, 1), (60, 1), (65, 1), (70, 0), (75, 0), (80, 0), (85, 1), (90, 1), (95, 1), (100, 1), (105, 1), (110, 1), (115, 0), (120, 0), (125, 0), (130, 0), (135, 0), (140, 0), (145, 0), (150, 0), (155, 0), (160, 0), (165, 0), (170, 0), (175, 0), (180, 1), (185, 1), (190, 1), (195, 1), (200, 1), (205, 1), (210, 0), (215, 0), (220, 0), (225, 0), (230, 0), (235, 0), (240, 1), (245, 1), (250, 1), (255, 1), (260, 1), (265, 1), (270, 1), (275, 1), (280, 1), (285, 1), (290, 1), (295, 0), (300, 1), (305, 1), (310, 1), (315, 1), (320, 1), (325, 0), (330, 1), (335, 1), (340, 1), (345, 1), (350, 1), (355, 1), (360, 1), (365, 1), (370, 1), (375, 1), (380, 1), (385, 1), (390, 1), (395, 0), (400, 0), (405, 1), (410, 1), (415, 1), (420, 1), (425, 1), (430, 1), (435, 0), (440, 0), (445, 0), (450, 1), (455, 1), (460, 1), (465, 1), (470, 1), (475, 1), (480, 1), (485, 1), (490, 1), (495, 1), (500, 1), (505, 1), (510, 0), (515, 1), (520, 1), (525, 1), (530, 1), (535, 0), (540, 1), (545, 1), (550, 1), (555, 1), (560, 1), (565, 1), (570, 1), (575, 0), (580, 0), (585, 1), (590, 1), (595, 0), (600, 1), (605, 0), (610, 0), (615, 0), (620, 0), (625, 1), (630, 1), (635, 1), (640, 1), (645, 1), (650, 1), (655, 1), (660, 1), (665, 1), (670, 1), (675, 1), (680, 1), (685, 1), (690, 0), (695, 1), (700, 0), (705, 1), (710, 0), (715, 0), (720, 0), (725, 0), (730, 0), (735, 0), (740, 0), (745, 0), (750, 0), (755, 1), (760, 1), (765, 1), (770, 1), (775, 1), (780, 1), (785, 0), (790, 0), (795, 0), (800, 0), (805, 0), (810, 1), (815, 1), (820, 0), (825, 0), (830, 0), (835, 0), (840, 0), (845, 0), (850, 0), (855, 0), (860, 0), (865, 0), (870, 0), (875, 0), (880, 0), (885, 0), (890, 0), (895, 0), (900, 1), (905, 1), (910, 1), (915, 1), (920, 0), (925, 0), (930, 1), (935, 1), (940, 0), (945, 0), (950, 1), (955, 0), (960, 1), (965, 1), (970, 0), (975, 0), (980, 0), (985, 1), (990, 1), (995, 1), (1000, 1), (1005, 1), (1010, 1), (1015, 1), (1020, 1), (1025, 1)]
Vdin0_8  din0_8  0 PWL (0n 0.0v 4.745n 0.0v 4.755n 0.0v 9.745n 0.0v 9.755n 0.0v 14.745n 0.0v 14.755n 0.0v 19.745n 0.0v 19.755n 0.0v 24.745n 0.0v 24.755n 0.0v 29.745n 0.0v 29.755n 0.0v 34.745n 0.0v 34.755n 0.0v 39.745n 0.0v 39.755n 0.0v 44.745n 0.0v 44.755n 0.0v 49.745n 0.0v 49.755n 1.1v 54.745n 1.1v 54.755n 1.1v 59.745n 1.1v 59.755n 1.1v 64.745n 1.1v 64.755n 1.1v 69.745n 1.1v 69.755n 0.0v 74.745n 0.0v 74.755n 0.0v 79.745n 0.0v 79.755n 0.0v 84.745n 0.0v 84.755n 1.1v 89.745n 1.1v 89.755n 1.1v 94.745n 1.1v 94.755n 1.1v 99.745n 1.1v 99.755n 1.1v 104.745n 1.1v 104.755n 1.1v 109.745n 1.1v 109.755n 1.1v 114.745n 1.1v 114.755n 0.0v 119.745n 0.0v 119.755n 0.0v 124.745n 0.0v 124.755n 0.0v 129.745n 0.0v 129.755n 0.0v 134.745n 0.0v 134.755n 0.0v 139.745n 0.0v 139.755n 0.0v 144.745n 0.0v 144.755n 0.0v 149.745n 0.0v 149.755n 0.0v 154.745n 0.0v 154.755n 0.0v 159.745n 0.0v 159.755n 0.0v 164.745n 0.0v 164.755n 0.0v 169.745n 0.0v 169.755n 0.0v 174.745n 0.0v 174.755n 0.0v 179.745n 0.0v 179.755n 1.1v 184.745n 1.1v 184.755n 1.1v 189.745n 1.1v 189.755n 1.1v 194.745n 1.1v 194.755n 1.1v 199.745n 1.1v 199.755n 1.1v 204.745n 1.1v 204.755n 1.1v 209.745n 1.1v 209.755n 0.0v 214.745n 0.0v 214.755n 0.0v 219.745n 0.0v 219.755n 0.0v 224.745n 0.0v 224.755n 0.0v 229.745n 0.0v 229.755n 0.0v 234.745n 0.0v 234.755n 0.0v 239.745n 0.0v 239.755n 1.1v 244.745n 1.1v 244.755n 1.1v 249.745n 1.1v 249.755n 1.1v 254.745n 1.1v 254.755n 1.1v 259.745n 1.1v 259.755n 1.1v 264.745n 1.1v 264.755n 1.1v 269.745n 1.1v 269.755n 1.1v 274.745n 1.1v 274.755n 1.1v 279.745n 1.1v 279.755n 1.1v 284.745n 1.1v 284.755n 1.1v 289.745n 1.1v 289.755n 1.1v 294.745n 1.1v 294.755n 0.0v 299.745n 0.0v 299.755n 1.1v 304.745n 1.1v 304.755n 1.1v 309.745n 1.1v 309.755n 1.1v 314.745n 1.1v 314.755n 1.1v 319.745n 1.1v 319.755n 1.1v 324.745n 1.1v 324.755n 0.0v 329.745n 0.0v 329.755n 1.1v 334.745n 1.1v 334.755n 1.1v 339.745n 1.1v 339.755n 1.1v 344.745n 1.1v 344.755n 1.1v 349.745n 1.1v 349.755n 1.1v 354.745n 1.1v 354.755n 1.1v 359.745n 1.1v 359.755n 1.1v 364.745n 1.1v 364.755n 1.1v 369.745n 1.1v 369.755n 1.1v 374.745n 1.1v 374.755n 1.1v 379.745n 1.1v 379.755n 1.1v 384.745n 1.1v 384.755n 1.1v 389.745n 1.1v 389.755n 1.1v 394.745n 1.1v 394.755n 0.0v 399.745n 0.0v 399.755n 0.0v 404.745n 0.0v 404.755n 1.1v 409.745n 1.1v 409.755n 1.1v 414.745n 1.1v 414.755n 1.1v 419.745n 1.1v 419.755n 1.1v 424.745n 1.1v 424.755n 1.1v 429.745n 1.1v 429.755n 1.1v 434.745n 1.1v 434.755n 0.0v 439.745n 0.0v 439.755n 0.0v 444.745n 0.0v 444.755n 0.0v 449.745n 0.0v 449.755n 1.1v 454.745n 1.1v 454.755n 1.1v 459.745n 1.1v 459.755n 1.1v 464.745n 1.1v 464.755n 1.1v 469.745n 1.1v 469.755n 1.1v 474.745n 1.1v 474.755n 1.1v 479.745n 1.1v 479.755n 1.1v 484.745n 1.1v 484.755n 1.1v 489.745n 1.1v 489.755n 1.1v 494.745n 1.1v 494.755n 1.1v 499.745n 1.1v 499.755n 1.1v 504.745n 1.1v 504.755n 1.1v 509.745n 1.1v 509.755n 0.0v 514.745n 0.0v 514.755n 1.1v 519.745n 1.1v 519.755n 1.1v 524.745n 1.1v 524.755n 1.1v 529.745n 1.1v 529.755n 1.1v 534.745n 1.1v 534.755n 0.0v 539.745n 0.0v 539.755n 1.1v 544.745n 1.1v 544.755n 1.1v 549.745n 1.1v 549.755n 1.1v 554.745n 1.1v 554.755n 1.1v 559.745n 1.1v 559.755n 1.1v 564.745n 1.1v 564.755n 1.1v 569.745n 1.1v 569.755n 1.1v 574.745n 1.1v 574.755n 0.0v 579.745n 0.0v 579.755n 0.0v 584.745n 0.0v 584.755n 1.1v 589.745n 1.1v 589.755n 1.1v 594.745n 1.1v 594.755n 0.0v 599.745n 0.0v 599.755n 1.1v 604.745n 1.1v 604.755n 0.0v 609.745n 0.0v 609.755n 0.0v 614.745n 0.0v 614.755n 0.0v 619.745n 0.0v 619.755n 0.0v 624.745n 0.0v 624.755n 1.1v 629.745n 1.1v 629.755n 1.1v 634.745n 1.1v 634.755n 1.1v 639.745n 1.1v 639.755n 1.1v 644.745n 1.1v 644.755n 1.1v 649.745n 1.1v 649.755n 1.1v 654.745n 1.1v 654.755n 1.1v 659.745n 1.1v 659.755n 1.1v 664.745n 1.1v 664.755n 1.1v 669.745n 1.1v 669.755n 1.1v 674.745n 1.1v 674.755n 1.1v 679.745n 1.1v 679.755n 1.1v 684.745n 1.1v 684.755n 1.1v 689.745n 1.1v 689.755n 0.0v 694.745n 0.0v 694.755n 1.1v 699.745n 1.1v 699.755n 0.0v 704.745n 0.0v 704.755n 1.1v 709.745n 1.1v 709.755n 0.0v 714.745n 0.0v 714.755n 0.0v 719.745n 0.0v 719.755n 0.0v 724.745n 0.0v 724.755n 0.0v 729.745n 0.0v 729.755n 0.0v 734.745n 0.0v 734.755n 0.0v 739.745n 0.0v 739.755n 0.0v 744.745n 0.0v 744.755n 0.0v 749.745n 0.0v 749.755n 0.0v 754.745n 0.0v 754.755n 1.1v 759.745n 1.1v 759.755n 1.1v 764.745n 1.1v 764.755n 1.1v 769.745n 1.1v 769.755n 1.1v 774.745n 1.1v 774.755n 1.1v 779.745n 1.1v 779.755n 1.1v 784.745n 1.1v 784.755n 0.0v 789.745n 0.0v 789.755n 0.0v 794.745n 0.0v 794.755n 0.0v 799.745n 0.0v 799.755n 0.0v 804.745n 0.0v 804.755n 0.0v 809.745n 0.0v 809.755n 1.1v 814.745n 1.1v 814.755n 1.1v 819.745n 1.1v 819.755n 0.0v 824.745n 0.0v 824.755n 0.0v 829.745n 0.0v 829.755n 0.0v 834.745n 0.0v 834.755n 0.0v 839.745n 0.0v 839.755n 0.0v 844.745n 0.0v 844.755n 0.0v 849.745n 0.0v 849.755n 0.0v 854.745n 0.0v 854.755n 0.0v 859.745n 0.0v 859.755n 0.0v 864.745n 0.0v 864.755n 0.0v 869.745n 0.0v 869.755n 0.0v 874.745n 0.0v 874.755n 0.0v 879.745n 0.0v 879.755n 0.0v 884.745n 0.0v 884.755n 0.0v 889.745n 0.0v 889.755n 0.0v 894.745n 0.0v 894.755n 0.0v 899.745n 0.0v 899.755n 1.1v 904.745n 1.1v 904.755n 1.1v 909.745n 1.1v 909.755n 1.1v 914.745n 1.1v 914.755n 1.1v 919.745n 1.1v 919.755n 0.0v 924.745n 0.0v 924.755n 0.0v 929.745n 0.0v 929.755n 1.1v 934.745n 1.1v 934.755n 1.1v 939.745n 1.1v 939.755n 0.0v 944.745n 0.0v 944.755n 0.0v 949.745n 0.0v 949.755n 1.1v 954.745n 1.1v 954.755n 0.0v 959.745n 0.0v 959.755n 1.1v 964.745n 1.1v 964.755n 1.1v 969.745n 1.1v 969.755n 0.0v 974.745n 0.0v 974.755n 0.0v 979.745n 0.0v 979.755n 0.0v 984.745n 0.0v 984.755n 1.1v 989.745n 1.1v 989.755n 1.1v 994.745n 1.1v 994.755n 1.1v 999.745n 1.1v 999.755n 1.1v 1004.745n 1.1v 1004.755n 1.1v 1009.745n 1.1v 1009.755n 1.1v 1014.745n 1.1v 1014.755n 1.1v 1019.745n 1.1v 1019.755n 1.1v 1024.745n 1.1v 1024.755n 1.1v )
* (time, data): [(0, 0), (5, 0), (10, 0), (15, 0), (20, 0), (25, 0), (30, 0), (35, 0), (40, 0), (45, 0), (50, 1), (55, 1), (60, 1), (65, 1), (70, 0), (75, 0), (80, 0), (85, 1), (90, 1), (95, 1), (100, 1), (105, 1), (110, 1), (115, 1), (120, 1), (125, 1), (130, 1), (135, 1), (140, 1), (145, 1), (150, 1), (155, 1), (160, 1), (165, 1), (170, 1), (175, 1), (180, 0), (185, 0), (190, 0), (195, 0), (200, 0), (205, 1), (210, 0), (215, 0), (220, 1), (225, 1), (230, 1), (235, 1), (240, 1), (245, 1), (250, 1), (255, 1), (260, 1), (265, 1), (270, 1), (275, 1), (280, 1), (285, 1), (290, 1), (295, 0), (300, 1), (305, 1), (310, 1), (315, 1), (320, 0), (325, 1), (330, 0), (335, 1), (340, 1), (345, 1), (350, 1), (355, 1), (360, 1), (365, 1), (370, 1), (375, 1), (380, 1), (385, 0), (390, 0), (395, 1), (400, 1), (405, 1), (410, 0), (415, 0), (420, 0), (425, 1), (430, 1), (435, 1), (440, 1), (445, 0), (450, 1), (455, 0), (460, 0), (465, 0), (470, 0), (475, 0), (480, 0), (485, 0), (490, 1), (495, 1), (500, 1), (505, 1), (510, 0), (515, 0), (520, 0), (525, 0), (530, 0), (535, 1), (540, 0), (545, 0), (550, 1), (555, 1), (560, 1), (565, 1), (570, 1), (575, 1), (580, 0), (585, 0), (590, 1), (595, 1), (600, 1), (605, 1), (610, 1), (615, 1), (620, 1), (625, 1), (630, 1), (635, 1), (640, 1), (645, 0), (650, 0), (655, 0), (660, 0), (665, 1), (670, 0), (675, 0), (680, 0), (685, 0), (690, 0), (695, 0), (700, 0), (705, 1), (710, 0), (715, 0), (720, 0), (725, 0), (730, 0), (735, 1), (740, 1), (745, 0), (750, 0), (755, 1), (760, 1), (765, 1), (770, 1), (775, 1), (780, 1), (785, 0), (790, 0), (795, 0), (800, 0), (805, 0), (810, 0), (815, 0), (820, 1), (825, 1), (830, 1), (835, 1), (840, 1), (845, 1), (850, 1), (855, 1), (860, 1), (865, 1), (870, 1), (875, 1), (880, 1), (885, 1), (890, 1), (895, 1), (900, 1), (905, 0), (910, 1), (915, 1), (920, 1), (925, 1), (930, 0), (935, 0), (940, 0), (945, 0), (950, 1), (955, 1), (960, 1), (965, 0), (970, 0), (975, 0), (980, 0), (985, 1), (990, 1), (995, 0), (1000, 0), (1005, 0), (1010, 1), (1015, 1), (1020, 1), (1025, 1)]
Vdin0_9  din0_9  0 PWL (0n 0.0v 4.745n 0.0v 4.755n 0.0v 9.745n 0.0v 9.755n 0.0v 14.745n 0.0v 14.755n 0.0v 19.745n 0.0v 19.755n 0.0v 24.745n 0.0v 24.755n 0.0v 29.745n 0.0v 29.755n 0.0v 34.745n 0.0v 34.755n 0.0v 39.745n 0.0v 39.755n 0.0v 44.745n 0.0v 44.755n 0.0v 49.745n 0.0v 49.755n 1.1v 54.745n 1.1v 54.755n 1.1v 59.745n 1.1v 59.755n 1.1v 64.745n 1.1v 64.755n 1.1v 69.745n 1.1v 69.755n 0.0v 74.745n 0.0v 74.755n 0.0v 79.745n 0.0v 79.755n 0.0v 84.745n 0.0v 84.755n 1.1v 89.745n 1.1v 89.755n 1.1v 94.745n 1.1v 94.755n 1.1v 99.745n 1.1v 99.755n 1.1v 104.745n 1.1v 104.755n 1.1v 109.745n 1.1v 109.755n 1.1v 114.745n 1.1v 114.755n 1.1v 119.745n 1.1v 119.755n 1.1v 124.745n 1.1v 124.755n 1.1v 129.745n 1.1v 129.755n 1.1v 134.745n 1.1v 134.755n 1.1v 139.745n 1.1v 139.755n 1.1v 144.745n 1.1v 144.755n 1.1v 149.745n 1.1v 149.755n 1.1v 154.745n 1.1v 154.755n 1.1v 159.745n 1.1v 159.755n 1.1v 164.745n 1.1v 164.755n 1.1v 169.745n 1.1v 169.755n 1.1v 174.745n 1.1v 174.755n 1.1v 179.745n 1.1v 179.755n 0.0v 184.745n 0.0v 184.755n 0.0v 189.745n 0.0v 189.755n 0.0v 194.745n 0.0v 194.755n 0.0v 199.745n 0.0v 199.755n 0.0v 204.745n 0.0v 204.755n 1.1v 209.745n 1.1v 209.755n 0.0v 214.745n 0.0v 214.755n 0.0v 219.745n 0.0v 219.755n 1.1v 224.745n 1.1v 224.755n 1.1v 229.745n 1.1v 229.755n 1.1v 234.745n 1.1v 234.755n 1.1v 239.745n 1.1v 239.755n 1.1v 244.745n 1.1v 244.755n 1.1v 249.745n 1.1v 249.755n 1.1v 254.745n 1.1v 254.755n 1.1v 259.745n 1.1v 259.755n 1.1v 264.745n 1.1v 264.755n 1.1v 269.745n 1.1v 269.755n 1.1v 274.745n 1.1v 274.755n 1.1v 279.745n 1.1v 279.755n 1.1v 284.745n 1.1v 284.755n 1.1v 289.745n 1.1v 289.755n 1.1v 294.745n 1.1v 294.755n 0.0v 299.745n 0.0v 299.755n 1.1v 304.745n 1.1v 304.755n 1.1v 309.745n 1.1v 309.755n 1.1v 314.745n 1.1v 314.755n 1.1v 319.745n 1.1v 319.755n 0.0v 324.745n 0.0v 324.755n 1.1v 329.745n 1.1v 329.755n 0.0v 334.745n 0.0v 334.755n 1.1v 339.745n 1.1v 339.755n 1.1v 344.745n 1.1v 344.755n 1.1v 349.745n 1.1v 349.755n 1.1v 354.745n 1.1v 354.755n 1.1v 359.745n 1.1v 359.755n 1.1v 364.745n 1.1v 364.755n 1.1v 369.745n 1.1v 369.755n 1.1v 374.745n 1.1v 374.755n 1.1v 379.745n 1.1v 379.755n 1.1v 384.745n 1.1v 384.755n 0.0v 389.745n 0.0v 389.755n 0.0v 394.745n 0.0v 394.755n 1.1v 399.745n 1.1v 399.755n 1.1v 404.745n 1.1v 404.755n 1.1v 409.745n 1.1v 409.755n 0.0v 414.745n 0.0v 414.755n 0.0v 419.745n 0.0v 419.755n 0.0v 424.745n 0.0v 424.755n 1.1v 429.745n 1.1v 429.755n 1.1v 434.745n 1.1v 434.755n 1.1v 439.745n 1.1v 439.755n 1.1v 444.745n 1.1v 444.755n 0.0v 449.745n 0.0v 449.755n 1.1v 454.745n 1.1v 454.755n 0.0v 459.745n 0.0v 459.755n 0.0v 464.745n 0.0v 464.755n 0.0v 469.745n 0.0v 469.755n 0.0v 474.745n 0.0v 474.755n 0.0v 479.745n 0.0v 479.755n 0.0v 484.745n 0.0v 484.755n 0.0v 489.745n 0.0v 489.755n 1.1v 494.745n 1.1v 494.755n 1.1v 499.745n 1.1v 499.755n 1.1v 504.745n 1.1v 504.755n 1.1v 509.745n 1.1v 509.755n 0.0v 514.745n 0.0v 514.755n 0.0v 519.745n 0.0v 519.755n 0.0v 524.745n 0.0v 524.755n 0.0v 529.745n 0.0v 529.755n 0.0v 534.745n 0.0v 534.755n 1.1v 539.745n 1.1v 539.755n 0.0v 544.745n 0.0v 544.755n 0.0v 549.745n 0.0v 549.755n 1.1v 554.745n 1.1v 554.755n 1.1v 559.745n 1.1v 559.755n 1.1v 564.745n 1.1v 564.755n 1.1v 569.745n 1.1v 569.755n 1.1v 574.745n 1.1v 574.755n 1.1v 579.745n 1.1v 579.755n 0.0v 584.745n 0.0v 584.755n 0.0v 589.745n 0.0v 589.755n 1.1v 594.745n 1.1v 594.755n 1.1v 599.745n 1.1v 599.755n 1.1v 604.745n 1.1v 604.755n 1.1v 609.745n 1.1v 609.755n 1.1v 614.745n 1.1v 614.755n 1.1v 619.745n 1.1v 619.755n 1.1v 624.745n 1.1v 624.755n 1.1v 629.745n 1.1v 629.755n 1.1v 634.745n 1.1v 634.755n 1.1v 639.745n 1.1v 639.755n 1.1v 644.745n 1.1v 644.755n 0.0v 649.745n 0.0v 649.755n 0.0v 654.745n 0.0v 654.755n 0.0v 659.745n 0.0v 659.755n 0.0v 664.745n 0.0v 664.755n 1.1v 669.745n 1.1v 669.755n 0.0v 674.745n 0.0v 674.755n 0.0v 679.745n 0.0v 679.755n 0.0v 684.745n 0.0v 684.755n 0.0v 689.745n 0.0v 689.755n 0.0v 694.745n 0.0v 694.755n 0.0v 699.745n 0.0v 699.755n 0.0v 704.745n 0.0v 704.755n 1.1v 709.745n 1.1v 709.755n 0.0v 714.745n 0.0v 714.755n 0.0v 719.745n 0.0v 719.755n 0.0v 724.745n 0.0v 724.755n 0.0v 729.745n 0.0v 729.755n 0.0v 734.745n 0.0v 734.755n 1.1v 739.745n 1.1v 739.755n 1.1v 744.745n 1.1v 744.755n 0.0v 749.745n 0.0v 749.755n 0.0v 754.745n 0.0v 754.755n 1.1v 759.745n 1.1v 759.755n 1.1v 764.745n 1.1v 764.755n 1.1v 769.745n 1.1v 769.755n 1.1v 774.745n 1.1v 774.755n 1.1v 779.745n 1.1v 779.755n 1.1v 784.745n 1.1v 784.755n 0.0v 789.745n 0.0v 789.755n 0.0v 794.745n 0.0v 794.755n 0.0v 799.745n 0.0v 799.755n 0.0v 804.745n 0.0v 804.755n 0.0v 809.745n 0.0v 809.755n 0.0v 814.745n 0.0v 814.755n 0.0v 819.745n 0.0v 819.755n 1.1v 824.745n 1.1v 824.755n 1.1v 829.745n 1.1v 829.755n 1.1v 834.745n 1.1v 834.755n 1.1v 839.745n 1.1v 839.755n 1.1v 844.745n 1.1v 844.755n 1.1v 849.745n 1.1v 849.755n 1.1v 854.745n 1.1v 854.755n 1.1v 859.745n 1.1v 859.755n 1.1v 864.745n 1.1v 864.755n 1.1v 869.745n 1.1v 869.755n 1.1v 874.745n 1.1v 874.755n 1.1v 879.745n 1.1v 879.755n 1.1v 884.745n 1.1v 884.755n 1.1v 889.745n 1.1v 889.755n 1.1v 894.745n 1.1v 894.755n 1.1v 899.745n 1.1v 899.755n 1.1v 904.745n 1.1v 904.755n 0.0v 909.745n 0.0v 909.755n 1.1v 914.745n 1.1v 914.755n 1.1v 919.745n 1.1v 919.755n 1.1v 924.745n 1.1v 924.755n 1.1v 929.745n 1.1v 929.755n 0.0v 934.745n 0.0v 934.755n 0.0v 939.745n 0.0v 939.755n 0.0v 944.745n 0.0v 944.755n 0.0v 949.745n 0.0v 949.755n 1.1v 954.745n 1.1v 954.755n 1.1v 959.745n 1.1v 959.755n 1.1v 964.745n 1.1v 964.755n 0.0v 969.745n 0.0v 969.755n 0.0v 974.745n 0.0v 974.755n 0.0v 979.745n 0.0v 979.755n 0.0v 984.745n 0.0v 984.755n 1.1v 989.745n 1.1v 989.755n 1.1v 994.745n 1.1v 994.755n 0.0v 999.745n 0.0v 999.755n 0.0v 1004.745n 0.0v 1004.755n 0.0v 1009.745n 0.0v 1009.755n 1.1v 1014.745n 1.1v 1014.755n 1.1v 1019.745n 1.1v 1019.755n 1.1v 1024.745n 1.1v 1024.755n 1.1v )
* (time, data): [(0, 0), (5, 1), (10, 1), (15, 0), (20, 0), (25, 0), (30, 0), (35, 0), (40, 0), (45, 0), (50, 1), (55, 1), (60, 1), (65, 1), (70, 0), (75, 0), (80, 0), (85, 1), (90, 1), (95, 1), (100, 1), (105, 1), (110, 1), (115, 1), (120, 1), (125, 1), (130, 1), (135, 1), (140, 0), (145, 1), (150, 1), (155, 1), (160, 1), (165, 1), (170, 1), (175, 1), (180, 1), (185, 1), (190, 1), (195, 1), (200, 1), (205, 1), (210, 1), (215, 1), (220, 1), (225, 1), (230, 1), (235, 1), (240, 1), (245, 1), (250, 1), (255, 1), (260, 1), (265, 1), (270, 1), (275, 1), (280, 0), (285, 0), (290, 1), (295, 0), (300, 1), (305, 1), (310, 1), (315, 0), (320, 1), (325, 0), (330, 1), (335, 1), (340, 0), (345, 0), (350, 0), (355, 0), (360, 0), (365, 0), (370, 0), (375, 0), (380, 0), (385, 1), (390, 1), (395, 1), (400, 1), (405, 0), (410, 1), (415, 1), (420, 1), (425, 1), (430, 1), (435, 0), (440, 0), (445, 1), (450, 0), (455, 0), (460, 0), (465, 0), (470, 0), (475, 0), (480, 0), (485, 0), (490, 0), (495, 0), (500, 0), (505, 0), (510, 0), (515, 0), (520, 0), (525, 0), (530, 0), (535, 0), (540, 0), (545, 0), (550, 1), (555, 1), (560, 1), (565, 1), (570, 0), (575, 0), (580, 0), (585, 1), (590, 1), (595, 0), (600, 0), (605, 1), (610, 1), (615, 1), (620, 1), (625, 0), (630, 0), (635, 0), (640, 0), (645, 1), (650, 1), (655, 1), (660, 1), (665, 1), (670, 0), (675, 0), (680, 0), (685, 0), (690, 0), (695, 1), (700, 1), (705, 0), (710, 1), (715, 1), (720, 1), (725, 1), (730, 1), (735, 1), (740, 1), (745, 1), (750, 1), (755, 1), (760, 1), (765, 0), (770, 0), (775, 0), (780, 0), (785, 1), (790, 1), (795, 1), (800, 1), (805, 1), (810, 1), (815, 1), (820, 1), (825, 1), (830, 1), (835, 0), (840, 0), (845, 0), (850, 0), (855, 0), (860, 1), (865, 1), (870, 1), (875, 1), (880, 1), (885, 1), (890, 1), (895, 1), (900, 1), (905, 0), (910, 1), (915, 1), (920, 1), (925, 1), (930, 1), (935, 0), (940, 0), (945, 0), (950, 1), (955, 1), (960, 0), (965, 1), (970, 1), (975, 1), (980, 1), (985, 0), (990, 1), (995, 1), (1000, 0), (1005, 0), (1010, 0), (1015, 0), (1020, 0), (1025, 0)]
Vdin0_10  din0_10  0 PWL (0n 0.0v 4.745n 0.0v 4.755n 1.1v 9.745n 1.1v 9.755n 1.1v 14.745n 1.1v 14.755n 0.0v 19.745n 0.0v 19.755n 0.0v 24.745n 0.0v 24.755n 0.0v 29.745n 0.0v 29.755n 0.0v 34.745n 0.0v 34.755n 0.0v 39.745n 0.0v 39.755n 0.0v 44.745n 0.0v 44.755n 0.0v 49.745n 0.0v 49.755n 1.1v 54.745n 1.1v 54.755n 1.1v 59.745n 1.1v 59.755n 1.1v 64.745n 1.1v 64.755n 1.1v 69.745n 1.1v 69.755n 0.0v 74.745n 0.0v 74.755n 0.0v 79.745n 0.0v 79.755n 0.0v 84.745n 0.0v 84.755n 1.1v 89.745n 1.1v 89.755n 1.1v 94.745n 1.1v 94.755n 1.1v 99.745n 1.1v 99.755n 1.1v 104.745n 1.1v 104.755n 1.1v 109.745n 1.1v 109.755n 1.1v 114.745n 1.1v 114.755n 1.1v 119.745n 1.1v 119.755n 1.1v 124.745n 1.1v 124.755n 1.1v 129.745n 1.1v 129.755n 1.1v 134.745n 1.1v 134.755n 1.1v 139.745n 1.1v 139.755n 0.0v 144.745n 0.0v 144.755n 1.1v 149.745n 1.1v 149.755n 1.1v 154.745n 1.1v 154.755n 1.1v 159.745n 1.1v 159.755n 1.1v 164.745n 1.1v 164.755n 1.1v 169.745n 1.1v 169.755n 1.1v 174.745n 1.1v 174.755n 1.1v 179.745n 1.1v 179.755n 1.1v 184.745n 1.1v 184.755n 1.1v 189.745n 1.1v 189.755n 1.1v 194.745n 1.1v 194.755n 1.1v 199.745n 1.1v 199.755n 1.1v 204.745n 1.1v 204.755n 1.1v 209.745n 1.1v 209.755n 1.1v 214.745n 1.1v 214.755n 1.1v 219.745n 1.1v 219.755n 1.1v 224.745n 1.1v 224.755n 1.1v 229.745n 1.1v 229.755n 1.1v 234.745n 1.1v 234.755n 1.1v 239.745n 1.1v 239.755n 1.1v 244.745n 1.1v 244.755n 1.1v 249.745n 1.1v 249.755n 1.1v 254.745n 1.1v 254.755n 1.1v 259.745n 1.1v 259.755n 1.1v 264.745n 1.1v 264.755n 1.1v 269.745n 1.1v 269.755n 1.1v 274.745n 1.1v 274.755n 1.1v 279.745n 1.1v 279.755n 0.0v 284.745n 0.0v 284.755n 0.0v 289.745n 0.0v 289.755n 1.1v 294.745n 1.1v 294.755n 0.0v 299.745n 0.0v 299.755n 1.1v 304.745n 1.1v 304.755n 1.1v 309.745n 1.1v 309.755n 1.1v 314.745n 1.1v 314.755n 0.0v 319.745n 0.0v 319.755n 1.1v 324.745n 1.1v 324.755n 0.0v 329.745n 0.0v 329.755n 1.1v 334.745n 1.1v 334.755n 1.1v 339.745n 1.1v 339.755n 0.0v 344.745n 0.0v 344.755n 0.0v 349.745n 0.0v 349.755n 0.0v 354.745n 0.0v 354.755n 0.0v 359.745n 0.0v 359.755n 0.0v 364.745n 0.0v 364.755n 0.0v 369.745n 0.0v 369.755n 0.0v 374.745n 0.0v 374.755n 0.0v 379.745n 0.0v 379.755n 0.0v 384.745n 0.0v 384.755n 1.1v 389.745n 1.1v 389.755n 1.1v 394.745n 1.1v 394.755n 1.1v 399.745n 1.1v 399.755n 1.1v 404.745n 1.1v 404.755n 0.0v 409.745n 0.0v 409.755n 1.1v 414.745n 1.1v 414.755n 1.1v 419.745n 1.1v 419.755n 1.1v 424.745n 1.1v 424.755n 1.1v 429.745n 1.1v 429.755n 1.1v 434.745n 1.1v 434.755n 0.0v 439.745n 0.0v 439.755n 0.0v 444.745n 0.0v 444.755n 1.1v 449.745n 1.1v 449.755n 0.0v 454.745n 0.0v 454.755n 0.0v 459.745n 0.0v 459.755n 0.0v 464.745n 0.0v 464.755n 0.0v 469.745n 0.0v 469.755n 0.0v 474.745n 0.0v 474.755n 0.0v 479.745n 0.0v 479.755n 0.0v 484.745n 0.0v 484.755n 0.0v 489.745n 0.0v 489.755n 0.0v 494.745n 0.0v 494.755n 0.0v 499.745n 0.0v 499.755n 0.0v 504.745n 0.0v 504.755n 0.0v 509.745n 0.0v 509.755n 0.0v 514.745n 0.0v 514.755n 0.0v 519.745n 0.0v 519.755n 0.0v 524.745n 0.0v 524.755n 0.0v 529.745n 0.0v 529.755n 0.0v 534.745n 0.0v 534.755n 0.0v 539.745n 0.0v 539.755n 0.0v 544.745n 0.0v 544.755n 0.0v 549.745n 0.0v 549.755n 1.1v 554.745n 1.1v 554.755n 1.1v 559.745n 1.1v 559.755n 1.1v 564.745n 1.1v 564.755n 1.1v 569.745n 1.1v 569.755n 0.0v 574.745n 0.0v 574.755n 0.0v 579.745n 0.0v 579.755n 0.0v 584.745n 0.0v 584.755n 1.1v 589.745n 1.1v 589.755n 1.1v 594.745n 1.1v 594.755n 0.0v 599.745n 0.0v 599.755n 0.0v 604.745n 0.0v 604.755n 1.1v 609.745n 1.1v 609.755n 1.1v 614.745n 1.1v 614.755n 1.1v 619.745n 1.1v 619.755n 1.1v 624.745n 1.1v 624.755n 0.0v 629.745n 0.0v 629.755n 0.0v 634.745n 0.0v 634.755n 0.0v 639.745n 0.0v 639.755n 0.0v 644.745n 0.0v 644.755n 1.1v 649.745n 1.1v 649.755n 1.1v 654.745n 1.1v 654.755n 1.1v 659.745n 1.1v 659.755n 1.1v 664.745n 1.1v 664.755n 1.1v 669.745n 1.1v 669.755n 0.0v 674.745n 0.0v 674.755n 0.0v 679.745n 0.0v 679.755n 0.0v 684.745n 0.0v 684.755n 0.0v 689.745n 0.0v 689.755n 0.0v 694.745n 0.0v 694.755n 1.1v 699.745n 1.1v 699.755n 1.1v 704.745n 1.1v 704.755n 0.0v 709.745n 0.0v 709.755n 1.1v 714.745n 1.1v 714.755n 1.1v 719.745n 1.1v 719.755n 1.1v 724.745n 1.1v 724.755n 1.1v 729.745n 1.1v 729.755n 1.1v 734.745n 1.1v 734.755n 1.1v 739.745n 1.1v 739.755n 1.1v 744.745n 1.1v 744.755n 1.1v 749.745n 1.1v 749.755n 1.1v 754.745n 1.1v 754.755n 1.1v 759.745n 1.1v 759.755n 1.1v 764.745n 1.1v 764.755n 0.0v 769.745n 0.0v 769.755n 0.0v 774.745n 0.0v 774.755n 0.0v 779.745n 0.0v 779.755n 0.0v 784.745n 0.0v 784.755n 1.1v 789.745n 1.1v 789.755n 1.1v 794.745n 1.1v 794.755n 1.1v 799.745n 1.1v 799.755n 1.1v 804.745n 1.1v 804.755n 1.1v 809.745n 1.1v 809.755n 1.1v 814.745n 1.1v 814.755n 1.1v 819.745n 1.1v 819.755n 1.1v 824.745n 1.1v 824.755n 1.1v 829.745n 1.1v 829.755n 1.1v 834.745n 1.1v 834.755n 0.0v 839.745n 0.0v 839.755n 0.0v 844.745n 0.0v 844.755n 0.0v 849.745n 0.0v 849.755n 0.0v 854.745n 0.0v 854.755n 0.0v 859.745n 0.0v 859.755n 1.1v 864.745n 1.1v 864.755n 1.1v 869.745n 1.1v 869.755n 1.1v 874.745n 1.1v 874.755n 1.1v 879.745n 1.1v 879.755n 1.1v 884.745n 1.1v 884.755n 1.1v 889.745n 1.1v 889.755n 1.1v 894.745n 1.1v 894.755n 1.1v 899.745n 1.1v 899.755n 1.1v 904.745n 1.1v 904.755n 0.0v 909.745n 0.0v 909.755n 1.1v 914.745n 1.1v 914.755n 1.1v 919.745n 1.1v 919.755n 1.1v 924.745n 1.1v 924.755n 1.1v 929.745n 1.1v 929.755n 1.1v 934.745n 1.1v 934.755n 0.0v 939.745n 0.0v 939.755n 0.0v 944.745n 0.0v 944.755n 0.0v 949.745n 0.0v 949.755n 1.1v 954.745n 1.1v 954.755n 1.1v 959.745n 1.1v 959.755n 0.0v 964.745n 0.0v 964.755n 1.1v 969.745n 1.1v 969.755n 1.1v 974.745n 1.1v 974.755n 1.1v 979.745n 1.1v 979.755n 1.1v 984.745n 1.1v 984.755n 0.0v 989.745n 0.0v 989.755n 1.1v 994.745n 1.1v 994.755n 1.1v 999.745n 1.1v 999.755n 0.0v 1004.745n 0.0v 1004.755n 0.0v 1009.745n 0.0v 1009.755n 0.0v 1014.745n 0.0v 1014.755n 0.0v 1019.745n 0.0v 1019.755n 0.0v 1024.745n 0.0v 1024.755n 0.0v )
* (time, data): [(0, 0), (5, 0), (10, 0), (15, 1), (20, 1), (25, 1), (30, 1), (35, 1), (40, 1), (45, 1), (50, 0), (55, 0), (60, 0), (65, 0), (70, 1), (75, 1), (80, 1), (85, 1), (90, 1), (95, 1), (100, 0), (105, 0), (110, 0), (115, 1), (120, 1), (125, 1), (130, 1), (135, 1), (140, 0), (145, 0), (150, 0), (155, 0), (160, 0), (165, 0), (170, 0), (175, 0), (180, 1), (185, 1), (190, 1), (195, 1), (200, 1), (205, 1), (210, 0), (215, 0), (220, 1), (225, 1), (230, 1), (235, 1), (240, 1), (245, 1), (250, 1), (255, 1), (260, 1), (265, 1), (270, 1), (275, 1), (280, 0), (285, 0), (290, 0), (295, 0), (300, 1), (305, 1), (310, 1), (315, 1), (320, 1), (325, 1), (330, 1), (335, 0), (340, 1), (345, 1), (350, 1), (355, 1), (360, 1), (365, 1), (370, 1), (375, 1), (380, 1), (385, 1), (390, 1), (395, 0), (400, 0), (405, 0), (410, 0), (415, 0), (420, 0), (425, 0), (430, 0), (435, 1), (440, 1), (445, 1), (450, 1), (455, 0), (460, 0), (465, 0), (470, 0), (475, 0), (480, 0), (485, 0), (490, 1), (495, 1), (500, 1), (505, 1), (510, 1), (515, 0), (520, 0), (525, 0), (530, 0), (535, 1), (540, 0), (545, 0), (550, 0), (555, 0), (560, 0), (565, 0), (570, 1), (575, 1), (580, 1), (585, 1), (590, 0), (595, 1), (600, 0), (605, 1), (610, 1), (615, 0), (620, 0), (625, 1), (630, 1), (635, 1), (640, 1), (645, 0), (650, 0), (655, 0), (660, 0), (665, 0), (670, 1), (675, 1), (680, 1), (685, 1), (690, 1), (695, 0), (700, 1), (705, 0), (710, 0), (715, 0), (720, 0), (725, 0), (730, 0), (735, 0), (740, 0), (745, 0), (750, 0), (755, 1), (760, 1), (765, 1), (770, 1), (775, 1), (780, 1), (785, 0), (790, 0), (795, 0), (800, 0), (805, 0), (810, 0), (815, 0), (820, 0), (825, 0), (830, 0), (835, 0), (840, 0), (845, 0), (850, 0), (855, 0), (860, 1), (865, 1), (870, 1), (875, 1), (880, 1), (885, 1), (890, 0), (895, 0), (900, 0), (905, 1), (910, 0), (915, 0), (920, 1), (925, 1), (930, 0), (935, 0), (940, 0), (945, 0), (950, 0), (955, 0), (960, 0), (965, 1), (970, 1), (975, 1), (980, 1), (985, 1), (990, 0), (995, 0), (1000, 1), (1005, 1), (1010, 0), (1015, 0), (1020, 0), (1025, 0)]
Vdin0_11  din0_11  0 PWL (0n 0.0v 4.745n 0.0v 4.755n 0.0v 9.745n 0.0v 9.755n 0.0v 14.745n 0.0v 14.755n 1.1v 19.745n 1.1v 19.755n 1.1v 24.745n 1.1v 24.755n 1.1v 29.745n 1.1v 29.755n 1.1v 34.745n 1.1v 34.755n 1.1v 39.745n 1.1v 39.755n 1.1v 44.745n 1.1v 44.755n 1.1v 49.745n 1.1v 49.755n 0.0v 54.745n 0.0v 54.755n 0.0v 59.745n 0.0v 59.755n 0.0v 64.745n 0.0v 64.755n 0.0v 69.745n 0.0v 69.755n 1.1v 74.745n 1.1v 74.755n 1.1v 79.745n 1.1v 79.755n 1.1v 84.745n 1.1v 84.755n 1.1v 89.745n 1.1v 89.755n 1.1v 94.745n 1.1v 94.755n 1.1v 99.745n 1.1v 99.755n 0.0v 104.745n 0.0v 104.755n 0.0v 109.745n 0.0v 109.755n 0.0v 114.745n 0.0v 114.755n 1.1v 119.745n 1.1v 119.755n 1.1v 124.745n 1.1v 124.755n 1.1v 129.745n 1.1v 129.755n 1.1v 134.745n 1.1v 134.755n 1.1v 139.745n 1.1v 139.755n 0.0v 144.745n 0.0v 144.755n 0.0v 149.745n 0.0v 149.755n 0.0v 154.745n 0.0v 154.755n 0.0v 159.745n 0.0v 159.755n 0.0v 164.745n 0.0v 164.755n 0.0v 169.745n 0.0v 169.755n 0.0v 174.745n 0.0v 174.755n 0.0v 179.745n 0.0v 179.755n 1.1v 184.745n 1.1v 184.755n 1.1v 189.745n 1.1v 189.755n 1.1v 194.745n 1.1v 194.755n 1.1v 199.745n 1.1v 199.755n 1.1v 204.745n 1.1v 204.755n 1.1v 209.745n 1.1v 209.755n 0.0v 214.745n 0.0v 214.755n 0.0v 219.745n 0.0v 219.755n 1.1v 224.745n 1.1v 224.755n 1.1v 229.745n 1.1v 229.755n 1.1v 234.745n 1.1v 234.755n 1.1v 239.745n 1.1v 239.755n 1.1v 244.745n 1.1v 244.755n 1.1v 249.745n 1.1v 249.755n 1.1v 254.745n 1.1v 254.755n 1.1v 259.745n 1.1v 259.755n 1.1v 264.745n 1.1v 264.755n 1.1v 269.745n 1.1v 269.755n 1.1v 274.745n 1.1v 274.755n 1.1v 279.745n 1.1v 279.755n 0.0v 284.745n 0.0v 284.755n 0.0v 289.745n 0.0v 289.755n 0.0v 294.745n 0.0v 294.755n 0.0v 299.745n 0.0v 299.755n 1.1v 304.745n 1.1v 304.755n 1.1v 309.745n 1.1v 309.755n 1.1v 314.745n 1.1v 314.755n 1.1v 319.745n 1.1v 319.755n 1.1v 324.745n 1.1v 324.755n 1.1v 329.745n 1.1v 329.755n 1.1v 334.745n 1.1v 334.755n 0.0v 339.745n 0.0v 339.755n 1.1v 344.745n 1.1v 344.755n 1.1v 349.745n 1.1v 349.755n 1.1v 354.745n 1.1v 354.755n 1.1v 359.745n 1.1v 359.755n 1.1v 364.745n 1.1v 364.755n 1.1v 369.745n 1.1v 369.755n 1.1v 374.745n 1.1v 374.755n 1.1v 379.745n 1.1v 379.755n 1.1v 384.745n 1.1v 384.755n 1.1v 389.745n 1.1v 389.755n 1.1v 394.745n 1.1v 394.755n 0.0v 399.745n 0.0v 399.755n 0.0v 404.745n 0.0v 404.755n 0.0v 409.745n 0.0v 409.755n 0.0v 414.745n 0.0v 414.755n 0.0v 419.745n 0.0v 419.755n 0.0v 424.745n 0.0v 424.755n 0.0v 429.745n 0.0v 429.755n 0.0v 434.745n 0.0v 434.755n 1.1v 439.745n 1.1v 439.755n 1.1v 444.745n 1.1v 444.755n 1.1v 449.745n 1.1v 449.755n 1.1v 454.745n 1.1v 454.755n 0.0v 459.745n 0.0v 459.755n 0.0v 464.745n 0.0v 464.755n 0.0v 469.745n 0.0v 469.755n 0.0v 474.745n 0.0v 474.755n 0.0v 479.745n 0.0v 479.755n 0.0v 484.745n 0.0v 484.755n 0.0v 489.745n 0.0v 489.755n 1.1v 494.745n 1.1v 494.755n 1.1v 499.745n 1.1v 499.755n 1.1v 504.745n 1.1v 504.755n 1.1v 509.745n 1.1v 509.755n 1.1v 514.745n 1.1v 514.755n 0.0v 519.745n 0.0v 519.755n 0.0v 524.745n 0.0v 524.755n 0.0v 529.745n 0.0v 529.755n 0.0v 534.745n 0.0v 534.755n 1.1v 539.745n 1.1v 539.755n 0.0v 544.745n 0.0v 544.755n 0.0v 549.745n 0.0v 549.755n 0.0v 554.745n 0.0v 554.755n 0.0v 559.745n 0.0v 559.755n 0.0v 564.745n 0.0v 564.755n 0.0v 569.745n 0.0v 569.755n 1.1v 574.745n 1.1v 574.755n 1.1v 579.745n 1.1v 579.755n 1.1v 584.745n 1.1v 584.755n 1.1v 589.745n 1.1v 589.755n 0.0v 594.745n 0.0v 594.755n 1.1v 599.745n 1.1v 599.755n 0.0v 604.745n 0.0v 604.755n 1.1v 609.745n 1.1v 609.755n 1.1v 614.745n 1.1v 614.755n 0.0v 619.745n 0.0v 619.755n 0.0v 624.745n 0.0v 624.755n 1.1v 629.745n 1.1v 629.755n 1.1v 634.745n 1.1v 634.755n 1.1v 639.745n 1.1v 639.755n 1.1v 644.745n 1.1v 644.755n 0.0v 649.745n 0.0v 649.755n 0.0v 654.745n 0.0v 654.755n 0.0v 659.745n 0.0v 659.755n 0.0v 664.745n 0.0v 664.755n 0.0v 669.745n 0.0v 669.755n 1.1v 674.745n 1.1v 674.755n 1.1v 679.745n 1.1v 679.755n 1.1v 684.745n 1.1v 684.755n 1.1v 689.745n 1.1v 689.755n 1.1v 694.745n 1.1v 694.755n 0.0v 699.745n 0.0v 699.755n 1.1v 704.745n 1.1v 704.755n 0.0v 709.745n 0.0v 709.755n 0.0v 714.745n 0.0v 714.755n 0.0v 719.745n 0.0v 719.755n 0.0v 724.745n 0.0v 724.755n 0.0v 729.745n 0.0v 729.755n 0.0v 734.745n 0.0v 734.755n 0.0v 739.745n 0.0v 739.755n 0.0v 744.745n 0.0v 744.755n 0.0v 749.745n 0.0v 749.755n 0.0v 754.745n 0.0v 754.755n 1.1v 759.745n 1.1v 759.755n 1.1v 764.745n 1.1v 764.755n 1.1v 769.745n 1.1v 769.755n 1.1v 774.745n 1.1v 774.755n 1.1v 779.745n 1.1v 779.755n 1.1v 784.745n 1.1v 784.755n 0.0v 789.745n 0.0v 789.755n 0.0v 794.745n 0.0v 794.755n 0.0v 799.745n 0.0v 799.755n 0.0v 804.745n 0.0v 804.755n 0.0v 809.745n 0.0v 809.755n 0.0v 814.745n 0.0v 814.755n 0.0v 819.745n 0.0v 819.755n 0.0v 824.745n 0.0v 824.755n 0.0v 829.745n 0.0v 829.755n 0.0v 834.745n 0.0v 834.755n 0.0v 839.745n 0.0v 839.755n 0.0v 844.745n 0.0v 844.755n 0.0v 849.745n 0.0v 849.755n 0.0v 854.745n 0.0v 854.755n 0.0v 859.745n 0.0v 859.755n 1.1v 864.745n 1.1v 864.755n 1.1v 869.745n 1.1v 869.755n 1.1v 874.745n 1.1v 874.755n 1.1v 879.745n 1.1v 879.755n 1.1v 884.745n 1.1v 884.755n 1.1v 889.745n 1.1v 889.755n 0.0v 894.745n 0.0v 894.755n 0.0v 899.745n 0.0v 899.755n 0.0v 904.745n 0.0v 904.755n 1.1v 909.745n 1.1v 909.755n 0.0v 914.745n 0.0v 914.755n 0.0v 919.745n 0.0v 919.755n 1.1v 924.745n 1.1v 924.755n 1.1v 929.745n 1.1v 929.755n 0.0v 934.745n 0.0v 934.755n 0.0v 939.745n 0.0v 939.755n 0.0v 944.745n 0.0v 944.755n 0.0v 949.745n 0.0v 949.755n 0.0v 954.745n 0.0v 954.755n 0.0v 959.745n 0.0v 959.755n 0.0v 964.745n 0.0v 964.755n 1.1v 969.745n 1.1v 969.755n 1.1v 974.745n 1.1v 974.755n 1.1v 979.745n 1.1v 979.755n 1.1v 984.745n 1.1v 984.755n 1.1v 989.745n 1.1v 989.755n 0.0v 994.745n 0.0v 994.755n 0.0v 999.745n 0.0v 999.755n 1.1v 1004.745n 1.1v 1004.755n 1.1v 1009.745n 1.1v 1009.755n 0.0v 1014.745n 0.0v 1014.755n 0.0v 1019.745n 0.0v 1019.755n 0.0v 1024.745n 0.0v 1024.755n 0.0v )
* (time, data): [(0, 0), (5, 1), (10, 0), (15, 1), (20, 1), (25, 1), (30, 1), (35, 1), (40, 1), (45, 1), (50, 1), (55, 1), (60, 1), (65, 1), (70, 1), (75, 1), (80, 1), (85, 0), (90, 0), (95, 0), (100, 0), (105, 0), (110, 0), (115, 0), (120, 0), (125, 0), (130, 0), (135, 0), (140, 1), (145, 1), (150, 1), (155, 1), (160, 1), (165, 1), (170, 1), (175, 1), (180, 0), (185, 0), (190, 0), (195, 0), (200, 0), (205, 0), (210, 0), (215, 0), (220, 1), (225, 1), (230, 1), (235, 1), (240, 0), (245, 0), (250, 0), (255, 0), (260, 0), (265, 0), (270, 0), (275, 0), (280, 1), (285, 1), (290, 0), (295, 0), (300, 0), (305, 0), (310, 0), (315, 1), (320, 1), (325, 1), (330, 1), (335, 1), (340, 1), (345, 1), (350, 1), (355, 1), (360, 1), (365, 1), (370, 1), (375, 1), (380, 1), (385, 1), (390, 1), (395, 1), (400, 1), (405, 0), (410, 1), (415, 1), (420, 1), (425, 0), (430, 0), (435, 0), (440, 0), (445, 1), (450, 0), (455, 1), (460, 1), (465, 1), (470, 1), (475, 1), (480, 1), (485, 1), (490, 1), (495, 1), (500, 1), (505, 1), (510, 0), (515, 0), (520, 0), (525, 0), (530, 0), (535, 0), (540, 1), (545, 1), (550, 0), (555, 0), (560, 0), (565, 0), (570, 0), (575, 1), (580, 0), (585, 0), (590, 0), (595, 1), (600, 1), (605, 0), (610, 0), (615, 1), (620, 1), (625, 1), (630, 1), (635, 1), (640, 1), (645, 0), (650, 0), (655, 0), (660, 0), (665, 1), (670, 0), (675, 0), (680, 0), (685, 0), (690, 0), (695, 0), (700, 0), (705, 0), (710, 0), (715, 0), (720, 0), (725, 0), (730, 0), (735, 1), (740, 1), (745, 0), (750, 0), (755, 1), (760, 1), (765, 1), (770, 1), (775, 1), (780, 1), (785, 0), (790, 0), (795, 0), (800, 0), (805, 0), (810, 0), (815, 1), (820, 0), (825, 0), (830, 0), (835, 0), (840, 0), (845, 0), (850, 0), (855, 0), (860, 1), (865, 1), (870, 1), (875, 1), (880, 1), (885, 1), (890, 0), (895, 0), (900, 0), (905, 1), (910, 1), (915, 1), (920, 1), (925, 1), (930, 0), (935, 1), (940, 1), (945, 1), (950, 1), (955, 0), (960, 1), (965, 1), (970, 1), (975, 1), (980, 1), (985, 0), (990, 1), (995, 0), (1000, 1), (1005, 1), (1010, 0), (1015, 0), (1020, 0), (1025, 0)]
Vdin0_12  din0_12  0 PWL (0n 0.0v 4.745n 0.0v 4.755n 1.1v 9.745n 1.1v 9.755n 0.0v 14.745n 0.0v 14.755n 1.1v 19.745n 1.1v 19.755n 1.1v 24.745n 1.1v 24.755n 1.1v 29.745n 1.1v 29.755n 1.1v 34.745n 1.1v 34.755n 1.1v 39.745n 1.1v 39.755n 1.1v 44.745n 1.1v 44.755n 1.1v 49.745n 1.1v 49.755n 1.1v 54.745n 1.1v 54.755n 1.1v 59.745n 1.1v 59.755n 1.1v 64.745n 1.1v 64.755n 1.1v 69.745n 1.1v 69.755n 1.1v 74.745n 1.1v 74.755n 1.1v 79.745n 1.1v 79.755n 1.1v 84.745n 1.1v 84.755n 0.0v 89.745n 0.0v 89.755n 0.0v 94.745n 0.0v 94.755n 0.0v 99.745n 0.0v 99.755n 0.0v 104.745n 0.0v 104.755n 0.0v 109.745n 0.0v 109.755n 0.0v 114.745n 0.0v 114.755n 0.0v 119.745n 0.0v 119.755n 0.0v 124.745n 0.0v 124.755n 0.0v 129.745n 0.0v 129.755n 0.0v 134.745n 0.0v 134.755n 0.0v 139.745n 0.0v 139.755n 1.1v 144.745n 1.1v 144.755n 1.1v 149.745n 1.1v 149.755n 1.1v 154.745n 1.1v 154.755n 1.1v 159.745n 1.1v 159.755n 1.1v 164.745n 1.1v 164.755n 1.1v 169.745n 1.1v 169.755n 1.1v 174.745n 1.1v 174.755n 1.1v 179.745n 1.1v 179.755n 0.0v 184.745n 0.0v 184.755n 0.0v 189.745n 0.0v 189.755n 0.0v 194.745n 0.0v 194.755n 0.0v 199.745n 0.0v 199.755n 0.0v 204.745n 0.0v 204.755n 0.0v 209.745n 0.0v 209.755n 0.0v 214.745n 0.0v 214.755n 0.0v 219.745n 0.0v 219.755n 1.1v 224.745n 1.1v 224.755n 1.1v 229.745n 1.1v 229.755n 1.1v 234.745n 1.1v 234.755n 1.1v 239.745n 1.1v 239.755n 0.0v 244.745n 0.0v 244.755n 0.0v 249.745n 0.0v 249.755n 0.0v 254.745n 0.0v 254.755n 0.0v 259.745n 0.0v 259.755n 0.0v 264.745n 0.0v 264.755n 0.0v 269.745n 0.0v 269.755n 0.0v 274.745n 0.0v 274.755n 0.0v 279.745n 0.0v 279.755n 1.1v 284.745n 1.1v 284.755n 1.1v 289.745n 1.1v 289.755n 0.0v 294.745n 0.0v 294.755n 0.0v 299.745n 0.0v 299.755n 0.0v 304.745n 0.0v 304.755n 0.0v 309.745n 0.0v 309.755n 0.0v 314.745n 0.0v 314.755n 1.1v 319.745n 1.1v 319.755n 1.1v 324.745n 1.1v 324.755n 1.1v 329.745n 1.1v 329.755n 1.1v 334.745n 1.1v 334.755n 1.1v 339.745n 1.1v 339.755n 1.1v 344.745n 1.1v 344.755n 1.1v 349.745n 1.1v 349.755n 1.1v 354.745n 1.1v 354.755n 1.1v 359.745n 1.1v 359.755n 1.1v 364.745n 1.1v 364.755n 1.1v 369.745n 1.1v 369.755n 1.1v 374.745n 1.1v 374.755n 1.1v 379.745n 1.1v 379.755n 1.1v 384.745n 1.1v 384.755n 1.1v 389.745n 1.1v 389.755n 1.1v 394.745n 1.1v 394.755n 1.1v 399.745n 1.1v 399.755n 1.1v 404.745n 1.1v 404.755n 0.0v 409.745n 0.0v 409.755n 1.1v 414.745n 1.1v 414.755n 1.1v 419.745n 1.1v 419.755n 1.1v 424.745n 1.1v 424.755n 0.0v 429.745n 0.0v 429.755n 0.0v 434.745n 0.0v 434.755n 0.0v 439.745n 0.0v 439.755n 0.0v 444.745n 0.0v 444.755n 1.1v 449.745n 1.1v 449.755n 0.0v 454.745n 0.0v 454.755n 1.1v 459.745n 1.1v 459.755n 1.1v 464.745n 1.1v 464.755n 1.1v 469.745n 1.1v 469.755n 1.1v 474.745n 1.1v 474.755n 1.1v 479.745n 1.1v 479.755n 1.1v 484.745n 1.1v 484.755n 1.1v 489.745n 1.1v 489.755n 1.1v 494.745n 1.1v 494.755n 1.1v 499.745n 1.1v 499.755n 1.1v 504.745n 1.1v 504.755n 1.1v 509.745n 1.1v 509.755n 0.0v 514.745n 0.0v 514.755n 0.0v 519.745n 0.0v 519.755n 0.0v 524.745n 0.0v 524.755n 0.0v 529.745n 0.0v 529.755n 0.0v 534.745n 0.0v 534.755n 0.0v 539.745n 0.0v 539.755n 1.1v 544.745n 1.1v 544.755n 1.1v 549.745n 1.1v 549.755n 0.0v 554.745n 0.0v 554.755n 0.0v 559.745n 0.0v 559.755n 0.0v 564.745n 0.0v 564.755n 0.0v 569.745n 0.0v 569.755n 0.0v 574.745n 0.0v 574.755n 1.1v 579.745n 1.1v 579.755n 0.0v 584.745n 0.0v 584.755n 0.0v 589.745n 0.0v 589.755n 0.0v 594.745n 0.0v 594.755n 1.1v 599.745n 1.1v 599.755n 1.1v 604.745n 1.1v 604.755n 0.0v 609.745n 0.0v 609.755n 0.0v 614.745n 0.0v 614.755n 1.1v 619.745n 1.1v 619.755n 1.1v 624.745n 1.1v 624.755n 1.1v 629.745n 1.1v 629.755n 1.1v 634.745n 1.1v 634.755n 1.1v 639.745n 1.1v 639.755n 1.1v 644.745n 1.1v 644.755n 0.0v 649.745n 0.0v 649.755n 0.0v 654.745n 0.0v 654.755n 0.0v 659.745n 0.0v 659.755n 0.0v 664.745n 0.0v 664.755n 1.1v 669.745n 1.1v 669.755n 0.0v 674.745n 0.0v 674.755n 0.0v 679.745n 0.0v 679.755n 0.0v 684.745n 0.0v 684.755n 0.0v 689.745n 0.0v 689.755n 0.0v 694.745n 0.0v 694.755n 0.0v 699.745n 0.0v 699.755n 0.0v 704.745n 0.0v 704.755n 0.0v 709.745n 0.0v 709.755n 0.0v 714.745n 0.0v 714.755n 0.0v 719.745n 0.0v 719.755n 0.0v 724.745n 0.0v 724.755n 0.0v 729.745n 0.0v 729.755n 0.0v 734.745n 0.0v 734.755n 1.1v 739.745n 1.1v 739.755n 1.1v 744.745n 1.1v 744.755n 0.0v 749.745n 0.0v 749.755n 0.0v 754.745n 0.0v 754.755n 1.1v 759.745n 1.1v 759.755n 1.1v 764.745n 1.1v 764.755n 1.1v 769.745n 1.1v 769.755n 1.1v 774.745n 1.1v 774.755n 1.1v 779.745n 1.1v 779.755n 1.1v 784.745n 1.1v 784.755n 0.0v 789.745n 0.0v 789.755n 0.0v 794.745n 0.0v 794.755n 0.0v 799.745n 0.0v 799.755n 0.0v 804.745n 0.0v 804.755n 0.0v 809.745n 0.0v 809.755n 0.0v 814.745n 0.0v 814.755n 1.1v 819.745n 1.1v 819.755n 0.0v 824.745n 0.0v 824.755n 0.0v 829.745n 0.0v 829.755n 0.0v 834.745n 0.0v 834.755n 0.0v 839.745n 0.0v 839.755n 0.0v 844.745n 0.0v 844.755n 0.0v 849.745n 0.0v 849.755n 0.0v 854.745n 0.0v 854.755n 0.0v 859.745n 0.0v 859.755n 1.1v 864.745n 1.1v 864.755n 1.1v 869.745n 1.1v 869.755n 1.1v 874.745n 1.1v 874.755n 1.1v 879.745n 1.1v 879.755n 1.1v 884.745n 1.1v 884.755n 1.1v 889.745n 1.1v 889.755n 0.0v 894.745n 0.0v 894.755n 0.0v 899.745n 0.0v 899.755n 0.0v 904.745n 0.0v 904.755n 1.1v 909.745n 1.1v 909.755n 1.1v 914.745n 1.1v 914.755n 1.1v 919.745n 1.1v 919.755n 1.1v 924.745n 1.1v 924.755n 1.1v 929.745n 1.1v 929.755n 0.0v 934.745n 0.0v 934.755n 1.1v 939.745n 1.1v 939.755n 1.1v 944.745n 1.1v 944.755n 1.1v 949.745n 1.1v 949.755n 1.1v 954.745n 1.1v 954.755n 0.0v 959.745n 0.0v 959.755n 1.1v 964.745n 1.1v 964.755n 1.1v 969.745n 1.1v 969.755n 1.1v 974.745n 1.1v 974.755n 1.1v 979.745n 1.1v 979.755n 1.1v 984.745n 1.1v 984.755n 0.0v 989.745n 0.0v 989.755n 1.1v 994.745n 1.1v 994.755n 0.0v 999.745n 0.0v 999.755n 1.1v 1004.745n 1.1v 1004.755n 1.1v 1009.745n 1.1v 1009.755n 0.0v 1014.745n 0.0v 1014.755n 0.0v 1019.745n 0.0v 1019.755n 0.0v 1024.745n 0.0v 1024.755n 0.0v )
* (time, data): [(0, 0), (5, 0), (10, 1), (15, 0), (20, 0), (25, 0), (30, 0), (35, 0), (40, 0), (45, 0), (50, 0), (55, 0), (60, 0), (65, 0), (70, 1), (75, 1), (80, 1), (85, 1), (90, 1), (95, 1), (100, 0), (105, 0), (110, 0), (115, 1), (120, 1), (125, 1), (130, 1), (135, 1), (140, 0), (145, 0), (150, 0), (155, 0), (160, 0), (165, 0), (170, 0), (175, 0), (180, 0), (185, 0), (190, 0), (195, 0), (200, 0), (205, 0), (210, 1), (215, 1), (220, 0), (225, 0), (230, 0), (235, 0), (240, 1), (245, 1), (250, 1), (255, 1), (260, 1), (265, 1), (270, 1), (275, 1), (280, 0), (285, 0), (290, 1), (295, 1), (300, 1), (305, 1), (310, 1), (315, 0), (320, 0), (325, 1), (330, 1), (335, 1), (340, 0), (345, 0), (350, 0), (355, 0), (360, 0), (365, 0), (370, 0), (375, 0), (380, 0), (385, 0), (390, 0), (395, 1), (400, 1), (405, 0), (410, 0), (415, 0), (420, 0), (425, 1), (430, 1), (435, 0), (440, 0), (445, 1), (450, 1), (455, 1), (460, 1), (465, 1), (470, 1), (475, 1), (480, 1), (485, 1), (490, 1), (495, 1), (500, 1), (505, 1), (510, 0), (515, 0), (520, 0), (525, 0), (530, 0), (535, 0), (540, 1), (545, 0), (550, 1), (555, 1), (560, 1), (565, 1), (570, 0), (575, 0), (580, 0), (585, 0), (590, 0), (595, 0), (600, 0), (605, 1), (610, 1), (615, 0), (620, 0), (625, 0), (630, 0), (635, 0), (640, 0), (645, 0), (650, 0), (655, 0), (660, 0), (665, 0), (670, 0), (675, 0), (680, 0), (685, 0), (690, 1), (695, 0), (700, 0), (705, 0), (710, 0), (715, 0), (720, 0), (725, 0), (730, 0), (735, 1), (740, 1), (745, 1), (750, 1), (755, 1), (760, 1), (765, 1), (770, 1), (775, 1), (780, 1), (785, 1), (790, 1), (795, 1), (800, 1), (805, 1), (810, 1), (815, 0), (820, 0), (825, 0), (830, 0), (835, 0), (840, 0), (845, 0), (850, 0), (855, 0), (860, 0), (865, 0), (870, 0), (875, 0), (880, 0), (885, 0), (890, 0), (895, 0), (900, 0), (905, 1), (910, 0), (915, 0), (920, 1), (925, 1), (930, 0), (935, 1), (940, 1), (945, 1), (950, 0), (955, 0), (960, 1), (965, 1), (970, 1), (975, 1), (980, 1), (985, 0), (990, 0), (995, 0), (1000, 1), (1005, 1), (1010, 0), (1015, 0), (1020, 0), (1025, 0)]
Vdin0_13  din0_13  0 PWL (0n 0.0v 4.745n 0.0v 4.755n 0.0v 9.745n 0.0v 9.755n 1.1v 14.745n 1.1v 14.755n 0.0v 19.745n 0.0v 19.755n 0.0v 24.745n 0.0v 24.755n 0.0v 29.745n 0.0v 29.755n 0.0v 34.745n 0.0v 34.755n 0.0v 39.745n 0.0v 39.755n 0.0v 44.745n 0.0v 44.755n 0.0v 49.745n 0.0v 49.755n 0.0v 54.745n 0.0v 54.755n 0.0v 59.745n 0.0v 59.755n 0.0v 64.745n 0.0v 64.755n 0.0v 69.745n 0.0v 69.755n 1.1v 74.745n 1.1v 74.755n 1.1v 79.745n 1.1v 79.755n 1.1v 84.745n 1.1v 84.755n 1.1v 89.745n 1.1v 89.755n 1.1v 94.745n 1.1v 94.755n 1.1v 99.745n 1.1v 99.755n 0.0v 104.745n 0.0v 104.755n 0.0v 109.745n 0.0v 109.755n 0.0v 114.745n 0.0v 114.755n 1.1v 119.745n 1.1v 119.755n 1.1v 124.745n 1.1v 124.755n 1.1v 129.745n 1.1v 129.755n 1.1v 134.745n 1.1v 134.755n 1.1v 139.745n 1.1v 139.755n 0.0v 144.745n 0.0v 144.755n 0.0v 149.745n 0.0v 149.755n 0.0v 154.745n 0.0v 154.755n 0.0v 159.745n 0.0v 159.755n 0.0v 164.745n 0.0v 164.755n 0.0v 169.745n 0.0v 169.755n 0.0v 174.745n 0.0v 174.755n 0.0v 179.745n 0.0v 179.755n 0.0v 184.745n 0.0v 184.755n 0.0v 189.745n 0.0v 189.755n 0.0v 194.745n 0.0v 194.755n 0.0v 199.745n 0.0v 199.755n 0.0v 204.745n 0.0v 204.755n 0.0v 209.745n 0.0v 209.755n 1.1v 214.745n 1.1v 214.755n 1.1v 219.745n 1.1v 219.755n 0.0v 224.745n 0.0v 224.755n 0.0v 229.745n 0.0v 229.755n 0.0v 234.745n 0.0v 234.755n 0.0v 239.745n 0.0v 239.755n 1.1v 244.745n 1.1v 244.755n 1.1v 249.745n 1.1v 249.755n 1.1v 254.745n 1.1v 254.755n 1.1v 259.745n 1.1v 259.755n 1.1v 264.745n 1.1v 264.755n 1.1v 269.745n 1.1v 269.755n 1.1v 274.745n 1.1v 274.755n 1.1v 279.745n 1.1v 279.755n 0.0v 284.745n 0.0v 284.755n 0.0v 289.745n 0.0v 289.755n 1.1v 294.745n 1.1v 294.755n 1.1v 299.745n 1.1v 299.755n 1.1v 304.745n 1.1v 304.755n 1.1v 309.745n 1.1v 309.755n 1.1v 314.745n 1.1v 314.755n 0.0v 319.745n 0.0v 319.755n 0.0v 324.745n 0.0v 324.755n 1.1v 329.745n 1.1v 329.755n 1.1v 334.745n 1.1v 334.755n 1.1v 339.745n 1.1v 339.755n 0.0v 344.745n 0.0v 344.755n 0.0v 349.745n 0.0v 349.755n 0.0v 354.745n 0.0v 354.755n 0.0v 359.745n 0.0v 359.755n 0.0v 364.745n 0.0v 364.755n 0.0v 369.745n 0.0v 369.755n 0.0v 374.745n 0.0v 374.755n 0.0v 379.745n 0.0v 379.755n 0.0v 384.745n 0.0v 384.755n 0.0v 389.745n 0.0v 389.755n 0.0v 394.745n 0.0v 394.755n 1.1v 399.745n 1.1v 399.755n 1.1v 404.745n 1.1v 404.755n 0.0v 409.745n 0.0v 409.755n 0.0v 414.745n 0.0v 414.755n 0.0v 419.745n 0.0v 419.755n 0.0v 424.745n 0.0v 424.755n 1.1v 429.745n 1.1v 429.755n 1.1v 434.745n 1.1v 434.755n 0.0v 439.745n 0.0v 439.755n 0.0v 444.745n 0.0v 444.755n 1.1v 449.745n 1.1v 449.755n 1.1v 454.745n 1.1v 454.755n 1.1v 459.745n 1.1v 459.755n 1.1v 464.745n 1.1v 464.755n 1.1v 469.745n 1.1v 469.755n 1.1v 474.745n 1.1v 474.755n 1.1v 479.745n 1.1v 479.755n 1.1v 484.745n 1.1v 484.755n 1.1v 489.745n 1.1v 489.755n 1.1v 494.745n 1.1v 494.755n 1.1v 499.745n 1.1v 499.755n 1.1v 504.745n 1.1v 504.755n 1.1v 509.745n 1.1v 509.755n 0.0v 514.745n 0.0v 514.755n 0.0v 519.745n 0.0v 519.755n 0.0v 524.745n 0.0v 524.755n 0.0v 529.745n 0.0v 529.755n 0.0v 534.745n 0.0v 534.755n 0.0v 539.745n 0.0v 539.755n 1.1v 544.745n 1.1v 544.755n 0.0v 549.745n 0.0v 549.755n 1.1v 554.745n 1.1v 554.755n 1.1v 559.745n 1.1v 559.755n 1.1v 564.745n 1.1v 564.755n 1.1v 569.745n 1.1v 569.755n 0.0v 574.745n 0.0v 574.755n 0.0v 579.745n 0.0v 579.755n 0.0v 584.745n 0.0v 584.755n 0.0v 589.745n 0.0v 589.755n 0.0v 594.745n 0.0v 594.755n 0.0v 599.745n 0.0v 599.755n 0.0v 604.745n 0.0v 604.755n 1.1v 609.745n 1.1v 609.755n 1.1v 614.745n 1.1v 614.755n 0.0v 619.745n 0.0v 619.755n 0.0v 624.745n 0.0v 624.755n 0.0v 629.745n 0.0v 629.755n 0.0v 634.745n 0.0v 634.755n 0.0v 639.745n 0.0v 639.755n 0.0v 644.745n 0.0v 644.755n 0.0v 649.745n 0.0v 649.755n 0.0v 654.745n 0.0v 654.755n 0.0v 659.745n 0.0v 659.755n 0.0v 664.745n 0.0v 664.755n 0.0v 669.745n 0.0v 669.755n 0.0v 674.745n 0.0v 674.755n 0.0v 679.745n 0.0v 679.755n 0.0v 684.745n 0.0v 684.755n 0.0v 689.745n 0.0v 689.755n 1.1v 694.745n 1.1v 694.755n 0.0v 699.745n 0.0v 699.755n 0.0v 704.745n 0.0v 704.755n 0.0v 709.745n 0.0v 709.755n 0.0v 714.745n 0.0v 714.755n 0.0v 719.745n 0.0v 719.755n 0.0v 724.745n 0.0v 724.755n 0.0v 729.745n 0.0v 729.755n 0.0v 734.745n 0.0v 734.755n 1.1v 739.745n 1.1v 739.755n 1.1v 744.745n 1.1v 744.755n 1.1v 749.745n 1.1v 749.755n 1.1v 754.745n 1.1v 754.755n 1.1v 759.745n 1.1v 759.755n 1.1v 764.745n 1.1v 764.755n 1.1v 769.745n 1.1v 769.755n 1.1v 774.745n 1.1v 774.755n 1.1v 779.745n 1.1v 779.755n 1.1v 784.745n 1.1v 784.755n 1.1v 789.745n 1.1v 789.755n 1.1v 794.745n 1.1v 794.755n 1.1v 799.745n 1.1v 799.755n 1.1v 804.745n 1.1v 804.755n 1.1v 809.745n 1.1v 809.755n 1.1v 814.745n 1.1v 814.755n 0.0v 819.745n 0.0v 819.755n 0.0v 824.745n 0.0v 824.755n 0.0v 829.745n 0.0v 829.755n 0.0v 834.745n 0.0v 834.755n 0.0v 839.745n 0.0v 839.755n 0.0v 844.745n 0.0v 844.755n 0.0v 849.745n 0.0v 849.755n 0.0v 854.745n 0.0v 854.755n 0.0v 859.745n 0.0v 859.755n 0.0v 864.745n 0.0v 864.755n 0.0v 869.745n 0.0v 869.755n 0.0v 874.745n 0.0v 874.755n 0.0v 879.745n 0.0v 879.755n 0.0v 884.745n 0.0v 884.755n 0.0v 889.745n 0.0v 889.755n 0.0v 894.745n 0.0v 894.755n 0.0v 899.745n 0.0v 899.755n 0.0v 904.745n 0.0v 904.755n 1.1v 909.745n 1.1v 909.755n 0.0v 914.745n 0.0v 914.755n 0.0v 919.745n 0.0v 919.755n 1.1v 924.745n 1.1v 924.755n 1.1v 929.745n 1.1v 929.755n 0.0v 934.745n 0.0v 934.755n 1.1v 939.745n 1.1v 939.755n 1.1v 944.745n 1.1v 944.755n 1.1v 949.745n 1.1v 949.755n 0.0v 954.745n 0.0v 954.755n 0.0v 959.745n 0.0v 959.755n 1.1v 964.745n 1.1v 964.755n 1.1v 969.745n 1.1v 969.755n 1.1v 974.745n 1.1v 974.755n 1.1v 979.745n 1.1v 979.755n 1.1v 984.745n 1.1v 984.755n 0.0v 989.745n 0.0v 989.755n 0.0v 994.745n 0.0v 994.755n 0.0v 999.745n 0.0v 999.755n 1.1v 1004.745n 1.1v 1004.755n 1.1v 1009.745n 1.1v 1009.755n 0.0v 1014.745n 0.0v 1014.755n 0.0v 1019.745n 0.0v 1019.755n 0.0v 1024.745n 0.0v 1024.755n 0.0v )
* (time, data): [(0, 0), (5, 1), (10, 1), (15, 0), (20, 0), (25, 0), (30, 0), (35, 0), (40, 0), (45, 0), (50, 1), (55, 1), (60, 1), (65, 1), (70, 0), (75, 0), (80, 0), (85, 1), (90, 1), (95, 1), (100, 0), (105, 0), (110, 0), (115, 0), (120, 0), (125, 0), (130, 0), (135, 0), (140, 1), (145, 0), (150, 0), (155, 0), (160, 0), (165, 0), (170, 0), (175, 0), (180, 1), (185, 1), (190, 1), (195, 1), (200, 1), (205, 0), (210, 0), (215, 0), (220, 1), (225, 1), (230, 1), (235, 1), (240, 1), (245, 1), (250, 1), (255, 1), (260, 1), (265, 1), (270, 0), (275, 0), (280, 0), (285, 0), (290, 0), (295, 0), (300, 1), (305, 1), (310, 1), (315, 1), (320, 1), (325, 0), (330, 0), (335, 1), (340, 1), (345, 1), (350, 1), (355, 1), (360, 1), (365, 1), (370, 1), (375, 1), (380, 1), (385, 1), (390, 1), (395, 0), (400, 0), (405, 1), (410, 0), (415, 0), (420, 0), (425, 1), (430, 1), (435, 0), (440, 0), (445, 0), (450, 1), (455, 0), (460, 0), (465, 0), (470, 0), (475, 0), (480, 0), (485, 0), (490, 1), (495, 1), (500, 1), (505, 1), (510, 0), (515, 1), (520, 1), (525, 1), (530, 1), (535, 1), (540, 1), (545, 1), (550, 0), (555, 0), (560, 0), (565, 0), (570, 1), (575, 1), (580, 0), (585, 0), (590, 1), (595, 0), (600, 0), (605, 1), (610, 1), (615, 1), (620, 1), (625, 1), (630, 1), (635, 1), (640, 1), (645, 1), (650, 1), (655, 1), (660, 1), (665, 1), (670, 0), (675, 0), (680, 0), (685, 0), (690, 0), (695, 0), (700, 1), (705, 1), (710, 1), (715, 1), (720, 1), (725, 1), (730, 1), (735, 0), (740, 0), (745, 0), (750, 0), (755, 0), (760, 0), (765, 1), (770, 1), (775, 1), (780, 1), (785, 1), (790, 1), (795, 1), (800, 1), (805, 1), (810, 0), (815, 1), (820, 1), (825, 1), (830, 1), (835, 1), (840, 1), (845, 1), (850, 1), (855, 1), (860, 1), (865, 1), (870, 1), (875, 1), (880, 1), (885, 1), (890, 1), (895, 1), (900, 1), (905, 1), (910, 0), (915, 0), (920, 1), (925, 1), (930, 1), (935, 1), (940, 1), (945, 1), (950, 1), (955, 1), (960, 0), (965, 1), (970, 1), (975, 1), (980, 1), (985, 0), (990, 0), (995, 0), (1000, 0), (1005, 0), (1010, 0), (1015, 0), (1020, 0), (1025, 0)]
Vdin0_14  din0_14  0 PWL (0n 0.0v 4.745n 0.0v 4.755n 1.1v 9.745n 1.1v 9.755n 1.1v 14.745n 1.1v 14.755n 0.0v 19.745n 0.0v 19.755n 0.0v 24.745n 0.0v 24.755n 0.0v 29.745n 0.0v 29.755n 0.0v 34.745n 0.0v 34.755n 0.0v 39.745n 0.0v 39.755n 0.0v 44.745n 0.0v 44.755n 0.0v 49.745n 0.0v 49.755n 1.1v 54.745n 1.1v 54.755n 1.1v 59.745n 1.1v 59.755n 1.1v 64.745n 1.1v 64.755n 1.1v 69.745n 1.1v 69.755n 0.0v 74.745n 0.0v 74.755n 0.0v 79.745n 0.0v 79.755n 0.0v 84.745n 0.0v 84.755n 1.1v 89.745n 1.1v 89.755n 1.1v 94.745n 1.1v 94.755n 1.1v 99.745n 1.1v 99.755n 0.0v 104.745n 0.0v 104.755n 0.0v 109.745n 0.0v 109.755n 0.0v 114.745n 0.0v 114.755n 0.0v 119.745n 0.0v 119.755n 0.0v 124.745n 0.0v 124.755n 0.0v 129.745n 0.0v 129.755n 0.0v 134.745n 0.0v 134.755n 0.0v 139.745n 0.0v 139.755n 1.1v 144.745n 1.1v 144.755n 0.0v 149.745n 0.0v 149.755n 0.0v 154.745n 0.0v 154.755n 0.0v 159.745n 0.0v 159.755n 0.0v 164.745n 0.0v 164.755n 0.0v 169.745n 0.0v 169.755n 0.0v 174.745n 0.0v 174.755n 0.0v 179.745n 0.0v 179.755n 1.1v 184.745n 1.1v 184.755n 1.1v 189.745n 1.1v 189.755n 1.1v 194.745n 1.1v 194.755n 1.1v 199.745n 1.1v 199.755n 1.1v 204.745n 1.1v 204.755n 0.0v 209.745n 0.0v 209.755n 0.0v 214.745n 0.0v 214.755n 0.0v 219.745n 0.0v 219.755n 1.1v 224.745n 1.1v 224.755n 1.1v 229.745n 1.1v 229.755n 1.1v 234.745n 1.1v 234.755n 1.1v 239.745n 1.1v 239.755n 1.1v 244.745n 1.1v 244.755n 1.1v 249.745n 1.1v 249.755n 1.1v 254.745n 1.1v 254.755n 1.1v 259.745n 1.1v 259.755n 1.1v 264.745n 1.1v 264.755n 1.1v 269.745n 1.1v 269.755n 0.0v 274.745n 0.0v 274.755n 0.0v 279.745n 0.0v 279.755n 0.0v 284.745n 0.0v 284.755n 0.0v 289.745n 0.0v 289.755n 0.0v 294.745n 0.0v 294.755n 0.0v 299.745n 0.0v 299.755n 1.1v 304.745n 1.1v 304.755n 1.1v 309.745n 1.1v 309.755n 1.1v 314.745n 1.1v 314.755n 1.1v 319.745n 1.1v 319.755n 1.1v 324.745n 1.1v 324.755n 0.0v 329.745n 0.0v 329.755n 0.0v 334.745n 0.0v 334.755n 1.1v 339.745n 1.1v 339.755n 1.1v 344.745n 1.1v 344.755n 1.1v 349.745n 1.1v 349.755n 1.1v 354.745n 1.1v 354.755n 1.1v 359.745n 1.1v 359.755n 1.1v 364.745n 1.1v 364.755n 1.1v 369.745n 1.1v 369.755n 1.1v 374.745n 1.1v 374.755n 1.1v 379.745n 1.1v 379.755n 1.1v 384.745n 1.1v 384.755n 1.1v 389.745n 1.1v 389.755n 1.1v 394.745n 1.1v 394.755n 0.0v 399.745n 0.0v 399.755n 0.0v 404.745n 0.0v 404.755n 1.1v 409.745n 1.1v 409.755n 0.0v 414.745n 0.0v 414.755n 0.0v 419.745n 0.0v 419.755n 0.0v 424.745n 0.0v 424.755n 1.1v 429.745n 1.1v 429.755n 1.1v 434.745n 1.1v 434.755n 0.0v 439.745n 0.0v 439.755n 0.0v 444.745n 0.0v 444.755n 0.0v 449.745n 0.0v 449.755n 1.1v 454.745n 1.1v 454.755n 0.0v 459.745n 0.0v 459.755n 0.0v 464.745n 0.0v 464.755n 0.0v 469.745n 0.0v 469.755n 0.0v 474.745n 0.0v 474.755n 0.0v 479.745n 0.0v 479.755n 0.0v 484.745n 0.0v 484.755n 0.0v 489.745n 0.0v 489.755n 1.1v 494.745n 1.1v 494.755n 1.1v 499.745n 1.1v 499.755n 1.1v 504.745n 1.1v 504.755n 1.1v 509.745n 1.1v 509.755n 0.0v 514.745n 0.0v 514.755n 1.1v 519.745n 1.1v 519.755n 1.1v 524.745n 1.1v 524.755n 1.1v 529.745n 1.1v 529.755n 1.1v 534.745n 1.1v 534.755n 1.1v 539.745n 1.1v 539.755n 1.1v 544.745n 1.1v 544.755n 1.1v 549.745n 1.1v 549.755n 0.0v 554.745n 0.0v 554.755n 0.0v 559.745n 0.0v 559.755n 0.0v 564.745n 0.0v 564.755n 0.0v 569.745n 0.0v 569.755n 1.1v 574.745n 1.1v 574.755n 1.1v 579.745n 1.1v 579.755n 0.0v 584.745n 0.0v 584.755n 0.0v 589.745n 0.0v 589.755n 1.1v 594.745n 1.1v 594.755n 0.0v 599.745n 0.0v 599.755n 0.0v 604.745n 0.0v 604.755n 1.1v 609.745n 1.1v 609.755n 1.1v 614.745n 1.1v 614.755n 1.1v 619.745n 1.1v 619.755n 1.1v 624.745n 1.1v 624.755n 1.1v 629.745n 1.1v 629.755n 1.1v 634.745n 1.1v 634.755n 1.1v 639.745n 1.1v 639.755n 1.1v 644.745n 1.1v 644.755n 1.1v 649.745n 1.1v 649.755n 1.1v 654.745n 1.1v 654.755n 1.1v 659.745n 1.1v 659.755n 1.1v 664.745n 1.1v 664.755n 1.1v 669.745n 1.1v 669.755n 0.0v 674.745n 0.0v 674.755n 0.0v 679.745n 0.0v 679.755n 0.0v 684.745n 0.0v 684.755n 0.0v 689.745n 0.0v 689.755n 0.0v 694.745n 0.0v 694.755n 0.0v 699.745n 0.0v 699.755n 1.1v 704.745n 1.1v 704.755n 1.1v 709.745n 1.1v 709.755n 1.1v 714.745n 1.1v 714.755n 1.1v 719.745n 1.1v 719.755n 1.1v 724.745n 1.1v 724.755n 1.1v 729.745n 1.1v 729.755n 1.1v 734.745n 1.1v 734.755n 0.0v 739.745n 0.0v 739.755n 0.0v 744.745n 0.0v 744.755n 0.0v 749.745n 0.0v 749.755n 0.0v 754.745n 0.0v 754.755n 0.0v 759.745n 0.0v 759.755n 0.0v 764.745n 0.0v 764.755n 1.1v 769.745n 1.1v 769.755n 1.1v 774.745n 1.1v 774.755n 1.1v 779.745n 1.1v 779.755n 1.1v 784.745n 1.1v 784.755n 1.1v 789.745n 1.1v 789.755n 1.1v 794.745n 1.1v 794.755n 1.1v 799.745n 1.1v 799.755n 1.1v 804.745n 1.1v 804.755n 1.1v 809.745n 1.1v 809.755n 0.0v 814.745n 0.0v 814.755n 1.1v 819.745n 1.1v 819.755n 1.1v 824.745n 1.1v 824.755n 1.1v 829.745n 1.1v 829.755n 1.1v 834.745n 1.1v 834.755n 1.1v 839.745n 1.1v 839.755n 1.1v 844.745n 1.1v 844.755n 1.1v 849.745n 1.1v 849.755n 1.1v 854.745n 1.1v 854.755n 1.1v 859.745n 1.1v 859.755n 1.1v 864.745n 1.1v 864.755n 1.1v 869.745n 1.1v 869.755n 1.1v 874.745n 1.1v 874.755n 1.1v 879.745n 1.1v 879.755n 1.1v 884.745n 1.1v 884.755n 1.1v 889.745n 1.1v 889.755n 1.1v 894.745n 1.1v 894.755n 1.1v 899.745n 1.1v 899.755n 1.1v 904.745n 1.1v 904.755n 1.1v 909.745n 1.1v 909.755n 0.0v 914.745n 0.0v 914.755n 0.0v 919.745n 0.0v 919.755n 1.1v 924.745n 1.1v 924.755n 1.1v 929.745n 1.1v 929.755n 1.1v 934.745n 1.1v 934.755n 1.1v 939.745n 1.1v 939.755n 1.1v 944.745n 1.1v 944.755n 1.1v 949.745n 1.1v 949.755n 1.1v 954.745n 1.1v 954.755n 1.1v 959.745n 1.1v 959.755n 0.0v 964.745n 0.0v 964.755n 1.1v 969.745n 1.1v 969.755n 1.1v 974.745n 1.1v 974.755n 1.1v 979.745n 1.1v 979.755n 1.1v 984.745n 1.1v 984.755n 0.0v 989.745n 0.0v 989.755n 0.0v 994.745n 0.0v 994.755n 0.0v 999.745n 0.0v 999.755n 0.0v 1004.745n 0.0v 1004.755n 0.0v 1009.745n 0.0v 1009.755n 0.0v 1014.745n 0.0v 1014.755n 0.0v 1019.745n 0.0v 1019.755n 0.0v 1024.745n 0.0v 1024.755n 0.0v )
* (time, data): [(0, 0), (5, 0), (10, 1), (15, 0), (20, 0), (25, 0), (30, 0), (35, 0), (40, 0), (45, 0), (50, 0), (55, 0), (60, 0), (65, 0), (70, 0), (75, 0), (80, 0), (85, 0), (90, 0), (95, 0), (100, 1), (105, 1), (110, 1), (115, 1), (120, 1), (125, 1), (130, 1), (135, 1), (140, 0), (145, 0), (150, 0), (155, 0), (160, 0), (165, 0), (170, 0), (175, 0), (180, 1), (185, 1), (190, 1), (195, 1), (200, 1), (205, 0), (210, 0), (215, 0), (220, 0), (225, 0), (230, 0), (235, 0), (240, 0), (245, 0), (250, 0), (255, 0), (260, 0), (265, 0), (270, 0), (275, 0), (280, 0), (285, 0), (290, 0), (295, 1), (300, 1), (305, 1), (310, 1), (315, 0), (320, 1), (325, 1), (330, 1), (335, 1), (340, 0), (345, 0), (350, 0), (355, 0), (360, 0), (365, 0), (370, 0), (375, 0), (380, 0), (385, 1), (390, 1), (395, 0), (400, 0), (405, 0), (410, 0), (415, 0), (420, 0), (425, 0), (430, 0), (435, 1), (440, 1), (445, 0), (450, 1), (455, 1), (460, 1), (465, 1), (470, 1), (475, 1), (480, 1), (485, 1), (490, 0), (495, 0), (500, 0), (505, 0), (510, 0), (515, 0), (520, 0), (525, 0), (530, 0), (535, 1), (540, 1), (545, 0), (550, 0), (555, 0), (560, 0), (565, 0), (570, 1), (575, 0), (580, 0), (585, 1), (590, 1), (595, 1), (600, 0), (605, 1), (610, 1), (615, 1), (620, 1), (625, 1), (630, 1), (635, 1), (640, 1), (645, 0), (650, 0), (655, 0), (660, 0), (665, 0), (670, 1), (675, 1), (680, 1), (685, 1), (690, 1), (695, 0), (700, 1), (705, 1), (710, 0), (715, 0), (720, 0), (725, 0), (730, 0), (735, 0), (740, 0), (745, 0), (750, 0), (755, 1), (760, 1), (765, 0), (770, 0), (775, 0), (780, 0), (785, 1), (790, 1), (795, 1), (800, 1), (805, 1), (810, 0), (815, 1), (820, 1), (825, 1), (830, 1), (835, 1), (840, 1), (845, 1), (850, 1), (855, 1), (860, 0), (865, 0), (870, 0), (875, 0), (880, 0), (885, 0), (890, 0), (895, 0), (900, 0), (905, 0), (910, 0), (915, 0), (920, 0), (925, 0), (930, 0), (935, 1), (940, 1), (945, 1), (950, 1), (955, 0), (960, 1), (965, 0), (970, 1), (975, 1), (980, 1), (985, 0), (990, 0), (995, 0), (1000, 0), (1005, 0), (1010, 0), (1015, 0), (1020, 0), (1025, 0)]
Vdin0_15  din0_15  0 PWL (0n 0.0v 4.745n 0.0v 4.755n 0.0v 9.745n 0.0v 9.755n 1.1v 14.745n 1.1v 14.755n 0.0v 19.745n 0.0v 19.755n 0.0v 24.745n 0.0v 24.755n 0.0v 29.745n 0.0v 29.755n 0.0v 34.745n 0.0v 34.755n 0.0v 39.745n 0.0v 39.755n 0.0v 44.745n 0.0v 44.755n 0.0v 49.745n 0.0v 49.755n 0.0v 54.745n 0.0v 54.755n 0.0v 59.745n 0.0v 59.755n 0.0v 64.745n 0.0v 64.755n 0.0v 69.745n 0.0v 69.755n 0.0v 74.745n 0.0v 74.755n 0.0v 79.745n 0.0v 79.755n 0.0v 84.745n 0.0v 84.755n 0.0v 89.745n 0.0v 89.755n 0.0v 94.745n 0.0v 94.755n 0.0v 99.745n 0.0v 99.755n 1.1v 104.745n 1.1v 104.755n 1.1v 109.745n 1.1v 109.755n 1.1v 114.745n 1.1v 114.755n 1.1v 119.745n 1.1v 119.755n 1.1v 124.745n 1.1v 124.755n 1.1v 129.745n 1.1v 129.755n 1.1v 134.745n 1.1v 134.755n 1.1v 139.745n 1.1v 139.755n 0.0v 144.745n 0.0v 144.755n 0.0v 149.745n 0.0v 149.755n 0.0v 154.745n 0.0v 154.755n 0.0v 159.745n 0.0v 159.755n 0.0v 164.745n 0.0v 164.755n 0.0v 169.745n 0.0v 169.755n 0.0v 174.745n 0.0v 174.755n 0.0v 179.745n 0.0v 179.755n 1.1v 184.745n 1.1v 184.755n 1.1v 189.745n 1.1v 189.755n 1.1v 194.745n 1.1v 194.755n 1.1v 199.745n 1.1v 199.755n 1.1v 204.745n 1.1v 204.755n 0.0v 209.745n 0.0v 209.755n 0.0v 214.745n 0.0v 214.755n 0.0v 219.745n 0.0v 219.755n 0.0v 224.745n 0.0v 224.755n 0.0v 229.745n 0.0v 229.755n 0.0v 234.745n 0.0v 234.755n 0.0v 239.745n 0.0v 239.755n 0.0v 244.745n 0.0v 244.755n 0.0v 249.745n 0.0v 249.755n 0.0v 254.745n 0.0v 254.755n 0.0v 259.745n 0.0v 259.755n 0.0v 264.745n 0.0v 264.755n 0.0v 269.745n 0.0v 269.755n 0.0v 274.745n 0.0v 274.755n 0.0v 279.745n 0.0v 279.755n 0.0v 284.745n 0.0v 284.755n 0.0v 289.745n 0.0v 289.755n 0.0v 294.745n 0.0v 294.755n 1.1v 299.745n 1.1v 299.755n 1.1v 304.745n 1.1v 304.755n 1.1v 309.745n 1.1v 309.755n 1.1v 314.745n 1.1v 314.755n 0.0v 319.745n 0.0v 319.755n 1.1v 324.745n 1.1v 324.755n 1.1v 329.745n 1.1v 329.755n 1.1v 334.745n 1.1v 334.755n 1.1v 339.745n 1.1v 339.755n 0.0v 344.745n 0.0v 344.755n 0.0v 349.745n 0.0v 349.755n 0.0v 354.745n 0.0v 354.755n 0.0v 359.745n 0.0v 359.755n 0.0v 364.745n 0.0v 364.755n 0.0v 369.745n 0.0v 369.755n 0.0v 374.745n 0.0v 374.755n 0.0v 379.745n 0.0v 379.755n 0.0v 384.745n 0.0v 384.755n 1.1v 389.745n 1.1v 389.755n 1.1v 394.745n 1.1v 394.755n 0.0v 399.745n 0.0v 399.755n 0.0v 404.745n 0.0v 404.755n 0.0v 409.745n 0.0v 409.755n 0.0v 414.745n 0.0v 414.755n 0.0v 419.745n 0.0v 419.755n 0.0v 424.745n 0.0v 424.755n 0.0v 429.745n 0.0v 429.755n 0.0v 434.745n 0.0v 434.755n 1.1v 439.745n 1.1v 439.755n 1.1v 444.745n 1.1v 444.755n 0.0v 449.745n 0.0v 449.755n 1.1v 454.745n 1.1v 454.755n 1.1v 459.745n 1.1v 459.755n 1.1v 464.745n 1.1v 464.755n 1.1v 469.745n 1.1v 469.755n 1.1v 474.745n 1.1v 474.755n 1.1v 479.745n 1.1v 479.755n 1.1v 484.745n 1.1v 484.755n 1.1v 489.745n 1.1v 489.755n 0.0v 494.745n 0.0v 494.755n 0.0v 499.745n 0.0v 499.755n 0.0v 504.745n 0.0v 504.755n 0.0v 509.745n 0.0v 509.755n 0.0v 514.745n 0.0v 514.755n 0.0v 519.745n 0.0v 519.755n 0.0v 524.745n 0.0v 524.755n 0.0v 529.745n 0.0v 529.755n 0.0v 534.745n 0.0v 534.755n 1.1v 539.745n 1.1v 539.755n 1.1v 544.745n 1.1v 544.755n 0.0v 549.745n 0.0v 549.755n 0.0v 554.745n 0.0v 554.755n 0.0v 559.745n 0.0v 559.755n 0.0v 564.745n 0.0v 564.755n 0.0v 569.745n 0.0v 569.755n 1.1v 574.745n 1.1v 574.755n 0.0v 579.745n 0.0v 579.755n 0.0v 584.745n 0.0v 584.755n 1.1v 589.745n 1.1v 589.755n 1.1v 594.745n 1.1v 594.755n 1.1v 599.745n 1.1v 599.755n 0.0v 604.745n 0.0v 604.755n 1.1v 609.745n 1.1v 609.755n 1.1v 614.745n 1.1v 614.755n 1.1v 619.745n 1.1v 619.755n 1.1v 624.745n 1.1v 624.755n 1.1v 629.745n 1.1v 629.755n 1.1v 634.745n 1.1v 634.755n 1.1v 639.745n 1.1v 639.755n 1.1v 644.745n 1.1v 644.755n 0.0v 649.745n 0.0v 649.755n 0.0v 654.745n 0.0v 654.755n 0.0v 659.745n 0.0v 659.755n 0.0v 664.745n 0.0v 664.755n 0.0v 669.745n 0.0v 669.755n 1.1v 674.745n 1.1v 674.755n 1.1v 679.745n 1.1v 679.755n 1.1v 684.745n 1.1v 684.755n 1.1v 689.745n 1.1v 689.755n 1.1v 694.745n 1.1v 694.755n 0.0v 699.745n 0.0v 699.755n 1.1v 704.745n 1.1v 704.755n 1.1v 709.745n 1.1v 709.755n 0.0v 714.745n 0.0v 714.755n 0.0v 719.745n 0.0v 719.755n 0.0v 724.745n 0.0v 724.755n 0.0v 729.745n 0.0v 729.755n 0.0v 734.745n 0.0v 734.755n 0.0v 739.745n 0.0v 739.755n 0.0v 744.745n 0.0v 744.755n 0.0v 749.745n 0.0v 749.755n 0.0v 754.745n 0.0v 754.755n 1.1v 759.745n 1.1v 759.755n 1.1v 764.745n 1.1v 764.755n 0.0v 769.745n 0.0v 769.755n 0.0v 774.745n 0.0v 774.755n 0.0v 779.745n 0.0v 779.755n 0.0v 784.745n 0.0v 784.755n 1.1v 789.745n 1.1v 789.755n 1.1v 794.745n 1.1v 794.755n 1.1v 799.745n 1.1v 799.755n 1.1v 804.745n 1.1v 804.755n 1.1v 809.745n 1.1v 809.755n 0.0v 814.745n 0.0v 814.755n 1.1v 819.745n 1.1v 819.755n 1.1v 824.745n 1.1v 824.755n 1.1v 829.745n 1.1v 829.755n 1.1v 834.745n 1.1v 834.755n 1.1v 839.745n 1.1v 839.755n 1.1v 844.745n 1.1v 844.755n 1.1v 849.745n 1.1v 849.755n 1.1v 854.745n 1.1v 854.755n 1.1v 859.745n 1.1v 859.755n 0.0v 864.745n 0.0v 864.755n 0.0v 869.745n 0.0v 869.755n 0.0v 874.745n 0.0v 874.755n 0.0v 879.745n 0.0v 879.755n 0.0v 884.745n 0.0v 884.755n 0.0v 889.745n 0.0v 889.755n 0.0v 894.745n 0.0v 894.755n 0.0v 899.745n 0.0v 899.755n 0.0v 904.745n 0.0v 904.755n 0.0v 909.745n 0.0v 909.755n 0.0v 914.745n 0.0v 914.755n 0.0v 919.745n 0.0v 919.755n 0.0v 924.745n 0.0v 924.755n 0.0v 929.745n 0.0v 929.755n 0.0v 934.745n 0.0v 934.755n 1.1v 939.745n 1.1v 939.755n 1.1v 944.745n 1.1v 944.755n 1.1v 949.745n 1.1v 949.755n 1.1v 954.745n 1.1v 954.755n 0.0v 959.745n 0.0v 959.755n 1.1v 964.745n 1.1v 964.755n 0.0v 969.745n 0.0v 969.755n 1.1v 974.745n 1.1v 974.755n 1.1v 979.745n 1.1v 979.755n 1.1v 984.745n 1.1v 984.755n 0.0v 989.745n 0.0v 989.755n 0.0v 994.745n 0.0v 994.755n 0.0v 999.745n 0.0v 999.755n 0.0v 1004.745n 0.0v 1004.755n 0.0v 1009.745n 0.0v 1009.755n 0.0v 1014.745n 0.0v 1014.755n 0.0v 1019.745n 0.0v 1019.755n 0.0v 1024.745n 0.0v 1024.755n 0.0v )
* (time, data): [(0, 0), (5, 0), (10, 1), (15, 1), (20, 1), (25, 1), (30, 1), (35, 1), (40, 1), (45, 1), (50, 1), (55, 1), (60, 1), (65, 1), (70, 0), (75, 0), (80, 0), (85, 0), (90, 0), (95, 0), (100, 0), (105, 0), (110, 0), (115, 1), (120, 1), (125, 1), (130, 1), (135, 1), (140, 0), (145, 1), (150, 1), (155, 1), (160, 1), (165, 1), (170, 1), (175, 1), (180, 0), (185, 0), (190, 0), (195, 0), (200, 0), (205, 1), (210, 0), (215, 0), (220, 0), (225, 0), (230, 0), (235, 0), (240, 1), (245, 1), (250, 1), (255, 1), (260, 1), (265, 1), (270, 1), (275, 1), (280, 1), (285, 1), (290, 1), (295, 1), (300, 1), (305, 1), (310, 1), (315, 1), (320, 1), (325, 0), (330, 0), (335, 0), (340, 0), (345, 0), (350, 0), (355, 0), (360, 0), (365, 0), (370, 0), (375, 0), (380, 0), (385, 1), (390, 1), (395, 1), (400, 1), (405, 0), (410, 1), (415, 1), (420, 1), (425, 1), (430, 1), (435, 1), (440, 1), (445, 0), (450, 1), (455, 0), (460, 0), (465, 0), (470, 0), (475, 0), (480, 0), (485, 0), (490, 1), (495, 1), (500, 1), (505, 1), (510, 0), (515, 1), (520, 1), (525, 1), (530, 1), (535, 0), (540, 0), (545, 1), (550, 0), (555, 0), (560, 0), (565, 0), (570, 0), (575, 0), (580, 1), (585, 0), (590, 1), (595, 0), (600, 1), (605, 0), (610, 0), (615, 1), (620, 1), (625, 0), (630, 0), (635, 0), (640, 0), (645, 0), (650, 0), (655, 0), (660, 0), (665, 1), (670, 1), (675, 1), (680, 1), (685, 1), (690, 0), (695, 1), (700, 0), (705, 0), (710, 0), (715, 0), (720, 0), (725, 0), (730, 0), (735, 0), (740, 0), (745, 0), (750, 0), (755, 0), (760, 0), (765, 1), (770, 1), (775, 1), (780, 1), (785, 1), (790, 1), (795, 1), (800, 1), (805, 1), (810, 1), (815, 1), (820, 0), (825, 0), (830, 0), (835, 0), (840, 0), (845, 0), (850, 0), (855, 0), (860, 0), (865, 0), (870, 0), (875, 0), (880, 0), (885, 0), (890, 0), (895, 0), (900, 1), (905, 0), (910, 0), (915, 0), (920, 1), (925, 1), (930, 1), (935, 1), (940, 1), (945, 1), (950, 0), (955, 1), (960, 0), (965, 1), (970, 0), (975, 0), (980, 0), (985, 0), (990, 0), (995, 1), (1000, 1), (1005, 1), (1010, 1), (1015, 1), (1020, 1), (1025, 1)]
Vdin0_16  din0_16  0 PWL (0n 0.0v 4.745n 0.0v 4.755n 0.0v 9.745n 0.0v 9.755n 1.1v 14.745n 1.1v 14.755n 1.1v 19.745n 1.1v 19.755n 1.1v 24.745n 1.1v 24.755n 1.1v 29.745n 1.1v 29.755n 1.1v 34.745n 1.1v 34.755n 1.1v 39.745n 1.1v 39.755n 1.1v 44.745n 1.1v 44.755n 1.1v 49.745n 1.1v 49.755n 1.1v 54.745n 1.1v 54.755n 1.1v 59.745n 1.1v 59.755n 1.1v 64.745n 1.1v 64.755n 1.1v 69.745n 1.1v 69.755n 0.0v 74.745n 0.0v 74.755n 0.0v 79.745n 0.0v 79.755n 0.0v 84.745n 0.0v 84.755n 0.0v 89.745n 0.0v 89.755n 0.0v 94.745n 0.0v 94.755n 0.0v 99.745n 0.0v 99.755n 0.0v 104.745n 0.0v 104.755n 0.0v 109.745n 0.0v 109.755n 0.0v 114.745n 0.0v 114.755n 1.1v 119.745n 1.1v 119.755n 1.1v 124.745n 1.1v 124.755n 1.1v 129.745n 1.1v 129.755n 1.1v 134.745n 1.1v 134.755n 1.1v 139.745n 1.1v 139.755n 0.0v 144.745n 0.0v 144.755n 1.1v 149.745n 1.1v 149.755n 1.1v 154.745n 1.1v 154.755n 1.1v 159.745n 1.1v 159.755n 1.1v 164.745n 1.1v 164.755n 1.1v 169.745n 1.1v 169.755n 1.1v 174.745n 1.1v 174.755n 1.1v 179.745n 1.1v 179.755n 0.0v 184.745n 0.0v 184.755n 0.0v 189.745n 0.0v 189.755n 0.0v 194.745n 0.0v 194.755n 0.0v 199.745n 0.0v 199.755n 0.0v 204.745n 0.0v 204.755n 1.1v 209.745n 1.1v 209.755n 0.0v 214.745n 0.0v 214.755n 0.0v 219.745n 0.0v 219.755n 0.0v 224.745n 0.0v 224.755n 0.0v 229.745n 0.0v 229.755n 0.0v 234.745n 0.0v 234.755n 0.0v 239.745n 0.0v 239.755n 1.1v 244.745n 1.1v 244.755n 1.1v 249.745n 1.1v 249.755n 1.1v 254.745n 1.1v 254.755n 1.1v 259.745n 1.1v 259.755n 1.1v 264.745n 1.1v 264.755n 1.1v 269.745n 1.1v 269.755n 1.1v 274.745n 1.1v 274.755n 1.1v 279.745n 1.1v 279.755n 1.1v 284.745n 1.1v 284.755n 1.1v 289.745n 1.1v 289.755n 1.1v 294.745n 1.1v 294.755n 1.1v 299.745n 1.1v 299.755n 1.1v 304.745n 1.1v 304.755n 1.1v 309.745n 1.1v 309.755n 1.1v 314.745n 1.1v 314.755n 1.1v 319.745n 1.1v 319.755n 1.1v 324.745n 1.1v 324.755n 0.0v 329.745n 0.0v 329.755n 0.0v 334.745n 0.0v 334.755n 0.0v 339.745n 0.0v 339.755n 0.0v 344.745n 0.0v 344.755n 0.0v 349.745n 0.0v 349.755n 0.0v 354.745n 0.0v 354.755n 0.0v 359.745n 0.0v 359.755n 0.0v 364.745n 0.0v 364.755n 0.0v 369.745n 0.0v 369.755n 0.0v 374.745n 0.0v 374.755n 0.0v 379.745n 0.0v 379.755n 0.0v 384.745n 0.0v 384.755n 1.1v 389.745n 1.1v 389.755n 1.1v 394.745n 1.1v 394.755n 1.1v 399.745n 1.1v 399.755n 1.1v 404.745n 1.1v 404.755n 0.0v 409.745n 0.0v 409.755n 1.1v 414.745n 1.1v 414.755n 1.1v 419.745n 1.1v 419.755n 1.1v 424.745n 1.1v 424.755n 1.1v 429.745n 1.1v 429.755n 1.1v 434.745n 1.1v 434.755n 1.1v 439.745n 1.1v 439.755n 1.1v 444.745n 1.1v 444.755n 0.0v 449.745n 0.0v 449.755n 1.1v 454.745n 1.1v 454.755n 0.0v 459.745n 0.0v 459.755n 0.0v 464.745n 0.0v 464.755n 0.0v 469.745n 0.0v 469.755n 0.0v 474.745n 0.0v 474.755n 0.0v 479.745n 0.0v 479.755n 0.0v 484.745n 0.0v 484.755n 0.0v 489.745n 0.0v 489.755n 1.1v 494.745n 1.1v 494.755n 1.1v 499.745n 1.1v 499.755n 1.1v 504.745n 1.1v 504.755n 1.1v 509.745n 1.1v 509.755n 0.0v 514.745n 0.0v 514.755n 1.1v 519.745n 1.1v 519.755n 1.1v 524.745n 1.1v 524.755n 1.1v 529.745n 1.1v 529.755n 1.1v 534.745n 1.1v 534.755n 0.0v 539.745n 0.0v 539.755n 0.0v 544.745n 0.0v 544.755n 1.1v 549.745n 1.1v 549.755n 0.0v 554.745n 0.0v 554.755n 0.0v 559.745n 0.0v 559.755n 0.0v 564.745n 0.0v 564.755n 0.0v 569.745n 0.0v 569.755n 0.0v 574.745n 0.0v 574.755n 0.0v 579.745n 0.0v 579.755n 1.1v 584.745n 1.1v 584.755n 0.0v 589.745n 0.0v 589.755n 1.1v 594.745n 1.1v 594.755n 0.0v 599.745n 0.0v 599.755n 1.1v 604.745n 1.1v 604.755n 0.0v 609.745n 0.0v 609.755n 0.0v 614.745n 0.0v 614.755n 1.1v 619.745n 1.1v 619.755n 1.1v 624.745n 1.1v 624.755n 0.0v 629.745n 0.0v 629.755n 0.0v 634.745n 0.0v 634.755n 0.0v 639.745n 0.0v 639.755n 0.0v 644.745n 0.0v 644.755n 0.0v 649.745n 0.0v 649.755n 0.0v 654.745n 0.0v 654.755n 0.0v 659.745n 0.0v 659.755n 0.0v 664.745n 0.0v 664.755n 1.1v 669.745n 1.1v 669.755n 1.1v 674.745n 1.1v 674.755n 1.1v 679.745n 1.1v 679.755n 1.1v 684.745n 1.1v 684.755n 1.1v 689.745n 1.1v 689.755n 0.0v 694.745n 0.0v 694.755n 1.1v 699.745n 1.1v 699.755n 0.0v 704.745n 0.0v 704.755n 0.0v 709.745n 0.0v 709.755n 0.0v 714.745n 0.0v 714.755n 0.0v 719.745n 0.0v 719.755n 0.0v 724.745n 0.0v 724.755n 0.0v 729.745n 0.0v 729.755n 0.0v 734.745n 0.0v 734.755n 0.0v 739.745n 0.0v 739.755n 0.0v 744.745n 0.0v 744.755n 0.0v 749.745n 0.0v 749.755n 0.0v 754.745n 0.0v 754.755n 0.0v 759.745n 0.0v 759.755n 0.0v 764.745n 0.0v 764.755n 1.1v 769.745n 1.1v 769.755n 1.1v 774.745n 1.1v 774.755n 1.1v 779.745n 1.1v 779.755n 1.1v 784.745n 1.1v 784.755n 1.1v 789.745n 1.1v 789.755n 1.1v 794.745n 1.1v 794.755n 1.1v 799.745n 1.1v 799.755n 1.1v 804.745n 1.1v 804.755n 1.1v 809.745n 1.1v 809.755n 1.1v 814.745n 1.1v 814.755n 1.1v 819.745n 1.1v 819.755n 0.0v 824.745n 0.0v 824.755n 0.0v 829.745n 0.0v 829.755n 0.0v 834.745n 0.0v 834.755n 0.0v 839.745n 0.0v 839.755n 0.0v 844.745n 0.0v 844.755n 0.0v 849.745n 0.0v 849.755n 0.0v 854.745n 0.0v 854.755n 0.0v 859.745n 0.0v 859.755n 0.0v 864.745n 0.0v 864.755n 0.0v 869.745n 0.0v 869.755n 0.0v 874.745n 0.0v 874.755n 0.0v 879.745n 0.0v 879.755n 0.0v 884.745n 0.0v 884.755n 0.0v 889.745n 0.0v 889.755n 0.0v 894.745n 0.0v 894.755n 0.0v 899.745n 0.0v 899.755n 1.1v 904.745n 1.1v 904.755n 0.0v 909.745n 0.0v 909.755n 0.0v 914.745n 0.0v 914.755n 0.0v 919.745n 0.0v 919.755n 1.1v 924.745n 1.1v 924.755n 1.1v 929.745n 1.1v 929.755n 1.1v 934.745n 1.1v 934.755n 1.1v 939.745n 1.1v 939.755n 1.1v 944.745n 1.1v 944.755n 1.1v 949.745n 1.1v 949.755n 0.0v 954.745n 0.0v 954.755n 1.1v 959.745n 1.1v 959.755n 0.0v 964.745n 0.0v 964.755n 1.1v 969.745n 1.1v 969.755n 0.0v 974.745n 0.0v 974.755n 0.0v 979.745n 0.0v 979.755n 0.0v 984.745n 0.0v 984.755n 0.0v 989.745n 0.0v 989.755n 0.0v 994.745n 0.0v 994.755n 1.1v 999.745n 1.1v 999.755n 1.1v 1004.745n 1.1v 1004.755n 1.1v 1009.745n 1.1v 1009.755n 1.1v 1014.745n 1.1v 1014.755n 1.1v 1019.745n 1.1v 1019.755n 1.1v 1024.745n 1.1v 1024.755n 1.1v )
* (time, data): [(0, 0), (5, 1), (10, 0), (15, 1), (20, 1), (25, 1), (30, 1), (35, 1), (40, 1), (45, 1), (50, 0), (55, 0), (60, 0), (65, 0), (70, 0), (75, 0), (80, 0), (85, 1), (90, 1), (95, 1), (100, 1), (105, 1), (110, 1), (115, 1), (120, 1), (125, 1), (130, 1), (135, 1), (140, 1), (145, 1), (150, 1), (155, 1), (160, 1), (165, 1), (170, 1), (175, 1), (180, 0), (185, 0), (190, 0), (195, 0), (200, 0), (205, 0), (210, 1), (215, 1), (220, 0), (225, 0), (230, 0), (235, 0), (240, 1), (245, 1), (250, 1), (255, 1), (260, 1), (265, 1), (270, 1), (275, 1), (280, 1), (285, 1), (290, 1), (295, 0), (300, 0), (305, 0), (310, 0), (315, 1), (320, 0), (325, 0), (330, 0), (335, 1), (340, 1), (345, 1), (350, 1), (355, 1), (360, 1), (365, 1), (370, 1), (375, 1), (380, 1), (385, 0), (390, 0), (395, 1), (400, 1), (405, 1), (410, 1), (415, 1), (420, 1), (425, 0), (430, 0), (435, 0), (440, 0), (445, 1), (450, 1), (455, 1), (460, 1), (465, 1), (470, 1), (475, 1), (480, 1), (485, 1), (490, 0), (495, 0), (500, 0), (505, 0), (510, 1), (515, 1), (520, 1), (525, 1), (530, 1), (535, 1), (540, 1), (545, 1), (550, 0), (555, 0), (560, 0), (565, 0), (570, 1), (575, 0), (580, 0), (585, 0), (590, 0), (595, 0), (600, 1), (605, 1), (610, 1), (615, 0), (620, 0), (625, 1), (630, 1), (635, 1), (640, 1), (645, 0), (650, 0), (655, 0), (660, 0), (665, 0), (670, 1), (675, 1), (680, 1), (685, 1), (690, 1), (695, 0), (700, 0), (705, 1), (710, 1), (715, 1), (720, 1), (725, 1), (730, 1), (735, 0), (740, 0), (745, 1), (750, 1), (755, 0), (760, 0), (765, 0), (770, 0), (775, 0), (780, 0), (785, 0), (790, 0), (795, 0), (800, 0), (805, 0), (810, 0), (815, 0), (820, 0), (825, 0), (830, 0), (835, 1), (840, 1), (845, 1), (850, 1), (855, 1), (860, 1), (865, 1), (870, 1), (875, 1), (880, 1), (885, 1), (890, 0), (895, 0), (900, 0), (905, 0), (910, 0), (915, 0), (920, 1), (925, 1), (930, 1), (935, 0), (940, 1), (945, 1), (950, 1), (955, 0), (960, 0), (965, 1), (970, 0), (975, 0), (980, 0), (985, 1), (990, 0), (995, 0), (1000, 0), (1005, 0), (1010, 1), (1015, 1), (1020, 1), (1025, 1)]
Vdin0_17  din0_17  0 PWL (0n 0.0v 4.745n 0.0v 4.755n 1.1v 9.745n 1.1v 9.755n 0.0v 14.745n 0.0v 14.755n 1.1v 19.745n 1.1v 19.755n 1.1v 24.745n 1.1v 24.755n 1.1v 29.745n 1.1v 29.755n 1.1v 34.745n 1.1v 34.755n 1.1v 39.745n 1.1v 39.755n 1.1v 44.745n 1.1v 44.755n 1.1v 49.745n 1.1v 49.755n 0.0v 54.745n 0.0v 54.755n 0.0v 59.745n 0.0v 59.755n 0.0v 64.745n 0.0v 64.755n 0.0v 69.745n 0.0v 69.755n 0.0v 74.745n 0.0v 74.755n 0.0v 79.745n 0.0v 79.755n 0.0v 84.745n 0.0v 84.755n 1.1v 89.745n 1.1v 89.755n 1.1v 94.745n 1.1v 94.755n 1.1v 99.745n 1.1v 99.755n 1.1v 104.745n 1.1v 104.755n 1.1v 109.745n 1.1v 109.755n 1.1v 114.745n 1.1v 114.755n 1.1v 119.745n 1.1v 119.755n 1.1v 124.745n 1.1v 124.755n 1.1v 129.745n 1.1v 129.755n 1.1v 134.745n 1.1v 134.755n 1.1v 139.745n 1.1v 139.755n 1.1v 144.745n 1.1v 144.755n 1.1v 149.745n 1.1v 149.755n 1.1v 154.745n 1.1v 154.755n 1.1v 159.745n 1.1v 159.755n 1.1v 164.745n 1.1v 164.755n 1.1v 169.745n 1.1v 169.755n 1.1v 174.745n 1.1v 174.755n 1.1v 179.745n 1.1v 179.755n 0.0v 184.745n 0.0v 184.755n 0.0v 189.745n 0.0v 189.755n 0.0v 194.745n 0.0v 194.755n 0.0v 199.745n 0.0v 199.755n 0.0v 204.745n 0.0v 204.755n 0.0v 209.745n 0.0v 209.755n 1.1v 214.745n 1.1v 214.755n 1.1v 219.745n 1.1v 219.755n 0.0v 224.745n 0.0v 224.755n 0.0v 229.745n 0.0v 229.755n 0.0v 234.745n 0.0v 234.755n 0.0v 239.745n 0.0v 239.755n 1.1v 244.745n 1.1v 244.755n 1.1v 249.745n 1.1v 249.755n 1.1v 254.745n 1.1v 254.755n 1.1v 259.745n 1.1v 259.755n 1.1v 264.745n 1.1v 264.755n 1.1v 269.745n 1.1v 269.755n 1.1v 274.745n 1.1v 274.755n 1.1v 279.745n 1.1v 279.755n 1.1v 284.745n 1.1v 284.755n 1.1v 289.745n 1.1v 289.755n 1.1v 294.745n 1.1v 294.755n 0.0v 299.745n 0.0v 299.755n 0.0v 304.745n 0.0v 304.755n 0.0v 309.745n 0.0v 309.755n 0.0v 314.745n 0.0v 314.755n 1.1v 319.745n 1.1v 319.755n 0.0v 324.745n 0.0v 324.755n 0.0v 329.745n 0.0v 329.755n 0.0v 334.745n 0.0v 334.755n 1.1v 339.745n 1.1v 339.755n 1.1v 344.745n 1.1v 344.755n 1.1v 349.745n 1.1v 349.755n 1.1v 354.745n 1.1v 354.755n 1.1v 359.745n 1.1v 359.755n 1.1v 364.745n 1.1v 364.755n 1.1v 369.745n 1.1v 369.755n 1.1v 374.745n 1.1v 374.755n 1.1v 379.745n 1.1v 379.755n 1.1v 384.745n 1.1v 384.755n 0.0v 389.745n 0.0v 389.755n 0.0v 394.745n 0.0v 394.755n 1.1v 399.745n 1.1v 399.755n 1.1v 404.745n 1.1v 404.755n 1.1v 409.745n 1.1v 409.755n 1.1v 414.745n 1.1v 414.755n 1.1v 419.745n 1.1v 419.755n 1.1v 424.745n 1.1v 424.755n 0.0v 429.745n 0.0v 429.755n 0.0v 434.745n 0.0v 434.755n 0.0v 439.745n 0.0v 439.755n 0.0v 444.745n 0.0v 444.755n 1.1v 449.745n 1.1v 449.755n 1.1v 454.745n 1.1v 454.755n 1.1v 459.745n 1.1v 459.755n 1.1v 464.745n 1.1v 464.755n 1.1v 469.745n 1.1v 469.755n 1.1v 474.745n 1.1v 474.755n 1.1v 479.745n 1.1v 479.755n 1.1v 484.745n 1.1v 484.755n 1.1v 489.745n 1.1v 489.755n 0.0v 494.745n 0.0v 494.755n 0.0v 499.745n 0.0v 499.755n 0.0v 504.745n 0.0v 504.755n 0.0v 509.745n 0.0v 509.755n 1.1v 514.745n 1.1v 514.755n 1.1v 519.745n 1.1v 519.755n 1.1v 524.745n 1.1v 524.755n 1.1v 529.745n 1.1v 529.755n 1.1v 534.745n 1.1v 534.755n 1.1v 539.745n 1.1v 539.755n 1.1v 544.745n 1.1v 544.755n 1.1v 549.745n 1.1v 549.755n 0.0v 554.745n 0.0v 554.755n 0.0v 559.745n 0.0v 559.755n 0.0v 564.745n 0.0v 564.755n 0.0v 569.745n 0.0v 569.755n 1.1v 574.745n 1.1v 574.755n 0.0v 579.745n 0.0v 579.755n 0.0v 584.745n 0.0v 584.755n 0.0v 589.745n 0.0v 589.755n 0.0v 594.745n 0.0v 594.755n 0.0v 599.745n 0.0v 599.755n 1.1v 604.745n 1.1v 604.755n 1.1v 609.745n 1.1v 609.755n 1.1v 614.745n 1.1v 614.755n 0.0v 619.745n 0.0v 619.755n 0.0v 624.745n 0.0v 624.755n 1.1v 629.745n 1.1v 629.755n 1.1v 634.745n 1.1v 634.755n 1.1v 639.745n 1.1v 639.755n 1.1v 644.745n 1.1v 644.755n 0.0v 649.745n 0.0v 649.755n 0.0v 654.745n 0.0v 654.755n 0.0v 659.745n 0.0v 659.755n 0.0v 664.745n 0.0v 664.755n 0.0v 669.745n 0.0v 669.755n 1.1v 674.745n 1.1v 674.755n 1.1v 679.745n 1.1v 679.755n 1.1v 684.745n 1.1v 684.755n 1.1v 689.745n 1.1v 689.755n 1.1v 694.745n 1.1v 694.755n 0.0v 699.745n 0.0v 699.755n 0.0v 704.745n 0.0v 704.755n 1.1v 709.745n 1.1v 709.755n 1.1v 714.745n 1.1v 714.755n 1.1v 719.745n 1.1v 719.755n 1.1v 724.745n 1.1v 724.755n 1.1v 729.745n 1.1v 729.755n 1.1v 734.745n 1.1v 734.755n 0.0v 739.745n 0.0v 739.755n 0.0v 744.745n 0.0v 744.755n 1.1v 749.745n 1.1v 749.755n 1.1v 754.745n 1.1v 754.755n 0.0v 759.745n 0.0v 759.755n 0.0v 764.745n 0.0v 764.755n 0.0v 769.745n 0.0v 769.755n 0.0v 774.745n 0.0v 774.755n 0.0v 779.745n 0.0v 779.755n 0.0v 784.745n 0.0v 784.755n 0.0v 789.745n 0.0v 789.755n 0.0v 794.745n 0.0v 794.755n 0.0v 799.745n 0.0v 799.755n 0.0v 804.745n 0.0v 804.755n 0.0v 809.745n 0.0v 809.755n 0.0v 814.745n 0.0v 814.755n 0.0v 819.745n 0.0v 819.755n 0.0v 824.745n 0.0v 824.755n 0.0v 829.745n 0.0v 829.755n 0.0v 834.745n 0.0v 834.755n 1.1v 839.745n 1.1v 839.755n 1.1v 844.745n 1.1v 844.755n 1.1v 849.745n 1.1v 849.755n 1.1v 854.745n 1.1v 854.755n 1.1v 859.745n 1.1v 859.755n 1.1v 864.745n 1.1v 864.755n 1.1v 869.745n 1.1v 869.755n 1.1v 874.745n 1.1v 874.755n 1.1v 879.745n 1.1v 879.755n 1.1v 884.745n 1.1v 884.755n 1.1v 889.745n 1.1v 889.755n 0.0v 894.745n 0.0v 894.755n 0.0v 899.745n 0.0v 899.755n 0.0v 904.745n 0.0v 904.755n 0.0v 909.745n 0.0v 909.755n 0.0v 914.745n 0.0v 914.755n 0.0v 919.745n 0.0v 919.755n 1.1v 924.745n 1.1v 924.755n 1.1v 929.745n 1.1v 929.755n 1.1v 934.745n 1.1v 934.755n 0.0v 939.745n 0.0v 939.755n 1.1v 944.745n 1.1v 944.755n 1.1v 949.745n 1.1v 949.755n 1.1v 954.745n 1.1v 954.755n 0.0v 959.745n 0.0v 959.755n 0.0v 964.745n 0.0v 964.755n 1.1v 969.745n 1.1v 969.755n 0.0v 974.745n 0.0v 974.755n 0.0v 979.745n 0.0v 979.755n 0.0v 984.745n 0.0v 984.755n 1.1v 989.745n 1.1v 989.755n 0.0v 994.745n 0.0v 994.755n 0.0v 999.745n 0.0v 999.755n 0.0v 1004.745n 0.0v 1004.755n 0.0v 1009.745n 0.0v 1009.755n 1.1v 1014.745n 1.1v 1014.755n 1.1v 1019.745n 1.1v 1019.755n 1.1v 1024.745n 1.1v 1024.755n 1.1v )
* (time, data): [(0, 0), (5, 0), (10, 1), (15, 1), (20, 1), (25, 1), (30, 1), (35, 1), (40, 1), (45, 1), (50, 1), (55, 1), (60, 1), (65, 1), (70, 1), (75, 1), (80, 1), (85, 1), (90, 1), (95, 1), (100, 1), (105, 1), (110, 1), (115, 1), (120, 1), (125, 1), (130, 1), (135, 1), (140, 1), (145, 0), (150, 0), (155, 0), (160, 0), (165, 0), (170, 0), (175, 0), (180, 0), (185, 0), (190, 0), (195, 0), (200, 0), (205, 0), (210, 0), (215, 0), (220, 1), (225, 1), (230, 1), (235, 1), (240, 1), (245, 1), (250, 1), (255, 1), (260, 1), (265, 1), (270, 0), (275, 0), (280, 0), (285, 0), (290, 1), (295, 0), (300, 1), (305, 1), (310, 1), (315, 1), (320, 0), (325, 0), (330, 0), (335, 1), (340, 0), (345, 0), (350, 0), (355, 0), (360, 0), (365, 0), (370, 0), (375, 0), (380, 0), (385, 0), (390, 0), (395, 1), (400, 1), (405, 1), (410, 0), (415, 0), (420, 0), (425, 1), (430, 1), (435, 0), (440, 0), (445, 0), (450, 0), (455, 0), (460, 0), (465, 0), (470, 0), (475, 0), (480, 0), (485, 0), (490, 0), (495, 0), (500, 0), (505, 0), (510, 0), (515, 0), (520, 0), (525, 0), (530, 0), (535, 1), (540, 1), (545, 0), (550, 1), (555, 1), (560, 1), (565, 1), (570, 0), (575, 0), (580, 1), (585, 0), (590, 0), (595, 0), (600, 0), (605, 0), (610, 0), (615, 0), (620, 0), (625, 0), (630, 0), (635, 0), (640, 0), (645, 0), (650, 0), (655, 0), (660, 0), (665, 1), (670, 0), (675, 0), (680, 0), (685, 0), (690, 0), (695, 1), (700, 1), (705, 1), (710, 1), (715, 1), (720, 1), (725, 1), (730, 1), (735, 1), (740, 1), (745, 0), (750, 0), (755, 0), (760, 0), (765, 1), (770, 1), (775, 1), (780, 1), (785, 1), (790, 1), (795, 1), (800, 1), (805, 1), (810, 1), (815, 1), (820, 1), (825, 1), (830, 1), (835, 0), (840, 0), (845, 0), (850, 0), (855, 0), (860, 1), (865, 1), (870, 1), (875, 1), (880, 1), (885, 1), (890, 1), (895, 1), (900, 0), (905, 0), (910, 1), (915, 1), (920, 1), (925, 1), (930, 0), (935, 1), (940, 0), (945, 0), (950, 0), (955, 1), (960, 0), (965, 0), (970, 1), (975, 1), (980, 1), (985, 0), (990, 0), (995, 0), (1000, 1), (1005, 1), (1010, 1), (1015, 1), (1020, 1), (1025, 1)]
Vdin0_18  din0_18  0 PWL (0n 0.0v 4.745n 0.0v 4.755n 0.0v 9.745n 0.0v 9.755n 1.1v 14.745n 1.1v 14.755n 1.1v 19.745n 1.1v 19.755n 1.1v 24.745n 1.1v 24.755n 1.1v 29.745n 1.1v 29.755n 1.1v 34.745n 1.1v 34.755n 1.1v 39.745n 1.1v 39.755n 1.1v 44.745n 1.1v 44.755n 1.1v 49.745n 1.1v 49.755n 1.1v 54.745n 1.1v 54.755n 1.1v 59.745n 1.1v 59.755n 1.1v 64.745n 1.1v 64.755n 1.1v 69.745n 1.1v 69.755n 1.1v 74.745n 1.1v 74.755n 1.1v 79.745n 1.1v 79.755n 1.1v 84.745n 1.1v 84.755n 1.1v 89.745n 1.1v 89.755n 1.1v 94.745n 1.1v 94.755n 1.1v 99.745n 1.1v 99.755n 1.1v 104.745n 1.1v 104.755n 1.1v 109.745n 1.1v 109.755n 1.1v 114.745n 1.1v 114.755n 1.1v 119.745n 1.1v 119.755n 1.1v 124.745n 1.1v 124.755n 1.1v 129.745n 1.1v 129.755n 1.1v 134.745n 1.1v 134.755n 1.1v 139.745n 1.1v 139.755n 1.1v 144.745n 1.1v 144.755n 0.0v 149.745n 0.0v 149.755n 0.0v 154.745n 0.0v 154.755n 0.0v 159.745n 0.0v 159.755n 0.0v 164.745n 0.0v 164.755n 0.0v 169.745n 0.0v 169.755n 0.0v 174.745n 0.0v 174.755n 0.0v 179.745n 0.0v 179.755n 0.0v 184.745n 0.0v 184.755n 0.0v 189.745n 0.0v 189.755n 0.0v 194.745n 0.0v 194.755n 0.0v 199.745n 0.0v 199.755n 0.0v 204.745n 0.0v 204.755n 0.0v 209.745n 0.0v 209.755n 0.0v 214.745n 0.0v 214.755n 0.0v 219.745n 0.0v 219.755n 1.1v 224.745n 1.1v 224.755n 1.1v 229.745n 1.1v 229.755n 1.1v 234.745n 1.1v 234.755n 1.1v 239.745n 1.1v 239.755n 1.1v 244.745n 1.1v 244.755n 1.1v 249.745n 1.1v 249.755n 1.1v 254.745n 1.1v 254.755n 1.1v 259.745n 1.1v 259.755n 1.1v 264.745n 1.1v 264.755n 1.1v 269.745n 1.1v 269.755n 0.0v 274.745n 0.0v 274.755n 0.0v 279.745n 0.0v 279.755n 0.0v 284.745n 0.0v 284.755n 0.0v 289.745n 0.0v 289.755n 1.1v 294.745n 1.1v 294.755n 0.0v 299.745n 0.0v 299.755n 1.1v 304.745n 1.1v 304.755n 1.1v 309.745n 1.1v 309.755n 1.1v 314.745n 1.1v 314.755n 1.1v 319.745n 1.1v 319.755n 0.0v 324.745n 0.0v 324.755n 0.0v 329.745n 0.0v 329.755n 0.0v 334.745n 0.0v 334.755n 1.1v 339.745n 1.1v 339.755n 0.0v 344.745n 0.0v 344.755n 0.0v 349.745n 0.0v 349.755n 0.0v 354.745n 0.0v 354.755n 0.0v 359.745n 0.0v 359.755n 0.0v 364.745n 0.0v 364.755n 0.0v 369.745n 0.0v 369.755n 0.0v 374.745n 0.0v 374.755n 0.0v 379.745n 0.0v 379.755n 0.0v 384.745n 0.0v 384.755n 0.0v 389.745n 0.0v 389.755n 0.0v 394.745n 0.0v 394.755n 1.1v 399.745n 1.1v 399.755n 1.1v 404.745n 1.1v 404.755n 1.1v 409.745n 1.1v 409.755n 0.0v 414.745n 0.0v 414.755n 0.0v 419.745n 0.0v 419.755n 0.0v 424.745n 0.0v 424.755n 1.1v 429.745n 1.1v 429.755n 1.1v 434.745n 1.1v 434.755n 0.0v 439.745n 0.0v 439.755n 0.0v 444.745n 0.0v 444.755n 0.0v 449.745n 0.0v 449.755n 0.0v 454.745n 0.0v 454.755n 0.0v 459.745n 0.0v 459.755n 0.0v 464.745n 0.0v 464.755n 0.0v 469.745n 0.0v 469.755n 0.0v 474.745n 0.0v 474.755n 0.0v 479.745n 0.0v 479.755n 0.0v 484.745n 0.0v 484.755n 0.0v 489.745n 0.0v 489.755n 0.0v 494.745n 0.0v 494.755n 0.0v 499.745n 0.0v 499.755n 0.0v 504.745n 0.0v 504.755n 0.0v 509.745n 0.0v 509.755n 0.0v 514.745n 0.0v 514.755n 0.0v 519.745n 0.0v 519.755n 0.0v 524.745n 0.0v 524.755n 0.0v 529.745n 0.0v 529.755n 0.0v 534.745n 0.0v 534.755n 1.1v 539.745n 1.1v 539.755n 1.1v 544.745n 1.1v 544.755n 0.0v 549.745n 0.0v 549.755n 1.1v 554.745n 1.1v 554.755n 1.1v 559.745n 1.1v 559.755n 1.1v 564.745n 1.1v 564.755n 1.1v 569.745n 1.1v 569.755n 0.0v 574.745n 0.0v 574.755n 0.0v 579.745n 0.0v 579.755n 1.1v 584.745n 1.1v 584.755n 0.0v 589.745n 0.0v 589.755n 0.0v 594.745n 0.0v 594.755n 0.0v 599.745n 0.0v 599.755n 0.0v 604.745n 0.0v 604.755n 0.0v 609.745n 0.0v 609.755n 0.0v 614.745n 0.0v 614.755n 0.0v 619.745n 0.0v 619.755n 0.0v 624.745n 0.0v 624.755n 0.0v 629.745n 0.0v 629.755n 0.0v 634.745n 0.0v 634.755n 0.0v 639.745n 0.0v 639.755n 0.0v 644.745n 0.0v 644.755n 0.0v 649.745n 0.0v 649.755n 0.0v 654.745n 0.0v 654.755n 0.0v 659.745n 0.0v 659.755n 0.0v 664.745n 0.0v 664.755n 1.1v 669.745n 1.1v 669.755n 0.0v 674.745n 0.0v 674.755n 0.0v 679.745n 0.0v 679.755n 0.0v 684.745n 0.0v 684.755n 0.0v 689.745n 0.0v 689.755n 0.0v 694.745n 0.0v 694.755n 1.1v 699.745n 1.1v 699.755n 1.1v 704.745n 1.1v 704.755n 1.1v 709.745n 1.1v 709.755n 1.1v 714.745n 1.1v 714.755n 1.1v 719.745n 1.1v 719.755n 1.1v 724.745n 1.1v 724.755n 1.1v 729.745n 1.1v 729.755n 1.1v 734.745n 1.1v 734.755n 1.1v 739.745n 1.1v 739.755n 1.1v 744.745n 1.1v 744.755n 0.0v 749.745n 0.0v 749.755n 0.0v 754.745n 0.0v 754.755n 0.0v 759.745n 0.0v 759.755n 0.0v 764.745n 0.0v 764.755n 1.1v 769.745n 1.1v 769.755n 1.1v 774.745n 1.1v 774.755n 1.1v 779.745n 1.1v 779.755n 1.1v 784.745n 1.1v 784.755n 1.1v 789.745n 1.1v 789.755n 1.1v 794.745n 1.1v 794.755n 1.1v 799.745n 1.1v 799.755n 1.1v 804.745n 1.1v 804.755n 1.1v 809.745n 1.1v 809.755n 1.1v 814.745n 1.1v 814.755n 1.1v 819.745n 1.1v 819.755n 1.1v 824.745n 1.1v 824.755n 1.1v 829.745n 1.1v 829.755n 1.1v 834.745n 1.1v 834.755n 0.0v 839.745n 0.0v 839.755n 0.0v 844.745n 0.0v 844.755n 0.0v 849.745n 0.0v 849.755n 0.0v 854.745n 0.0v 854.755n 0.0v 859.745n 0.0v 859.755n 1.1v 864.745n 1.1v 864.755n 1.1v 869.745n 1.1v 869.755n 1.1v 874.745n 1.1v 874.755n 1.1v 879.745n 1.1v 879.755n 1.1v 884.745n 1.1v 884.755n 1.1v 889.745n 1.1v 889.755n 1.1v 894.745n 1.1v 894.755n 1.1v 899.745n 1.1v 899.755n 0.0v 904.745n 0.0v 904.755n 0.0v 909.745n 0.0v 909.755n 1.1v 914.745n 1.1v 914.755n 1.1v 919.745n 1.1v 919.755n 1.1v 924.745n 1.1v 924.755n 1.1v 929.745n 1.1v 929.755n 0.0v 934.745n 0.0v 934.755n 1.1v 939.745n 1.1v 939.755n 0.0v 944.745n 0.0v 944.755n 0.0v 949.745n 0.0v 949.755n 0.0v 954.745n 0.0v 954.755n 1.1v 959.745n 1.1v 959.755n 0.0v 964.745n 0.0v 964.755n 0.0v 969.745n 0.0v 969.755n 1.1v 974.745n 1.1v 974.755n 1.1v 979.745n 1.1v 979.755n 1.1v 984.745n 1.1v 984.755n 0.0v 989.745n 0.0v 989.755n 0.0v 994.745n 0.0v 994.755n 0.0v 999.745n 0.0v 999.755n 1.1v 1004.745n 1.1v 1004.755n 1.1v 1009.745n 1.1v 1009.755n 1.1v 1014.745n 1.1v 1014.755n 1.1v 1019.745n 1.1v 1019.755n 1.1v 1024.745n 1.1v 1024.755n 1.1v )
* (time, data): [(0, 0), (5, 0), (10, 0), (15, 0), (20, 0), (25, 0), (30, 0), (35, 0), (40, 0), (45, 0), (50, 1), (55, 1), (60, 1), (65, 1), (70, 1), (75, 1), (80, 1), (85, 1), (90, 1), (95, 1), (100, 0), (105, 0), (110, 0), (115, 0), (120, 0), (125, 0), (130, 0), (135, 0), (140, 1), (145, 1), (150, 1), (155, 1), (160, 1), (165, 1), (170, 1), (175, 1), (180, 1), (185, 1), (190, 1), (195, 1), (200, 1), (205, 0), (210, 0), (215, 0), (220, 0), (225, 0), (230, 0), (235, 0), (240, 1), (245, 1), (250, 1), (255, 1), (260, 1), (265, 1), (270, 0), (275, 0), (280, 1), (285, 1), (290, 1), (295, 0), (300, 1), (305, 1), (310, 1), (315, 0), (320, 1), (325, 1), (330, 1), (335, 1), (340, 1), (345, 1), (350, 1), (355, 1), (360, 1), (365, 1), (370, 1), (375, 1), (380, 1), (385, 0), (390, 0), (395, 1), (400, 1), (405, 0), (410, 0), (415, 0), (420, 0), (425, 0), (430, 0), (435, 0), (440, 0), (445, 1), (450, 1), (455, 1), (460, 1), (465, 1), (470, 1), (475, 1), (480, 1), (485, 1), (490, 1), (495, 1), (500, 1), (505, 1), (510, 1), (515, 1), (520, 1), (525, 1), (530, 1), (535, 1), (540, 0), (545, 1), (550, 1), (555, 1), (560, 1), (565, 1), (570, 1), (575, 1), (580, 1), (585, 0), (590, 1), (595, 1), (600, 1), (605, 1), (610, 1), (615, 1), (620, 1), (625, 0), (630, 0), (635, 0), (640, 0), (645, 1), (650, 1), (655, 1), (660, 1), (665, 0), (670, 0), (675, 0), (680, 0), (685, 0), (690, 0), (695, 0), (700, 0), (705, 0), (710, 1), (715, 1), (720, 1), (725, 1), (730, 1), (735, 1), (740, 1), (745, 0), (750, 0), (755, 0), (760, 0), (765, 0), (770, 0), (775, 0), (780, 0), (785, 0), (790, 0), (795, 0), (800, 0), (805, 0), (810, 0), (815, 1), (820, 1), (825, 1), (830, 1), (835, 1), (840, 1), (845, 1), (850, 1), (855, 1), (860, 0), (865, 0), (870, 0), (875, 0), (880, 0), (885, 0), (890, 0), (895, 0), (900, 1), (905, 1), (910, 0), (915, 0), (920, 1), (925, 1), (930, 0), (935, 1), (940, 1), (945, 1), (950, 0), (955, 1), (960, 1), (965, 0), (970, 1), (975, 1), (980, 1), (985, 0), (990, 1), (995, 1), (1000, 0), (1005, 0), (1010, 0), (1015, 0), (1020, 0), (1025, 0)]
Vdin0_19  din0_19  0 PWL (0n 0.0v 4.745n 0.0v 4.755n 0.0v 9.745n 0.0v 9.755n 0.0v 14.745n 0.0v 14.755n 0.0v 19.745n 0.0v 19.755n 0.0v 24.745n 0.0v 24.755n 0.0v 29.745n 0.0v 29.755n 0.0v 34.745n 0.0v 34.755n 0.0v 39.745n 0.0v 39.755n 0.0v 44.745n 0.0v 44.755n 0.0v 49.745n 0.0v 49.755n 1.1v 54.745n 1.1v 54.755n 1.1v 59.745n 1.1v 59.755n 1.1v 64.745n 1.1v 64.755n 1.1v 69.745n 1.1v 69.755n 1.1v 74.745n 1.1v 74.755n 1.1v 79.745n 1.1v 79.755n 1.1v 84.745n 1.1v 84.755n 1.1v 89.745n 1.1v 89.755n 1.1v 94.745n 1.1v 94.755n 1.1v 99.745n 1.1v 99.755n 0.0v 104.745n 0.0v 104.755n 0.0v 109.745n 0.0v 109.755n 0.0v 114.745n 0.0v 114.755n 0.0v 119.745n 0.0v 119.755n 0.0v 124.745n 0.0v 124.755n 0.0v 129.745n 0.0v 129.755n 0.0v 134.745n 0.0v 134.755n 0.0v 139.745n 0.0v 139.755n 1.1v 144.745n 1.1v 144.755n 1.1v 149.745n 1.1v 149.755n 1.1v 154.745n 1.1v 154.755n 1.1v 159.745n 1.1v 159.755n 1.1v 164.745n 1.1v 164.755n 1.1v 169.745n 1.1v 169.755n 1.1v 174.745n 1.1v 174.755n 1.1v 179.745n 1.1v 179.755n 1.1v 184.745n 1.1v 184.755n 1.1v 189.745n 1.1v 189.755n 1.1v 194.745n 1.1v 194.755n 1.1v 199.745n 1.1v 199.755n 1.1v 204.745n 1.1v 204.755n 0.0v 209.745n 0.0v 209.755n 0.0v 214.745n 0.0v 214.755n 0.0v 219.745n 0.0v 219.755n 0.0v 224.745n 0.0v 224.755n 0.0v 229.745n 0.0v 229.755n 0.0v 234.745n 0.0v 234.755n 0.0v 239.745n 0.0v 239.755n 1.1v 244.745n 1.1v 244.755n 1.1v 249.745n 1.1v 249.755n 1.1v 254.745n 1.1v 254.755n 1.1v 259.745n 1.1v 259.755n 1.1v 264.745n 1.1v 264.755n 1.1v 269.745n 1.1v 269.755n 0.0v 274.745n 0.0v 274.755n 0.0v 279.745n 0.0v 279.755n 1.1v 284.745n 1.1v 284.755n 1.1v 289.745n 1.1v 289.755n 1.1v 294.745n 1.1v 294.755n 0.0v 299.745n 0.0v 299.755n 1.1v 304.745n 1.1v 304.755n 1.1v 309.745n 1.1v 309.755n 1.1v 314.745n 1.1v 314.755n 0.0v 319.745n 0.0v 319.755n 1.1v 324.745n 1.1v 324.755n 1.1v 329.745n 1.1v 329.755n 1.1v 334.745n 1.1v 334.755n 1.1v 339.745n 1.1v 339.755n 1.1v 344.745n 1.1v 344.755n 1.1v 349.745n 1.1v 349.755n 1.1v 354.745n 1.1v 354.755n 1.1v 359.745n 1.1v 359.755n 1.1v 364.745n 1.1v 364.755n 1.1v 369.745n 1.1v 369.755n 1.1v 374.745n 1.1v 374.755n 1.1v 379.745n 1.1v 379.755n 1.1v 384.745n 1.1v 384.755n 0.0v 389.745n 0.0v 389.755n 0.0v 394.745n 0.0v 394.755n 1.1v 399.745n 1.1v 399.755n 1.1v 404.745n 1.1v 404.755n 0.0v 409.745n 0.0v 409.755n 0.0v 414.745n 0.0v 414.755n 0.0v 419.745n 0.0v 419.755n 0.0v 424.745n 0.0v 424.755n 0.0v 429.745n 0.0v 429.755n 0.0v 434.745n 0.0v 434.755n 0.0v 439.745n 0.0v 439.755n 0.0v 444.745n 0.0v 444.755n 1.1v 449.745n 1.1v 449.755n 1.1v 454.745n 1.1v 454.755n 1.1v 459.745n 1.1v 459.755n 1.1v 464.745n 1.1v 464.755n 1.1v 469.745n 1.1v 469.755n 1.1v 474.745n 1.1v 474.755n 1.1v 479.745n 1.1v 479.755n 1.1v 484.745n 1.1v 484.755n 1.1v 489.745n 1.1v 489.755n 1.1v 494.745n 1.1v 494.755n 1.1v 499.745n 1.1v 499.755n 1.1v 504.745n 1.1v 504.755n 1.1v 509.745n 1.1v 509.755n 1.1v 514.745n 1.1v 514.755n 1.1v 519.745n 1.1v 519.755n 1.1v 524.745n 1.1v 524.755n 1.1v 529.745n 1.1v 529.755n 1.1v 534.745n 1.1v 534.755n 1.1v 539.745n 1.1v 539.755n 0.0v 544.745n 0.0v 544.755n 1.1v 549.745n 1.1v 549.755n 1.1v 554.745n 1.1v 554.755n 1.1v 559.745n 1.1v 559.755n 1.1v 564.745n 1.1v 564.755n 1.1v 569.745n 1.1v 569.755n 1.1v 574.745n 1.1v 574.755n 1.1v 579.745n 1.1v 579.755n 1.1v 584.745n 1.1v 584.755n 0.0v 589.745n 0.0v 589.755n 1.1v 594.745n 1.1v 594.755n 1.1v 599.745n 1.1v 599.755n 1.1v 604.745n 1.1v 604.755n 1.1v 609.745n 1.1v 609.755n 1.1v 614.745n 1.1v 614.755n 1.1v 619.745n 1.1v 619.755n 1.1v 624.745n 1.1v 624.755n 0.0v 629.745n 0.0v 629.755n 0.0v 634.745n 0.0v 634.755n 0.0v 639.745n 0.0v 639.755n 0.0v 644.745n 0.0v 644.755n 1.1v 649.745n 1.1v 649.755n 1.1v 654.745n 1.1v 654.755n 1.1v 659.745n 1.1v 659.755n 1.1v 664.745n 1.1v 664.755n 0.0v 669.745n 0.0v 669.755n 0.0v 674.745n 0.0v 674.755n 0.0v 679.745n 0.0v 679.755n 0.0v 684.745n 0.0v 684.755n 0.0v 689.745n 0.0v 689.755n 0.0v 694.745n 0.0v 694.755n 0.0v 699.745n 0.0v 699.755n 0.0v 704.745n 0.0v 704.755n 0.0v 709.745n 0.0v 709.755n 1.1v 714.745n 1.1v 714.755n 1.1v 719.745n 1.1v 719.755n 1.1v 724.745n 1.1v 724.755n 1.1v 729.745n 1.1v 729.755n 1.1v 734.745n 1.1v 734.755n 1.1v 739.745n 1.1v 739.755n 1.1v 744.745n 1.1v 744.755n 0.0v 749.745n 0.0v 749.755n 0.0v 754.745n 0.0v 754.755n 0.0v 759.745n 0.0v 759.755n 0.0v 764.745n 0.0v 764.755n 0.0v 769.745n 0.0v 769.755n 0.0v 774.745n 0.0v 774.755n 0.0v 779.745n 0.0v 779.755n 0.0v 784.745n 0.0v 784.755n 0.0v 789.745n 0.0v 789.755n 0.0v 794.745n 0.0v 794.755n 0.0v 799.745n 0.0v 799.755n 0.0v 804.745n 0.0v 804.755n 0.0v 809.745n 0.0v 809.755n 0.0v 814.745n 0.0v 814.755n 1.1v 819.745n 1.1v 819.755n 1.1v 824.745n 1.1v 824.755n 1.1v 829.745n 1.1v 829.755n 1.1v 834.745n 1.1v 834.755n 1.1v 839.745n 1.1v 839.755n 1.1v 844.745n 1.1v 844.755n 1.1v 849.745n 1.1v 849.755n 1.1v 854.745n 1.1v 854.755n 1.1v 859.745n 1.1v 859.755n 0.0v 864.745n 0.0v 864.755n 0.0v 869.745n 0.0v 869.755n 0.0v 874.745n 0.0v 874.755n 0.0v 879.745n 0.0v 879.755n 0.0v 884.745n 0.0v 884.755n 0.0v 889.745n 0.0v 889.755n 0.0v 894.745n 0.0v 894.755n 0.0v 899.745n 0.0v 899.755n 1.1v 904.745n 1.1v 904.755n 1.1v 909.745n 1.1v 909.755n 0.0v 914.745n 0.0v 914.755n 0.0v 919.745n 0.0v 919.755n 1.1v 924.745n 1.1v 924.755n 1.1v 929.745n 1.1v 929.755n 0.0v 934.745n 0.0v 934.755n 1.1v 939.745n 1.1v 939.755n 1.1v 944.745n 1.1v 944.755n 1.1v 949.745n 1.1v 949.755n 0.0v 954.745n 0.0v 954.755n 1.1v 959.745n 1.1v 959.755n 1.1v 964.745n 1.1v 964.755n 0.0v 969.745n 0.0v 969.755n 1.1v 974.745n 1.1v 974.755n 1.1v 979.745n 1.1v 979.755n 1.1v 984.745n 1.1v 984.755n 0.0v 989.745n 0.0v 989.755n 1.1v 994.745n 1.1v 994.755n 1.1v 999.745n 1.1v 999.755n 0.0v 1004.745n 0.0v 1004.755n 0.0v 1009.745n 0.0v 1009.755n 0.0v 1014.745n 0.0v 1014.755n 0.0v 1019.745n 0.0v 1019.755n 0.0v 1024.745n 0.0v 1024.755n 0.0v )
* (time, data): [(0, 0), (5, 1), (10, 0), (15, 1), (20, 1), (25, 1), (30, 1), (35, 1), (40, 1), (45, 1), (50, 1), (55, 1), (60, 1), (65, 1), (70, 1), (75, 1), (80, 1), (85, 0), (90, 0), (95, 0), (100, 0), (105, 0), (110, 0), (115, 1), (120, 1), (125, 1), (130, 1), (135, 1), (140, 0), (145, 1), (150, 1), (155, 1), (160, 1), (165, 1), (170, 1), (175, 1), (180, 0), (185, 0), (190, 0), (195, 0), (200, 0), (205, 1), (210, 0), (215, 0), (220, 0), (225, 0), (230, 0), (235, 0), (240, 1), (245, 1), (250, 1), (255, 1), (260, 1), (265, 1), (270, 1), (275, 1), (280, 1), (285, 1), (290, 1), (295, 1), (300, 0), (305, 0), (310, 0), (315, 0), (320, 1), (325, 0), (330, 0), (335, 1), (340, 1), (345, 1), (350, 1), (355, 1), (360, 1), (365, 1), (370, 1), (375, 1), (380, 1), (385, 1), (390, 1), (395, 0), (400, 0), (405, 1), (410, 1), (415, 1), (420, 1), (425, 0), (430, 0), (435, 1), (440, 1), (445, 1), (450, 0), (455, 1), (460, 1), (465, 1), (470, 1), (475, 1), (480, 1), (485, 1), (490, 0), (495, 0), (500, 0), (505, 0), (510, 1), (515, 1), (520, 1), (525, 1), (530, 1), (535, 1), (540, 1), (545, 1), (550, 1), (555, 1), (560, 1), (565, 1), (570, 0), (575, 0), (580, 0), (585, 0), (590, 1), (595, 0), (600, 1), (605, 1), (610, 1), (615, 1), (620, 1), (625, 1), (630, 1), (635, 1), (640, 1), (645, 0), (650, 0), (655, 0), (660, 0), (665, 0), (670, 0), (675, 0), (680, 0), (685, 0), (690, 0), (695, 1), (700, 1), (705, 0), (710, 1), (715, 1), (720, 1), (725, 1), (730, 1), (735, 1), (740, 1), (745, 0), (750, 0), (755, 1), (760, 1), (765, 0), (770, 0), (775, 0), (780, 0), (785, 0), (790, 0), (795, 0), (800, 0), (805, 0), (810, 0), (815, 1), (820, 1), (825, 1), (830, 1), (835, 0), (840, 0), (845, 0), (850, 0), (855, 0), (860, 0), (865, 0), (870, 0), (875, 0), (880, 0), (885, 0), (890, 1), (895, 1), (900, 1), (905, 1), (910, 1), (915, 1), (920, 1), (925, 1), (930, 0), (935, 0), (940, 0), (945, 0), (950, 0), (955, 1), (960, 1), (965, 1), (970, 0), (975, 0), (980, 0), (985, 0), (990, 0), (995, 1), (1000, 0), (1005, 0), (1010, 0), (1015, 0), (1020, 0), (1025, 0)]
Vdin0_20  din0_20  0 PWL (0n 0.0v 4.745n 0.0v 4.755n 1.1v 9.745n 1.1v 9.755n 0.0v 14.745n 0.0v 14.755n 1.1v 19.745n 1.1v 19.755n 1.1v 24.745n 1.1v 24.755n 1.1v 29.745n 1.1v 29.755n 1.1v 34.745n 1.1v 34.755n 1.1v 39.745n 1.1v 39.755n 1.1v 44.745n 1.1v 44.755n 1.1v 49.745n 1.1v 49.755n 1.1v 54.745n 1.1v 54.755n 1.1v 59.745n 1.1v 59.755n 1.1v 64.745n 1.1v 64.755n 1.1v 69.745n 1.1v 69.755n 1.1v 74.745n 1.1v 74.755n 1.1v 79.745n 1.1v 79.755n 1.1v 84.745n 1.1v 84.755n 0.0v 89.745n 0.0v 89.755n 0.0v 94.745n 0.0v 94.755n 0.0v 99.745n 0.0v 99.755n 0.0v 104.745n 0.0v 104.755n 0.0v 109.745n 0.0v 109.755n 0.0v 114.745n 0.0v 114.755n 1.1v 119.745n 1.1v 119.755n 1.1v 124.745n 1.1v 124.755n 1.1v 129.745n 1.1v 129.755n 1.1v 134.745n 1.1v 134.755n 1.1v 139.745n 1.1v 139.755n 0.0v 144.745n 0.0v 144.755n 1.1v 149.745n 1.1v 149.755n 1.1v 154.745n 1.1v 154.755n 1.1v 159.745n 1.1v 159.755n 1.1v 164.745n 1.1v 164.755n 1.1v 169.745n 1.1v 169.755n 1.1v 174.745n 1.1v 174.755n 1.1v 179.745n 1.1v 179.755n 0.0v 184.745n 0.0v 184.755n 0.0v 189.745n 0.0v 189.755n 0.0v 194.745n 0.0v 194.755n 0.0v 199.745n 0.0v 199.755n 0.0v 204.745n 0.0v 204.755n 1.1v 209.745n 1.1v 209.755n 0.0v 214.745n 0.0v 214.755n 0.0v 219.745n 0.0v 219.755n 0.0v 224.745n 0.0v 224.755n 0.0v 229.745n 0.0v 229.755n 0.0v 234.745n 0.0v 234.755n 0.0v 239.745n 0.0v 239.755n 1.1v 244.745n 1.1v 244.755n 1.1v 249.745n 1.1v 249.755n 1.1v 254.745n 1.1v 254.755n 1.1v 259.745n 1.1v 259.755n 1.1v 264.745n 1.1v 264.755n 1.1v 269.745n 1.1v 269.755n 1.1v 274.745n 1.1v 274.755n 1.1v 279.745n 1.1v 279.755n 1.1v 284.745n 1.1v 284.755n 1.1v 289.745n 1.1v 289.755n 1.1v 294.745n 1.1v 294.755n 1.1v 299.745n 1.1v 299.755n 0.0v 304.745n 0.0v 304.755n 0.0v 309.745n 0.0v 309.755n 0.0v 314.745n 0.0v 314.755n 0.0v 319.745n 0.0v 319.755n 1.1v 324.745n 1.1v 324.755n 0.0v 329.745n 0.0v 329.755n 0.0v 334.745n 0.0v 334.755n 1.1v 339.745n 1.1v 339.755n 1.1v 344.745n 1.1v 344.755n 1.1v 349.745n 1.1v 349.755n 1.1v 354.745n 1.1v 354.755n 1.1v 359.745n 1.1v 359.755n 1.1v 364.745n 1.1v 364.755n 1.1v 369.745n 1.1v 369.755n 1.1v 374.745n 1.1v 374.755n 1.1v 379.745n 1.1v 379.755n 1.1v 384.745n 1.1v 384.755n 1.1v 389.745n 1.1v 389.755n 1.1v 394.745n 1.1v 394.755n 0.0v 399.745n 0.0v 399.755n 0.0v 404.745n 0.0v 404.755n 1.1v 409.745n 1.1v 409.755n 1.1v 414.745n 1.1v 414.755n 1.1v 419.745n 1.1v 419.755n 1.1v 424.745n 1.1v 424.755n 0.0v 429.745n 0.0v 429.755n 0.0v 434.745n 0.0v 434.755n 1.1v 439.745n 1.1v 439.755n 1.1v 444.745n 1.1v 444.755n 1.1v 449.745n 1.1v 449.755n 0.0v 454.745n 0.0v 454.755n 1.1v 459.745n 1.1v 459.755n 1.1v 464.745n 1.1v 464.755n 1.1v 469.745n 1.1v 469.755n 1.1v 474.745n 1.1v 474.755n 1.1v 479.745n 1.1v 479.755n 1.1v 484.745n 1.1v 484.755n 1.1v 489.745n 1.1v 489.755n 0.0v 494.745n 0.0v 494.755n 0.0v 499.745n 0.0v 499.755n 0.0v 504.745n 0.0v 504.755n 0.0v 509.745n 0.0v 509.755n 1.1v 514.745n 1.1v 514.755n 1.1v 519.745n 1.1v 519.755n 1.1v 524.745n 1.1v 524.755n 1.1v 529.745n 1.1v 529.755n 1.1v 534.745n 1.1v 534.755n 1.1v 539.745n 1.1v 539.755n 1.1v 544.745n 1.1v 544.755n 1.1v 549.745n 1.1v 549.755n 1.1v 554.745n 1.1v 554.755n 1.1v 559.745n 1.1v 559.755n 1.1v 564.745n 1.1v 564.755n 1.1v 569.745n 1.1v 569.755n 0.0v 574.745n 0.0v 574.755n 0.0v 579.745n 0.0v 579.755n 0.0v 584.745n 0.0v 584.755n 0.0v 589.745n 0.0v 589.755n 1.1v 594.745n 1.1v 594.755n 0.0v 599.745n 0.0v 599.755n 1.1v 604.745n 1.1v 604.755n 1.1v 609.745n 1.1v 609.755n 1.1v 614.745n 1.1v 614.755n 1.1v 619.745n 1.1v 619.755n 1.1v 624.745n 1.1v 624.755n 1.1v 629.745n 1.1v 629.755n 1.1v 634.745n 1.1v 634.755n 1.1v 639.745n 1.1v 639.755n 1.1v 644.745n 1.1v 644.755n 0.0v 649.745n 0.0v 649.755n 0.0v 654.745n 0.0v 654.755n 0.0v 659.745n 0.0v 659.755n 0.0v 664.745n 0.0v 664.755n 0.0v 669.745n 0.0v 669.755n 0.0v 674.745n 0.0v 674.755n 0.0v 679.745n 0.0v 679.755n 0.0v 684.745n 0.0v 684.755n 0.0v 689.745n 0.0v 689.755n 0.0v 694.745n 0.0v 694.755n 1.1v 699.745n 1.1v 699.755n 1.1v 704.745n 1.1v 704.755n 0.0v 709.745n 0.0v 709.755n 1.1v 714.745n 1.1v 714.755n 1.1v 719.745n 1.1v 719.755n 1.1v 724.745n 1.1v 724.755n 1.1v 729.745n 1.1v 729.755n 1.1v 734.745n 1.1v 734.755n 1.1v 739.745n 1.1v 739.755n 1.1v 744.745n 1.1v 744.755n 0.0v 749.745n 0.0v 749.755n 0.0v 754.745n 0.0v 754.755n 1.1v 759.745n 1.1v 759.755n 1.1v 764.745n 1.1v 764.755n 0.0v 769.745n 0.0v 769.755n 0.0v 774.745n 0.0v 774.755n 0.0v 779.745n 0.0v 779.755n 0.0v 784.745n 0.0v 784.755n 0.0v 789.745n 0.0v 789.755n 0.0v 794.745n 0.0v 794.755n 0.0v 799.745n 0.0v 799.755n 0.0v 804.745n 0.0v 804.755n 0.0v 809.745n 0.0v 809.755n 0.0v 814.745n 0.0v 814.755n 1.1v 819.745n 1.1v 819.755n 1.1v 824.745n 1.1v 824.755n 1.1v 829.745n 1.1v 829.755n 1.1v 834.745n 1.1v 834.755n 0.0v 839.745n 0.0v 839.755n 0.0v 844.745n 0.0v 844.755n 0.0v 849.745n 0.0v 849.755n 0.0v 854.745n 0.0v 854.755n 0.0v 859.745n 0.0v 859.755n 0.0v 864.745n 0.0v 864.755n 0.0v 869.745n 0.0v 869.755n 0.0v 874.745n 0.0v 874.755n 0.0v 879.745n 0.0v 879.755n 0.0v 884.745n 0.0v 884.755n 0.0v 889.745n 0.0v 889.755n 1.1v 894.745n 1.1v 894.755n 1.1v 899.745n 1.1v 899.755n 1.1v 904.745n 1.1v 904.755n 1.1v 909.745n 1.1v 909.755n 1.1v 914.745n 1.1v 914.755n 1.1v 919.745n 1.1v 919.755n 1.1v 924.745n 1.1v 924.755n 1.1v 929.745n 1.1v 929.755n 0.0v 934.745n 0.0v 934.755n 0.0v 939.745n 0.0v 939.755n 0.0v 944.745n 0.0v 944.755n 0.0v 949.745n 0.0v 949.755n 0.0v 954.745n 0.0v 954.755n 1.1v 959.745n 1.1v 959.755n 1.1v 964.745n 1.1v 964.755n 1.1v 969.745n 1.1v 969.755n 0.0v 974.745n 0.0v 974.755n 0.0v 979.745n 0.0v 979.755n 0.0v 984.745n 0.0v 984.755n 0.0v 989.745n 0.0v 989.755n 0.0v 994.745n 0.0v 994.755n 1.1v 999.745n 1.1v 999.755n 0.0v 1004.745n 0.0v 1004.755n 0.0v 1009.745n 0.0v 1009.755n 0.0v 1014.745n 0.0v 1014.755n 0.0v 1019.745n 0.0v 1019.755n 0.0v 1024.745n 0.0v 1024.755n 0.0v )
* (time, data): [(0, 0), (5, 0), (10, 0), (15, 0), (20, 0), (25, 0), (30, 0), (35, 0), (40, 0), (45, 0), (50, 0), (55, 0), (60, 0), (65, 0), (70, 0), (75, 0), (80, 0), (85, 0), (90, 0), (95, 0), (100, 0), (105, 0), (110, 0), (115, 1), (120, 1), (125, 1), (130, 1), (135, 1), (140, 0), (145, 0), (150, 0), (155, 0), (160, 0), (165, 0), (170, 0), (175, 0), (180, 1), (185, 1), (190, 1), (195, 1), (200, 1), (205, 0), (210, 0), (215, 0), (220, 0), (225, 0), (230, 0), (235, 0), (240, 1), (245, 1), (250, 1), (255, 1), (260, 1), (265, 1), (270, 0), (275, 0), (280, 0), (285, 0), (290, 1), (295, 0), (300, 1), (305, 1), (310, 1), (315, 1), (320, 1), (325, 1), (330, 1), (335, 1), (340, 0), (345, 0), (350, 0), (355, 0), (360, 0), (365, 0), (370, 0), (375, 0), (380, 0), (385, 0), (390, 0), (395, 1), (400, 1), (405, 1), (410, 0), (415, 0), (420, 0), (425, 0), (430, 0), (435, 0), (440, 0), (445, 1), (450, 1), (455, 1), (460, 1), (465, 1), (470, 1), (475, 1), (480, 1), (485, 1), (490, 1), (495, 1), (500, 1), (505, 1), (510, 0), (515, 1), (520, 1), (525, 1), (530, 1), (535, 1), (540, 0), (545, 0), (550, 0), (555, 0), (560, 0), (565, 0), (570, 1), (575, 1), (580, 1), (585, 1), (590, 0), (595, 1), (600, 1), (605, 1), (610, 1), (615, 1), (620, 1), (625, 1), (630, 1), (635, 1), (640, 1), (645, 1), (650, 1), (655, 1), (660, 1), (665, 0), (670, 0), (675, 0), (680, 0), (685, 0), (690, 1), (695, 1), (700, 1), (705, 1), (710, 0), (715, 0), (720, 0), (725, 0), (730, 0), (735, 1), (740, 1), (745, 1), (750, 1), (755, 0), (760, 0), (765, 0), (770, 0), (775, 0), (780, 0), (785, 0), (790, 0), (795, 0), (800, 0), (805, 0), (810, 0), (815, 0), (820, 1), (825, 1), (830, 1), (835, 0), (840, 0), (845, 0), (850, 0), (855, 0), (860, 0), (865, 0), (870, 0), (875, 0), (880, 0), (885, 0), (890, 1), (895, 1), (900, 1), (905, 1), (910, 1), (915, 1), (920, 1), (925, 1), (930, 1), (935, 1), (940, 0), (945, 0), (950, 0), (955, 0), (960, 0), (965, 1), (970, 0), (975, 0), (980, 0), (985, 0), (990, 1), (995, 1), (1000, 1), (1005, 1), (1010, 1), (1015, 1), (1020, 1), (1025, 1)]
Vdin0_21  din0_21  0 PWL (0n 0.0v 4.745n 0.0v 4.755n 0.0v 9.745n 0.0v 9.755n 0.0v 14.745n 0.0v 14.755n 0.0v 19.745n 0.0v 19.755n 0.0v 24.745n 0.0v 24.755n 0.0v 29.745n 0.0v 29.755n 0.0v 34.745n 0.0v 34.755n 0.0v 39.745n 0.0v 39.755n 0.0v 44.745n 0.0v 44.755n 0.0v 49.745n 0.0v 49.755n 0.0v 54.745n 0.0v 54.755n 0.0v 59.745n 0.0v 59.755n 0.0v 64.745n 0.0v 64.755n 0.0v 69.745n 0.0v 69.755n 0.0v 74.745n 0.0v 74.755n 0.0v 79.745n 0.0v 79.755n 0.0v 84.745n 0.0v 84.755n 0.0v 89.745n 0.0v 89.755n 0.0v 94.745n 0.0v 94.755n 0.0v 99.745n 0.0v 99.755n 0.0v 104.745n 0.0v 104.755n 0.0v 109.745n 0.0v 109.755n 0.0v 114.745n 0.0v 114.755n 1.1v 119.745n 1.1v 119.755n 1.1v 124.745n 1.1v 124.755n 1.1v 129.745n 1.1v 129.755n 1.1v 134.745n 1.1v 134.755n 1.1v 139.745n 1.1v 139.755n 0.0v 144.745n 0.0v 144.755n 0.0v 149.745n 0.0v 149.755n 0.0v 154.745n 0.0v 154.755n 0.0v 159.745n 0.0v 159.755n 0.0v 164.745n 0.0v 164.755n 0.0v 169.745n 0.0v 169.755n 0.0v 174.745n 0.0v 174.755n 0.0v 179.745n 0.0v 179.755n 1.1v 184.745n 1.1v 184.755n 1.1v 189.745n 1.1v 189.755n 1.1v 194.745n 1.1v 194.755n 1.1v 199.745n 1.1v 199.755n 1.1v 204.745n 1.1v 204.755n 0.0v 209.745n 0.0v 209.755n 0.0v 214.745n 0.0v 214.755n 0.0v 219.745n 0.0v 219.755n 0.0v 224.745n 0.0v 224.755n 0.0v 229.745n 0.0v 229.755n 0.0v 234.745n 0.0v 234.755n 0.0v 239.745n 0.0v 239.755n 1.1v 244.745n 1.1v 244.755n 1.1v 249.745n 1.1v 249.755n 1.1v 254.745n 1.1v 254.755n 1.1v 259.745n 1.1v 259.755n 1.1v 264.745n 1.1v 264.755n 1.1v 269.745n 1.1v 269.755n 0.0v 274.745n 0.0v 274.755n 0.0v 279.745n 0.0v 279.755n 0.0v 284.745n 0.0v 284.755n 0.0v 289.745n 0.0v 289.755n 1.1v 294.745n 1.1v 294.755n 0.0v 299.745n 0.0v 299.755n 1.1v 304.745n 1.1v 304.755n 1.1v 309.745n 1.1v 309.755n 1.1v 314.745n 1.1v 314.755n 1.1v 319.745n 1.1v 319.755n 1.1v 324.745n 1.1v 324.755n 1.1v 329.745n 1.1v 329.755n 1.1v 334.745n 1.1v 334.755n 1.1v 339.745n 1.1v 339.755n 0.0v 344.745n 0.0v 344.755n 0.0v 349.745n 0.0v 349.755n 0.0v 354.745n 0.0v 354.755n 0.0v 359.745n 0.0v 359.755n 0.0v 364.745n 0.0v 364.755n 0.0v 369.745n 0.0v 369.755n 0.0v 374.745n 0.0v 374.755n 0.0v 379.745n 0.0v 379.755n 0.0v 384.745n 0.0v 384.755n 0.0v 389.745n 0.0v 389.755n 0.0v 394.745n 0.0v 394.755n 1.1v 399.745n 1.1v 399.755n 1.1v 404.745n 1.1v 404.755n 1.1v 409.745n 1.1v 409.755n 0.0v 414.745n 0.0v 414.755n 0.0v 419.745n 0.0v 419.755n 0.0v 424.745n 0.0v 424.755n 0.0v 429.745n 0.0v 429.755n 0.0v 434.745n 0.0v 434.755n 0.0v 439.745n 0.0v 439.755n 0.0v 444.745n 0.0v 444.755n 1.1v 449.745n 1.1v 449.755n 1.1v 454.745n 1.1v 454.755n 1.1v 459.745n 1.1v 459.755n 1.1v 464.745n 1.1v 464.755n 1.1v 469.745n 1.1v 469.755n 1.1v 474.745n 1.1v 474.755n 1.1v 479.745n 1.1v 479.755n 1.1v 484.745n 1.1v 484.755n 1.1v 489.745n 1.1v 489.755n 1.1v 494.745n 1.1v 494.755n 1.1v 499.745n 1.1v 499.755n 1.1v 504.745n 1.1v 504.755n 1.1v 509.745n 1.1v 509.755n 0.0v 514.745n 0.0v 514.755n 1.1v 519.745n 1.1v 519.755n 1.1v 524.745n 1.1v 524.755n 1.1v 529.745n 1.1v 529.755n 1.1v 534.745n 1.1v 534.755n 1.1v 539.745n 1.1v 539.755n 0.0v 544.745n 0.0v 544.755n 0.0v 549.745n 0.0v 549.755n 0.0v 554.745n 0.0v 554.755n 0.0v 559.745n 0.0v 559.755n 0.0v 564.745n 0.0v 564.755n 0.0v 569.745n 0.0v 569.755n 1.1v 574.745n 1.1v 574.755n 1.1v 579.745n 1.1v 579.755n 1.1v 584.745n 1.1v 584.755n 1.1v 589.745n 1.1v 589.755n 0.0v 594.745n 0.0v 594.755n 1.1v 599.745n 1.1v 599.755n 1.1v 604.745n 1.1v 604.755n 1.1v 609.745n 1.1v 609.755n 1.1v 614.745n 1.1v 614.755n 1.1v 619.745n 1.1v 619.755n 1.1v 624.745n 1.1v 624.755n 1.1v 629.745n 1.1v 629.755n 1.1v 634.745n 1.1v 634.755n 1.1v 639.745n 1.1v 639.755n 1.1v 644.745n 1.1v 644.755n 1.1v 649.745n 1.1v 649.755n 1.1v 654.745n 1.1v 654.755n 1.1v 659.745n 1.1v 659.755n 1.1v 664.745n 1.1v 664.755n 0.0v 669.745n 0.0v 669.755n 0.0v 674.745n 0.0v 674.755n 0.0v 679.745n 0.0v 679.755n 0.0v 684.745n 0.0v 684.755n 0.0v 689.745n 0.0v 689.755n 1.1v 694.745n 1.1v 694.755n 1.1v 699.745n 1.1v 699.755n 1.1v 704.745n 1.1v 704.755n 1.1v 709.745n 1.1v 709.755n 0.0v 714.745n 0.0v 714.755n 0.0v 719.745n 0.0v 719.755n 0.0v 724.745n 0.0v 724.755n 0.0v 729.745n 0.0v 729.755n 0.0v 734.745n 0.0v 734.755n 1.1v 739.745n 1.1v 739.755n 1.1v 744.745n 1.1v 744.755n 1.1v 749.745n 1.1v 749.755n 1.1v 754.745n 1.1v 754.755n 0.0v 759.745n 0.0v 759.755n 0.0v 764.745n 0.0v 764.755n 0.0v 769.745n 0.0v 769.755n 0.0v 774.745n 0.0v 774.755n 0.0v 779.745n 0.0v 779.755n 0.0v 784.745n 0.0v 784.755n 0.0v 789.745n 0.0v 789.755n 0.0v 794.745n 0.0v 794.755n 0.0v 799.745n 0.0v 799.755n 0.0v 804.745n 0.0v 804.755n 0.0v 809.745n 0.0v 809.755n 0.0v 814.745n 0.0v 814.755n 0.0v 819.745n 0.0v 819.755n 1.1v 824.745n 1.1v 824.755n 1.1v 829.745n 1.1v 829.755n 1.1v 834.745n 1.1v 834.755n 0.0v 839.745n 0.0v 839.755n 0.0v 844.745n 0.0v 844.755n 0.0v 849.745n 0.0v 849.755n 0.0v 854.745n 0.0v 854.755n 0.0v 859.745n 0.0v 859.755n 0.0v 864.745n 0.0v 864.755n 0.0v 869.745n 0.0v 869.755n 0.0v 874.745n 0.0v 874.755n 0.0v 879.745n 0.0v 879.755n 0.0v 884.745n 0.0v 884.755n 0.0v 889.745n 0.0v 889.755n 1.1v 894.745n 1.1v 894.755n 1.1v 899.745n 1.1v 899.755n 1.1v 904.745n 1.1v 904.755n 1.1v 909.745n 1.1v 909.755n 1.1v 914.745n 1.1v 914.755n 1.1v 919.745n 1.1v 919.755n 1.1v 924.745n 1.1v 924.755n 1.1v 929.745n 1.1v 929.755n 1.1v 934.745n 1.1v 934.755n 1.1v 939.745n 1.1v 939.755n 0.0v 944.745n 0.0v 944.755n 0.0v 949.745n 0.0v 949.755n 0.0v 954.745n 0.0v 954.755n 0.0v 959.745n 0.0v 959.755n 0.0v 964.745n 0.0v 964.755n 1.1v 969.745n 1.1v 969.755n 0.0v 974.745n 0.0v 974.755n 0.0v 979.745n 0.0v 979.755n 0.0v 984.745n 0.0v 984.755n 0.0v 989.745n 0.0v 989.755n 1.1v 994.745n 1.1v 994.755n 1.1v 999.745n 1.1v 999.755n 1.1v 1004.745n 1.1v 1004.755n 1.1v 1009.745n 1.1v 1009.755n 1.1v 1014.745n 1.1v 1014.755n 1.1v 1019.745n 1.1v 1019.755n 1.1v 1024.745n 1.1v 1024.755n 1.1v )
* (time, data): [(0, 0), (5, 0), (10, 0), (15, 0), (20, 0), (25, 0), (30, 0), (35, 0), (40, 0), (45, 0), (50, 0), (55, 0), (60, 0), (65, 0), (70, 0), (75, 0), (80, 0), (85, 0), (90, 0), (95, 0), (100, 0), (105, 0), (110, 0), (115, 0), (120, 0), (125, 0), (130, 0), (135, 0), (140, 1), (145, 0), (150, 0), (155, 0), (160, 0), (165, 0), (170, 0), (175, 0), (180, 0), (185, 0), (190, 0), (195, 0), (200, 0), (205, 0), (210, 0), (215, 0), (220, 1), (225, 1), (230, 1), (235, 1), (240, 1), (245, 1), (250, 1), (255, 1), (260, 1), (265, 1), (270, 1), (275, 1), (280, 0), (285, 0), (290, 0), (295, 1), (300, 0), (305, 0), (310, 0), (315, 1), (320, 1), (325, 1), (330, 0), (335, 1), (340, 0), (345, 0), (350, 0), (355, 0), (360, 0), (365, 0), (370, 0), (375, 0), (380, 0), (385, 1), (390, 1), (395, 0), (400, 0), (405, 1), (410, 0), (415, 0), (420, 0), (425, 0), (430, 0), (435, 1), (440, 1), (445, 1), (450, 0), (455, 0), (460, 0), (465, 0), (470, 0), (475, 0), (480, 0), (485, 0), (490, 0), (495, 0), (500, 0), (505, 0), (510, 1), (515, 0), (520, 0), (525, 0), (530, 0), (535, 0), (540, 1), (545, 1), (550, 1), (555, 1), (560, 1), (565, 1), (570, 1), (575, 1), (580, 0), (585, 0), (590, 0), (595, 1), (600, 1), (605, 0), (610, 0), (615, 0), (620, 0), (625, 0), (630, 0), (635, 0), (640, 0), (645, 1), (650, 1), (655, 1), (660, 1), (665, 0), (670, 1), (675, 1), (680, 1), (685, 1), (690, 1), (695, 1), (700, 0), (705, 0), (710, 1), (715, 1), (720, 1), (725, 1), (730, 1), (735, 1), (740, 1), (745, 1), (750, 1), (755, 1), (760, 1), (765, 0), (770, 0), (775, 0), (780, 0), (785, 1), (790, 1), (795, 1), (800, 1), (805, 1), (810, 1), (815, 0), (820, 1), (825, 1), (830, 1), (835, 1), (840, 1), (845, 1), (850, 1), (855, 1), (860, 0), (865, 0), (870, 0), (875, 0), (880, 0), (885, 0), (890, 0), (895, 0), (900, 0), (905, 0), (910, 0), (915, 0), (920, 1), (925, 1), (930, 0), (935, 0), (940, 0), (945, 0), (950, 1), (955, 0), (960, 1), (965, 1), (970, 1), (975, 1), (980, 1), (985, 1), (990, 1), (995, 0), (1000, 1), (1005, 1), (1010, 0), (1015, 0), (1020, 0), (1025, 0)]
Vdin0_22  din0_22  0 PWL (0n 0.0v 4.745n 0.0v 4.755n 0.0v 9.745n 0.0v 9.755n 0.0v 14.745n 0.0v 14.755n 0.0v 19.745n 0.0v 19.755n 0.0v 24.745n 0.0v 24.755n 0.0v 29.745n 0.0v 29.755n 0.0v 34.745n 0.0v 34.755n 0.0v 39.745n 0.0v 39.755n 0.0v 44.745n 0.0v 44.755n 0.0v 49.745n 0.0v 49.755n 0.0v 54.745n 0.0v 54.755n 0.0v 59.745n 0.0v 59.755n 0.0v 64.745n 0.0v 64.755n 0.0v 69.745n 0.0v 69.755n 0.0v 74.745n 0.0v 74.755n 0.0v 79.745n 0.0v 79.755n 0.0v 84.745n 0.0v 84.755n 0.0v 89.745n 0.0v 89.755n 0.0v 94.745n 0.0v 94.755n 0.0v 99.745n 0.0v 99.755n 0.0v 104.745n 0.0v 104.755n 0.0v 109.745n 0.0v 109.755n 0.0v 114.745n 0.0v 114.755n 0.0v 119.745n 0.0v 119.755n 0.0v 124.745n 0.0v 124.755n 0.0v 129.745n 0.0v 129.755n 0.0v 134.745n 0.0v 134.755n 0.0v 139.745n 0.0v 139.755n 1.1v 144.745n 1.1v 144.755n 0.0v 149.745n 0.0v 149.755n 0.0v 154.745n 0.0v 154.755n 0.0v 159.745n 0.0v 159.755n 0.0v 164.745n 0.0v 164.755n 0.0v 169.745n 0.0v 169.755n 0.0v 174.745n 0.0v 174.755n 0.0v 179.745n 0.0v 179.755n 0.0v 184.745n 0.0v 184.755n 0.0v 189.745n 0.0v 189.755n 0.0v 194.745n 0.0v 194.755n 0.0v 199.745n 0.0v 199.755n 0.0v 204.745n 0.0v 204.755n 0.0v 209.745n 0.0v 209.755n 0.0v 214.745n 0.0v 214.755n 0.0v 219.745n 0.0v 219.755n 1.1v 224.745n 1.1v 224.755n 1.1v 229.745n 1.1v 229.755n 1.1v 234.745n 1.1v 234.755n 1.1v 239.745n 1.1v 239.755n 1.1v 244.745n 1.1v 244.755n 1.1v 249.745n 1.1v 249.755n 1.1v 254.745n 1.1v 254.755n 1.1v 259.745n 1.1v 259.755n 1.1v 264.745n 1.1v 264.755n 1.1v 269.745n 1.1v 269.755n 1.1v 274.745n 1.1v 274.755n 1.1v 279.745n 1.1v 279.755n 0.0v 284.745n 0.0v 284.755n 0.0v 289.745n 0.0v 289.755n 0.0v 294.745n 0.0v 294.755n 1.1v 299.745n 1.1v 299.755n 0.0v 304.745n 0.0v 304.755n 0.0v 309.745n 0.0v 309.755n 0.0v 314.745n 0.0v 314.755n 1.1v 319.745n 1.1v 319.755n 1.1v 324.745n 1.1v 324.755n 1.1v 329.745n 1.1v 329.755n 0.0v 334.745n 0.0v 334.755n 1.1v 339.745n 1.1v 339.755n 0.0v 344.745n 0.0v 344.755n 0.0v 349.745n 0.0v 349.755n 0.0v 354.745n 0.0v 354.755n 0.0v 359.745n 0.0v 359.755n 0.0v 364.745n 0.0v 364.755n 0.0v 369.745n 0.0v 369.755n 0.0v 374.745n 0.0v 374.755n 0.0v 379.745n 0.0v 379.755n 0.0v 384.745n 0.0v 384.755n 1.1v 389.745n 1.1v 389.755n 1.1v 394.745n 1.1v 394.755n 0.0v 399.745n 0.0v 399.755n 0.0v 404.745n 0.0v 404.755n 1.1v 409.745n 1.1v 409.755n 0.0v 414.745n 0.0v 414.755n 0.0v 419.745n 0.0v 419.755n 0.0v 424.745n 0.0v 424.755n 0.0v 429.745n 0.0v 429.755n 0.0v 434.745n 0.0v 434.755n 1.1v 439.745n 1.1v 439.755n 1.1v 444.745n 1.1v 444.755n 1.1v 449.745n 1.1v 449.755n 0.0v 454.745n 0.0v 454.755n 0.0v 459.745n 0.0v 459.755n 0.0v 464.745n 0.0v 464.755n 0.0v 469.745n 0.0v 469.755n 0.0v 474.745n 0.0v 474.755n 0.0v 479.745n 0.0v 479.755n 0.0v 484.745n 0.0v 484.755n 0.0v 489.745n 0.0v 489.755n 0.0v 494.745n 0.0v 494.755n 0.0v 499.745n 0.0v 499.755n 0.0v 504.745n 0.0v 504.755n 0.0v 509.745n 0.0v 509.755n 1.1v 514.745n 1.1v 514.755n 0.0v 519.745n 0.0v 519.755n 0.0v 524.745n 0.0v 524.755n 0.0v 529.745n 0.0v 529.755n 0.0v 534.745n 0.0v 534.755n 0.0v 539.745n 0.0v 539.755n 1.1v 544.745n 1.1v 544.755n 1.1v 549.745n 1.1v 549.755n 1.1v 554.745n 1.1v 554.755n 1.1v 559.745n 1.1v 559.755n 1.1v 564.745n 1.1v 564.755n 1.1v 569.745n 1.1v 569.755n 1.1v 574.745n 1.1v 574.755n 1.1v 579.745n 1.1v 579.755n 0.0v 584.745n 0.0v 584.755n 0.0v 589.745n 0.0v 589.755n 0.0v 594.745n 0.0v 594.755n 1.1v 599.745n 1.1v 599.755n 1.1v 604.745n 1.1v 604.755n 0.0v 609.745n 0.0v 609.755n 0.0v 614.745n 0.0v 614.755n 0.0v 619.745n 0.0v 619.755n 0.0v 624.745n 0.0v 624.755n 0.0v 629.745n 0.0v 629.755n 0.0v 634.745n 0.0v 634.755n 0.0v 639.745n 0.0v 639.755n 0.0v 644.745n 0.0v 644.755n 1.1v 649.745n 1.1v 649.755n 1.1v 654.745n 1.1v 654.755n 1.1v 659.745n 1.1v 659.755n 1.1v 664.745n 1.1v 664.755n 0.0v 669.745n 0.0v 669.755n 1.1v 674.745n 1.1v 674.755n 1.1v 679.745n 1.1v 679.755n 1.1v 684.745n 1.1v 684.755n 1.1v 689.745n 1.1v 689.755n 1.1v 694.745n 1.1v 694.755n 1.1v 699.745n 1.1v 699.755n 0.0v 704.745n 0.0v 704.755n 0.0v 709.745n 0.0v 709.755n 1.1v 714.745n 1.1v 714.755n 1.1v 719.745n 1.1v 719.755n 1.1v 724.745n 1.1v 724.755n 1.1v 729.745n 1.1v 729.755n 1.1v 734.745n 1.1v 734.755n 1.1v 739.745n 1.1v 739.755n 1.1v 744.745n 1.1v 744.755n 1.1v 749.745n 1.1v 749.755n 1.1v 754.745n 1.1v 754.755n 1.1v 759.745n 1.1v 759.755n 1.1v 764.745n 1.1v 764.755n 0.0v 769.745n 0.0v 769.755n 0.0v 774.745n 0.0v 774.755n 0.0v 779.745n 0.0v 779.755n 0.0v 784.745n 0.0v 784.755n 1.1v 789.745n 1.1v 789.755n 1.1v 794.745n 1.1v 794.755n 1.1v 799.745n 1.1v 799.755n 1.1v 804.745n 1.1v 804.755n 1.1v 809.745n 1.1v 809.755n 1.1v 814.745n 1.1v 814.755n 0.0v 819.745n 0.0v 819.755n 1.1v 824.745n 1.1v 824.755n 1.1v 829.745n 1.1v 829.755n 1.1v 834.745n 1.1v 834.755n 1.1v 839.745n 1.1v 839.755n 1.1v 844.745n 1.1v 844.755n 1.1v 849.745n 1.1v 849.755n 1.1v 854.745n 1.1v 854.755n 1.1v 859.745n 1.1v 859.755n 0.0v 864.745n 0.0v 864.755n 0.0v 869.745n 0.0v 869.755n 0.0v 874.745n 0.0v 874.755n 0.0v 879.745n 0.0v 879.755n 0.0v 884.745n 0.0v 884.755n 0.0v 889.745n 0.0v 889.755n 0.0v 894.745n 0.0v 894.755n 0.0v 899.745n 0.0v 899.755n 0.0v 904.745n 0.0v 904.755n 0.0v 909.745n 0.0v 909.755n 0.0v 914.745n 0.0v 914.755n 0.0v 919.745n 0.0v 919.755n 1.1v 924.745n 1.1v 924.755n 1.1v 929.745n 1.1v 929.755n 0.0v 934.745n 0.0v 934.755n 0.0v 939.745n 0.0v 939.755n 0.0v 944.745n 0.0v 944.755n 0.0v 949.745n 0.0v 949.755n 1.1v 954.745n 1.1v 954.755n 0.0v 959.745n 0.0v 959.755n 1.1v 964.745n 1.1v 964.755n 1.1v 969.745n 1.1v 969.755n 1.1v 974.745n 1.1v 974.755n 1.1v 979.745n 1.1v 979.755n 1.1v 984.745n 1.1v 984.755n 1.1v 989.745n 1.1v 989.755n 1.1v 994.745n 1.1v 994.755n 0.0v 999.745n 0.0v 999.755n 1.1v 1004.745n 1.1v 1004.755n 1.1v 1009.745n 1.1v 1009.755n 0.0v 1014.745n 0.0v 1014.755n 0.0v 1019.745n 0.0v 1019.755n 0.0v 1024.745n 0.0v 1024.755n 0.0v )
* (time, data): [(0, 0), (5, 0), (10, 0), (15, 0), (20, 0), (25, 0), (30, 0), (35, 0), (40, 0), (45, 0), (50, 0), (55, 0), (60, 0), (65, 0), (70, 1), (75, 1), (80, 1), (85, 1), (90, 1), (95, 1), (100, 0), (105, 0), (110, 0), (115, 0), (120, 0), (125, 0), (130, 0), (135, 0), (140, 1), (145, 1), (150, 1), (155, 1), (160, 1), (165, 1), (170, 1), (175, 1), (180, 0), (185, 0), (190, 0), (195, 0), (200, 0), (205, 1), (210, 0), (215, 0), (220, 1), (225, 1), (230, 1), (235, 1), (240, 0), (245, 0), (250, 0), (255, 0), (260, 0), (265, 0), (270, 1), (275, 1), (280, 1), (285, 1), (290, 0), (295, 0), (300, 0), (305, 0), (310, 0), (315, 0), (320, 1), (325, 1), (330, 0), (335, 1), (340, 0), (345, 0), (350, 0), (355, 0), (360, 0), (365, 0), (370, 0), (375, 0), (380, 0), (385, 1), (390, 1), (395, 1), (400, 1), (405, 1), (410, 0), (415, 0), (420, 0), (425, 0), (430, 0), (435, 1), (440, 1), (445, 1), (450, 1), (455, 1), (460, 1), (465, 1), (470, 1), (475, 1), (480, 1), (485, 1), (490, 0), (495, 0), (500, 0), (505, 0), (510, 0), (515, 0), (520, 0), (525, 0), (530, 0), (535, 0), (540, 0), (545, 0), (550, 0), (555, 0), (560, 0), (565, 0), (570, 0), (575, 1), (580, 1), (585, 1), (590, 1), (595, 1), (600, 0), (605, 1), (610, 1), (615, 0), (620, 0), (625, 1), (630, 1), (635, 1), (640, 1), (645, 0), (650, 0), (655, 0), (660, 0), (665, 0), (670, 1), (675, 1), (680, 1), (685, 1), (690, 1), (695, 0), (700, 0), (705, 1), (710, 0), (715, 0), (720, 0), (725, 0), (730, 0), (735, 0), (740, 0), (745, 0), (750, 0), (755, 0), (760, 0), (765, 1), (770, 1), (775, 1), (780, 1), (785, 1), (790, 1), (795, 1), (800, 1), (805, 1), (810, 1), (815, 1), (820, 1), (825, 1), (830, 1), (835, 1), (840, 1), (845, 1), (850, 1), (855, 1), (860, 0), (865, 0), (870, 0), (875, 0), (880, 0), (885, 0), (890, 0), (895, 0), (900, 0), (905, 0), (910, 1), (915, 1), (920, 1), (925, 1), (930, 1), (935, 1), (940, 1), (945, 1), (950, 0), (955, 0), (960, 1), (965, 1), (970, 0), (975, 0), (980, 0), (985, 1), (990, 1), (995, 0), (1000, 1), (1005, 1), (1010, 0), (1015, 0), (1020, 0), (1025, 0)]
Vdin0_23  din0_23  0 PWL (0n 0.0v 4.745n 0.0v 4.755n 0.0v 9.745n 0.0v 9.755n 0.0v 14.745n 0.0v 14.755n 0.0v 19.745n 0.0v 19.755n 0.0v 24.745n 0.0v 24.755n 0.0v 29.745n 0.0v 29.755n 0.0v 34.745n 0.0v 34.755n 0.0v 39.745n 0.0v 39.755n 0.0v 44.745n 0.0v 44.755n 0.0v 49.745n 0.0v 49.755n 0.0v 54.745n 0.0v 54.755n 0.0v 59.745n 0.0v 59.755n 0.0v 64.745n 0.0v 64.755n 0.0v 69.745n 0.0v 69.755n 1.1v 74.745n 1.1v 74.755n 1.1v 79.745n 1.1v 79.755n 1.1v 84.745n 1.1v 84.755n 1.1v 89.745n 1.1v 89.755n 1.1v 94.745n 1.1v 94.755n 1.1v 99.745n 1.1v 99.755n 0.0v 104.745n 0.0v 104.755n 0.0v 109.745n 0.0v 109.755n 0.0v 114.745n 0.0v 114.755n 0.0v 119.745n 0.0v 119.755n 0.0v 124.745n 0.0v 124.755n 0.0v 129.745n 0.0v 129.755n 0.0v 134.745n 0.0v 134.755n 0.0v 139.745n 0.0v 139.755n 1.1v 144.745n 1.1v 144.755n 1.1v 149.745n 1.1v 149.755n 1.1v 154.745n 1.1v 154.755n 1.1v 159.745n 1.1v 159.755n 1.1v 164.745n 1.1v 164.755n 1.1v 169.745n 1.1v 169.755n 1.1v 174.745n 1.1v 174.755n 1.1v 179.745n 1.1v 179.755n 0.0v 184.745n 0.0v 184.755n 0.0v 189.745n 0.0v 189.755n 0.0v 194.745n 0.0v 194.755n 0.0v 199.745n 0.0v 199.755n 0.0v 204.745n 0.0v 204.755n 1.1v 209.745n 1.1v 209.755n 0.0v 214.745n 0.0v 214.755n 0.0v 219.745n 0.0v 219.755n 1.1v 224.745n 1.1v 224.755n 1.1v 229.745n 1.1v 229.755n 1.1v 234.745n 1.1v 234.755n 1.1v 239.745n 1.1v 239.755n 0.0v 244.745n 0.0v 244.755n 0.0v 249.745n 0.0v 249.755n 0.0v 254.745n 0.0v 254.755n 0.0v 259.745n 0.0v 259.755n 0.0v 264.745n 0.0v 264.755n 0.0v 269.745n 0.0v 269.755n 1.1v 274.745n 1.1v 274.755n 1.1v 279.745n 1.1v 279.755n 1.1v 284.745n 1.1v 284.755n 1.1v 289.745n 1.1v 289.755n 0.0v 294.745n 0.0v 294.755n 0.0v 299.745n 0.0v 299.755n 0.0v 304.745n 0.0v 304.755n 0.0v 309.745n 0.0v 309.755n 0.0v 314.745n 0.0v 314.755n 0.0v 319.745n 0.0v 319.755n 1.1v 324.745n 1.1v 324.755n 1.1v 329.745n 1.1v 329.755n 0.0v 334.745n 0.0v 334.755n 1.1v 339.745n 1.1v 339.755n 0.0v 344.745n 0.0v 344.755n 0.0v 349.745n 0.0v 349.755n 0.0v 354.745n 0.0v 354.755n 0.0v 359.745n 0.0v 359.755n 0.0v 364.745n 0.0v 364.755n 0.0v 369.745n 0.0v 369.755n 0.0v 374.745n 0.0v 374.755n 0.0v 379.745n 0.0v 379.755n 0.0v 384.745n 0.0v 384.755n 1.1v 389.745n 1.1v 389.755n 1.1v 394.745n 1.1v 394.755n 1.1v 399.745n 1.1v 399.755n 1.1v 404.745n 1.1v 404.755n 1.1v 409.745n 1.1v 409.755n 0.0v 414.745n 0.0v 414.755n 0.0v 419.745n 0.0v 419.755n 0.0v 424.745n 0.0v 424.755n 0.0v 429.745n 0.0v 429.755n 0.0v 434.745n 0.0v 434.755n 1.1v 439.745n 1.1v 439.755n 1.1v 444.745n 1.1v 444.755n 1.1v 449.745n 1.1v 449.755n 1.1v 454.745n 1.1v 454.755n 1.1v 459.745n 1.1v 459.755n 1.1v 464.745n 1.1v 464.755n 1.1v 469.745n 1.1v 469.755n 1.1v 474.745n 1.1v 474.755n 1.1v 479.745n 1.1v 479.755n 1.1v 484.745n 1.1v 484.755n 1.1v 489.745n 1.1v 489.755n 0.0v 494.745n 0.0v 494.755n 0.0v 499.745n 0.0v 499.755n 0.0v 504.745n 0.0v 504.755n 0.0v 509.745n 0.0v 509.755n 0.0v 514.745n 0.0v 514.755n 0.0v 519.745n 0.0v 519.755n 0.0v 524.745n 0.0v 524.755n 0.0v 529.745n 0.0v 529.755n 0.0v 534.745n 0.0v 534.755n 0.0v 539.745n 0.0v 539.755n 0.0v 544.745n 0.0v 544.755n 0.0v 549.745n 0.0v 549.755n 0.0v 554.745n 0.0v 554.755n 0.0v 559.745n 0.0v 559.755n 0.0v 564.745n 0.0v 564.755n 0.0v 569.745n 0.0v 569.755n 0.0v 574.745n 0.0v 574.755n 1.1v 579.745n 1.1v 579.755n 1.1v 584.745n 1.1v 584.755n 1.1v 589.745n 1.1v 589.755n 1.1v 594.745n 1.1v 594.755n 1.1v 599.745n 1.1v 599.755n 0.0v 604.745n 0.0v 604.755n 1.1v 609.745n 1.1v 609.755n 1.1v 614.745n 1.1v 614.755n 0.0v 619.745n 0.0v 619.755n 0.0v 624.745n 0.0v 624.755n 1.1v 629.745n 1.1v 629.755n 1.1v 634.745n 1.1v 634.755n 1.1v 639.745n 1.1v 639.755n 1.1v 644.745n 1.1v 644.755n 0.0v 649.745n 0.0v 649.755n 0.0v 654.745n 0.0v 654.755n 0.0v 659.745n 0.0v 659.755n 0.0v 664.745n 0.0v 664.755n 0.0v 669.745n 0.0v 669.755n 1.1v 674.745n 1.1v 674.755n 1.1v 679.745n 1.1v 679.755n 1.1v 684.745n 1.1v 684.755n 1.1v 689.745n 1.1v 689.755n 1.1v 694.745n 1.1v 694.755n 0.0v 699.745n 0.0v 699.755n 0.0v 704.745n 0.0v 704.755n 1.1v 709.745n 1.1v 709.755n 0.0v 714.745n 0.0v 714.755n 0.0v 719.745n 0.0v 719.755n 0.0v 724.745n 0.0v 724.755n 0.0v 729.745n 0.0v 729.755n 0.0v 734.745n 0.0v 734.755n 0.0v 739.745n 0.0v 739.755n 0.0v 744.745n 0.0v 744.755n 0.0v 749.745n 0.0v 749.755n 0.0v 754.745n 0.0v 754.755n 0.0v 759.745n 0.0v 759.755n 0.0v 764.745n 0.0v 764.755n 1.1v 769.745n 1.1v 769.755n 1.1v 774.745n 1.1v 774.755n 1.1v 779.745n 1.1v 779.755n 1.1v 784.745n 1.1v 784.755n 1.1v 789.745n 1.1v 789.755n 1.1v 794.745n 1.1v 794.755n 1.1v 799.745n 1.1v 799.755n 1.1v 804.745n 1.1v 804.755n 1.1v 809.745n 1.1v 809.755n 1.1v 814.745n 1.1v 814.755n 1.1v 819.745n 1.1v 819.755n 1.1v 824.745n 1.1v 824.755n 1.1v 829.745n 1.1v 829.755n 1.1v 834.745n 1.1v 834.755n 1.1v 839.745n 1.1v 839.755n 1.1v 844.745n 1.1v 844.755n 1.1v 849.745n 1.1v 849.755n 1.1v 854.745n 1.1v 854.755n 1.1v 859.745n 1.1v 859.755n 0.0v 864.745n 0.0v 864.755n 0.0v 869.745n 0.0v 869.755n 0.0v 874.745n 0.0v 874.755n 0.0v 879.745n 0.0v 879.755n 0.0v 884.745n 0.0v 884.755n 0.0v 889.745n 0.0v 889.755n 0.0v 894.745n 0.0v 894.755n 0.0v 899.745n 0.0v 899.755n 0.0v 904.745n 0.0v 904.755n 0.0v 909.745n 0.0v 909.755n 1.1v 914.745n 1.1v 914.755n 1.1v 919.745n 1.1v 919.755n 1.1v 924.745n 1.1v 924.755n 1.1v 929.745n 1.1v 929.755n 1.1v 934.745n 1.1v 934.755n 1.1v 939.745n 1.1v 939.755n 1.1v 944.745n 1.1v 944.755n 1.1v 949.745n 1.1v 949.755n 0.0v 954.745n 0.0v 954.755n 0.0v 959.745n 0.0v 959.755n 1.1v 964.745n 1.1v 964.755n 1.1v 969.745n 1.1v 969.755n 0.0v 974.745n 0.0v 974.755n 0.0v 979.745n 0.0v 979.755n 0.0v 984.745n 0.0v 984.755n 1.1v 989.745n 1.1v 989.755n 1.1v 994.745n 1.1v 994.755n 0.0v 999.745n 0.0v 999.755n 1.1v 1004.745n 1.1v 1004.755n 1.1v 1009.745n 1.1v 1009.755n 0.0v 1014.745n 0.0v 1014.755n 0.0v 1019.745n 0.0v 1019.755n 0.0v 1024.745n 0.0v 1024.755n 0.0v )
* (time, data): [(0, 0), (5, 1), (10, 0), (15, 1), (20, 1), (25, 1), (30, 1), (35, 1), (40, 1), (45, 1), (50, 1), (55, 1), (60, 1), (65, 1), (70, 1), (75, 1), (80, 1), (85, 0), (90, 0), (95, 0), (100, 1), (105, 1), (110, 1), (115, 1), (120, 1), (125, 1), (130, 1), (135, 1), (140, 0), (145, 0), (150, 0), (155, 0), (160, 0), (165, 0), (170, 0), (175, 0), (180, 1), (185, 1), (190, 1), (195, 1), (200, 1), (205, 0), (210, 1), (215, 1), (220, 1), (225, 1), (230, 1), (235, 1), (240, 1), (245, 1), (250, 1), (255, 1), (260, 1), (265, 1), (270, 0), (275, 0), (280, 1), (285, 1), (290, 1), (295, 1), (300, 0), (305, 0), (310, 0), (315, 0), (320, 1), (325, 1), (330, 0), (335, 1), (340, 1), (345, 1), (350, 1), (355, 1), (360, 1), (365, 1), (370, 1), (375, 1), (380, 1), (385, 0), (390, 0), (395, 1), (400, 1), (405, 0), (410, 0), (415, 0), (420, 0), (425, 0), (430, 0), (435, 0), (440, 0), (445, 1), (450, 0), (455, 1), (460, 1), (465, 1), (470, 1), (475, 1), (480, 1), (485, 1), (490, 1), (495, 1), (500, 1), (505, 1), (510, 1), (515, 1), (520, 1), (525, 1), (530, 1), (535, 1), (540, 0), (545, 1), (550, 1), (555, 1), (560, 1), (565, 1), (570, 1), (575, 1), (580, 0), (585, 1), (590, 0), (595, 1), (600, 1), (605, 0), (610, 0), (615, 1), (620, 1), (625, 0), (630, 0), (635, 0), (640, 0), (645, 1), (650, 1), (655, 1), (660, 1), (665, 0), (670, 1), (675, 1), (680, 1), (685, 1), (690, 0), (695, 1), (700, 0), (705, 1), (710, 1), (715, 1), (720, 1), (725, 1), (730, 1), (735, 1), (740, 1), (745, 0), (750, 0), (755, 0), (760, 0), (765, 0), (770, 0), (775, 0), (780, 0), (785, 0), (790, 0), (795, 0), (800, 0), (805, 0), (810, 0), (815, 0), (820, 1), (825, 1), (830, 1), (835, 1), (840, 1), (845, 1), (850, 1), (855, 1), (860, 1), (865, 1), (870, 1), (875, 1), (880, 1), (885, 1), (890, 1), (895, 1), (900, 0), (905, 1), (910, 0), (915, 0), (920, 1), (925, 1), (930, 0), (935, 0), (940, 1), (945, 1), (950, 1), (955, 0), (960, 0), (965, 1), (970, 0), (975, 0), (980, 0), (985, 1), (990, 1), (995, 1), (1000, 0), (1005, 0), (1010, 1), (1015, 1), (1020, 1), (1025, 1)]
Vdin0_24  din0_24  0 PWL (0n 0.0v 4.745n 0.0v 4.755n 1.1v 9.745n 1.1v 9.755n 0.0v 14.745n 0.0v 14.755n 1.1v 19.745n 1.1v 19.755n 1.1v 24.745n 1.1v 24.755n 1.1v 29.745n 1.1v 29.755n 1.1v 34.745n 1.1v 34.755n 1.1v 39.745n 1.1v 39.755n 1.1v 44.745n 1.1v 44.755n 1.1v 49.745n 1.1v 49.755n 1.1v 54.745n 1.1v 54.755n 1.1v 59.745n 1.1v 59.755n 1.1v 64.745n 1.1v 64.755n 1.1v 69.745n 1.1v 69.755n 1.1v 74.745n 1.1v 74.755n 1.1v 79.745n 1.1v 79.755n 1.1v 84.745n 1.1v 84.755n 0.0v 89.745n 0.0v 89.755n 0.0v 94.745n 0.0v 94.755n 0.0v 99.745n 0.0v 99.755n 1.1v 104.745n 1.1v 104.755n 1.1v 109.745n 1.1v 109.755n 1.1v 114.745n 1.1v 114.755n 1.1v 119.745n 1.1v 119.755n 1.1v 124.745n 1.1v 124.755n 1.1v 129.745n 1.1v 129.755n 1.1v 134.745n 1.1v 134.755n 1.1v 139.745n 1.1v 139.755n 0.0v 144.745n 0.0v 144.755n 0.0v 149.745n 0.0v 149.755n 0.0v 154.745n 0.0v 154.755n 0.0v 159.745n 0.0v 159.755n 0.0v 164.745n 0.0v 164.755n 0.0v 169.745n 0.0v 169.755n 0.0v 174.745n 0.0v 174.755n 0.0v 179.745n 0.0v 179.755n 1.1v 184.745n 1.1v 184.755n 1.1v 189.745n 1.1v 189.755n 1.1v 194.745n 1.1v 194.755n 1.1v 199.745n 1.1v 199.755n 1.1v 204.745n 1.1v 204.755n 0.0v 209.745n 0.0v 209.755n 1.1v 214.745n 1.1v 214.755n 1.1v 219.745n 1.1v 219.755n 1.1v 224.745n 1.1v 224.755n 1.1v 229.745n 1.1v 229.755n 1.1v 234.745n 1.1v 234.755n 1.1v 239.745n 1.1v 239.755n 1.1v 244.745n 1.1v 244.755n 1.1v 249.745n 1.1v 249.755n 1.1v 254.745n 1.1v 254.755n 1.1v 259.745n 1.1v 259.755n 1.1v 264.745n 1.1v 264.755n 1.1v 269.745n 1.1v 269.755n 0.0v 274.745n 0.0v 274.755n 0.0v 279.745n 0.0v 279.755n 1.1v 284.745n 1.1v 284.755n 1.1v 289.745n 1.1v 289.755n 1.1v 294.745n 1.1v 294.755n 1.1v 299.745n 1.1v 299.755n 0.0v 304.745n 0.0v 304.755n 0.0v 309.745n 0.0v 309.755n 0.0v 314.745n 0.0v 314.755n 0.0v 319.745n 0.0v 319.755n 1.1v 324.745n 1.1v 324.755n 1.1v 329.745n 1.1v 329.755n 0.0v 334.745n 0.0v 334.755n 1.1v 339.745n 1.1v 339.755n 1.1v 344.745n 1.1v 344.755n 1.1v 349.745n 1.1v 349.755n 1.1v 354.745n 1.1v 354.755n 1.1v 359.745n 1.1v 359.755n 1.1v 364.745n 1.1v 364.755n 1.1v 369.745n 1.1v 369.755n 1.1v 374.745n 1.1v 374.755n 1.1v 379.745n 1.1v 379.755n 1.1v 384.745n 1.1v 384.755n 0.0v 389.745n 0.0v 389.755n 0.0v 394.745n 0.0v 394.755n 1.1v 399.745n 1.1v 399.755n 1.1v 404.745n 1.1v 404.755n 0.0v 409.745n 0.0v 409.755n 0.0v 414.745n 0.0v 414.755n 0.0v 419.745n 0.0v 419.755n 0.0v 424.745n 0.0v 424.755n 0.0v 429.745n 0.0v 429.755n 0.0v 434.745n 0.0v 434.755n 0.0v 439.745n 0.0v 439.755n 0.0v 444.745n 0.0v 444.755n 1.1v 449.745n 1.1v 449.755n 0.0v 454.745n 0.0v 454.755n 1.1v 459.745n 1.1v 459.755n 1.1v 464.745n 1.1v 464.755n 1.1v 469.745n 1.1v 469.755n 1.1v 474.745n 1.1v 474.755n 1.1v 479.745n 1.1v 479.755n 1.1v 484.745n 1.1v 484.755n 1.1v 489.745n 1.1v 489.755n 1.1v 494.745n 1.1v 494.755n 1.1v 499.745n 1.1v 499.755n 1.1v 504.745n 1.1v 504.755n 1.1v 509.745n 1.1v 509.755n 1.1v 514.745n 1.1v 514.755n 1.1v 519.745n 1.1v 519.755n 1.1v 524.745n 1.1v 524.755n 1.1v 529.745n 1.1v 529.755n 1.1v 534.745n 1.1v 534.755n 1.1v 539.745n 1.1v 539.755n 0.0v 544.745n 0.0v 544.755n 1.1v 549.745n 1.1v 549.755n 1.1v 554.745n 1.1v 554.755n 1.1v 559.745n 1.1v 559.755n 1.1v 564.745n 1.1v 564.755n 1.1v 569.745n 1.1v 569.755n 1.1v 574.745n 1.1v 574.755n 1.1v 579.745n 1.1v 579.755n 0.0v 584.745n 0.0v 584.755n 1.1v 589.745n 1.1v 589.755n 0.0v 594.745n 0.0v 594.755n 1.1v 599.745n 1.1v 599.755n 1.1v 604.745n 1.1v 604.755n 0.0v 609.745n 0.0v 609.755n 0.0v 614.745n 0.0v 614.755n 1.1v 619.745n 1.1v 619.755n 1.1v 624.745n 1.1v 624.755n 0.0v 629.745n 0.0v 629.755n 0.0v 634.745n 0.0v 634.755n 0.0v 639.745n 0.0v 639.755n 0.0v 644.745n 0.0v 644.755n 1.1v 649.745n 1.1v 649.755n 1.1v 654.745n 1.1v 654.755n 1.1v 659.745n 1.1v 659.755n 1.1v 664.745n 1.1v 664.755n 0.0v 669.745n 0.0v 669.755n 1.1v 674.745n 1.1v 674.755n 1.1v 679.745n 1.1v 679.755n 1.1v 684.745n 1.1v 684.755n 1.1v 689.745n 1.1v 689.755n 0.0v 694.745n 0.0v 694.755n 1.1v 699.745n 1.1v 699.755n 0.0v 704.745n 0.0v 704.755n 1.1v 709.745n 1.1v 709.755n 1.1v 714.745n 1.1v 714.755n 1.1v 719.745n 1.1v 719.755n 1.1v 724.745n 1.1v 724.755n 1.1v 729.745n 1.1v 729.755n 1.1v 734.745n 1.1v 734.755n 1.1v 739.745n 1.1v 739.755n 1.1v 744.745n 1.1v 744.755n 0.0v 749.745n 0.0v 749.755n 0.0v 754.745n 0.0v 754.755n 0.0v 759.745n 0.0v 759.755n 0.0v 764.745n 0.0v 764.755n 0.0v 769.745n 0.0v 769.755n 0.0v 774.745n 0.0v 774.755n 0.0v 779.745n 0.0v 779.755n 0.0v 784.745n 0.0v 784.755n 0.0v 789.745n 0.0v 789.755n 0.0v 794.745n 0.0v 794.755n 0.0v 799.745n 0.0v 799.755n 0.0v 804.745n 0.0v 804.755n 0.0v 809.745n 0.0v 809.755n 0.0v 814.745n 0.0v 814.755n 0.0v 819.745n 0.0v 819.755n 1.1v 824.745n 1.1v 824.755n 1.1v 829.745n 1.1v 829.755n 1.1v 834.745n 1.1v 834.755n 1.1v 839.745n 1.1v 839.755n 1.1v 844.745n 1.1v 844.755n 1.1v 849.745n 1.1v 849.755n 1.1v 854.745n 1.1v 854.755n 1.1v 859.745n 1.1v 859.755n 1.1v 864.745n 1.1v 864.755n 1.1v 869.745n 1.1v 869.755n 1.1v 874.745n 1.1v 874.755n 1.1v 879.745n 1.1v 879.755n 1.1v 884.745n 1.1v 884.755n 1.1v 889.745n 1.1v 889.755n 1.1v 894.745n 1.1v 894.755n 1.1v 899.745n 1.1v 899.755n 0.0v 904.745n 0.0v 904.755n 1.1v 909.745n 1.1v 909.755n 0.0v 914.745n 0.0v 914.755n 0.0v 919.745n 0.0v 919.755n 1.1v 924.745n 1.1v 924.755n 1.1v 929.745n 1.1v 929.755n 0.0v 934.745n 0.0v 934.755n 0.0v 939.745n 0.0v 939.755n 1.1v 944.745n 1.1v 944.755n 1.1v 949.745n 1.1v 949.755n 1.1v 954.745n 1.1v 954.755n 0.0v 959.745n 0.0v 959.755n 0.0v 964.745n 0.0v 964.755n 1.1v 969.745n 1.1v 969.755n 0.0v 974.745n 0.0v 974.755n 0.0v 979.745n 0.0v 979.755n 0.0v 984.745n 0.0v 984.755n 1.1v 989.745n 1.1v 989.755n 1.1v 994.745n 1.1v 994.755n 1.1v 999.745n 1.1v 999.755n 0.0v 1004.745n 0.0v 1004.755n 0.0v 1009.745n 0.0v 1009.755n 1.1v 1014.745n 1.1v 1014.755n 1.1v 1019.745n 1.1v 1019.755n 1.1v 1024.745n 1.1v 1024.755n 1.1v )
* (time, data): [(0, 0), (5, 0), (10, 1), (15, 1), (20, 1), (25, 1), (30, 1), (35, 1), (40, 1), (45, 1), (50, 0), (55, 0), (60, 0), (65, 0), (70, 0), (75, 0), (80, 0), (85, 1), (90, 1), (95, 1), (100, 0), (105, 0), (110, 0), (115, 1), (120, 1), (125, 1), (130, 1), (135, 1), (140, 0), (145, 1), (150, 1), (155, 1), (160, 1), (165, 1), (170, 1), (175, 1), (180, 0), (185, 0), (190, 0), (195, 0), (200, 0), (205, 1), (210, 1), (215, 1), (220, 1), (225, 1), (230, 1), (235, 1), (240, 0), (245, 0), (250, 0), (255, 0), (260, 0), (265, 0), (270, 0), (275, 0), (280, 1), (285, 1), (290, 1), (295, 1), (300, 0), (305, 0), (310, 0), (315, 0), (320, 0), (325, 1), (330, 0), (335, 1), (340, 1), (345, 1), (350, 1), (355, 1), (360, 1), (365, 1), (370, 1), (375, 1), (380, 1), (385, 0), (390, 0), (395, 0), (400, 0), (405, 0), (410, 1), (415, 1), (420, 1), (425, 0), (430, 0), (435, 0), (440, 0), (445, 1), (450, 1), (455, 0), (460, 0), (465, 0), (470, 0), (475, 0), (480, 0), (485, 0), (490, 1), (495, 1), (500, 1), (505, 1), (510, 1), (515, 0), (520, 0), (525, 0), (530, 0), (535, 1), (540, 1), (545, 1), (550, 0), (555, 0), (560, 0), (565, 0), (570, 1), (575, 1), (580, 0), (585, 1), (590, 1), (595, 1), (600, 0), (605, 0), (610, 0), (615, 1), (620, 1), (625, 1), (630, 1), (635, 1), (640, 1), (645, 0), (650, 0), (655, 0), (660, 0), (665, 1), (670, 1), (675, 1), (680, 1), (685, 1), (690, 0), (695, 0), (700, 1), (705, 0), (710, 1), (715, 1), (720, 1), (725, 1), (730, 1), (735, 1), (740, 1), (745, 1), (750, 1), (755, 1), (760, 1), (765, 1), (770, 1), (775, 1), (780, 1), (785, 1), (790, 1), (795, 1), (800, 1), (805, 1), (810, 1), (815, 1), (820, 1), (825, 1), (830, 1), (835, 1), (840, 1), (845, 1), (850, 1), (855, 1), (860, 1), (865, 1), (870, 1), (875, 1), (880, 1), (885, 1), (890, 1), (895, 1), (900, 1), (905, 1), (910, 1), (915, 1), (920, 0), (925, 0), (930, 0), (935, 0), (940, 0), (945, 0), (950, 0), (955, 1), (960, 0), (965, 1), (970, 1), (975, 1), (980, 1), (985, 1), (990, 0), (995, 1), (1000, 0), (1005, 0), (1010, 1), (1015, 1), (1020, 1), (1025, 1)]
Vdin0_25  din0_25  0 PWL (0n 0.0v 4.745n 0.0v 4.755n 0.0v 9.745n 0.0v 9.755n 1.1v 14.745n 1.1v 14.755n 1.1v 19.745n 1.1v 19.755n 1.1v 24.745n 1.1v 24.755n 1.1v 29.745n 1.1v 29.755n 1.1v 34.745n 1.1v 34.755n 1.1v 39.745n 1.1v 39.755n 1.1v 44.745n 1.1v 44.755n 1.1v 49.745n 1.1v 49.755n 0.0v 54.745n 0.0v 54.755n 0.0v 59.745n 0.0v 59.755n 0.0v 64.745n 0.0v 64.755n 0.0v 69.745n 0.0v 69.755n 0.0v 74.745n 0.0v 74.755n 0.0v 79.745n 0.0v 79.755n 0.0v 84.745n 0.0v 84.755n 1.1v 89.745n 1.1v 89.755n 1.1v 94.745n 1.1v 94.755n 1.1v 99.745n 1.1v 99.755n 0.0v 104.745n 0.0v 104.755n 0.0v 109.745n 0.0v 109.755n 0.0v 114.745n 0.0v 114.755n 1.1v 119.745n 1.1v 119.755n 1.1v 124.745n 1.1v 124.755n 1.1v 129.745n 1.1v 129.755n 1.1v 134.745n 1.1v 134.755n 1.1v 139.745n 1.1v 139.755n 0.0v 144.745n 0.0v 144.755n 1.1v 149.745n 1.1v 149.755n 1.1v 154.745n 1.1v 154.755n 1.1v 159.745n 1.1v 159.755n 1.1v 164.745n 1.1v 164.755n 1.1v 169.745n 1.1v 169.755n 1.1v 174.745n 1.1v 174.755n 1.1v 179.745n 1.1v 179.755n 0.0v 184.745n 0.0v 184.755n 0.0v 189.745n 0.0v 189.755n 0.0v 194.745n 0.0v 194.755n 0.0v 199.745n 0.0v 199.755n 0.0v 204.745n 0.0v 204.755n 1.1v 209.745n 1.1v 209.755n 1.1v 214.745n 1.1v 214.755n 1.1v 219.745n 1.1v 219.755n 1.1v 224.745n 1.1v 224.755n 1.1v 229.745n 1.1v 229.755n 1.1v 234.745n 1.1v 234.755n 1.1v 239.745n 1.1v 239.755n 0.0v 244.745n 0.0v 244.755n 0.0v 249.745n 0.0v 249.755n 0.0v 254.745n 0.0v 254.755n 0.0v 259.745n 0.0v 259.755n 0.0v 264.745n 0.0v 264.755n 0.0v 269.745n 0.0v 269.755n 0.0v 274.745n 0.0v 274.755n 0.0v 279.745n 0.0v 279.755n 1.1v 284.745n 1.1v 284.755n 1.1v 289.745n 1.1v 289.755n 1.1v 294.745n 1.1v 294.755n 1.1v 299.745n 1.1v 299.755n 0.0v 304.745n 0.0v 304.755n 0.0v 309.745n 0.0v 309.755n 0.0v 314.745n 0.0v 314.755n 0.0v 319.745n 0.0v 319.755n 0.0v 324.745n 0.0v 324.755n 1.1v 329.745n 1.1v 329.755n 0.0v 334.745n 0.0v 334.755n 1.1v 339.745n 1.1v 339.755n 1.1v 344.745n 1.1v 344.755n 1.1v 349.745n 1.1v 349.755n 1.1v 354.745n 1.1v 354.755n 1.1v 359.745n 1.1v 359.755n 1.1v 364.745n 1.1v 364.755n 1.1v 369.745n 1.1v 369.755n 1.1v 374.745n 1.1v 374.755n 1.1v 379.745n 1.1v 379.755n 1.1v 384.745n 1.1v 384.755n 0.0v 389.745n 0.0v 389.755n 0.0v 394.745n 0.0v 394.755n 0.0v 399.745n 0.0v 399.755n 0.0v 404.745n 0.0v 404.755n 0.0v 409.745n 0.0v 409.755n 1.1v 414.745n 1.1v 414.755n 1.1v 419.745n 1.1v 419.755n 1.1v 424.745n 1.1v 424.755n 0.0v 429.745n 0.0v 429.755n 0.0v 434.745n 0.0v 434.755n 0.0v 439.745n 0.0v 439.755n 0.0v 444.745n 0.0v 444.755n 1.1v 449.745n 1.1v 449.755n 1.1v 454.745n 1.1v 454.755n 0.0v 459.745n 0.0v 459.755n 0.0v 464.745n 0.0v 464.755n 0.0v 469.745n 0.0v 469.755n 0.0v 474.745n 0.0v 474.755n 0.0v 479.745n 0.0v 479.755n 0.0v 484.745n 0.0v 484.755n 0.0v 489.745n 0.0v 489.755n 1.1v 494.745n 1.1v 494.755n 1.1v 499.745n 1.1v 499.755n 1.1v 504.745n 1.1v 504.755n 1.1v 509.745n 1.1v 509.755n 1.1v 514.745n 1.1v 514.755n 0.0v 519.745n 0.0v 519.755n 0.0v 524.745n 0.0v 524.755n 0.0v 529.745n 0.0v 529.755n 0.0v 534.745n 0.0v 534.755n 1.1v 539.745n 1.1v 539.755n 1.1v 544.745n 1.1v 544.755n 1.1v 549.745n 1.1v 549.755n 0.0v 554.745n 0.0v 554.755n 0.0v 559.745n 0.0v 559.755n 0.0v 564.745n 0.0v 564.755n 0.0v 569.745n 0.0v 569.755n 1.1v 574.745n 1.1v 574.755n 1.1v 579.745n 1.1v 579.755n 0.0v 584.745n 0.0v 584.755n 1.1v 589.745n 1.1v 589.755n 1.1v 594.745n 1.1v 594.755n 1.1v 599.745n 1.1v 599.755n 0.0v 604.745n 0.0v 604.755n 0.0v 609.745n 0.0v 609.755n 0.0v 614.745n 0.0v 614.755n 1.1v 619.745n 1.1v 619.755n 1.1v 624.745n 1.1v 624.755n 1.1v 629.745n 1.1v 629.755n 1.1v 634.745n 1.1v 634.755n 1.1v 639.745n 1.1v 639.755n 1.1v 644.745n 1.1v 644.755n 0.0v 649.745n 0.0v 649.755n 0.0v 654.745n 0.0v 654.755n 0.0v 659.745n 0.0v 659.755n 0.0v 664.745n 0.0v 664.755n 1.1v 669.745n 1.1v 669.755n 1.1v 674.745n 1.1v 674.755n 1.1v 679.745n 1.1v 679.755n 1.1v 684.745n 1.1v 684.755n 1.1v 689.745n 1.1v 689.755n 0.0v 694.745n 0.0v 694.755n 0.0v 699.745n 0.0v 699.755n 1.1v 704.745n 1.1v 704.755n 0.0v 709.745n 0.0v 709.755n 1.1v 714.745n 1.1v 714.755n 1.1v 719.745n 1.1v 719.755n 1.1v 724.745n 1.1v 724.755n 1.1v 729.745n 1.1v 729.755n 1.1v 734.745n 1.1v 734.755n 1.1v 739.745n 1.1v 739.755n 1.1v 744.745n 1.1v 744.755n 1.1v 749.745n 1.1v 749.755n 1.1v 754.745n 1.1v 754.755n 1.1v 759.745n 1.1v 759.755n 1.1v 764.745n 1.1v 764.755n 1.1v 769.745n 1.1v 769.755n 1.1v 774.745n 1.1v 774.755n 1.1v 779.745n 1.1v 779.755n 1.1v 784.745n 1.1v 784.755n 1.1v 789.745n 1.1v 789.755n 1.1v 794.745n 1.1v 794.755n 1.1v 799.745n 1.1v 799.755n 1.1v 804.745n 1.1v 804.755n 1.1v 809.745n 1.1v 809.755n 1.1v 814.745n 1.1v 814.755n 1.1v 819.745n 1.1v 819.755n 1.1v 824.745n 1.1v 824.755n 1.1v 829.745n 1.1v 829.755n 1.1v 834.745n 1.1v 834.755n 1.1v 839.745n 1.1v 839.755n 1.1v 844.745n 1.1v 844.755n 1.1v 849.745n 1.1v 849.755n 1.1v 854.745n 1.1v 854.755n 1.1v 859.745n 1.1v 859.755n 1.1v 864.745n 1.1v 864.755n 1.1v 869.745n 1.1v 869.755n 1.1v 874.745n 1.1v 874.755n 1.1v 879.745n 1.1v 879.755n 1.1v 884.745n 1.1v 884.755n 1.1v 889.745n 1.1v 889.755n 1.1v 894.745n 1.1v 894.755n 1.1v 899.745n 1.1v 899.755n 1.1v 904.745n 1.1v 904.755n 1.1v 909.745n 1.1v 909.755n 1.1v 914.745n 1.1v 914.755n 1.1v 919.745n 1.1v 919.755n 0.0v 924.745n 0.0v 924.755n 0.0v 929.745n 0.0v 929.755n 0.0v 934.745n 0.0v 934.755n 0.0v 939.745n 0.0v 939.755n 0.0v 944.745n 0.0v 944.755n 0.0v 949.745n 0.0v 949.755n 0.0v 954.745n 0.0v 954.755n 1.1v 959.745n 1.1v 959.755n 0.0v 964.745n 0.0v 964.755n 1.1v 969.745n 1.1v 969.755n 1.1v 974.745n 1.1v 974.755n 1.1v 979.745n 1.1v 979.755n 1.1v 984.745n 1.1v 984.755n 1.1v 989.745n 1.1v 989.755n 0.0v 994.745n 0.0v 994.755n 1.1v 999.745n 1.1v 999.755n 0.0v 1004.745n 0.0v 1004.755n 0.0v 1009.745n 0.0v 1009.755n 1.1v 1014.745n 1.1v 1014.755n 1.1v 1019.745n 1.1v 1019.755n 1.1v 1024.745n 1.1v 1024.755n 1.1v )
* (time, data): [(0, 0), (5, 0), (10, 0), (15, 0), (20, 0), (25, 0), (30, 0), (35, 0), (40, 0), (45, 0), (50, 1), (55, 1), (60, 1), (65, 1), (70, 0), (75, 0), (80, 0), (85, 1), (90, 1), (95, 1), (100, 1), (105, 1), (110, 1), (115, 1), (120, 1), (125, 1), (130, 1), (135, 1), (140, 0), (145, 1), (150, 1), (155, 1), (160, 1), (165, 1), (170, 1), (175, 1), (180, 1), (185, 1), (190, 1), (195, 1), (200, 1), (205, 0), (210, 0), (215, 0), (220, 0), (225, 0), (230, 0), (235, 0), (240, 1), (245, 1), (250, 1), (255, 1), (260, 1), (265, 1), (270, 0), (275, 0), (280, 0), (285, 0), (290, 1), (295, 0), (300, 0), (305, 0), (310, 0), (315, 1), (320, 1), (325, 0), (330, 0), (335, 0), (340, 1), (345, 1), (350, 1), (355, 1), (360, 1), (365, 1), (370, 1), (375, 1), (380, 1), (385, 0), (390, 0), (395, 0), (400, 0), (405, 1), (410, 1), (415, 1), (420, 1), (425, 1), (430, 1), (435, 1), (440, 1), (445, 0), (450, 0), (455, 0), (460, 0), (465, 0), (470, 0), (475, 0), (480, 0), (485, 0), (490, 0), (495, 0), (500, 0), (505, 0), (510, 0), (515, 1), (520, 1), (525, 1), (530, 1), (535, 1), (540, 0), (545, 1), (550, 1), (555, 1), (560, 1), (565, 1), (570, 0), (575, 0), (580, 0), (585, 1), (590, 1), (595, 1), (600, 1), (605, 1), (610, 1), (615, 0), (620, 0), (625, 0), (630, 0), (635, 0), (640, 0), (645, 0), (650, 0), (655, 0), (660, 0), (665, 1), (670, 0), (675, 0), (680, 0), (685, 0), (690, 1), (695, 1), (700, 0), (705, 1), (710, 0), (715, 0), (720, 0), (725, 0), (730, 0), (735, 1), (740, 1), (745, 0), (750, 0), (755, 1), (760, 1), (765, 1), (770, 1), (775, 1), (780, 1), (785, 0), (790, 0), (795, 0), (800, 0), (805, 0), (810, 0), (815, 1), (820, 0), (825, 0), (830, 0), (835, 0), (840, 0), (845, 0), (850, 0), (855, 0), (860, 0), (865, 0), (870, 0), (875, 0), (880, 0), (885, 0), (890, 0), (895, 0), (900, 1), (905, 1), (910, 0), (915, 0), (920, 1), (925, 1), (930, 1), (935, 0), (940, 1), (945, 1), (950, 0), (955, 0), (960, 0), (965, 0), (970, 0), (975, 0), (980, 0), (985, 1), (990, 0), (995, 0), (1000, 1), (1005, 1), (1010, 0), (1015, 0), (1020, 0), (1025, 0)]
Vdin0_26  din0_26  0 PWL (0n 0.0v 4.745n 0.0v 4.755n 0.0v 9.745n 0.0v 9.755n 0.0v 14.745n 0.0v 14.755n 0.0v 19.745n 0.0v 19.755n 0.0v 24.745n 0.0v 24.755n 0.0v 29.745n 0.0v 29.755n 0.0v 34.745n 0.0v 34.755n 0.0v 39.745n 0.0v 39.755n 0.0v 44.745n 0.0v 44.755n 0.0v 49.745n 0.0v 49.755n 1.1v 54.745n 1.1v 54.755n 1.1v 59.745n 1.1v 59.755n 1.1v 64.745n 1.1v 64.755n 1.1v 69.745n 1.1v 69.755n 0.0v 74.745n 0.0v 74.755n 0.0v 79.745n 0.0v 79.755n 0.0v 84.745n 0.0v 84.755n 1.1v 89.745n 1.1v 89.755n 1.1v 94.745n 1.1v 94.755n 1.1v 99.745n 1.1v 99.755n 1.1v 104.745n 1.1v 104.755n 1.1v 109.745n 1.1v 109.755n 1.1v 114.745n 1.1v 114.755n 1.1v 119.745n 1.1v 119.755n 1.1v 124.745n 1.1v 124.755n 1.1v 129.745n 1.1v 129.755n 1.1v 134.745n 1.1v 134.755n 1.1v 139.745n 1.1v 139.755n 0.0v 144.745n 0.0v 144.755n 1.1v 149.745n 1.1v 149.755n 1.1v 154.745n 1.1v 154.755n 1.1v 159.745n 1.1v 159.755n 1.1v 164.745n 1.1v 164.755n 1.1v 169.745n 1.1v 169.755n 1.1v 174.745n 1.1v 174.755n 1.1v 179.745n 1.1v 179.755n 1.1v 184.745n 1.1v 184.755n 1.1v 189.745n 1.1v 189.755n 1.1v 194.745n 1.1v 194.755n 1.1v 199.745n 1.1v 199.755n 1.1v 204.745n 1.1v 204.755n 0.0v 209.745n 0.0v 209.755n 0.0v 214.745n 0.0v 214.755n 0.0v 219.745n 0.0v 219.755n 0.0v 224.745n 0.0v 224.755n 0.0v 229.745n 0.0v 229.755n 0.0v 234.745n 0.0v 234.755n 0.0v 239.745n 0.0v 239.755n 1.1v 244.745n 1.1v 244.755n 1.1v 249.745n 1.1v 249.755n 1.1v 254.745n 1.1v 254.755n 1.1v 259.745n 1.1v 259.755n 1.1v 264.745n 1.1v 264.755n 1.1v 269.745n 1.1v 269.755n 0.0v 274.745n 0.0v 274.755n 0.0v 279.745n 0.0v 279.755n 0.0v 284.745n 0.0v 284.755n 0.0v 289.745n 0.0v 289.755n 1.1v 294.745n 1.1v 294.755n 0.0v 299.745n 0.0v 299.755n 0.0v 304.745n 0.0v 304.755n 0.0v 309.745n 0.0v 309.755n 0.0v 314.745n 0.0v 314.755n 1.1v 319.745n 1.1v 319.755n 1.1v 324.745n 1.1v 324.755n 0.0v 329.745n 0.0v 329.755n 0.0v 334.745n 0.0v 334.755n 0.0v 339.745n 0.0v 339.755n 1.1v 344.745n 1.1v 344.755n 1.1v 349.745n 1.1v 349.755n 1.1v 354.745n 1.1v 354.755n 1.1v 359.745n 1.1v 359.755n 1.1v 364.745n 1.1v 364.755n 1.1v 369.745n 1.1v 369.755n 1.1v 374.745n 1.1v 374.755n 1.1v 379.745n 1.1v 379.755n 1.1v 384.745n 1.1v 384.755n 0.0v 389.745n 0.0v 389.755n 0.0v 394.745n 0.0v 394.755n 0.0v 399.745n 0.0v 399.755n 0.0v 404.745n 0.0v 404.755n 1.1v 409.745n 1.1v 409.755n 1.1v 414.745n 1.1v 414.755n 1.1v 419.745n 1.1v 419.755n 1.1v 424.745n 1.1v 424.755n 1.1v 429.745n 1.1v 429.755n 1.1v 434.745n 1.1v 434.755n 1.1v 439.745n 1.1v 439.755n 1.1v 444.745n 1.1v 444.755n 0.0v 449.745n 0.0v 449.755n 0.0v 454.745n 0.0v 454.755n 0.0v 459.745n 0.0v 459.755n 0.0v 464.745n 0.0v 464.755n 0.0v 469.745n 0.0v 469.755n 0.0v 474.745n 0.0v 474.755n 0.0v 479.745n 0.0v 479.755n 0.0v 484.745n 0.0v 484.755n 0.0v 489.745n 0.0v 489.755n 0.0v 494.745n 0.0v 494.755n 0.0v 499.745n 0.0v 499.755n 0.0v 504.745n 0.0v 504.755n 0.0v 509.745n 0.0v 509.755n 0.0v 514.745n 0.0v 514.755n 1.1v 519.745n 1.1v 519.755n 1.1v 524.745n 1.1v 524.755n 1.1v 529.745n 1.1v 529.755n 1.1v 534.745n 1.1v 534.755n 1.1v 539.745n 1.1v 539.755n 0.0v 544.745n 0.0v 544.755n 1.1v 549.745n 1.1v 549.755n 1.1v 554.745n 1.1v 554.755n 1.1v 559.745n 1.1v 559.755n 1.1v 564.745n 1.1v 564.755n 1.1v 569.745n 1.1v 569.755n 0.0v 574.745n 0.0v 574.755n 0.0v 579.745n 0.0v 579.755n 0.0v 584.745n 0.0v 584.755n 1.1v 589.745n 1.1v 589.755n 1.1v 594.745n 1.1v 594.755n 1.1v 599.745n 1.1v 599.755n 1.1v 604.745n 1.1v 604.755n 1.1v 609.745n 1.1v 609.755n 1.1v 614.745n 1.1v 614.755n 0.0v 619.745n 0.0v 619.755n 0.0v 624.745n 0.0v 624.755n 0.0v 629.745n 0.0v 629.755n 0.0v 634.745n 0.0v 634.755n 0.0v 639.745n 0.0v 639.755n 0.0v 644.745n 0.0v 644.755n 0.0v 649.745n 0.0v 649.755n 0.0v 654.745n 0.0v 654.755n 0.0v 659.745n 0.0v 659.755n 0.0v 664.745n 0.0v 664.755n 1.1v 669.745n 1.1v 669.755n 0.0v 674.745n 0.0v 674.755n 0.0v 679.745n 0.0v 679.755n 0.0v 684.745n 0.0v 684.755n 0.0v 689.745n 0.0v 689.755n 1.1v 694.745n 1.1v 694.755n 1.1v 699.745n 1.1v 699.755n 0.0v 704.745n 0.0v 704.755n 1.1v 709.745n 1.1v 709.755n 0.0v 714.745n 0.0v 714.755n 0.0v 719.745n 0.0v 719.755n 0.0v 724.745n 0.0v 724.755n 0.0v 729.745n 0.0v 729.755n 0.0v 734.745n 0.0v 734.755n 1.1v 739.745n 1.1v 739.755n 1.1v 744.745n 1.1v 744.755n 0.0v 749.745n 0.0v 749.755n 0.0v 754.745n 0.0v 754.755n 1.1v 759.745n 1.1v 759.755n 1.1v 764.745n 1.1v 764.755n 1.1v 769.745n 1.1v 769.755n 1.1v 774.745n 1.1v 774.755n 1.1v 779.745n 1.1v 779.755n 1.1v 784.745n 1.1v 784.755n 0.0v 789.745n 0.0v 789.755n 0.0v 794.745n 0.0v 794.755n 0.0v 799.745n 0.0v 799.755n 0.0v 804.745n 0.0v 804.755n 0.0v 809.745n 0.0v 809.755n 0.0v 814.745n 0.0v 814.755n 1.1v 819.745n 1.1v 819.755n 0.0v 824.745n 0.0v 824.755n 0.0v 829.745n 0.0v 829.755n 0.0v 834.745n 0.0v 834.755n 0.0v 839.745n 0.0v 839.755n 0.0v 844.745n 0.0v 844.755n 0.0v 849.745n 0.0v 849.755n 0.0v 854.745n 0.0v 854.755n 0.0v 859.745n 0.0v 859.755n 0.0v 864.745n 0.0v 864.755n 0.0v 869.745n 0.0v 869.755n 0.0v 874.745n 0.0v 874.755n 0.0v 879.745n 0.0v 879.755n 0.0v 884.745n 0.0v 884.755n 0.0v 889.745n 0.0v 889.755n 0.0v 894.745n 0.0v 894.755n 0.0v 899.745n 0.0v 899.755n 1.1v 904.745n 1.1v 904.755n 1.1v 909.745n 1.1v 909.755n 0.0v 914.745n 0.0v 914.755n 0.0v 919.745n 0.0v 919.755n 1.1v 924.745n 1.1v 924.755n 1.1v 929.745n 1.1v 929.755n 1.1v 934.745n 1.1v 934.755n 0.0v 939.745n 0.0v 939.755n 1.1v 944.745n 1.1v 944.755n 1.1v 949.745n 1.1v 949.755n 0.0v 954.745n 0.0v 954.755n 0.0v 959.745n 0.0v 959.755n 0.0v 964.745n 0.0v 964.755n 0.0v 969.745n 0.0v 969.755n 0.0v 974.745n 0.0v 974.755n 0.0v 979.745n 0.0v 979.755n 0.0v 984.745n 0.0v 984.755n 1.1v 989.745n 1.1v 989.755n 0.0v 994.745n 0.0v 994.755n 0.0v 999.745n 0.0v 999.755n 1.1v 1004.745n 1.1v 1004.755n 1.1v 1009.745n 1.1v 1009.755n 0.0v 1014.745n 0.0v 1014.755n 0.0v 1019.745n 0.0v 1019.755n 0.0v 1024.745n 0.0v 1024.755n 0.0v )
* (time, data): [(0, 0), (5, 0), (10, 1), (15, 0), (20, 0), (25, 0), (30, 0), (35, 0), (40, 0), (45, 0), (50, 1), (55, 1), (60, 1), (65, 1), (70, 1), (75, 1), (80, 1), (85, 1), (90, 1), (95, 1), (100, 1), (105, 1), (110, 1), (115, 1), (120, 1), (125, 1), (130, 1), (135, 1), (140, 0), (145, 0), (150, 0), (155, 0), (160, 0), (165, 0), (170, 0), (175, 0), (180, 0), (185, 0), (190, 0), (195, 0), (200, 0), (205, 0), (210, 0), (215, 0), (220, 0), (225, 0), (230, 0), (235, 0), (240, 1), (245, 1), (250, 1), (255, 1), (260, 1), (265, 1), (270, 1), (275, 1), (280, 1), (285, 1), (290, 1), (295, 0), (300, 0), (305, 0), (310, 0), (315, 1), (320, 1), (325, 0), (330, 1), (335, 1), (340, 0), (345, 0), (350, 0), (355, 0), (360, 0), (365, 0), (370, 0), (375, 0), (380, 0), (385, 1), (390, 1), (395, 1), (400, 1), (405, 1), (410, 0), (415, 0), (420, 0), (425, 1), (430, 1), (435, 0), (440, 0), (445, 0), (450, 1), (455, 1), (460, 1), (465, 1), (470, 1), (475, 1), (480, 1), (485, 1), (490, 1), (495, 1), (500, 1), (505, 1), (510, 0), (515, 0), (520, 0), (525, 0), (530, 0), (535, 0), (540, 0), (545, 1), (550, 0), (555, 0), (560, 0), (565, 0), (570, 1), (575, 0), (580, 1), (585, 0), (590, 0), (595, 0), (600, 0), (605, 1), (610, 1), (615, 0), (620, 0), (625, 1), (630, 1), (635, 1), (640, 1), (645, 0), (650, 0), (655, 0), (660, 0), (665, 1), (670, 1), (675, 1), (680, 1), (685, 1), (690, 1), (695, 1), (700, 0), (705, 1), (710, 1), (715, 1), (720, 1), (725, 1), (730, 1), (735, 1), (740, 1), (745, 0), (750, 0), (755, 1), (760, 1), (765, 1), (770, 1), (775, 1), (780, 1), (785, 1), (790, 1), (795, 1), (800, 1), (805, 1), (810, 1), (815, 1), (820, 0), (825, 0), (830, 0), (835, 0), (840, 0), (845, 0), (850, 0), (855, 0), (860, 0), (865, 0), (870, 0), (875, 0), (880, 0), (885, 0), (890, 0), (895, 0), (900, 0), (905, 1), (910, 0), (915, 0), (920, 0), (925, 0), (930, 1), (935, 1), (940, 1), (945, 1), (950, 1), (955, 1), (960, 1), (965, 1), (970, 0), (975, 0), (980, 0), (985, 0), (990, 0), (995, 1), (1000, 0), (1005, 0), (1010, 0), (1015, 0), (1020, 0), (1025, 0)]
Vdin0_27  din0_27  0 PWL (0n 0.0v 4.745n 0.0v 4.755n 0.0v 9.745n 0.0v 9.755n 1.1v 14.745n 1.1v 14.755n 0.0v 19.745n 0.0v 19.755n 0.0v 24.745n 0.0v 24.755n 0.0v 29.745n 0.0v 29.755n 0.0v 34.745n 0.0v 34.755n 0.0v 39.745n 0.0v 39.755n 0.0v 44.745n 0.0v 44.755n 0.0v 49.745n 0.0v 49.755n 1.1v 54.745n 1.1v 54.755n 1.1v 59.745n 1.1v 59.755n 1.1v 64.745n 1.1v 64.755n 1.1v 69.745n 1.1v 69.755n 1.1v 74.745n 1.1v 74.755n 1.1v 79.745n 1.1v 79.755n 1.1v 84.745n 1.1v 84.755n 1.1v 89.745n 1.1v 89.755n 1.1v 94.745n 1.1v 94.755n 1.1v 99.745n 1.1v 99.755n 1.1v 104.745n 1.1v 104.755n 1.1v 109.745n 1.1v 109.755n 1.1v 114.745n 1.1v 114.755n 1.1v 119.745n 1.1v 119.755n 1.1v 124.745n 1.1v 124.755n 1.1v 129.745n 1.1v 129.755n 1.1v 134.745n 1.1v 134.755n 1.1v 139.745n 1.1v 139.755n 0.0v 144.745n 0.0v 144.755n 0.0v 149.745n 0.0v 149.755n 0.0v 154.745n 0.0v 154.755n 0.0v 159.745n 0.0v 159.755n 0.0v 164.745n 0.0v 164.755n 0.0v 169.745n 0.0v 169.755n 0.0v 174.745n 0.0v 174.755n 0.0v 179.745n 0.0v 179.755n 0.0v 184.745n 0.0v 184.755n 0.0v 189.745n 0.0v 189.755n 0.0v 194.745n 0.0v 194.755n 0.0v 199.745n 0.0v 199.755n 0.0v 204.745n 0.0v 204.755n 0.0v 209.745n 0.0v 209.755n 0.0v 214.745n 0.0v 214.755n 0.0v 219.745n 0.0v 219.755n 0.0v 224.745n 0.0v 224.755n 0.0v 229.745n 0.0v 229.755n 0.0v 234.745n 0.0v 234.755n 0.0v 239.745n 0.0v 239.755n 1.1v 244.745n 1.1v 244.755n 1.1v 249.745n 1.1v 249.755n 1.1v 254.745n 1.1v 254.755n 1.1v 259.745n 1.1v 259.755n 1.1v 264.745n 1.1v 264.755n 1.1v 269.745n 1.1v 269.755n 1.1v 274.745n 1.1v 274.755n 1.1v 279.745n 1.1v 279.755n 1.1v 284.745n 1.1v 284.755n 1.1v 289.745n 1.1v 289.755n 1.1v 294.745n 1.1v 294.755n 0.0v 299.745n 0.0v 299.755n 0.0v 304.745n 0.0v 304.755n 0.0v 309.745n 0.0v 309.755n 0.0v 314.745n 0.0v 314.755n 1.1v 319.745n 1.1v 319.755n 1.1v 324.745n 1.1v 324.755n 0.0v 329.745n 0.0v 329.755n 1.1v 334.745n 1.1v 334.755n 1.1v 339.745n 1.1v 339.755n 0.0v 344.745n 0.0v 344.755n 0.0v 349.745n 0.0v 349.755n 0.0v 354.745n 0.0v 354.755n 0.0v 359.745n 0.0v 359.755n 0.0v 364.745n 0.0v 364.755n 0.0v 369.745n 0.0v 369.755n 0.0v 374.745n 0.0v 374.755n 0.0v 379.745n 0.0v 379.755n 0.0v 384.745n 0.0v 384.755n 1.1v 389.745n 1.1v 389.755n 1.1v 394.745n 1.1v 394.755n 1.1v 399.745n 1.1v 399.755n 1.1v 404.745n 1.1v 404.755n 1.1v 409.745n 1.1v 409.755n 0.0v 414.745n 0.0v 414.755n 0.0v 419.745n 0.0v 419.755n 0.0v 424.745n 0.0v 424.755n 1.1v 429.745n 1.1v 429.755n 1.1v 434.745n 1.1v 434.755n 0.0v 439.745n 0.0v 439.755n 0.0v 444.745n 0.0v 444.755n 0.0v 449.745n 0.0v 449.755n 1.1v 454.745n 1.1v 454.755n 1.1v 459.745n 1.1v 459.755n 1.1v 464.745n 1.1v 464.755n 1.1v 469.745n 1.1v 469.755n 1.1v 474.745n 1.1v 474.755n 1.1v 479.745n 1.1v 479.755n 1.1v 484.745n 1.1v 484.755n 1.1v 489.745n 1.1v 489.755n 1.1v 494.745n 1.1v 494.755n 1.1v 499.745n 1.1v 499.755n 1.1v 504.745n 1.1v 504.755n 1.1v 509.745n 1.1v 509.755n 0.0v 514.745n 0.0v 514.755n 0.0v 519.745n 0.0v 519.755n 0.0v 524.745n 0.0v 524.755n 0.0v 529.745n 0.0v 529.755n 0.0v 534.745n 0.0v 534.755n 0.0v 539.745n 0.0v 539.755n 0.0v 544.745n 0.0v 544.755n 1.1v 549.745n 1.1v 549.755n 0.0v 554.745n 0.0v 554.755n 0.0v 559.745n 0.0v 559.755n 0.0v 564.745n 0.0v 564.755n 0.0v 569.745n 0.0v 569.755n 1.1v 574.745n 1.1v 574.755n 0.0v 579.745n 0.0v 579.755n 1.1v 584.745n 1.1v 584.755n 0.0v 589.745n 0.0v 589.755n 0.0v 594.745n 0.0v 594.755n 0.0v 599.745n 0.0v 599.755n 0.0v 604.745n 0.0v 604.755n 1.1v 609.745n 1.1v 609.755n 1.1v 614.745n 1.1v 614.755n 0.0v 619.745n 0.0v 619.755n 0.0v 624.745n 0.0v 624.755n 1.1v 629.745n 1.1v 629.755n 1.1v 634.745n 1.1v 634.755n 1.1v 639.745n 1.1v 639.755n 1.1v 644.745n 1.1v 644.755n 0.0v 649.745n 0.0v 649.755n 0.0v 654.745n 0.0v 654.755n 0.0v 659.745n 0.0v 659.755n 0.0v 664.745n 0.0v 664.755n 1.1v 669.745n 1.1v 669.755n 1.1v 674.745n 1.1v 674.755n 1.1v 679.745n 1.1v 679.755n 1.1v 684.745n 1.1v 684.755n 1.1v 689.745n 1.1v 689.755n 1.1v 694.745n 1.1v 694.755n 1.1v 699.745n 1.1v 699.755n 0.0v 704.745n 0.0v 704.755n 1.1v 709.745n 1.1v 709.755n 1.1v 714.745n 1.1v 714.755n 1.1v 719.745n 1.1v 719.755n 1.1v 724.745n 1.1v 724.755n 1.1v 729.745n 1.1v 729.755n 1.1v 734.745n 1.1v 734.755n 1.1v 739.745n 1.1v 739.755n 1.1v 744.745n 1.1v 744.755n 0.0v 749.745n 0.0v 749.755n 0.0v 754.745n 0.0v 754.755n 1.1v 759.745n 1.1v 759.755n 1.1v 764.745n 1.1v 764.755n 1.1v 769.745n 1.1v 769.755n 1.1v 774.745n 1.1v 774.755n 1.1v 779.745n 1.1v 779.755n 1.1v 784.745n 1.1v 784.755n 1.1v 789.745n 1.1v 789.755n 1.1v 794.745n 1.1v 794.755n 1.1v 799.745n 1.1v 799.755n 1.1v 804.745n 1.1v 804.755n 1.1v 809.745n 1.1v 809.755n 1.1v 814.745n 1.1v 814.755n 1.1v 819.745n 1.1v 819.755n 0.0v 824.745n 0.0v 824.755n 0.0v 829.745n 0.0v 829.755n 0.0v 834.745n 0.0v 834.755n 0.0v 839.745n 0.0v 839.755n 0.0v 844.745n 0.0v 844.755n 0.0v 849.745n 0.0v 849.755n 0.0v 854.745n 0.0v 854.755n 0.0v 859.745n 0.0v 859.755n 0.0v 864.745n 0.0v 864.755n 0.0v 869.745n 0.0v 869.755n 0.0v 874.745n 0.0v 874.755n 0.0v 879.745n 0.0v 879.755n 0.0v 884.745n 0.0v 884.755n 0.0v 889.745n 0.0v 889.755n 0.0v 894.745n 0.0v 894.755n 0.0v 899.745n 0.0v 899.755n 0.0v 904.745n 0.0v 904.755n 1.1v 909.745n 1.1v 909.755n 0.0v 914.745n 0.0v 914.755n 0.0v 919.745n 0.0v 919.755n 0.0v 924.745n 0.0v 924.755n 0.0v 929.745n 0.0v 929.755n 1.1v 934.745n 1.1v 934.755n 1.1v 939.745n 1.1v 939.755n 1.1v 944.745n 1.1v 944.755n 1.1v 949.745n 1.1v 949.755n 1.1v 954.745n 1.1v 954.755n 1.1v 959.745n 1.1v 959.755n 1.1v 964.745n 1.1v 964.755n 1.1v 969.745n 1.1v 969.755n 0.0v 974.745n 0.0v 974.755n 0.0v 979.745n 0.0v 979.755n 0.0v 984.745n 0.0v 984.755n 0.0v 989.745n 0.0v 989.755n 0.0v 994.745n 0.0v 994.755n 1.1v 999.745n 1.1v 999.755n 0.0v 1004.745n 0.0v 1004.755n 0.0v 1009.745n 0.0v 1009.755n 0.0v 1014.745n 0.0v 1014.755n 0.0v 1019.745n 0.0v 1019.755n 0.0v 1024.745n 0.0v 1024.755n 0.0v )
* (time, data): [(0, 0), (5, 0), (10, 1), (15, 1), (20, 1), (25, 1), (30, 1), (35, 1), (40, 1), (45, 1), (50, 0), (55, 0), (60, 0), (65, 0), (70, 1), (75, 1), (80, 1), (85, 0), (90, 0), (95, 0), (100, 0), (105, 0), (110, 0), (115, 1), (120, 1), (125, 1), (130, 1), (135, 1), (140, 1), (145, 0), (150, 0), (155, 0), (160, 0), (165, 0), (170, 0), (175, 0), (180, 1), (185, 1), (190, 1), (195, 1), (200, 1), (205, 1), (210, 0), (215, 0), (220, 0), (225, 0), (230, 0), (235, 0), (240, 0), (245, 0), (250, 0), (255, 0), (260, 0), (265, 0), (270, 1), (275, 1), (280, 1), (285, 1), (290, 0), (295, 0), (300, 0), (305, 0), (310, 0), (315, 0), (320, 1), (325, 1), (330, 1), (335, 1), (340, 0), (345, 0), (350, 0), (355, 0), (360, 0), (365, 0), (370, 0), (375, 0), (380, 0), (385, 0), (390, 0), (395, 0), (400, 0), (405, 0), (410, 1), (415, 1), (420, 1), (425, 1), (430, 1), (435, 1), (440, 1), (445, 1), (450, 0), (455, 1), (460, 1), (465, 1), (470, 1), (475, 1), (480, 1), (485, 1), (490, 1), (495, 1), (500, 1), (505, 1), (510, 1), (515, 1), (520, 1), (525, 1), (530, 1), (535, 1), (540, 0), (545, 0), (550, 1), (555, 1), (560, 1), (565, 1), (570, 1), (575, 0), (580, 0), (585, 1), (590, 0), (595, 0), (600, 0), (605, 1), (610, 1), (615, 1), (620, 1), (625, 1), (630, 1), (635, 1), (640, 1), (645, 0), (650, 0), (655, 0), (660, 0), (665, 1), (670, 1), (675, 1), (680, 1), (685, 1), (690, 0), (695, 1), (700, 1), (705, 1), (710, 0), (715, 0), (720, 0), (725, 0), (730, 0), (735, 0), (740, 0), (745, 1), (750, 1), (755, 1), (760, 1), (765, 0), (770, 0), (775, 0), (780, 0), (785, 0), (790, 0), (795, 0), (800, 0), (805, 0), (810, 1), (815, 0), (820, 1), (825, 1), (830, 1), (835, 0), (840, 0), (845, 0), (850, 0), (855, 0), (860, 1), (865, 1), (870, 1), (875, 1), (880, 1), (885, 1), (890, 0), (895, 0), (900, 0), (905, 0), (910, 0), (915, 0), (920, 1), (925, 1), (930, 0), (935, 1), (940, 0), (945, 0), (950, 1), (955, 1), (960, 0), (965, 0), (970, 1), (975, 1), (980, 1), (985, 1), (990, 1), (995, 1), (1000, 0), (1005, 0), (1010, 1), (1015, 1), (1020, 1), (1025, 1)]
Vdin0_28  din0_28  0 PWL (0n 0.0v 4.745n 0.0v 4.755n 0.0v 9.745n 0.0v 9.755n 1.1v 14.745n 1.1v 14.755n 1.1v 19.745n 1.1v 19.755n 1.1v 24.745n 1.1v 24.755n 1.1v 29.745n 1.1v 29.755n 1.1v 34.745n 1.1v 34.755n 1.1v 39.745n 1.1v 39.755n 1.1v 44.745n 1.1v 44.755n 1.1v 49.745n 1.1v 49.755n 0.0v 54.745n 0.0v 54.755n 0.0v 59.745n 0.0v 59.755n 0.0v 64.745n 0.0v 64.755n 0.0v 69.745n 0.0v 69.755n 1.1v 74.745n 1.1v 74.755n 1.1v 79.745n 1.1v 79.755n 1.1v 84.745n 1.1v 84.755n 0.0v 89.745n 0.0v 89.755n 0.0v 94.745n 0.0v 94.755n 0.0v 99.745n 0.0v 99.755n 0.0v 104.745n 0.0v 104.755n 0.0v 109.745n 0.0v 109.755n 0.0v 114.745n 0.0v 114.755n 1.1v 119.745n 1.1v 119.755n 1.1v 124.745n 1.1v 124.755n 1.1v 129.745n 1.1v 129.755n 1.1v 134.745n 1.1v 134.755n 1.1v 139.745n 1.1v 139.755n 1.1v 144.745n 1.1v 144.755n 0.0v 149.745n 0.0v 149.755n 0.0v 154.745n 0.0v 154.755n 0.0v 159.745n 0.0v 159.755n 0.0v 164.745n 0.0v 164.755n 0.0v 169.745n 0.0v 169.755n 0.0v 174.745n 0.0v 174.755n 0.0v 179.745n 0.0v 179.755n 1.1v 184.745n 1.1v 184.755n 1.1v 189.745n 1.1v 189.755n 1.1v 194.745n 1.1v 194.755n 1.1v 199.745n 1.1v 199.755n 1.1v 204.745n 1.1v 204.755n 1.1v 209.745n 1.1v 209.755n 0.0v 214.745n 0.0v 214.755n 0.0v 219.745n 0.0v 219.755n 0.0v 224.745n 0.0v 224.755n 0.0v 229.745n 0.0v 229.755n 0.0v 234.745n 0.0v 234.755n 0.0v 239.745n 0.0v 239.755n 0.0v 244.745n 0.0v 244.755n 0.0v 249.745n 0.0v 249.755n 0.0v 254.745n 0.0v 254.755n 0.0v 259.745n 0.0v 259.755n 0.0v 264.745n 0.0v 264.755n 0.0v 269.745n 0.0v 269.755n 1.1v 274.745n 1.1v 274.755n 1.1v 279.745n 1.1v 279.755n 1.1v 284.745n 1.1v 284.755n 1.1v 289.745n 1.1v 289.755n 0.0v 294.745n 0.0v 294.755n 0.0v 299.745n 0.0v 299.755n 0.0v 304.745n 0.0v 304.755n 0.0v 309.745n 0.0v 309.755n 0.0v 314.745n 0.0v 314.755n 0.0v 319.745n 0.0v 319.755n 1.1v 324.745n 1.1v 324.755n 1.1v 329.745n 1.1v 329.755n 1.1v 334.745n 1.1v 334.755n 1.1v 339.745n 1.1v 339.755n 0.0v 344.745n 0.0v 344.755n 0.0v 349.745n 0.0v 349.755n 0.0v 354.745n 0.0v 354.755n 0.0v 359.745n 0.0v 359.755n 0.0v 364.745n 0.0v 364.755n 0.0v 369.745n 0.0v 369.755n 0.0v 374.745n 0.0v 374.755n 0.0v 379.745n 0.0v 379.755n 0.0v 384.745n 0.0v 384.755n 0.0v 389.745n 0.0v 389.755n 0.0v 394.745n 0.0v 394.755n 0.0v 399.745n 0.0v 399.755n 0.0v 404.745n 0.0v 404.755n 0.0v 409.745n 0.0v 409.755n 1.1v 414.745n 1.1v 414.755n 1.1v 419.745n 1.1v 419.755n 1.1v 424.745n 1.1v 424.755n 1.1v 429.745n 1.1v 429.755n 1.1v 434.745n 1.1v 434.755n 1.1v 439.745n 1.1v 439.755n 1.1v 444.745n 1.1v 444.755n 1.1v 449.745n 1.1v 449.755n 0.0v 454.745n 0.0v 454.755n 1.1v 459.745n 1.1v 459.755n 1.1v 464.745n 1.1v 464.755n 1.1v 469.745n 1.1v 469.755n 1.1v 474.745n 1.1v 474.755n 1.1v 479.745n 1.1v 479.755n 1.1v 484.745n 1.1v 484.755n 1.1v 489.745n 1.1v 489.755n 1.1v 494.745n 1.1v 494.755n 1.1v 499.745n 1.1v 499.755n 1.1v 504.745n 1.1v 504.755n 1.1v 509.745n 1.1v 509.755n 1.1v 514.745n 1.1v 514.755n 1.1v 519.745n 1.1v 519.755n 1.1v 524.745n 1.1v 524.755n 1.1v 529.745n 1.1v 529.755n 1.1v 534.745n 1.1v 534.755n 1.1v 539.745n 1.1v 539.755n 0.0v 544.745n 0.0v 544.755n 0.0v 549.745n 0.0v 549.755n 1.1v 554.745n 1.1v 554.755n 1.1v 559.745n 1.1v 559.755n 1.1v 564.745n 1.1v 564.755n 1.1v 569.745n 1.1v 569.755n 1.1v 574.745n 1.1v 574.755n 0.0v 579.745n 0.0v 579.755n 0.0v 584.745n 0.0v 584.755n 1.1v 589.745n 1.1v 589.755n 0.0v 594.745n 0.0v 594.755n 0.0v 599.745n 0.0v 599.755n 0.0v 604.745n 0.0v 604.755n 1.1v 609.745n 1.1v 609.755n 1.1v 614.745n 1.1v 614.755n 1.1v 619.745n 1.1v 619.755n 1.1v 624.745n 1.1v 624.755n 1.1v 629.745n 1.1v 629.755n 1.1v 634.745n 1.1v 634.755n 1.1v 639.745n 1.1v 639.755n 1.1v 644.745n 1.1v 644.755n 0.0v 649.745n 0.0v 649.755n 0.0v 654.745n 0.0v 654.755n 0.0v 659.745n 0.0v 659.755n 0.0v 664.745n 0.0v 664.755n 1.1v 669.745n 1.1v 669.755n 1.1v 674.745n 1.1v 674.755n 1.1v 679.745n 1.1v 679.755n 1.1v 684.745n 1.1v 684.755n 1.1v 689.745n 1.1v 689.755n 0.0v 694.745n 0.0v 694.755n 1.1v 699.745n 1.1v 699.755n 1.1v 704.745n 1.1v 704.755n 1.1v 709.745n 1.1v 709.755n 0.0v 714.745n 0.0v 714.755n 0.0v 719.745n 0.0v 719.755n 0.0v 724.745n 0.0v 724.755n 0.0v 729.745n 0.0v 729.755n 0.0v 734.745n 0.0v 734.755n 0.0v 739.745n 0.0v 739.755n 0.0v 744.745n 0.0v 744.755n 1.1v 749.745n 1.1v 749.755n 1.1v 754.745n 1.1v 754.755n 1.1v 759.745n 1.1v 759.755n 1.1v 764.745n 1.1v 764.755n 0.0v 769.745n 0.0v 769.755n 0.0v 774.745n 0.0v 774.755n 0.0v 779.745n 0.0v 779.755n 0.0v 784.745n 0.0v 784.755n 0.0v 789.745n 0.0v 789.755n 0.0v 794.745n 0.0v 794.755n 0.0v 799.745n 0.0v 799.755n 0.0v 804.745n 0.0v 804.755n 0.0v 809.745n 0.0v 809.755n 1.1v 814.745n 1.1v 814.755n 0.0v 819.745n 0.0v 819.755n 1.1v 824.745n 1.1v 824.755n 1.1v 829.745n 1.1v 829.755n 1.1v 834.745n 1.1v 834.755n 0.0v 839.745n 0.0v 839.755n 0.0v 844.745n 0.0v 844.755n 0.0v 849.745n 0.0v 849.755n 0.0v 854.745n 0.0v 854.755n 0.0v 859.745n 0.0v 859.755n 1.1v 864.745n 1.1v 864.755n 1.1v 869.745n 1.1v 869.755n 1.1v 874.745n 1.1v 874.755n 1.1v 879.745n 1.1v 879.755n 1.1v 884.745n 1.1v 884.755n 1.1v 889.745n 1.1v 889.755n 0.0v 894.745n 0.0v 894.755n 0.0v 899.745n 0.0v 899.755n 0.0v 904.745n 0.0v 904.755n 0.0v 909.745n 0.0v 909.755n 0.0v 914.745n 0.0v 914.755n 0.0v 919.745n 0.0v 919.755n 1.1v 924.745n 1.1v 924.755n 1.1v 929.745n 1.1v 929.755n 0.0v 934.745n 0.0v 934.755n 1.1v 939.745n 1.1v 939.755n 0.0v 944.745n 0.0v 944.755n 0.0v 949.745n 0.0v 949.755n 1.1v 954.745n 1.1v 954.755n 1.1v 959.745n 1.1v 959.755n 0.0v 964.745n 0.0v 964.755n 0.0v 969.745n 0.0v 969.755n 1.1v 974.745n 1.1v 974.755n 1.1v 979.745n 1.1v 979.755n 1.1v 984.745n 1.1v 984.755n 1.1v 989.745n 1.1v 989.755n 1.1v 994.745n 1.1v 994.755n 1.1v 999.745n 1.1v 999.755n 0.0v 1004.745n 0.0v 1004.755n 0.0v 1009.745n 0.0v 1009.755n 1.1v 1014.745n 1.1v 1014.755n 1.1v 1019.745n 1.1v 1019.755n 1.1v 1024.745n 1.1v 1024.755n 1.1v )
* (time, data): [(0, 0), (5, 0), (10, 0), (15, 1), (20, 1), (25, 1), (30, 1), (35, 1), (40, 1), (45, 1), (50, 1), (55, 1), (60, 1), (65, 1), (70, 1), (75, 1), (80, 1), (85, 1), (90, 1), (95, 1), (100, 0), (105, 0), (110, 0), (115, 1), (120, 1), (125, 1), (130, 1), (135, 1), (140, 1), (145, 0), (150, 0), (155, 0), (160, 0), (165, 0), (170, 0), (175, 0), (180, 0), (185, 0), (190, 0), (195, 0), (200, 0), (205, 1), (210, 0), (215, 0), (220, 0), (225, 0), (230, 0), (235, 0), (240, 1), (245, 1), (250, 1), (255, 1), (260, 1), (265, 1), (270, 1), (275, 1), (280, 1), (285, 1), (290, 0), (295, 0), (300, 0), (305, 0), (310, 0), (315, 1), (320, 0), (325, 1), (330, 0), (335, 0), (340, 1), (345, 1), (350, 1), (355, 1), (360, 1), (365, 1), (370, 1), (375, 1), (380, 1), (385, 1), (390, 1), (395, 1), (400, 1), (405, 0), (410, 1), (415, 1), (420, 1), (425, 1), (430, 1), (435, 0), (440, 0), (445, 1), (450, 1), (455, 0), (460, 0), (465, 0), (470, 0), (475, 0), (480, 0), (485, 0), (490, 1), (495, 1), (500, 1), (505, 1), (510, 1), (515, 1), (520, 1), (525, 1), (530, 1), (535, 1), (540, 1), (545, 1), (550, 1), (555, 1), (560, 1), (565, 1), (570, 0), (575, 1), (580, 1), (585, 0), (590, 1), (595, 1), (600, 0), (605, 1), (610, 1), (615, 1), (620, 1), (625, 0), (630, 0), (635, 0), (640, 0), (645, 0), (650, 0), (655, 0), (660, 0), (665, 1), (670, 1), (675, 1), (680, 1), (685, 1), (690, 0), (695, 0), (700, 0), (705, 1), (710, 1), (715, 1), (720, 1), (725, 1), (730, 1), (735, 1), (740, 1), (745, 0), (750, 0), (755, 0), (760, 0), (765, 1), (770, 1), (775, 1), (780, 1), (785, 1), (790, 1), (795, 1), (800, 1), (805, 1), (810, 0), (815, 0), (820, 1), (825, 1), (830, 1), (835, 1), (840, 1), (845, 1), (850, 1), (855, 1), (860, 0), (865, 0), (870, 0), (875, 0), (880, 0), (885, 0), (890, 0), (895, 0), (900, 1), (905, 1), (910, 0), (915, 0), (920, 0), (925, 0), (930, 0), (935, 1), (940, 0), (945, 0), (950, 1), (955, 1), (960, 0), (965, 0), (970, 1), (975, 1), (980, 1), (985, 1), (990, 0), (995, 0), (1000, 1), (1005, 1), (1010, 1), (1015, 1), (1020, 1), (1025, 1)]
Vdin0_29  din0_29  0 PWL (0n 0.0v 4.745n 0.0v 4.755n 0.0v 9.745n 0.0v 9.755n 0.0v 14.745n 0.0v 14.755n 1.1v 19.745n 1.1v 19.755n 1.1v 24.745n 1.1v 24.755n 1.1v 29.745n 1.1v 29.755n 1.1v 34.745n 1.1v 34.755n 1.1v 39.745n 1.1v 39.755n 1.1v 44.745n 1.1v 44.755n 1.1v 49.745n 1.1v 49.755n 1.1v 54.745n 1.1v 54.755n 1.1v 59.745n 1.1v 59.755n 1.1v 64.745n 1.1v 64.755n 1.1v 69.745n 1.1v 69.755n 1.1v 74.745n 1.1v 74.755n 1.1v 79.745n 1.1v 79.755n 1.1v 84.745n 1.1v 84.755n 1.1v 89.745n 1.1v 89.755n 1.1v 94.745n 1.1v 94.755n 1.1v 99.745n 1.1v 99.755n 0.0v 104.745n 0.0v 104.755n 0.0v 109.745n 0.0v 109.755n 0.0v 114.745n 0.0v 114.755n 1.1v 119.745n 1.1v 119.755n 1.1v 124.745n 1.1v 124.755n 1.1v 129.745n 1.1v 129.755n 1.1v 134.745n 1.1v 134.755n 1.1v 139.745n 1.1v 139.755n 1.1v 144.745n 1.1v 144.755n 0.0v 149.745n 0.0v 149.755n 0.0v 154.745n 0.0v 154.755n 0.0v 159.745n 0.0v 159.755n 0.0v 164.745n 0.0v 164.755n 0.0v 169.745n 0.0v 169.755n 0.0v 174.745n 0.0v 174.755n 0.0v 179.745n 0.0v 179.755n 0.0v 184.745n 0.0v 184.755n 0.0v 189.745n 0.0v 189.755n 0.0v 194.745n 0.0v 194.755n 0.0v 199.745n 0.0v 199.755n 0.0v 204.745n 0.0v 204.755n 1.1v 209.745n 1.1v 209.755n 0.0v 214.745n 0.0v 214.755n 0.0v 219.745n 0.0v 219.755n 0.0v 224.745n 0.0v 224.755n 0.0v 229.745n 0.0v 229.755n 0.0v 234.745n 0.0v 234.755n 0.0v 239.745n 0.0v 239.755n 1.1v 244.745n 1.1v 244.755n 1.1v 249.745n 1.1v 249.755n 1.1v 254.745n 1.1v 254.755n 1.1v 259.745n 1.1v 259.755n 1.1v 264.745n 1.1v 264.755n 1.1v 269.745n 1.1v 269.755n 1.1v 274.745n 1.1v 274.755n 1.1v 279.745n 1.1v 279.755n 1.1v 284.745n 1.1v 284.755n 1.1v 289.745n 1.1v 289.755n 0.0v 294.745n 0.0v 294.755n 0.0v 299.745n 0.0v 299.755n 0.0v 304.745n 0.0v 304.755n 0.0v 309.745n 0.0v 309.755n 0.0v 314.745n 0.0v 314.755n 1.1v 319.745n 1.1v 319.755n 0.0v 324.745n 0.0v 324.755n 1.1v 329.745n 1.1v 329.755n 0.0v 334.745n 0.0v 334.755n 0.0v 339.745n 0.0v 339.755n 1.1v 344.745n 1.1v 344.755n 1.1v 349.745n 1.1v 349.755n 1.1v 354.745n 1.1v 354.755n 1.1v 359.745n 1.1v 359.755n 1.1v 364.745n 1.1v 364.755n 1.1v 369.745n 1.1v 369.755n 1.1v 374.745n 1.1v 374.755n 1.1v 379.745n 1.1v 379.755n 1.1v 384.745n 1.1v 384.755n 1.1v 389.745n 1.1v 389.755n 1.1v 394.745n 1.1v 394.755n 1.1v 399.745n 1.1v 399.755n 1.1v 404.745n 1.1v 404.755n 0.0v 409.745n 0.0v 409.755n 1.1v 414.745n 1.1v 414.755n 1.1v 419.745n 1.1v 419.755n 1.1v 424.745n 1.1v 424.755n 1.1v 429.745n 1.1v 429.755n 1.1v 434.745n 1.1v 434.755n 0.0v 439.745n 0.0v 439.755n 0.0v 444.745n 0.0v 444.755n 1.1v 449.745n 1.1v 449.755n 1.1v 454.745n 1.1v 454.755n 0.0v 459.745n 0.0v 459.755n 0.0v 464.745n 0.0v 464.755n 0.0v 469.745n 0.0v 469.755n 0.0v 474.745n 0.0v 474.755n 0.0v 479.745n 0.0v 479.755n 0.0v 484.745n 0.0v 484.755n 0.0v 489.745n 0.0v 489.755n 1.1v 494.745n 1.1v 494.755n 1.1v 499.745n 1.1v 499.755n 1.1v 504.745n 1.1v 504.755n 1.1v 509.745n 1.1v 509.755n 1.1v 514.745n 1.1v 514.755n 1.1v 519.745n 1.1v 519.755n 1.1v 524.745n 1.1v 524.755n 1.1v 529.745n 1.1v 529.755n 1.1v 534.745n 1.1v 534.755n 1.1v 539.745n 1.1v 539.755n 1.1v 544.745n 1.1v 544.755n 1.1v 549.745n 1.1v 549.755n 1.1v 554.745n 1.1v 554.755n 1.1v 559.745n 1.1v 559.755n 1.1v 564.745n 1.1v 564.755n 1.1v 569.745n 1.1v 569.755n 0.0v 574.745n 0.0v 574.755n 1.1v 579.745n 1.1v 579.755n 1.1v 584.745n 1.1v 584.755n 0.0v 589.745n 0.0v 589.755n 1.1v 594.745n 1.1v 594.755n 1.1v 599.745n 1.1v 599.755n 0.0v 604.745n 0.0v 604.755n 1.1v 609.745n 1.1v 609.755n 1.1v 614.745n 1.1v 614.755n 1.1v 619.745n 1.1v 619.755n 1.1v 624.745n 1.1v 624.755n 0.0v 629.745n 0.0v 629.755n 0.0v 634.745n 0.0v 634.755n 0.0v 639.745n 0.0v 639.755n 0.0v 644.745n 0.0v 644.755n 0.0v 649.745n 0.0v 649.755n 0.0v 654.745n 0.0v 654.755n 0.0v 659.745n 0.0v 659.755n 0.0v 664.745n 0.0v 664.755n 1.1v 669.745n 1.1v 669.755n 1.1v 674.745n 1.1v 674.755n 1.1v 679.745n 1.1v 679.755n 1.1v 684.745n 1.1v 684.755n 1.1v 689.745n 1.1v 689.755n 0.0v 694.745n 0.0v 694.755n 0.0v 699.745n 0.0v 699.755n 0.0v 704.745n 0.0v 704.755n 1.1v 709.745n 1.1v 709.755n 1.1v 714.745n 1.1v 714.755n 1.1v 719.745n 1.1v 719.755n 1.1v 724.745n 1.1v 724.755n 1.1v 729.745n 1.1v 729.755n 1.1v 734.745n 1.1v 734.755n 1.1v 739.745n 1.1v 739.755n 1.1v 744.745n 1.1v 744.755n 0.0v 749.745n 0.0v 749.755n 0.0v 754.745n 0.0v 754.755n 0.0v 759.745n 0.0v 759.755n 0.0v 764.745n 0.0v 764.755n 1.1v 769.745n 1.1v 769.755n 1.1v 774.745n 1.1v 774.755n 1.1v 779.745n 1.1v 779.755n 1.1v 784.745n 1.1v 784.755n 1.1v 789.745n 1.1v 789.755n 1.1v 794.745n 1.1v 794.755n 1.1v 799.745n 1.1v 799.755n 1.1v 804.745n 1.1v 804.755n 1.1v 809.745n 1.1v 809.755n 0.0v 814.745n 0.0v 814.755n 0.0v 819.745n 0.0v 819.755n 1.1v 824.745n 1.1v 824.755n 1.1v 829.745n 1.1v 829.755n 1.1v 834.745n 1.1v 834.755n 1.1v 839.745n 1.1v 839.755n 1.1v 844.745n 1.1v 844.755n 1.1v 849.745n 1.1v 849.755n 1.1v 854.745n 1.1v 854.755n 1.1v 859.745n 1.1v 859.755n 0.0v 864.745n 0.0v 864.755n 0.0v 869.745n 0.0v 869.755n 0.0v 874.745n 0.0v 874.755n 0.0v 879.745n 0.0v 879.755n 0.0v 884.745n 0.0v 884.755n 0.0v 889.745n 0.0v 889.755n 0.0v 894.745n 0.0v 894.755n 0.0v 899.745n 0.0v 899.755n 1.1v 904.745n 1.1v 904.755n 1.1v 909.745n 1.1v 909.755n 0.0v 914.745n 0.0v 914.755n 0.0v 919.745n 0.0v 919.755n 0.0v 924.745n 0.0v 924.755n 0.0v 929.745n 0.0v 929.755n 0.0v 934.745n 0.0v 934.755n 1.1v 939.745n 1.1v 939.755n 0.0v 944.745n 0.0v 944.755n 0.0v 949.745n 0.0v 949.755n 1.1v 954.745n 1.1v 954.755n 1.1v 959.745n 1.1v 959.755n 0.0v 964.745n 0.0v 964.755n 0.0v 969.745n 0.0v 969.755n 1.1v 974.745n 1.1v 974.755n 1.1v 979.745n 1.1v 979.755n 1.1v 984.745n 1.1v 984.755n 1.1v 989.745n 1.1v 989.755n 0.0v 994.745n 0.0v 994.755n 0.0v 999.745n 0.0v 999.755n 1.1v 1004.745n 1.1v 1004.755n 1.1v 1009.745n 1.1v 1009.755n 1.1v 1014.745n 1.1v 1014.755n 1.1v 1019.745n 1.1v 1019.755n 1.1v 1024.745n 1.1v 1024.755n 1.1v )
* (time, data): [(0, 0), (5, 0), (10, 0), (15, 0), (20, 0), (25, 0), (30, 0), (35, 0), (40, 0), (45, 0), (50, 0), (55, 0), (60, 0), (65, 0), (70, 1), (75, 1), (80, 1), (85, 1), (90, 1), (95, 1), (100, 1), (105, 1), (110, 1), (115, 0), (120, 0), (125, 0), (130, 0), (135, 0), (140, 1), (145, 1), (150, 1), (155, 1), (160, 1), (165, 1), (170, 1), (175, 1), (180, 1), (185, 1), (190, 1), (195, 1), (200, 1), (205, 0), (210, 1), (215, 1), (220, 0), (225, 0), (230, 0), (235, 0), (240, 1), (245, 1), (250, 1), (255, 1), (260, 1), (265, 1), (270, 1), (275, 1), (280, 1), (285, 1), (290, 0), (295, 0), (300, 0), (305, 0), (310, 0), (315, 1), (320, 1), (325, 1), (330, 1), (335, 0), (340, 1), (345, 1), (350, 1), (355, 1), (360, 1), (365, 1), (370, 1), (375, 1), (380, 1), (385, 1), (390, 1), (395, 1), (400, 1), (405, 1), (410, 0), (415, 0), (420, 0), (425, 1), (430, 1), (435, 0), (440, 0), (445, 0), (450, 0), (455, 1), (460, 1), (465, 1), (470, 1), (475, 1), (480, 1), (485, 1), (490, 0), (495, 0), (500, 0), (505, 0), (510, 1), (515, 0), (520, 0), (525, 0), (530, 0), (535, 0), (540, 0), (545, 0), (550, 0), (555, 0), (560, 0), (565, 0), (570, 0), (575, 1), (580, 0), (585, 0), (590, 0), (595, 0), (600, 0), (605, 1), (610, 1), (615, 0), (620, 0), (625, 0), (630, 0), (635, 0), (640, 0), (645, 0), (650, 0), (655, 0), (660, 0), (665, 1), (670, 1), (675, 1), (680, 1), (685, 1), (690, 1), (695, 0), (700, 1), (705, 1), (710, 0), (715, 0), (720, 0), (725, 0), (730, 0), (735, 1), (740, 1), (745, 0), (750, 0), (755, 0), (760, 0), (765, 0), (770, 0), (775, 0), (780, 0), (785, 0), (790, 0), (795, 0), (800, 0), (805, 0), (810, 0), (815, 0), (820, 1), (825, 1), (830, 1), (835, 1), (840, 1), (845, 1), (850, 1), (855, 1), (860, 1), (865, 1), (870, 1), (875, 1), (880, 1), (885, 1), (890, 1), (895, 1), (900, 1), (905, 0), (910, 1), (915, 1), (920, 0), (925, 0), (930, 0), (935, 1), (940, 1), (945, 1), (950, 1), (955, 0), (960, 1), (965, 1), (970, 1), (975, 1), (980, 1), (985, 0), (990, 0), (995, 0), (1000, 1), (1005, 1), (1010, 0), (1015, 0), (1020, 0), (1025, 0)]
Vdin0_30  din0_30  0 PWL (0n 0.0v 4.745n 0.0v 4.755n 0.0v 9.745n 0.0v 9.755n 0.0v 14.745n 0.0v 14.755n 0.0v 19.745n 0.0v 19.755n 0.0v 24.745n 0.0v 24.755n 0.0v 29.745n 0.0v 29.755n 0.0v 34.745n 0.0v 34.755n 0.0v 39.745n 0.0v 39.755n 0.0v 44.745n 0.0v 44.755n 0.0v 49.745n 0.0v 49.755n 0.0v 54.745n 0.0v 54.755n 0.0v 59.745n 0.0v 59.755n 0.0v 64.745n 0.0v 64.755n 0.0v 69.745n 0.0v 69.755n 1.1v 74.745n 1.1v 74.755n 1.1v 79.745n 1.1v 79.755n 1.1v 84.745n 1.1v 84.755n 1.1v 89.745n 1.1v 89.755n 1.1v 94.745n 1.1v 94.755n 1.1v 99.745n 1.1v 99.755n 1.1v 104.745n 1.1v 104.755n 1.1v 109.745n 1.1v 109.755n 1.1v 114.745n 1.1v 114.755n 0.0v 119.745n 0.0v 119.755n 0.0v 124.745n 0.0v 124.755n 0.0v 129.745n 0.0v 129.755n 0.0v 134.745n 0.0v 134.755n 0.0v 139.745n 0.0v 139.755n 1.1v 144.745n 1.1v 144.755n 1.1v 149.745n 1.1v 149.755n 1.1v 154.745n 1.1v 154.755n 1.1v 159.745n 1.1v 159.755n 1.1v 164.745n 1.1v 164.755n 1.1v 169.745n 1.1v 169.755n 1.1v 174.745n 1.1v 174.755n 1.1v 179.745n 1.1v 179.755n 1.1v 184.745n 1.1v 184.755n 1.1v 189.745n 1.1v 189.755n 1.1v 194.745n 1.1v 194.755n 1.1v 199.745n 1.1v 199.755n 1.1v 204.745n 1.1v 204.755n 0.0v 209.745n 0.0v 209.755n 1.1v 214.745n 1.1v 214.755n 1.1v 219.745n 1.1v 219.755n 0.0v 224.745n 0.0v 224.755n 0.0v 229.745n 0.0v 229.755n 0.0v 234.745n 0.0v 234.755n 0.0v 239.745n 0.0v 239.755n 1.1v 244.745n 1.1v 244.755n 1.1v 249.745n 1.1v 249.755n 1.1v 254.745n 1.1v 254.755n 1.1v 259.745n 1.1v 259.755n 1.1v 264.745n 1.1v 264.755n 1.1v 269.745n 1.1v 269.755n 1.1v 274.745n 1.1v 274.755n 1.1v 279.745n 1.1v 279.755n 1.1v 284.745n 1.1v 284.755n 1.1v 289.745n 1.1v 289.755n 0.0v 294.745n 0.0v 294.755n 0.0v 299.745n 0.0v 299.755n 0.0v 304.745n 0.0v 304.755n 0.0v 309.745n 0.0v 309.755n 0.0v 314.745n 0.0v 314.755n 1.1v 319.745n 1.1v 319.755n 1.1v 324.745n 1.1v 324.755n 1.1v 329.745n 1.1v 329.755n 1.1v 334.745n 1.1v 334.755n 0.0v 339.745n 0.0v 339.755n 1.1v 344.745n 1.1v 344.755n 1.1v 349.745n 1.1v 349.755n 1.1v 354.745n 1.1v 354.755n 1.1v 359.745n 1.1v 359.755n 1.1v 364.745n 1.1v 364.755n 1.1v 369.745n 1.1v 369.755n 1.1v 374.745n 1.1v 374.755n 1.1v 379.745n 1.1v 379.755n 1.1v 384.745n 1.1v 384.755n 1.1v 389.745n 1.1v 389.755n 1.1v 394.745n 1.1v 394.755n 1.1v 399.745n 1.1v 399.755n 1.1v 404.745n 1.1v 404.755n 1.1v 409.745n 1.1v 409.755n 0.0v 414.745n 0.0v 414.755n 0.0v 419.745n 0.0v 419.755n 0.0v 424.745n 0.0v 424.755n 1.1v 429.745n 1.1v 429.755n 1.1v 434.745n 1.1v 434.755n 0.0v 439.745n 0.0v 439.755n 0.0v 444.745n 0.0v 444.755n 0.0v 449.745n 0.0v 449.755n 0.0v 454.745n 0.0v 454.755n 1.1v 459.745n 1.1v 459.755n 1.1v 464.745n 1.1v 464.755n 1.1v 469.745n 1.1v 469.755n 1.1v 474.745n 1.1v 474.755n 1.1v 479.745n 1.1v 479.755n 1.1v 484.745n 1.1v 484.755n 1.1v 489.745n 1.1v 489.755n 0.0v 494.745n 0.0v 494.755n 0.0v 499.745n 0.0v 499.755n 0.0v 504.745n 0.0v 504.755n 0.0v 509.745n 0.0v 509.755n 1.1v 514.745n 1.1v 514.755n 0.0v 519.745n 0.0v 519.755n 0.0v 524.745n 0.0v 524.755n 0.0v 529.745n 0.0v 529.755n 0.0v 534.745n 0.0v 534.755n 0.0v 539.745n 0.0v 539.755n 0.0v 544.745n 0.0v 544.755n 0.0v 549.745n 0.0v 549.755n 0.0v 554.745n 0.0v 554.755n 0.0v 559.745n 0.0v 559.755n 0.0v 564.745n 0.0v 564.755n 0.0v 569.745n 0.0v 569.755n 0.0v 574.745n 0.0v 574.755n 1.1v 579.745n 1.1v 579.755n 0.0v 584.745n 0.0v 584.755n 0.0v 589.745n 0.0v 589.755n 0.0v 594.745n 0.0v 594.755n 0.0v 599.745n 0.0v 599.755n 0.0v 604.745n 0.0v 604.755n 1.1v 609.745n 1.1v 609.755n 1.1v 614.745n 1.1v 614.755n 0.0v 619.745n 0.0v 619.755n 0.0v 624.745n 0.0v 624.755n 0.0v 629.745n 0.0v 629.755n 0.0v 634.745n 0.0v 634.755n 0.0v 639.745n 0.0v 639.755n 0.0v 644.745n 0.0v 644.755n 0.0v 649.745n 0.0v 649.755n 0.0v 654.745n 0.0v 654.755n 0.0v 659.745n 0.0v 659.755n 0.0v 664.745n 0.0v 664.755n 1.1v 669.745n 1.1v 669.755n 1.1v 674.745n 1.1v 674.755n 1.1v 679.745n 1.1v 679.755n 1.1v 684.745n 1.1v 684.755n 1.1v 689.745n 1.1v 689.755n 1.1v 694.745n 1.1v 694.755n 0.0v 699.745n 0.0v 699.755n 1.1v 704.745n 1.1v 704.755n 1.1v 709.745n 1.1v 709.755n 0.0v 714.745n 0.0v 714.755n 0.0v 719.745n 0.0v 719.755n 0.0v 724.745n 0.0v 724.755n 0.0v 729.745n 0.0v 729.755n 0.0v 734.745n 0.0v 734.755n 1.1v 739.745n 1.1v 739.755n 1.1v 744.745n 1.1v 744.755n 0.0v 749.745n 0.0v 749.755n 0.0v 754.745n 0.0v 754.755n 0.0v 759.745n 0.0v 759.755n 0.0v 764.745n 0.0v 764.755n 0.0v 769.745n 0.0v 769.755n 0.0v 774.745n 0.0v 774.755n 0.0v 779.745n 0.0v 779.755n 0.0v 784.745n 0.0v 784.755n 0.0v 789.745n 0.0v 789.755n 0.0v 794.745n 0.0v 794.755n 0.0v 799.745n 0.0v 799.755n 0.0v 804.745n 0.0v 804.755n 0.0v 809.745n 0.0v 809.755n 0.0v 814.745n 0.0v 814.755n 0.0v 819.745n 0.0v 819.755n 1.1v 824.745n 1.1v 824.755n 1.1v 829.745n 1.1v 829.755n 1.1v 834.745n 1.1v 834.755n 1.1v 839.745n 1.1v 839.755n 1.1v 844.745n 1.1v 844.755n 1.1v 849.745n 1.1v 849.755n 1.1v 854.745n 1.1v 854.755n 1.1v 859.745n 1.1v 859.755n 1.1v 864.745n 1.1v 864.755n 1.1v 869.745n 1.1v 869.755n 1.1v 874.745n 1.1v 874.755n 1.1v 879.745n 1.1v 879.755n 1.1v 884.745n 1.1v 884.755n 1.1v 889.745n 1.1v 889.755n 1.1v 894.745n 1.1v 894.755n 1.1v 899.745n 1.1v 899.755n 1.1v 904.745n 1.1v 904.755n 0.0v 909.745n 0.0v 909.755n 1.1v 914.745n 1.1v 914.755n 1.1v 919.745n 1.1v 919.755n 0.0v 924.745n 0.0v 924.755n 0.0v 929.745n 0.0v 929.755n 0.0v 934.745n 0.0v 934.755n 1.1v 939.745n 1.1v 939.755n 1.1v 944.745n 1.1v 944.755n 1.1v 949.745n 1.1v 949.755n 1.1v 954.745n 1.1v 954.755n 0.0v 959.745n 0.0v 959.755n 1.1v 964.745n 1.1v 964.755n 1.1v 969.745n 1.1v 969.755n 1.1v 974.745n 1.1v 974.755n 1.1v 979.745n 1.1v 979.755n 1.1v 984.745n 1.1v 984.755n 0.0v 989.745n 0.0v 989.755n 0.0v 994.745n 0.0v 994.755n 0.0v 999.745n 0.0v 999.755n 1.1v 1004.745n 1.1v 1004.755n 1.1v 1009.745n 1.1v 1009.755n 0.0v 1014.745n 0.0v 1014.755n 0.0v 1019.745n 0.0v 1019.755n 0.0v 1024.745n 0.0v 1024.755n 0.0v )
* (time, data): [(0, 0), (5, 0), (10, 1), (15, 1), (20, 1), (25, 1), (30, 1), (35, 1), (40, 1), (45, 1), (50, 1), (55, 1), (60, 1), (65, 1), (70, 0), (75, 0), (80, 0), (85, 1), (90, 1), (95, 1), (100, 0), (105, 0), (110, 0), (115, 0), (120, 0), (125, 0), (130, 0), (135, 0), (140, 1), (145, 0), (150, 0), (155, 0), (160, 0), (165, 0), (170, 0), (175, 0), (180, 1), (185, 1), (190, 1), (195, 1), (200, 1), (205, 0), (210, 0), (215, 0), (220, 1), (225, 1), (230, 1), (235, 1), (240, 1), (245, 1), (250, 1), (255, 1), (260, 1), (265, 1), (270, 1), (275, 1), (280, 0), (285, 0), (290, 1), (295, 1), (300, 1), (305, 1), (310, 1), (315, 0), (320, 0), (325, 0), (330, 0), (335, 1), (340, 1), (345, 1), (350, 1), (355, 1), (360, 1), (365, 1), (370, 1), (375, 1), (380, 1), (385, 1), (390, 1), (395, 1), (400, 1), (405, 1), (410, 1), (415, 1), (420, 1), (425, 0), (430, 0), (435, 0), (440, 0), (445, 1), (450, 0), (455, 0), (460, 0), (465, 0), (470, 0), (475, 0), (480, 0), (485, 0), (490, 0), (495, 0), (500, 0), (505, 0), (510, 1), (515, 0), (520, 0), (525, 0), (530, 0), (535, 0), (540, 0), (545, 0), (550, 1), (555, 1), (560, 1), (565, 1), (570, 0), (575, 0), (580, 1), (585, 0), (590, 1), (595, 0), (600, 0), (605, 0), (610, 0), (615, 0), (620, 0), (625, 1), (630, 1), (635, 1), (640, 1), (645, 0), (650, 0), (655, 0), (660, 0), (665, 1), (670, 0), (675, 0), (680, 0), (685, 0), (690, 0), (695, 1), (700, 1), (705, 1), (710, 0), (715, 0), (720, 0), (725, 0), (730, 0), (735, 1), (740, 1), (745, 0), (750, 0), (755, 0), (760, 0), (765, 1), (770, 1), (775, 1), (780, 1), (785, 1), (790, 1), (795, 1), (800, 1), (805, 1), (810, 1), (815, 0), (820, 1), (825, 1), (830, 1), (835, 1), (840, 1), (845, 1), (850, 1), (855, 1), (860, 0), (865, 0), (870, 0), (875, 0), (880, 0), (885, 0), (890, 1), (895, 1), (900, 1), (905, 1), (910, 1), (915, 1), (920, 0), (925, 0), (930, 1), (935, 0), (940, 0), (945, 0), (950, 1), (955, 1), (960, 1), (965, 0), (970, 1), (975, 1), (980, 1), (985, 1), (990, 0), (995, 0), (1000, 0), (1005, 0), (1010, 0), (1015, 0), (1020, 0), (1025, 0)]
Vdin0_31  din0_31  0 PWL (0n 0.0v 4.745n 0.0v 4.755n 0.0v 9.745n 0.0v 9.755n 1.1v 14.745n 1.1v 14.755n 1.1v 19.745n 1.1v 19.755n 1.1v 24.745n 1.1v 24.755n 1.1v 29.745n 1.1v 29.755n 1.1v 34.745n 1.1v 34.755n 1.1v 39.745n 1.1v 39.755n 1.1v 44.745n 1.1v 44.755n 1.1v 49.745n 1.1v 49.755n 1.1v 54.745n 1.1v 54.755n 1.1v 59.745n 1.1v 59.755n 1.1v 64.745n 1.1v 64.755n 1.1v 69.745n 1.1v 69.755n 0.0v 74.745n 0.0v 74.755n 0.0v 79.745n 0.0v 79.755n 0.0v 84.745n 0.0v 84.755n 1.1v 89.745n 1.1v 89.755n 1.1v 94.745n 1.1v 94.755n 1.1v 99.745n 1.1v 99.755n 0.0v 104.745n 0.0v 104.755n 0.0v 109.745n 0.0v 109.755n 0.0v 114.745n 0.0v 114.755n 0.0v 119.745n 0.0v 119.755n 0.0v 124.745n 0.0v 124.755n 0.0v 129.745n 0.0v 129.755n 0.0v 134.745n 0.0v 134.755n 0.0v 139.745n 0.0v 139.755n 1.1v 144.745n 1.1v 144.755n 0.0v 149.745n 0.0v 149.755n 0.0v 154.745n 0.0v 154.755n 0.0v 159.745n 0.0v 159.755n 0.0v 164.745n 0.0v 164.755n 0.0v 169.745n 0.0v 169.755n 0.0v 174.745n 0.0v 174.755n 0.0v 179.745n 0.0v 179.755n 1.1v 184.745n 1.1v 184.755n 1.1v 189.745n 1.1v 189.755n 1.1v 194.745n 1.1v 194.755n 1.1v 199.745n 1.1v 199.755n 1.1v 204.745n 1.1v 204.755n 0.0v 209.745n 0.0v 209.755n 0.0v 214.745n 0.0v 214.755n 0.0v 219.745n 0.0v 219.755n 1.1v 224.745n 1.1v 224.755n 1.1v 229.745n 1.1v 229.755n 1.1v 234.745n 1.1v 234.755n 1.1v 239.745n 1.1v 239.755n 1.1v 244.745n 1.1v 244.755n 1.1v 249.745n 1.1v 249.755n 1.1v 254.745n 1.1v 254.755n 1.1v 259.745n 1.1v 259.755n 1.1v 264.745n 1.1v 264.755n 1.1v 269.745n 1.1v 269.755n 1.1v 274.745n 1.1v 274.755n 1.1v 279.745n 1.1v 279.755n 0.0v 284.745n 0.0v 284.755n 0.0v 289.745n 0.0v 289.755n 1.1v 294.745n 1.1v 294.755n 1.1v 299.745n 1.1v 299.755n 1.1v 304.745n 1.1v 304.755n 1.1v 309.745n 1.1v 309.755n 1.1v 314.745n 1.1v 314.755n 0.0v 319.745n 0.0v 319.755n 0.0v 324.745n 0.0v 324.755n 0.0v 329.745n 0.0v 329.755n 0.0v 334.745n 0.0v 334.755n 1.1v 339.745n 1.1v 339.755n 1.1v 344.745n 1.1v 344.755n 1.1v 349.745n 1.1v 349.755n 1.1v 354.745n 1.1v 354.755n 1.1v 359.745n 1.1v 359.755n 1.1v 364.745n 1.1v 364.755n 1.1v 369.745n 1.1v 369.755n 1.1v 374.745n 1.1v 374.755n 1.1v 379.745n 1.1v 379.755n 1.1v 384.745n 1.1v 384.755n 1.1v 389.745n 1.1v 389.755n 1.1v 394.745n 1.1v 394.755n 1.1v 399.745n 1.1v 399.755n 1.1v 404.745n 1.1v 404.755n 1.1v 409.745n 1.1v 409.755n 1.1v 414.745n 1.1v 414.755n 1.1v 419.745n 1.1v 419.755n 1.1v 424.745n 1.1v 424.755n 0.0v 429.745n 0.0v 429.755n 0.0v 434.745n 0.0v 434.755n 0.0v 439.745n 0.0v 439.755n 0.0v 444.745n 0.0v 444.755n 1.1v 449.745n 1.1v 449.755n 0.0v 454.745n 0.0v 454.755n 0.0v 459.745n 0.0v 459.755n 0.0v 464.745n 0.0v 464.755n 0.0v 469.745n 0.0v 469.755n 0.0v 474.745n 0.0v 474.755n 0.0v 479.745n 0.0v 479.755n 0.0v 484.745n 0.0v 484.755n 0.0v 489.745n 0.0v 489.755n 0.0v 494.745n 0.0v 494.755n 0.0v 499.745n 0.0v 499.755n 0.0v 504.745n 0.0v 504.755n 0.0v 509.745n 0.0v 509.755n 1.1v 514.745n 1.1v 514.755n 0.0v 519.745n 0.0v 519.755n 0.0v 524.745n 0.0v 524.755n 0.0v 529.745n 0.0v 529.755n 0.0v 534.745n 0.0v 534.755n 0.0v 539.745n 0.0v 539.755n 0.0v 544.745n 0.0v 544.755n 0.0v 549.745n 0.0v 549.755n 1.1v 554.745n 1.1v 554.755n 1.1v 559.745n 1.1v 559.755n 1.1v 564.745n 1.1v 564.755n 1.1v 569.745n 1.1v 569.755n 0.0v 574.745n 0.0v 574.755n 0.0v 579.745n 0.0v 579.755n 1.1v 584.745n 1.1v 584.755n 0.0v 589.745n 0.0v 589.755n 1.1v 594.745n 1.1v 594.755n 0.0v 599.745n 0.0v 599.755n 0.0v 604.745n 0.0v 604.755n 0.0v 609.745n 0.0v 609.755n 0.0v 614.745n 0.0v 614.755n 0.0v 619.745n 0.0v 619.755n 0.0v 624.745n 0.0v 624.755n 1.1v 629.745n 1.1v 629.755n 1.1v 634.745n 1.1v 634.755n 1.1v 639.745n 1.1v 639.755n 1.1v 644.745n 1.1v 644.755n 0.0v 649.745n 0.0v 649.755n 0.0v 654.745n 0.0v 654.755n 0.0v 659.745n 0.0v 659.755n 0.0v 664.745n 0.0v 664.755n 1.1v 669.745n 1.1v 669.755n 0.0v 674.745n 0.0v 674.755n 0.0v 679.745n 0.0v 679.755n 0.0v 684.745n 0.0v 684.755n 0.0v 689.745n 0.0v 689.755n 0.0v 694.745n 0.0v 694.755n 1.1v 699.745n 1.1v 699.755n 1.1v 704.745n 1.1v 704.755n 1.1v 709.745n 1.1v 709.755n 0.0v 714.745n 0.0v 714.755n 0.0v 719.745n 0.0v 719.755n 0.0v 724.745n 0.0v 724.755n 0.0v 729.745n 0.0v 729.755n 0.0v 734.745n 0.0v 734.755n 1.1v 739.745n 1.1v 739.755n 1.1v 744.745n 1.1v 744.755n 0.0v 749.745n 0.0v 749.755n 0.0v 754.745n 0.0v 754.755n 0.0v 759.745n 0.0v 759.755n 0.0v 764.745n 0.0v 764.755n 1.1v 769.745n 1.1v 769.755n 1.1v 774.745n 1.1v 774.755n 1.1v 779.745n 1.1v 779.755n 1.1v 784.745n 1.1v 784.755n 1.1v 789.745n 1.1v 789.755n 1.1v 794.745n 1.1v 794.755n 1.1v 799.745n 1.1v 799.755n 1.1v 804.745n 1.1v 804.755n 1.1v 809.745n 1.1v 809.755n 1.1v 814.745n 1.1v 814.755n 0.0v 819.745n 0.0v 819.755n 1.1v 824.745n 1.1v 824.755n 1.1v 829.745n 1.1v 829.755n 1.1v 834.745n 1.1v 834.755n 1.1v 839.745n 1.1v 839.755n 1.1v 844.745n 1.1v 844.755n 1.1v 849.745n 1.1v 849.755n 1.1v 854.745n 1.1v 854.755n 1.1v 859.745n 1.1v 859.755n 0.0v 864.745n 0.0v 864.755n 0.0v 869.745n 0.0v 869.755n 0.0v 874.745n 0.0v 874.755n 0.0v 879.745n 0.0v 879.755n 0.0v 884.745n 0.0v 884.755n 0.0v 889.745n 0.0v 889.755n 1.1v 894.745n 1.1v 894.755n 1.1v 899.745n 1.1v 899.755n 1.1v 904.745n 1.1v 904.755n 1.1v 909.745n 1.1v 909.755n 1.1v 914.745n 1.1v 914.755n 1.1v 919.745n 1.1v 919.755n 0.0v 924.745n 0.0v 924.755n 0.0v 929.745n 0.0v 929.755n 1.1v 934.745n 1.1v 934.755n 0.0v 939.745n 0.0v 939.755n 0.0v 944.745n 0.0v 944.755n 0.0v 949.745n 0.0v 949.755n 1.1v 954.745n 1.1v 954.755n 1.1v 959.745n 1.1v 959.755n 1.1v 964.745n 1.1v 964.755n 0.0v 969.745n 0.0v 969.755n 1.1v 974.745n 1.1v 974.755n 1.1v 979.745n 1.1v 979.755n 1.1v 984.745n 1.1v 984.755n 1.1v 989.745n 1.1v 989.755n 0.0v 994.745n 0.0v 994.755n 0.0v 999.745n 0.0v 999.755n 0.0v 1004.745n 0.0v 1004.755n 0.0v 1009.745n 0.0v 1009.755n 0.0v 1014.745n 0.0v 1014.755n 0.0v 1019.745n 0.0v 1019.755n 0.0v 1024.745n 0.0v 1024.755n 0.0v )
* (time, data): [(0, 0), (5, 0), (10, 0), (15, 0), (20, 0), (25, 0), (30, 0), (35, 0), (40, 0), (45, 0), (50, 0), (55, 0), (60, 0), (65, 0), (70, 0), (75, 0), (80, 0), (85, 0), (90, 0), (95, 0), (100, 0), (105, 0), (110, 0), (115, 0), (120, 0), (125, 0), (130, 0), (135, 0), (140, 0), (145, 0), (150, 0), (155, 0), (160, 0), (165, 0), (170, 0), (175, 0), (180, 0), (185, 0), (190, 0), (195, 0), (200, 0), (205, 0), (210, 0), (215, 0), (220, 0), (225, 0), (230, 0), (235, 0), (240, 0), (245, 0), (250, 0), (255, 0), (260, 0), (265, 0), (270, 0), (275, 0), (280, 0), (285, 0), (290, 0), (295, 0), (300, 0), (305, 0), (310, 0), (315, 0), (320, 0), (325, 0), (330, 0), (335, 0), (340, 0), (345, 0), (350, 0), (355, 0), (360, 0), (365, 0), (370, 0), (375, 0), (380, 0), (385, 0), (390, 0), (395, 0), (400, 0), (405, 0), (410, 0), (415, 0), (420, 0), (425, 0), (430, 0), (435, 0), (440, 0), (445, 0), (450, 0), (455, 0), (460, 0), (465, 0), (470, 0), (475, 0), (480, 0), (485, 0), (490, 0), (495, 0), (500, 0), (505, 0), (510, 0), (515, 0), (520, 0), (525, 0), (530, 0), (535, 0), (540, 0), (545, 0), (550, 0), (555, 0), (560, 0), (565, 0), (570, 0), (575, 0), (580, 0), (585, 0), (590, 0), (595, 0), (600, 0), (605, 0), (610, 0), (615, 0), (620, 0), (625, 0), (630, 0), (635, 0), (640, 0), (645, 0), (650, 0), (655, 0), (660, 0), (665, 0), (670, 0), (675, 0), (680, 0), (685, 0), (690, 0), (695, 0), (700, 0), (705, 0), (710, 0), (715, 0), (720, 0), (725, 0), (730, 0), (735, 0), (740, 0), (745, 0), (750, 0), (755, 0), (760, 0), (765, 0), (770, 0), (775, 0), (780, 0), (785, 0), (790, 0), (795, 0), (800, 0), (805, 0), (810, 0), (815, 0), (820, 0), (825, 0), (830, 0), (835, 0), (840, 0), (845, 0), (850, 0), (855, 0), (860, 0), (865, 0), (870, 0), (875, 0), (880, 0), (885, 0), (890, 0), (895, 0), (900, 0), (905, 0), (910, 0), (915, 0), (920, 0), (925, 0), (930, 0), (935, 0), (940, 0), (945, 0), (950, 0), (955, 0), (960, 0), (965, 0), (970, 0), (975, 0), (980, 0), (985, 0), (990, 0), (995, 0), (1000, 0), (1005, 0), (1010, 0), (1015, 0), (1020, 0), (1025, 0)]
Va0_0  a0_0  0 PWL (0n 0.0v 4.745n 0.0v 4.755n 0.0v 9.745n 0.0v 9.755n 0.0v 14.745n 0.0v 14.755n 0.0v 19.745n 0.0v 19.755n 0.0v 24.745n 0.0v 24.755n 0.0v 29.745n 0.0v 29.755n 0.0v 34.745n 0.0v 34.755n 0.0v 39.745n 0.0v 39.755n 0.0v 44.745n 0.0v 44.755n 0.0v 49.745n 0.0v 49.755n 0.0v 54.745n 0.0v 54.755n 0.0v 59.745n 0.0v 59.755n 0.0v 64.745n 0.0v 64.755n 0.0v 69.745n 0.0v 69.755n 0.0v 74.745n 0.0v 74.755n 0.0v 79.745n 0.0v 79.755n 0.0v 84.745n 0.0v 84.755n 0.0v 89.745n 0.0v 89.755n 0.0v 94.745n 0.0v 94.755n 0.0v 99.745n 0.0v 99.755n 0.0v 104.745n 0.0v 104.755n 0.0v 109.745n 0.0v 109.755n 0.0v 114.745n 0.0v 114.755n 0.0v 119.745n 0.0v 119.755n 0.0v 124.745n 0.0v 124.755n 0.0v 129.745n 0.0v 129.755n 0.0v 134.745n 0.0v 134.755n 0.0v 139.745n 0.0v 139.755n 0.0v 144.745n 0.0v 144.755n 0.0v 149.745n 0.0v 149.755n 0.0v 154.745n 0.0v 154.755n 0.0v 159.745n 0.0v 159.755n 0.0v 164.745n 0.0v 164.755n 0.0v 169.745n 0.0v 169.755n 0.0v 174.745n 0.0v 174.755n 0.0v 179.745n 0.0v 179.755n 0.0v 184.745n 0.0v 184.755n 0.0v 189.745n 0.0v 189.755n 0.0v 194.745n 0.0v 194.755n 0.0v 199.745n 0.0v 199.755n 0.0v 204.745n 0.0v 204.755n 0.0v 209.745n 0.0v 209.755n 0.0v 214.745n 0.0v 214.755n 0.0v 219.745n 0.0v 219.755n 0.0v 224.745n 0.0v 224.755n 0.0v 229.745n 0.0v 229.755n 0.0v 234.745n 0.0v 234.755n 0.0v 239.745n 0.0v 239.755n 0.0v 244.745n 0.0v 244.755n 0.0v 249.745n 0.0v 249.755n 0.0v 254.745n 0.0v 254.755n 0.0v 259.745n 0.0v 259.755n 0.0v 264.745n 0.0v 264.755n 0.0v 269.745n 0.0v 269.755n 0.0v 274.745n 0.0v 274.755n 0.0v 279.745n 0.0v 279.755n 0.0v 284.745n 0.0v 284.755n 0.0v 289.745n 0.0v 289.755n 0.0v 294.745n 0.0v 294.755n 0.0v 299.745n 0.0v 299.755n 0.0v 304.745n 0.0v 304.755n 0.0v 309.745n 0.0v 309.755n 0.0v 314.745n 0.0v 314.755n 0.0v 319.745n 0.0v 319.755n 0.0v 324.745n 0.0v 324.755n 0.0v 329.745n 0.0v 329.755n 0.0v 334.745n 0.0v 334.755n 0.0v 339.745n 0.0v 339.755n 0.0v 344.745n 0.0v 344.755n 0.0v 349.745n 0.0v 349.755n 0.0v 354.745n 0.0v 354.755n 0.0v 359.745n 0.0v 359.755n 0.0v 364.745n 0.0v 364.755n 0.0v 369.745n 0.0v 369.755n 0.0v 374.745n 0.0v 374.755n 0.0v 379.745n 0.0v 379.755n 0.0v 384.745n 0.0v 384.755n 0.0v 389.745n 0.0v 389.755n 0.0v 394.745n 0.0v 394.755n 0.0v 399.745n 0.0v 399.755n 0.0v 404.745n 0.0v 404.755n 0.0v 409.745n 0.0v 409.755n 0.0v 414.745n 0.0v 414.755n 0.0v 419.745n 0.0v 419.755n 0.0v 424.745n 0.0v 424.755n 0.0v 429.745n 0.0v 429.755n 0.0v 434.745n 0.0v 434.755n 0.0v 439.745n 0.0v 439.755n 0.0v 444.745n 0.0v 444.755n 0.0v 449.745n 0.0v 449.755n 0.0v 454.745n 0.0v 454.755n 0.0v 459.745n 0.0v 459.755n 0.0v 464.745n 0.0v 464.755n 0.0v 469.745n 0.0v 469.755n 0.0v 474.745n 0.0v 474.755n 0.0v 479.745n 0.0v 479.755n 0.0v 484.745n 0.0v 484.755n 0.0v 489.745n 0.0v 489.755n 0.0v 494.745n 0.0v 494.755n 0.0v 499.745n 0.0v 499.755n 0.0v 504.745n 0.0v 504.755n 0.0v 509.745n 0.0v 509.755n 0.0v 514.745n 0.0v 514.755n 0.0v 519.745n 0.0v 519.755n 0.0v 524.745n 0.0v 524.755n 0.0v 529.745n 0.0v 529.755n 0.0v 534.745n 0.0v 534.755n 0.0v 539.745n 0.0v 539.755n 0.0v 544.745n 0.0v 544.755n 0.0v 549.745n 0.0v 549.755n 0.0v 554.745n 0.0v 554.755n 0.0v 559.745n 0.0v 559.755n 0.0v 564.745n 0.0v 564.755n 0.0v 569.745n 0.0v 569.755n 0.0v 574.745n 0.0v 574.755n 0.0v 579.745n 0.0v 579.755n 0.0v 584.745n 0.0v 584.755n 0.0v 589.745n 0.0v 589.755n 0.0v 594.745n 0.0v 594.755n 0.0v 599.745n 0.0v 599.755n 0.0v 604.745n 0.0v 604.755n 0.0v 609.745n 0.0v 609.755n 0.0v 614.745n 0.0v 614.755n 0.0v 619.745n 0.0v 619.755n 0.0v 624.745n 0.0v 624.755n 0.0v 629.745n 0.0v 629.755n 0.0v 634.745n 0.0v 634.755n 0.0v 639.745n 0.0v 639.755n 0.0v 644.745n 0.0v 644.755n 0.0v 649.745n 0.0v 649.755n 0.0v 654.745n 0.0v 654.755n 0.0v 659.745n 0.0v 659.755n 0.0v 664.745n 0.0v 664.755n 0.0v 669.745n 0.0v 669.755n 0.0v 674.745n 0.0v 674.755n 0.0v 679.745n 0.0v 679.755n 0.0v 684.745n 0.0v 684.755n 0.0v 689.745n 0.0v 689.755n 0.0v 694.745n 0.0v 694.755n 0.0v 699.745n 0.0v 699.755n 0.0v 704.745n 0.0v 704.755n 0.0v 709.745n 0.0v 709.755n 0.0v 714.745n 0.0v 714.755n 0.0v 719.745n 0.0v 719.755n 0.0v 724.745n 0.0v 724.755n 0.0v 729.745n 0.0v 729.755n 0.0v 734.745n 0.0v 734.755n 0.0v 739.745n 0.0v 739.755n 0.0v 744.745n 0.0v 744.755n 0.0v 749.745n 0.0v 749.755n 0.0v 754.745n 0.0v 754.755n 0.0v 759.745n 0.0v 759.755n 0.0v 764.745n 0.0v 764.755n 0.0v 769.745n 0.0v 769.755n 0.0v 774.745n 0.0v 774.755n 0.0v 779.745n 0.0v 779.755n 0.0v 784.745n 0.0v 784.755n 0.0v 789.745n 0.0v 789.755n 0.0v 794.745n 0.0v 794.755n 0.0v 799.745n 0.0v 799.755n 0.0v 804.745n 0.0v 804.755n 0.0v 809.745n 0.0v 809.755n 0.0v 814.745n 0.0v 814.755n 0.0v 819.745n 0.0v 819.755n 0.0v 824.745n 0.0v 824.755n 0.0v 829.745n 0.0v 829.755n 0.0v 834.745n 0.0v 834.755n 0.0v 839.745n 0.0v 839.755n 0.0v 844.745n 0.0v 844.755n 0.0v 849.745n 0.0v 849.755n 0.0v 854.745n 0.0v 854.755n 0.0v 859.745n 0.0v 859.755n 0.0v 864.745n 0.0v 864.755n 0.0v 869.745n 0.0v 869.755n 0.0v 874.745n 0.0v 874.755n 0.0v 879.745n 0.0v 879.755n 0.0v 884.745n 0.0v 884.755n 0.0v 889.745n 0.0v 889.755n 0.0v 894.745n 0.0v 894.755n 0.0v 899.745n 0.0v 899.755n 0.0v 904.745n 0.0v 904.755n 0.0v 909.745n 0.0v 909.755n 0.0v 914.745n 0.0v 914.755n 0.0v 919.745n 0.0v 919.755n 0.0v 924.745n 0.0v 924.755n 0.0v 929.745n 0.0v 929.755n 0.0v 934.745n 0.0v 934.755n 0.0v 939.745n 0.0v 939.755n 0.0v 944.745n 0.0v 944.755n 0.0v 949.745n 0.0v 949.755n 0.0v 954.745n 0.0v 954.755n 0.0v 959.745n 0.0v 959.755n 0.0v 964.745n 0.0v 964.755n 0.0v 969.745n 0.0v 969.755n 0.0v 974.745n 0.0v 974.755n 0.0v 979.745n 0.0v 979.755n 0.0v 984.745n 0.0v 984.755n 0.0v 989.745n 0.0v 989.755n 0.0v 994.745n 0.0v 994.755n 0.0v 999.745n 0.0v 999.755n 0.0v 1004.745n 0.0v 1004.755n 0.0v 1009.745n 0.0v 1009.755n 0.0v 1014.745n 0.0v 1014.755n 0.0v 1019.745n 0.0v 1019.755n 0.0v 1024.745n 0.0v 1024.755n 0.0v )
* (time, data): [(0, 0), (5, 1), (10, 1), (15, 0), (20, 0), (25, 0), (30, 0), (35, 0), (40, 0), (45, 0), (50, 0), (55, 0), (60, 0), (65, 1), (70, 0), (75, 0), (80, 0), (85, 1), (90, 1), (95, 1), (100, 0), (105, 0), (110, 0), (115, 0), (120, 0), (125, 0), (130, 0), (135, 0), (140, 0), (145, 1), (150, 1), (155, 0), (160, 0), (165, 0), (170, 1), (175, 0), (180, 0), (185, 0), (190, 0), (195, 0), (200, 0), (205, 0), (210, 1), (215, 1), (220, 0), (225, 0), (230, 1), (235, 1), (240, 0), (245, 1), (250, 1), (255, 1), (260, 0), (265, 0), (270, 1), (275, 0), (280, 0), (285, 0), (290, 0), (295, 0), (300, 1), (305, 1), (310, 0), (315, 0), (320, 1), (325, 1), (330, 1), (335, 0), (340, 0), (345, 0), (350, 0), (355, 1), (360, 1), (365, 1), (370, 1), (375, 1), (380, 1), (385, 1), (390, 1), (395, 0), (400, 1), (405, 0), (410, 0), (415, 0), (420, 0), (425, 1), (430, 1), (435, 0), (440, 1), (445, 1), (450, 1), (455, 1), (460, 1), (465, 1), (470, 1), (475, 1), (480, 1), (485, 1), (490, 0), (495, 0), (500, 0), (505, 0), (510, 0), (515, 0), (520, 0), (525, 0), (530, 0), (535, 1), (540, 0), (545, 0), (550, 1), (555, 1), (560, 1), (565, 0), (570, 0), (575, 0), (580, 1), (585, 1), (590, 1), (595, 1), (600, 1), (605, 1), (610, 0), (615, 0), (620, 0), (625, 0), (630, 1), (635, 0), (640, 0), (645, 1), (650, 0), (655, 1), (660, 0), (665, 0), (670, 1), (675, 1), (680, 1), (685, 1), (690, 1), (695, 1), (700, 1), (705, 0), (710, 0), (715, 0), (720, 0), (725, 0), (730, 0), (735, 0), (740, 0), (745, 0), (750, 0), (755, 1), (760, 1), (765, 1), (770, 0), (775, 1), (780, 1), (785, 1), (790, 1), (795, 1), (800, 1), (805, 0), (810, 0), (815, 0), (820, 0), (825, 0), (830, 0), (835, 1), (840, 1), (845, 1), (850, 1), (855, 1), (860, 1), (865, 1), (870, 1), (875, 0), (880, 0), (885, 1), (890, 0), (895, 0), (900, 1), (905, 1), (910, 0), (915, 0), (920, 1), (925, 1), (930, 0), (935, 0), (940, 0), (945, 0), (950, 1), (955, 0), (960, 1), (965, 1), (970, 1), (975, 1), (980, 0), (985, 1), (990, 0), (995, 1), (1000, 0), (1005, 1), (1010, 0), (1015, 1), (1020, 1), (1025, 1)]
Va0_1  a0_1  0 PWL (0n 0.0v 4.745n 0.0v 4.755n 1.1v 9.745n 1.1v 9.755n 1.1v 14.745n 1.1v 14.755n 0.0v 19.745n 0.0v 19.755n 0.0v 24.745n 0.0v 24.755n 0.0v 29.745n 0.0v 29.755n 0.0v 34.745n 0.0v 34.755n 0.0v 39.745n 0.0v 39.755n 0.0v 44.745n 0.0v 44.755n 0.0v 49.745n 0.0v 49.755n 0.0v 54.745n 0.0v 54.755n 0.0v 59.745n 0.0v 59.755n 0.0v 64.745n 0.0v 64.755n 1.1v 69.745n 1.1v 69.755n 0.0v 74.745n 0.0v 74.755n 0.0v 79.745n 0.0v 79.755n 0.0v 84.745n 0.0v 84.755n 1.1v 89.745n 1.1v 89.755n 1.1v 94.745n 1.1v 94.755n 1.1v 99.745n 1.1v 99.755n 0.0v 104.745n 0.0v 104.755n 0.0v 109.745n 0.0v 109.755n 0.0v 114.745n 0.0v 114.755n 0.0v 119.745n 0.0v 119.755n 0.0v 124.745n 0.0v 124.755n 0.0v 129.745n 0.0v 129.755n 0.0v 134.745n 0.0v 134.755n 0.0v 139.745n 0.0v 139.755n 0.0v 144.745n 0.0v 144.755n 1.1v 149.745n 1.1v 149.755n 1.1v 154.745n 1.1v 154.755n 0.0v 159.745n 0.0v 159.755n 0.0v 164.745n 0.0v 164.755n 0.0v 169.745n 0.0v 169.755n 1.1v 174.745n 1.1v 174.755n 0.0v 179.745n 0.0v 179.755n 0.0v 184.745n 0.0v 184.755n 0.0v 189.745n 0.0v 189.755n 0.0v 194.745n 0.0v 194.755n 0.0v 199.745n 0.0v 199.755n 0.0v 204.745n 0.0v 204.755n 0.0v 209.745n 0.0v 209.755n 1.1v 214.745n 1.1v 214.755n 1.1v 219.745n 1.1v 219.755n 0.0v 224.745n 0.0v 224.755n 0.0v 229.745n 0.0v 229.755n 1.1v 234.745n 1.1v 234.755n 1.1v 239.745n 1.1v 239.755n 0.0v 244.745n 0.0v 244.755n 1.1v 249.745n 1.1v 249.755n 1.1v 254.745n 1.1v 254.755n 1.1v 259.745n 1.1v 259.755n 0.0v 264.745n 0.0v 264.755n 0.0v 269.745n 0.0v 269.755n 1.1v 274.745n 1.1v 274.755n 0.0v 279.745n 0.0v 279.755n 0.0v 284.745n 0.0v 284.755n 0.0v 289.745n 0.0v 289.755n 0.0v 294.745n 0.0v 294.755n 0.0v 299.745n 0.0v 299.755n 1.1v 304.745n 1.1v 304.755n 1.1v 309.745n 1.1v 309.755n 0.0v 314.745n 0.0v 314.755n 0.0v 319.745n 0.0v 319.755n 1.1v 324.745n 1.1v 324.755n 1.1v 329.745n 1.1v 329.755n 1.1v 334.745n 1.1v 334.755n 0.0v 339.745n 0.0v 339.755n 0.0v 344.745n 0.0v 344.755n 0.0v 349.745n 0.0v 349.755n 0.0v 354.745n 0.0v 354.755n 1.1v 359.745n 1.1v 359.755n 1.1v 364.745n 1.1v 364.755n 1.1v 369.745n 1.1v 369.755n 1.1v 374.745n 1.1v 374.755n 1.1v 379.745n 1.1v 379.755n 1.1v 384.745n 1.1v 384.755n 1.1v 389.745n 1.1v 389.755n 1.1v 394.745n 1.1v 394.755n 0.0v 399.745n 0.0v 399.755n 1.1v 404.745n 1.1v 404.755n 0.0v 409.745n 0.0v 409.755n 0.0v 414.745n 0.0v 414.755n 0.0v 419.745n 0.0v 419.755n 0.0v 424.745n 0.0v 424.755n 1.1v 429.745n 1.1v 429.755n 1.1v 434.745n 1.1v 434.755n 0.0v 439.745n 0.0v 439.755n 1.1v 444.745n 1.1v 444.755n 1.1v 449.745n 1.1v 449.755n 1.1v 454.745n 1.1v 454.755n 1.1v 459.745n 1.1v 459.755n 1.1v 464.745n 1.1v 464.755n 1.1v 469.745n 1.1v 469.755n 1.1v 474.745n 1.1v 474.755n 1.1v 479.745n 1.1v 479.755n 1.1v 484.745n 1.1v 484.755n 1.1v 489.745n 1.1v 489.755n 0.0v 494.745n 0.0v 494.755n 0.0v 499.745n 0.0v 499.755n 0.0v 504.745n 0.0v 504.755n 0.0v 509.745n 0.0v 509.755n 0.0v 514.745n 0.0v 514.755n 0.0v 519.745n 0.0v 519.755n 0.0v 524.745n 0.0v 524.755n 0.0v 529.745n 0.0v 529.755n 0.0v 534.745n 0.0v 534.755n 1.1v 539.745n 1.1v 539.755n 0.0v 544.745n 0.0v 544.755n 0.0v 549.745n 0.0v 549.755n 1.1v 554.745n 1.1v 554.755n 1.1v 559.745n 1.1v 559.755n 1.1v 564.745n 1.1v 564.755n 0.0v 569.745n 0.0v 569.755n 0.0v 574.745n 0.0v 574.755n 0.0v 579.745n 0.0v 579.755n 1.1v 584.745n 1.1v 584.755n 1.1v 589.745n 1.1v 589.755n 1.1v 594.745n 1.1v 594.755n 1.1v 599.745n 1.1v 599.755n 1.1v 604.745n 1.1v 604.755n 1.1v 609.745n 1.1v 609.755n 0.0v 614.745n 0.0v 614.755n 0.0v 619.745n 0.0v 619.755n 0.0v 624.745n 0.0v 624.755n 0.0v 629.745n 0.0v 629.755n 1.1v 634.745n 1.1v 634.755n 0.0v 639.745n 0.0v 639.755n 0.0v 644.745n 0.0v 644.755n 1.1v 649.745n 1.1v 649.755n 0.0v 654.745n 0.0v 654.755n 1.1v 659.745n 1.1v 659.755n 0.0v 664.745n 0.0v 664.755n 0.0v 669.745n 0.0v 669.755n 1.1v 674.745n 1.1v 674.755n 1.1v 679.745n 1.1v 679.755n 1.1v 684.745n 1.1v 684.755n 1.1v 689.745n 1.1v 689.755n 1.1v 694.745n 1.1v 694.755n 1.1v 699.745n 1.1v 699.755n 1.1v 704.745n 1.1v 704.755n 0.0v 709.745n 0.0v 709.755n 0.0v 714.745n 0.0v 714.755n 0.0v 719.745n 0.0v 719.755n 0.0v 724.745n 0.0v 724.755n 0.0v 729.745n 0.0v 729.755n 0.0v 734.745n 0.0v 734.755n 0.0v 739.745n 0.0v 739.755n 0.0v 744.745n 0.0v 744.755n 0.0v 749.745n 0.0v 749.755n 0.0v 754.745n 0.0v 754.755n 1.1v 759.745n 1.1v 759.755n 1.1v 764.745n 1.1v 764.755n 1.1v 769.745n 1.1v 769.755n 0.0v 774.745n 0.0v 774.755n 1.1v 779.745n 1.1v 779.755n 1.1v 784.745n 1.1v 784.755n 1.1v 789.745n 1.1v 789.755n 1.1v 794.745n 1.1v 794.755n 1.1v 799.745n 1.1v 799.755n 1.1v 804.745n 1.1v 804.755n 0.0v 809.745n 0.0v 809.755n 0.0v 814.745n 0.0v 814.755n 0.0v 819.745n 0.0v 819.755n 0.0v 824.745n 0.0v 824.755n 0.0v 829.745n 0.0v 829.755n 0.0v 834.745n 0.0v 834.755n 1.1v 839.745n 1.1v 839.755n 1.1v 844.745n 1.1v 844.755n 1.1v 849.745n 1.1v 849.755n 1.1v 854.745n 1.1v 854.755n 1.1v 859.745n 1.1v 859.755n 1.1v 864.745n 1.1v 864.755n 1.1v 869.745n 1.1v 869.755n 1.1v 874.745n 1.1v 874.755n 0.0v 879.745n 0.0v 879.755n 0.0v 884.745n 0.0v 884.755n 1.1v 889.745n 1.1v 889.755n 0.0v 894.745n 0.0v 894.755n 0.0v 899.745n 0.0v 899.755n 1.1v 904.745n 1.1v 904.755n 1.1v 909.745n 1.1v 909.755n 0.0v 914.745n 0.0v 914.755n 0.0v 919.745n 0.0v 919.755n 1.1v 924.745n 1.1v 924.755n 1.1v 929.745n 1.1v 929.755n 0.0v 934.745n 0.0v 934.755n 0.0v 939.745n 0.0v 939.755n 0.0v 944.745n 0.0v 944.755n 0.0v 949.745n 0.0v 949.755n 1.1v 954.745n 1.1v 954.755n 0.0v 959.745n 0.0v 959.755n 1.1v 964.745n 1.1v 964.755n 1.1v 969.745n 1.1v 969.755n 1.1v 974.745n 1.1v 974.755n 1.1v 979.745n 1.1v 979.755n 0.0v 984.745n 0.0v 984.755n 1.1v 989.745n 1.1v 989.755n 0.0v 994.745n 0.0v 994.755n 1.1v 999.745n 1.1v 999.755n 0.0v 1004.745n 0.0v 1004.755n 1.1v 1009.745n 1.1v 1009.755n 0.0v 1014.745n 0.0v 1014.755n 1.1v 1019.745n 1.1v 1019.755n 1.1v 1024.745n 1.1v 1024.755n 1.1v )
* (time, data): [(0, 0), (5, 1), (10, 1), (15, 0), (20, 0), (25, 0), (30, 0), (35, 0), (40, 0), (45, 0), (50, 0), (55, 0), (60, 0), (65, 1), (70, 0), (75, 0), (80, 0), (85, 1), (90, 1), (95, 1), (100, 0), (105, 0), (110, 0), (115, 0), (120, 0), (125, 0), (130, 0), (135, 0), (140, 0), (145, 1), (150, 1), (155, 0), (160, 0), (165, 0), (170, 1), (175, 0), (180, 0), (185, 0), (190, 0), (195, 0), (200, 0), (205, 0), (210, 1), (215, 1), (220, 0), (225, 0), (230, 1), (235, 1), (240, 0), (245, 1), (250, 1), (255, 1), (260, 0), (265, 0), (270, 1), (275, 0), (280, 0), (285, 0), (290, 0), (295, 0), (300, 1), (305, 1), (310, 0), (315, 0), (320, 1), (325, 1), (330, 1), (335, 0), (340, 0), (345, 0), (350, 0), (355, 1), (360, 1), (365, 1), (370, 1), (375, 1), (380, 1), (385, 1), (390, 1), (395, 0), (400, 1), (405, 0), (410, 0), (415, 0), (420, 0), (425, 1), (430, 1), (435, 0), (440, 1), (445, 1), (450, 1), (455, 1), (460, 1), (465, 1), (470, 1), (475, 1), (480, 1), (485, 1), (490, 0), (495, 0), (500, 0), (505, 0), (510, 0), (515, 0), (520, 0), (525, 0), (530, 0), (535, 1), (540, 0), (545, 0), (550, 1), (555, 1), (560, 1), (565, 0), (570, 0), (575, 0), (580, 1), (585, 1), (590, 1), (595, 1), (600, 1), (605, 1), (610, 0), (615, 0), (620, 0), (625, 0), (630, 1), (635, 0), (640, 0), (645, 1), (650, 0), (655, 1), (660, 0), (665, 0), (670, 1), (675, 1), (680, 1), (685, 1), (690, 1), (695, 1), (700, 1), (705, 0), (710, 0), (715, 0), (720, 0), (725, 0), (730, 0), (735, 0), (740, 0), (745, 0), (750, 0), (755, 1), (760, 1), (765, 1), (770, 0), (775, 1), (780, 1), (785, 1), (790, 1), (795, 1), (800, 1), (805, 0), (810, 0), (815, 0), (820, 0), (825, 0), (830, 0), (835, 1), (840, 1), (845, 1), (850, 1), (855, 1), (860, 1), (865, 1), (870, 1), (875, 0), (880, 0), (885, 1), (890, 0), (895, 0), (900, 1), (905, 1), (910, 0), (915, 0), (920, 1), (925, 1), (930, 0), (935, 0), (940, 0), (945, 0), (950, 1), (955, 0), (960, 1), (965, 1), (970, 1), (975, 1), (980, 0), (985, 1), (990, 0), (995, 1), (1000, 0), (1005, 1), (1010, 0), (1015, 1), (1020, 1), (1025, 1)]
Va0_2  a0_2  0 PWL (0n 0.0v 4.745n 0.0v 4.755n 1.1v 9.745n 1.1v 9.755n 1.1v 14.745n 1.1v 14.755n 0.0v 19.745n 0.0v 19.755n 0.0v 24.745n 0.0v 24.755n 0.0v 29.745n 0.0v 29.755n 0.0v 34.745n 0.0v 34.755n 0.0v 39.745n 0.0v 39.755n 0.0v 44.745n 0.0v 44.755n 0.0v 49.745n 0.0v 49.755n 0.0v 54.745n 0.0v 54.755n 0.0v 59.745n 0.0v 59.755n 0.0v 64.745n 0.0v 64.755n 1.1v 69.745n 1.1v 69.755n 0.0v 74.745n 0.0v 74.755n 0.0v 79.745n 0.0v 79.755n 0.0v 84.745n 0.0v 84.755n 1.1v 89.745n 1.1v 89.755n 1.1v 94.745n 1.1v 94.755n 1.1v 99.745n 1.1v 99.755n 0.0v 104.745n 0.0v 104.755n 0.0v 109.745n 0.0v 109.755n 0.0v 114.745n 0.0v 114.755n 0.0v 119.745n 0.0v 119.755n 0.0v 124.745n 0.0v 124.755n 0.0v 129.745n 0.0v 129.755n 0.0v 134.745n 0.0v 134.755n 0.0v 139.745n 0.0v 139.755n 0.0v 144.745n 0.0v 144.755n 1.1v 149.745n 1.1v 149.755n 1.1v 154.745n 1.1v 154.755n 0.0v 159.745n 0.0v 159.755n 0.0v 164.745n 0.0v 164.755n 0.0v 169.745n 0.0v 169.755n 1.1v 174.745n 1.1v 174.755n 0.0v 179.745n 0.0v 179.755n 0.0v 184.745n 0.0v 184.755n 0.0v 189.745n 0.0v 189.755n 0.0v 194.745n 0.0v 194.755n 0.0v 199.745n 0.0v 199.755n 0.0v 204.745n 0.0v 204.755n 0.0v 209.745n 0.0v 209.755n 1.1v 214.745n 1.1v 214.755n 1.1v 219.745n 1.1v 219.755n 0.0v 224.745n 0.0v 224.755n 0.0v 229.745n 0.0v 229.755n 1.1v 234.745n 1.1v 234.755n 1.1v 239.745n 1.1v 239.755n 0.0v 244.745n 0.0v 244.755n 1.1v 249.745n 1.1v 249.755n 1.1v 254.745n 1.1v 254.755n 1.1v 259.745n 1.1v 259.755n 0.0v 264.745n 0.0v 264.755n 0.0v 269.745n 0.0v 269.755n 1.1v 274.745n 1.1v 274.755n 0.0v 279.745n 0.0v 279.755n 0.0v 284.745n 0.0v 284.755n 0.0v 289.745n 0.0v 289.755n 0.0v 294.745n 0.0v 294.755n 0.0v 299.745n 0.0v 299.755n 1.1v 304.745n 1.1v 304.755n 1.1v 309.745n 1.1v 309.755n 0.0v 314.745n 0.0v 314.755n 0.0v 319.745n 0.0v 319.755n 1.1v 324.745n 1.1v 324.755n 1.1v 329.745n 1.1v 329.755n 1.1v 334.745n 1.1v 334.755n 0.0v 339.745n 0.0v 339.755n 0.0v 344.745n 0.0v 344.755n 0.0v 349.745n 0.0v 349.755n 0.0v 354.745n 0.0v 354.755n 1.1v 359.745n 1.1v 359.755n 1.1v 364.745n 1.1v 364.755n 1.1v 369.745n 1.1v 369.755n 1.1v 374.745n 1.1v 374.755n 1.1v 379.745n 1.1v 379.755n 1.1v 384.745n 1.1v 384.755n 1.1v 389.745n 1.1v 389.755n 1.1v 394.745n 1.1v 394.755n 0.0v 399.745n 0.0v 399.755n 1.1v 404.745n 1.1v 404.755n 0.0v 409.745n 0.0v 409.755n 0.0v 414.745n 0.0v 414.755n 0.0v 419.745n 0.0v 419.755n 0.0v 424.745n 0.0v 424.755n 1.1v 429.745n 1.1v 429.755n 1.1v 434.745n 1.1v 434.755n 0.0v 439.745n 0.0v 439.755n 1.1v 444.745n 1.1v 444.755n 1.1v 449.745n 1.1v 449.755n 1.1v 454.745n 1.1v 454.755n 1.1v 459.745n 1.1v 459.755n 1.1v 464.745n 1.1v 464.755n 1.1v 469.745n 1.1v 469.755n 1.1v 474.745n 1.1v 474.755n 1.1v 479.745n 1.1v 479.755n 1.1v 484.745n 1.1v 484.755n 1.1v 489.745n 1.1v 489.755n 0.0v 494.745n 0.0v 494.755n 0.0v 499.745n 0.0v 499.755n 0.0v 504.745n 0.0v 504.755n 0.0v 509.745n 0.0v 509.755n 0.0v 514.745n 0.0v 514.755n 0.0v 519.745n 0.0v 519.755n 0.0v 524.745n 0.0v 524.755n 0.0v 529.745n 0.0v 529.755n 0.0v 534.745n 0.0v 534.755n 1.1v 539.745n 1.1v 539.755n 0.0v 544.745n 0.0v 544.755n 0.0v 549.745n 0.0v 549.755n 1.1v 554.745n 1.1v 554.755n 1.1v 559.745n 1.1v 559.755n 1.1v 564.745n 1.1v 564.755n 0.0v 569.745n 0.0v 569.755n 0.0v 574.745n 0.0v 574.755n 0.0v 579.745n 0.0v 579.755n 1.1v 584.745n 1.1v 584.755n 1.1v 589.745n 1.1v 589.755n 1.1v 594.745n 1.1v 594.755n 1.1v 599.745n 1.1v 599.755n 1.1v 604.745n 1.1v 604.755n 1.1v 609.745n 1.1v 609.755n 0.0v 614.745n 0.0v 614.755n 0.0v 619.745n 0.0v 619.755n 0.0v 624.745n 0.0v 624.755n 0.0v 629.745n 0.0v 629.755n 1.1v 634.745n 1.1v 634.755n 0.0v 639.745n 0.0v 639.755n 0.0v 644.745n 0.0v 644.755n 1.1v 649.745n 1.1v 649.755n 0.0v 654.745n 0.0v 654.755n 1.1v 659.745n 1.1v 659.755n 0.0v 664.745n 0.0v 664.755n 0.0v 669.745n 0.0v 669.755n 1.1v 674.745n 1.1v 674.755n 1.1v 679.745n 1.1v 679.755n 1.1v 684.745n 1.1v 684.755n 1.1v 689.745n 1.1v 689.755n 1.1v 694.745n 1.1v 694.755n 1.1v 699.745n 1.1v 699.755n 1.1v 704.745n 1.1v 704.755n 0.0v 709.745n 0.0v 709.755n 0.0v 714.745n 0.0v 714.755n 0.0v 719.745n 0.0v 719.755n 0.0v 724.745n 0.0v 724.755n 0.0v 729.745n 0.0v 729.755n 0.0v 734.745n 0.0v 734.755n 0.0v 739.745n 0.0v 739.755n 0.0v 744.745n 0.0v 744.755n 0.0v 749.745n 0.0v 749.755n 0.0v 754.745n 0.0v 754.755n 1.1v 759.745n 1.1v 759.755n 1.1v 764.745n 1.1v 764.755n 1.1v 769.745n 1.1v 769.755n 0.0v 774.745n 0.0v 774.755n 1.1v 779.745n 1.1v 779.755n 1.1v 784.745n 1.1v 784.755n 1.1v 789.745n 1.1v 789.755n 1.1v 794.745n 1.1v 794.755n 1.1v 799.745n 1.1v 799.755n 1.1v 804.745n 1.1v 804.755n 0.0v 809.745n 0.0v 809.755n 0.0v 814.745n 0.0v 814.755n 0.0v 819.745n 0.0v 819.755n 0.0v 824.745n 0.0v 824.755n 0.0v 829.745n 0.0v 829.755n 0.0v 834.745n 0.0v 834.755n 1.1v 839.745n 1.1v 839.755n 1.1v 844.745n 1.1v 844.755n 1.1v 849.745n 1.1v 849.755n 1.1v 854.745n 1.1v 854.755n 1.1v 859.745n 1.1v 859.755n 1.1v 864.745n 1.1v 864.755n 1.1v 869.745n 1.1v 869.755n 1.1v 874.745n 1.1v 874.755n 0.0v 879.745n 0.0v 879.755n 0.0v 884.745n 0.0v 884.755n 1.1v 889.745n 1.1v 889.755n 0.0v 894.745n 0.0v 894.755n 0.0v 899.745n 0.0v 899.755n 1.1v 904.745n 1.1v 904.755n 1.1v 909.745n 1.1v 909.755n 0.0v 914.745n 0.0v 914.755n 0.0v 919.745n 0.0v 919.755n 1.1v 924.745n 1.1v 924.755n 1.1v 929.745n 1.1v 929.755n 0.0v 934.745n 0.0v 934.755n 0.0v 939.745n 0.0v 939.755n 0.0v 944.745n 0.0v 944.755n 0.0v 949.745n 0.0v 949.755n 1.1v 954.745n 1.1v 954.755n 0.0v 959.745n 0.0v 959.755n 1.1v 964.745n 1.1v 964.755n 1.1v 969.745n 1.1v 969.755n 1.1v 974.745n 1.1v 974.755n 1.1v 979.745n 1.1v 979.755n 0.0v 984.745n 0.0v 984.755n 1.1v 989.745n 1.1v 989.755n 0.0v 994.745n 0.0v 994.755n 1.1v 999.745n 1.1v 999.755n 0.0v 1004.745n 0.0v 1004.755n 1.1v 1009.745n 1.1v 1009.755n 0.0v 1014.745n 0.0v 1014.755n 1.1v 1019.745n 1.1v 1019.755n 1.1v 1024.745n 1.1v 1024.755n 1.1v )
* (time, data): [(0, 0), (5, 1), (10, 1), (15, 0), (20, 0), (25, 0), (30, 0), (35, 0), (40, 0), (45, 0), (50, 0), (55, 0), (60, 0), (65, 1), (70, 0), (75, 0), (80, 0), (85, 1), (90, 1), (95, 1), (100, 0), (105, 0), (110, 0), (115, 0), (120, 0), (125, 0), (130, 0), (135, 0), (140, 0), (145, 1), (150, 1), (155, 0), (160, 0), (165, 0), (170, 1), (175, 0), (180, 0), (185, 0), (190, 0), (195, 0), (200, 0), (205, 0), (210, 1), (215, 1), (220, 0), (225, 0), (230, 1), (235, 1), (240, 0), (245, 1), (250, 1), (255, 1), (260, 0), (265, 0), (270, 1), (275, 0), (280, 0), (285, 0), (290, 0), (295, 0), (300, 1), (305, 1), (310, 0), (315, 0), (320, 1), (325, 1), (330, 1), (335, 0), (340, 0), (345, 0), (350, 0), (355, 1), (360, 1), (365, 1), (370, 1), (375, 1), (380, 1), (385, 1), (390, 1), (395, 0), (400, 1), (405, 0), (410, 0), (415, 0), (420, 0), (425, 1), (430, 1), (435, 0), (440, 1), (445, 1), (450, 1), (455, 1), (460, 1), (465, 1), (470, 1), (475, 1), (480, 1), (485, 1), (490, 0), (495, 0), (500, 0), (505, 0), (510, 0), (515, 0), (520, 0), (525, 0), (530, 0), (535, 1), (540, 0), (545, 0), (550, 1), (555, 1), (560, 1), (565, 0), (570, 0), (575, 0), (580, 1), (585, 1), (590, 1), (595, 1), (600, 1), (605, 1), (610, 0), (615, 0), (620, 0), (625, 0), (630, 1), (635, 0), (640, 0), (645, 1), (650, 0), (655, 1), (660, 0), (665, 0), (670, 1), (675, 1), (680, 1), (685, 1), (690, 1), (695, 1), (700, 1), (705, 0), (710, 0), (715, 0), (720, 0), (725, 0), (730, 0), (735, 0), (740, 0), (745, 0), (750, 0), (755, 1), (760, 1), (765, 1), (770, 0), (775, 1), (780, 1), (785, 1), (790, 1), (795, 1), (800, 1), (805, 0), (810, 0), (815, 0), (820, 0), (825, 0), (830, 0), (835, 1), (840, 1), (845, 1), (850, 1), (855, 1), (860, 1), (865, 1), (870, 1), (875, 0), (880, 0), (885, 1), (890, 0), (895, 0), (900, 1), (905, 1), (910, 0), (915, 0), (920, 1), (925, 1), (930, 0), (935, 0), (940, 0), (945, 0), (950, 1), (955, 0), (960, 1), (965, 1), (970, 1), (975, 1), (980, 0), (985, 1), (990, 0), (995, 1), (1000, 0), (1005, 1), (1010, 0), (1015, 1), (1020, 1), (1025, 1)]
Va0_3  a0_3  0 PWL (0n 0.0v 4.745n 0.0v 4.755n 1.1v 9.745n 1.1v 9.755n 1.1v 14.745n 1.1v 14.755n 0.0v 19.745n 0.0v 19.755n 0.0v 24.745n 0.0v 24.755n 0.0v 29.745n 0.0v 29.755n 0.0v 34.745n 0.0v 34.755n 0.0v 39.745n 0.0v 39.755n 0.0v 44.745n 0.0v 44.755n 0.0v 49.745n 0.0v 49.755n 0.0v 54.745n 0.0v 54.755n 0.0v 59.745n 0.0v 59.755n 0.0v 64.745n 0.0v 64.755n 1.1v 69.745n 1.1v 69.755n 0.0v 74.745n 0.0v 74.755n 0.0v 79.745n 0.0v 79.755n 0.0v 84.745n 0.0v 84.755n 1.1v 89.745n 1.1v 89.755n 1.1v 94.745n 1.1v 94.755n 1.1v 99.745n 1.1v 99.755n 0.0v 104.745n 0.0v 104.755n 0.0v 109.745n 0.0v 109.755n 0.0v 114.745n 0.0v 114.755n 0.0v 119.745n 0.0v 119.755n 0.0v 124.745n 0.0v 124.755n 0.0v 129.745n 0.0v 129.755n 0.0v 134.745n 0.0v 134.755n 0.0v 139.745n 0.0v 139.755n 0.0v 144.745n 0.0v 144.755n 1.1v 149.745n 1.1v 149.755n 1.1v 154.745n 1.1v 154.755n 0.0v 159.745n 0.0v 159.755n 0.0v 164.745n 0.0v 164.755n 0.0v 169.745n 0.0v 169.755n 1.1v 174.745n 1.1v 174.755n 0.0v 179.745n 0.0v 179.755n 0.0v 184.745n 0.0v 184.755n 0.0v 189.745n 0.0v 189.755n 0.0v 194.745n 0.0v 194.755n 0.0v 199.745n 0.0v 199.755n 0.0v 204.745n 0.0v 204.755n 0.0v 209.745n 0.0v 209.755n 1.1v 214.745n 1.1v 214.755n 1.1v 219.745n 1.1v 219.755n 0.0v 224.745n 0.0v 224.755n 0.0v 229.745n 0.0v 229.755n 1.1v 234.745n 1.1v 234.755n 1.1v 239.745n 1.1v 239.755n 0.0v 244.745n 0.0v 244.755n 1.1v 249.745n 1.1v 249.755n 1.1v 254.745n 1.1v 254.755n 1.1v 259.745n 1.1v 259.755n 0.0v 264.745n 0.0v 264.755n 0.0v 269.745n 0.0v 269.755n 1.1v 274.745n 1.1v 274.755n 0.0v 279.745n 0.0v 279.755n 0.0v 284.745n 0.0v 284.755n 0.0v 289.745n 0.0v 289.755n 0.0v 294.745n 0.0v 294.755n 0.0v 299.745n 0.0v 299.755n 1.1v 304.745n 1.1v 304.755n 1.1v 309.745n 1.1v 309.755n 0.0v 314.745n 0.0v 314.755n 0.0v 319.745n 0.0v 319.755n 1.1v 324.745n 1.1v 324.755n 1.1v 329.745n 1.1v 329.755n 1.1v 334.745n 1.1v 334.755n 0.0v 339.745n 0.0v 339.755n 0.0v 344.745n 0.0v 344.755n 0.0v 349.745n 0.0v 349.755n 0.0v 354.745n 0.0v 354.755n 1.1v 359.745n 1.1v 359.755n 1.1v 364.745n 1.1v 364.755n 1.1v 369.745n 1.1v 369.755n 1.1v 374.745n 1.1v 374.755n 1.1v 379.745n 1.1v 379.755n 1.1v 384.745n 1.1v 384.755n 1.1v 389.745n 1.1v 389.755n 1.1v 394.745n 1.1v 394.755n 0.0v 399.745n 0.0v 399.755n 1.1v 404.745n 1.1v 404.755n 0.0v 409.745n 0.0v 409.755n 0.0v 414.745n 0.0v 414.755n 0.0v 419.745n 0.0v 419.755n 0.0v 424.745n 0.0v 424.755n 1.1v 429.745n 1.1v 429.755n 1.1v 434.745n 1.1v 434.755n 0.0v 439.745n 0.0v 439.755n 1.1v 444.745n 1.1v 444.755n 1.1v 449.745n 1.1v 449.755n 1.1v 454.745n 1.1v 454.755n 1.1v 459.745n 1.1v 459.755n 1.1v 464.745n 1.1v 464.755n 1.1v 469.745n 1.1v 469.755n 1.1v 474.745n 1.1v 474.755n 1.1v 479.745n 1.1v 479.755n 1.1v 484.745n 1.1v 484.755n 1.1v 489.745n 1.1v 489.755n 0.0v 494.745n 0.0v 494.755n 0.0v 499.745n 0.0v 499.755n 0.0v 504.745n 0.0v 504.755n 0.0v 509.745n 0.0v 509.755n 0.0v 514.745n 0.0v 514.755n 0.0v 519.745n 0.0v 519.755n 0.0v 524.745n 0.0v 524.755n 0.0v 529.745n 0.0v 529.755n 0.0v 534.745n 0.0v 534.755n 1.1v 539.745n 1.1v 539.755n 0.0v 544.745n 0.0v 544.755n 0.0v 549.745n 0.0v 549.755n 1.1v 554.745n 1.1v 554.755n 1.1v 559.745n 1.1v 559.755n 1.1v 564.745n 1.1v 564.755n 0.0v 569.745n 0.0v 569.755n 0.0v 574.745n 0.0v 574.755n 0.0v 579.745n 0.0v 579.755n 1.1v 584.745n 1.1v 584.755n 1.1v 589.745n 1.1v 589.755n 1.1v 594.745n 1.1v 594.755n 1.1v 599.745n 1.1v 599.755n 1.1v 604.745n 1.1v 604.755n 1.1v 609.745n 1.1v 609.755n 0.0v 614.745n 0.0v 614.755n 0.0v 619.745n 0.0v 619.755n 0.0v 624.745n 0.0v 624.755n 0.0v 629.745n 0.0v 629.755n 1.1v 634.745n 1.1v 634.755n 0.0v 639.745n 0.0v 639.755n 0.0v 644.745n 0.0v 644.755n 1.1v 649.745n 1.1v 649.755n 0.0v 654.745n 0.0v 654.755n 1.1v 659.745n 1.1v 659.755n 0.0v 664.745n 0.0v 664.755n 0.0v 669.745n 0.0v 669.755n 1.1v 674.745n 1.1v 674.755n 1.1v 679.745n 1.1v 679.755n 1.1v 684.745n 1.1v 684.755n 1.1v 689.745n 1.1v 689.755n 1.1v 694.745n 1.1v 694.755n 1.1v 699.745n 1.1v 699.755n 1.1v 704.745n 1.1v 704.755n 0.0v 709.745n 0.0v 709.755n 0.0v 714.745n 0.0v 714.755n 0.0v 719.745n 0.0v 719.755n 0.0v 724.745n 0.0v 724.755n 0.0v 729.745n 0.0v 729.755n 0.0v 734.745n 0.0v 734.755n 0.0v 739.745n 0.0v 739.755n 0.0v 744.745n 0.0v 744.755n 0.0v 749.745n 0.0v 749.755n 0.0v 754.745n 0.0v 754.755n 1.1v 759.745n 1.1v 759.755n 1.1v 764.745n 1.1v 764.755n 1.1v 769.745n 1.1v 769.755n 0.0v 774.745n 0.0v 774.755n 1.1v 779.745n 1.1v 779.755n 1.1v 784.745n 1.1v 784.755n 1.1v 789.745n 1.1v 789.755n 1.1v 794.745n 1.1v 794.755n 1.1v 799.745n 1.1v 799.755n 1.1v 804.745n 1.1v 804.755n 0.0v 809.745n 0.0v 809.755n 0.0v 814.745n 0.0v 814.755n 0.0v 819.745n 0.0v 819.755n 0.0v 824.745n 0.0v 824.755n 0.0v 829.745n 0.0v 829.755n 0.0v 834.745n 0.0v 834.755n 1.1v 839.745n 1.1v 839.755n 1.1v 844.745n 1.1v 844.755n 1.1v 849.745n 1.1v 849.755n 1.1v 854.745n 1.1v 854.755n 1.1v 859.745n 1.1v 859.755n 1.1v 864.745n 1.1v 864.755n 1.1v 869.745n 1.1v 869.755n 1.1v 874.745n 1.1v 874.755n 0.0v 879.745n 0.0v 879.755n 0.0v 884.745n 0.0v 884.755n 1.1v 889.745n 1.1v 889.755n 0.0v 894.745n 0.0v 894.755n 0.0v 899.745n 0.0v 899.755n 1.1v 904.745n 1.1v 904.755n 1.1v 909.745n 1.1v 909.755n 0.0v 914.745n 0.0v 914.755n 0.0v 919.745n 0.0v 919.755n 1.1v 924.745n 1.1v 924.755n 1.1v 929.745n 1.1v 929.755n 0.0v 934.745n 0.0v 934.755n 0.0v 939.745n 0.0v 939.755n 0.0v 944.745n 0.0v 944.755n 0.0v 949.745n 0.0v 949.755n 1.1v 954.745n 1.1v 954.755n 0.0v 959.745n 0.0v 959.755n 1.1v 964.745n 1.1v 964.755n 1.1v 969.745n 1.1v 969.755n 1.1v 974.745n 1.1v 974.755n 1.1v 979.745n 1.1v 979.755n 0.0v 984.745n 0.0v 984.755n 1.1v 989.745n 1.1v 989.755n 0.0v 994.745n 0.0v 994.755n 1.1v 999.745n 1.1v 999.755n 0.0v 1004.745n 0.0v 1004.755n 1.1v 1009.745n 1.1v 1009.755n 0.0v 1014.745n 0.0v 1014.755n 1.1v 1019.745n 1.1v 1019.755n 1.1v 1024.745n 1.1v 1024.755n 1.1v )
* (time, data): [(0, 0), (5, 1), (10, 1), (15, 0), (20, 0), (25, 0), (30, 0), (35, 0), (40, 0), (45, 0), (50, 0), (55, 0), (60, 0), (65, 1), (70, 0), (75, 0), (80, 0), (85, 1), (90, 1), (95, 1), (100, 0), (105, 0), (110, 0), (115, 0), (120, 0), (125, 0), (130, 0), (135, 0), (140, 0), (145, 1), (150, 1), (155, 0), (160, 0), (165, 0), (170, 1), (175, 0), (180, 0), (185, 0), (190, 0), (195, 0), (200, 0), (205, 0), (210, 1), (215, 1), (220, 0), (225, 0), (230, 1), (235, 1), (240, 0), (245, 1), (250, 1), (255, 1), (260, 0), (265, 0), (270, 1), (275, 0), (280, 0), (285, 0), (290, 0), (295, 0), (300, 1), (305, 1), (310, 0), (315, 0), (320, 1), (325, 1), (330, 1), (335, 0), (340, 0), (345, 0), (350, 0), (355, 1), (360, 1), (365, 1), (370, 1), (375, 1), (380, 1), (385, 1), (390, 1), (395, 0), (400, 1), (405, 0), (410, 0), (415, 0), (420, 0), (425, 1), (430, 1), (435, 0), (440, 1), (445, 1), (450, 1), (455, 1), (460, 1), (465, 1), (470, 1), (475, 1), (480, 1), (485, 1), (490, 0), (495, 0), (500, 0), (505, 0), (510, 0), (515, 0), (520, 0), (525, 0), (530, 0), (535, 1), (540, 0), (545, 0), (550, 1), (555, 1), (560, 1), (565, 0), (570, 0), (575, 0), (580, 1), (585, 1), (590, 1), (595, 1), (600, 1), (605, 1), (610, 0), (615, 0), (620, 0), (625, 0), (630, 1), (635, 0), (640, 0), (645, 1), (650, 0), (655, 1), (660, 0), (665, 0), (670, 1), (675, 1), (680, 1), (685, 1), (690, 1), (695, 1), (700, 1), (705, 0), (710, 0), (715, 0), (720, 0), (725, 0), (730, 0), (735, 0), (740, 0), (745, 0), (750, 0), (755, 1), (760, 1), (765, 1), (770, 0), (775, 1), (780, 1), (785, 1), (790, 1), (795, 1), (800, 1), (805, 0), (810, 0), (815, 0), (820, 0), (825, 0), (830, 0), (835, 1), (840, 1), (845, 1), (850, 1), (855, 1), (860, 1), (865, 1), (870, 1), (875, 0), (880, 0), (885, 1), (890, 0), (895, 0), (900, 1), (905, 1), (910, 0), (915, 0), (920, 1), (925, 1), (930, 0), (935, 0), (940, 0), (945, 0), (950, 1), (955, 0), (960, 1), (965, 1), (970, 1), (975, 1), (980, 0), (985, 1), (990, 0), (995, 1), (1000, 0), (1005, 1), (1010, 0), (1015, 1), (1020, 1), (1025, 1)]
Va0_4  a0_4  0 PWL (0n 0.0v 4.745n 0.0v 4.755n 1.1v 9.745n 1.1v 9.755n 1.1v 14.745n 1.1v 14.755n 0.0v 19.745n 0.0v 19.755n 0.0v 24.745n 0.0v 24.755n 0.0v 29.745n 0.0v 29.755n 0.0v 34.745n 0.0v 34.755n 0.0v 39.745n 0.0v 39.755n 0.0v 44.745n 0.0v 44.755n 0.0v 49.745n 0.0v 49.755n 0.0v 54.745n 0.0v 54.755n 0.0v 59.745n 0.0v 59.755n 0.0v 64.745n 0.0v 64.755n 1.1v 69.745n 1.1v 69.755n 0.0v 74.745n 0.0v 74.755n 0.0v 79.745n 0.0v 79.755n 0.0v 84.745n 0.0v 84.755n 1.1v 89.745n 1.1v 89.755n 1.1v 94.745n 1.1v 94.755n 1.1v 99.745n 1.1v 99.755n 0.0v 104.745n 0.0v 104.755n 0.0v 109.745n 0.0v 109.755n 0.0v 114.745n 0.0v 114.755n 0.0v 119.745n 0.0v 119.755n 0.0v 124.745n 0.0v 124.755n 0.0v 129.745n 0.0v 129.755n 0.0v 134.745n 0.0v 134.755n 0.0v 139.745n 0.0v 139.755n 0.0v 144.745n 0.0v 144.755n 1.1v 149.745n 1.1v 149.755n 1.1v 154.745n 1.1v 154.755n 0.0v 159.745n 0.0v 159.755n 0.0v 164.745n 0.0v 164.755n 0.0v 169.745n 0.0v 169.755n 1.1v 174.745n 1.1v 174.755n 0.0v 179.745n 0.0v 179.755n 0.0v 184.745n 0.0v 184.755n 0.0v 189.745n 0.0v 189.755n 0.0v 194.745n 0.0v 194.755n 0.0v 199.745n 0.0v 199.755n 0.0v 204.745n 0.0v 204.755n 0.0v 209.745n 0.0v 209.755n 1.1v 214.745n 1.1v 214.755n 1.1v 219.745n 1.1v 219.755n 0.0v 224.745n 0.0v 224.755n 0.0v 229.745n 0.0v 229.755n 1.1v 234.745n 1.1v 234.755n 1.1v 239.745n 1.1v 239.755n 0.0v 244.745n 0.0v 244.755n 1.1v 249.745n 1.1v 249.755n 1.1v 254.745n 1.1v 254.755n 1.1v 259.745n 1.1v 259.755n 0.0v 264.745n 0.0v 264.755n 0.0v 269.745n 0.0v 269.755n 1.1v 274.745n 1.1v 274.755n 0.0v 279.745n 0.0v 279.755n 0.0v 284.745n 0.0v 284.755n 0.0v 289.745n 0.0v 289.755n 0.0v 294.745n 0.0v 294.755n 0.0v 299.745n 0.0v 299.755n 1.1v 304.745n 1.1v 304.755n 1.1v 309.745n 1.1v 309.755n 0.0v 314.745n 0.0v 314.755n 0.0v 319.745n 0.0v 319.755n 1.1v 324.745n 1.1v 324.755n 1.1v 329.745n 1.1v 329.755n 1.1v 334.745n 1.1v 334.755n 0.0v 339.745n 0.0v 339.755n 0.0v 344.745n 0.0v 344.755n 0.0v 349.745n 0.0v 349.755n 0.0v 354.745n 0.0v 354.755n 1.1v 359.745n 1.1v 359.755n 1.1v 364.745n 1.1v 364.755n 1.1v 369.745n 1.1v 369.755n 1.1v 374.745n 1.1v 374.755n 1.1v 379.745n 1.1v 379.755n 1.1v 384.745n 1.1v 384.755n 1.1v 389.745n 1.1v 389.755n 1.1v 394.745n 1.1v 394.755n 0.0v 399.745n 0.0v 399.755n 1.1v 404.745n 1.1v 404.755n 0.0v 409.745n 0.0v 409.755n 0.0v 414.745n 0.0v 414.755n 0.0v 419.745n 0.0v 419.755n 0.0v 424.745n 0.0v 424.755n 1.1v 429.745n 1.1v 429.755n 1.1v 434.745n 1.1v 434.755n 0.0v 439.745n 0.0v 439.755n 1.1v 444.745n 1.1v 444.755n 1.1v 449.745n 1.1v 449.755n 1.1v 454.745n 1.1v 454.755n 1.1v 459.745n 1.1v 459.755n 1.1v 464.745n 1.1v 464.755n 1.1v 469.745n 1.1v 469.755n 1.1v 474.745n 1.1v 474.755n 1.1v 479.745n 1.1v 479.755n 1.1v 484.745n 1.1v 484.755n 1.1v 489.745n 1.1v 489.755n 0.0v 494.745n 0.0v 494.755n 0.0v 499.745n 0.0v 499.755n 0.0v 504.745n 0.0v 504.755n 0.0v 509.745n 0.0v 509.755n 0.0v 514.745n 0.0v 514.755n 0.0v 519.745n 0.0v 519.755n 0.0v 524.745n 0.0v 524.755n 0.0v 529.745n 0.0v 529.755n 0.0v 534.745n 0.0v 534.755n 1.1v 539.745n 1.1v 539.755n 0.0v 544.745n 0.0v 544.755n 0.0v 549.745n 0.0v 549.755n 1.1v 554.745n 1.1v 554.755n 1.1v 559.745n 1.1v 559.755n 1.1v 564.745n 1.1v 564.755n 0.0v 569.745n 0.0v 569.755n 0.0v 574.745n 0.0v 574.755n 0.0v 579.745n 0.0v 579.755n 1.1v 584.745n 1.1v 584.755n 1.1v 589.745n 1.1v 589.755n 1.1v 594.745n 1.1v 594.755n 1.1v 599.745n 1.1v 599.755n 1.1v 604.745n 1.1v 604.755n 1.1v 609.745n 1.1v 609.755n 0.0v 614.745n 0.0v 614.755n 0.0v 619.745n 0.0v 619.755n 0.0v 624.745n 0.0v 624.755n 0.0v 629.745n 0.0v 629.755n 1.1v 634.745n 1.1v 634.755n 0.0v 639.745n 0.0v 639.755n 0.0v 644.745n 0.0v 644.755n 1.1v 649.745n 1.1v 649.755n 0.0v 654.745n 0.0v 654.755n 1.1v 659.745n 1.1v 659.755n 0.0v 664.745n 0.0v 664.755n 0.0v 669.745n 0.0v 669.755n 1.1v 674.745n 1.1v 674.755n 1.1v 679.745n 1.1v 679.755n 1.1v 684.745n 1.1v 684.755n 1.1v 689.745n 1.1v 689.755n 1.1v 694.745n 1.1v 694.755n 1.1v 699.745n 1.1v 699.755n 1.1v 704.745n 1.1v 704.755n 0.0v 709.745n 0.0v 709.755n 0.0v 714.745n 0.0v 714.755n 0.0v 719.745n 0.0v 719.755n 0.0v 724.745n 0.0v 724.755n 0.0v 729.745n 0.0v 729.755n 0.0v 734.745n 0.0v 734.755n 0.0v 739.745n 0.0v 739.755n 0.0v 744.745n 0.0v 744.755n 0.0v 749.745n 0.0v 749.755n 0.0v 754.745n 0.0v 754.755n 1.1v 759.745n 1.1v 759.755n 1.1v 764.745n 1.1v 764.755n 1.1v 769.745n 1.1v 769.755n 0.0v 774.745n 0.0v 774.755n 1.1v 779.745n 1.1v 779.755n 1.1v 784.745n 1.1v 784.755n 1.1v 789.745n 1.1v 789.755n 1.1v 794.745n 1.1v 794.755n 1.1v 799.745n 1.1v 799.755n 1.1v 804.745n 1.1v 804.755n 0.0v 809.745n 0.0v 809.755n 0.0v 814.745n 0.0v 814.755n 0.0v 819.745n 0.0v 819.755n 0.0v 824.745n 0.0v 824.755n 0.0v 829.745n 0.0v 829.755n 0.0v 834.745n 0.0v 834.755n 1.1v 839.745n 1.1v 839.755n 1.1v 844.745n 1.1v 844.755n 1.1v 849.745n 1.1v 849.755n 1.1v 854.745n 1.1v 854.755n 1.1v 859.745n 1.1v 859.755n 1.1v 864.745n 1.1v 864.755n 1.1v 869.745n 1.1v 869.755n 1.1v 874.745n 1.1v 874.755n 0.0v 879.745n 0.0v 879.755n 0.0v 884.745n 0.0v 884.755n 1.1v 889.745n 1.1v 889.755n 0.0v 894.745n 0.0v 894.755n 0.0v 899.745n 0.0v 899.755n 1.1v 904.745n 1.1v 904.755n 1.1v 909.745n 1.1v 909.755n 0.0v 914.745n 0.0v 914.755n 0.0v 919.745n 0.0v 919.755n 1.1v 924.745n 1.1v 924.755n 1.1v 929.745n 1.1v 929.755n 0.0v 934.745n 0.0v 934.755n 0.0v 939.745n 0.0v 939.755n 0.0v 944.745n 0.0v 944.755n 0.0v 949.745n 0.0v 949.755n 1.1v 954.745n 1.1v 954.755n 0.0v 959.745n 0.0v 959.755n 1.1v 964.745n 1.1v 964.755n 1.1v 969.745n 1.1v 969.755n 1.1v 974.745n 1.1v 974.755n 1.1v 979.745n 1.1v 979.755n 0.0v 984.745n 0.0v 984.755n 1.1v 989.745n 1.1v 989.755n 0.0v 994.745n 0.0v 994.755n 1.1v 999.745n 1.1v 999.755n 0.0v 1004.745n 0.0v 1004.755n 1.1v 1009.745n 1.1v 1009.755n 0.0v 1014.745n 0.0v 1014.755n 1.1v 1019.745n 1.1v 1019.755n 1.1v 1024.745n 1.1v 1024.755n 1.1v )
* (time, data): [(0, 0), (5, 1), (10, 1), (15, 0), (20, 0), (25, 0), (30, 0), (35, 0), (40, 0), (45, 0), (50, 0), (55, 0), (60, 0), (65, 1), (70, 0), (75, 0), (80, 0), (85, 1), (90, 1), (95, 1), (100, 0), (105, 0), (110, 0), (115, 0), (120, 0), (125, 0), (130, 0), (135, 0), (140, 0), (145, 1), (150, 1), (155, 0), (160, 0), (165, 0), (170, 1), (175, 0), (180, 0), (185, 0), (190, 0), (195, 0), (200, 0), (205, 0), (210, 1), (215, 1), (220, 0), (225, 0), (230, 1), (235, 1), (240, 0), (245, 1), (250, 1), (255, 1), (260, 0), (265, 0), (270, 1), (275, 0), (280, 0), (285, 0), (290, 0), (295, 0), (300, 1), (305, 1), (310, 0), (315, 0), (320, 1), (325, 1), (330, 1), (335, 0), (340, 0), (345, 0), (350, 0), (355, 1), (360, 1), (365, 1), (370, 1), (375, 1), (380, 1), (385, 1), (390, 1), (395, 0), (400, 1), (405, 0), (410, 0), (415, 0), (420, 0), (425, 1), (430, 1), (435, 0), (440, 1), (445, 1), (450, 1), (455, 1), (460, 1), (465, 1), (470, 1), (475, 1), (480, 1), (485, 1), (490, 0), (495, 0), (500, 0), (505, 0), (510, 0), (515, 0), (520, 0), (525, 0), (530, 0), (535, 1), (540, 0), (545, 0), (550, 1), (555, 1), (560, 1), (565, 0), (570, 0), (575, 0), (580, 1), (585, 1), (590, 1), (595, 1), (600, 1), (605, 1), (610, 0), (615, 0), (620, 0), (625, 0), (630, 1), (635, 0), (640, 0), (645, 1), (650, 0), (655, 1), (660, 0), (665, 0), (670, 1), (675, 1), (680, 1), (685, 1), (690, 1), (695, 1), (700, 1), (705, 0), (710, 0), (715, 0), (720, 0), (725, 0), (730, 0), (735, 0), (740, 0), (745, 0), (750, 0), (755, 1), (760, 1), (765, 1), (770, 0), (775, 1), (780, 1), (785, 1), (790, 1), (795, 1), (800, 1), (805, 0), (810, 0), (815, 0), (820, 0), (825, 0), (830, 0), (835, 1), (840, 1), (845, 1), (850, 1), (855, 1), (860, 1), (865, 1), (870, 1), (875, 0), (880, 0), (885, 1), (890, 0), (895, 0), (900, 1), (905, 1), (910, 0), (915, 0), (920, 1), (925, 1), (930, 0), (935, 0), (940, 0), (945, 0), (950, 1), (955, 0), (960, 1), (965, 1), (970, 1), (975, 1), (980, 0), (985, 1), (990, 0), (995, 1), (1000, 0), (1005, 1), (1010, 0), (1015, 1), (1020, 1), (1025, 1)]
Va0_5  a0_5  0 PWL (0n 0.0v 4.745n 0.0v 4.755n 1.1v 9.745n 1.1v 9.755n 1.1v 14.745n 1.1v 14.755n 0.0v 19.745n 0.0v 19.755n 0.0v 24.745n 0.0v 24.755n 0.0v 29.745n 0.0v 29.755n 0.0v 34.745n 0.0v 34.755n 0.0v 39.745n 0.0v 39.755n 0.0v 44.745n 0.0v 44.755n 0.0v 49.745n 0.0v 49.755n 0.0v 54.745n 0.0v 54.755n 0.0v 59.745n 0.0v 59.755n 0.0v 64.745n 0.0v 64.755n 1.1v 69.745n 1.1v 69.755n 0.0v 74.745n 0.0v 74.755n 0.0v 79.745n 0.0v 79.755n 0.0v 84.745n 0.0v 84.755n 1.1v 89.745n 1.1v 89.755n 1.1v 94.745n 1.1v 94.755n 1.1v 99.745n 1.1v 99.755n 0.0v 104.745n 0.0v 104.755n 0.0v 109.745n 0.0v 109.755n 0.0v 114.745n 0.0v 114.755n 0.0v 119.745n 0.0v 119.755n 0.0v 124.745n 0.0v 124.755n 0.0v 129.745n 0.0v 129.755n 0.0v 134.745n 0.0v 134.755n 0.0v 139.745n 0.0v 139.755n 0.0v 144.745n 0.0v 144.755n 1.1v 149.745n 1.1v 149.755n 1.1v 154.745n 1.1v 154.755n 0.0v 159.745n 0.0v 159.755n 0.0v 164.745n 0.0v 164.755n 0.0v 169.745n 0.0v 169.755n 1.1v 174.745n 1.1v 174.755n 0.0v 179.745n 0.0v 179.755n 0.0v 184.745n 0.0v 184.755n 0.0v 189.745n 0.0v 189.755n 0.0v 194.745n 0.0v 194.755n 0.0v 199.745n 0.0v 199.755n 0.0v 204.745n 0.0v 204.755n 0.0v 209.745n 0.0v 209.755n 1.1v 214.745n 1.1v 214.755n 1.1v 219.745n 1.1v 219.755n 0.0v 224.745n 0.0v 224.755n 0.0v 229.745n 0.0v 229.755n 1.1v 234.745n 1.1v 234.755n 1.1v 239.745n 1.1v 239.755n 0.0v 244.745n 0.0v 244.755n 1.1v 249.745n 1.1v 249.755n 1.1v 254.745n 1.1v 254.755n 1.1v 259.745n 1.1v 259.755n 0.0v 264.745n 0.0v 264.755n 0.0v 269.745n 0.0v 269.755n 1.1v 274.745n 1.1v 274.755n 0.0v 279.745n 0.0v 279.755n 0.0v 284.745n 0.0v 284.755n 0.0v 289.745n 0.0v 289.755n 0.0v 294.745n 0.0v 294.755n 0.0v 299.745n 0.0v 299.755n 1.1v 304.745n 1.1v 304.755n 1.1v 309.745n 1.1v 309.755n 0.0v 314.745n 0.0v 314.755n 0.0v 319.745n 0.0v 319.755n 1.1v 324.745n 1.1v 324.755n 1.1v 329.745n 1.1v 329.755n 1.1v 334.745n 1.1v 334.755n 0.0v 339.745n 0.0v 339.755n 0.0v 344.745n 0.0v 344.755n 0.0v 349.745n 0.0v 349.755n 0.0v 354.745n 0.0v 354.755n 1.1v 359.745n 1.1v 359.755n 1.1v 364.745n 1.1v 364.755n 1.1v 369.745n 1.1v 369.755n 1.1v 374.745n 1.1v 374.755n 1.1v 379.745n 1.1v 379.755n 1.1v 384.745n 1.1v 384.755n 1.1v 389.745n 1.1v 389.755n 1.1v 394.745n 1.1v 394.755n 0.0v 399.745n 0.0v 399.755n 1.1v 404.745n 1.1v 404.755n 0.0v 409.745n 0.0v 409.755n 0.0v 414.745n 0.0v 414.755n 0.0v 419.745n 0.0v 419.755n 0.0v 424.745n 0.0v 424.755n 1.1v 429.745n 1.1v 429.755n 1.1v 434.745n 1.1v 434.755n 0.0v 439.745n 0.0v 439.755n 1.1v 444.745n 1.1v 444.755n 1.1v 449.745n 1.1v 449.755n 1.1v 454.745n 1.1v 454.755n 1.1v 459.745n 1.1v 459.755n 1.1v 464.745n 1.1v 464.755n 1.1v 469.745n 1.1v 469.755n 1.1v 474.745n 1.1v 474.755n 1.1v 479.745n 1.1v 479.755n 1.1v 484.745n 1.1v 484.755n 1.1v 489.745n 1.1v 489.755n 0.0v 494.745n 0.0v 494.755n 0.0v 499.745n 0.0v 499.755n 0.0v 504.745n 0.0v 504.755n 0.0v 509.745n 0.0v 509.755n 0.0v 514.745n 0.0v 514.755n 0.0v 519.745n 0.0v 519.755n 0.0v 524.745n 0.0v 524.755n 0.0v 529.745n 0.0v 529.755n 0.0v 534.745n 0.0v 534.755n 1.1v 539.745n 1.1v 539.755n 0.0v 544.745n 0.0v 544.755n 0.0v 549.745n 0.0v 549.755n 1.1v 554.745n 1.1v 554.755n 1.1v 559.745n 1.1v 559.755n 1.1v 564.745n 1.1v 564.755n 0.0v 569.745n 0.0v 569.755n 0.0v 574.745n 0.0v 574.755n 0.0v 579.745n 0.0v 579.755n 1.1v 584.745n 1.1v 584.755n 1.1v 589.745n 1.1v 589.755n 1.1v 594.745n 1.1v 594.755n 1.1v 599.745n 1.1v 599.755n 1.1v 604.745n 1.1v 604.755n 1.1v 609.745n 1.1v 609.755n 0.0v 614.745n 0.0v 614.755n 0.0v 619.745n 0.0v 619.755n 0.0v 624.745n 0.0v 624.755n 0.0v 629.745n 0.0v 629.755n 1.1v 634.745n 1.1v 634.755n 0.0v 639.745n 0.0v 639.755n 0.0v 644.745n 0.0v 644.755n 1.1v 649.745n 1.1v 649.755n 0.0v 654.745n 0.0v 654.755n 1.1v 659.745n 1.1v 659.755n 0.0v 664.745n 0.0v 664.755n 0.0v 669.745n 0.0v 669.755n 1.1v 674.745n 1.1v 674.755n 1.1v 679.745n 1.1v 679.755n 1.1v 684.745n 1.1v 684.755n 1.1v 689.745n 1.1v 689.755n 1.1v 694.745n 1.1v 694.755n 1.1v 699.745n 1.1v 699.755n 1.1v 704.745n 1.1v 704.755n 0.0v 709.745n 0.0v 709.755n 0.0v 714.745n 0.0v 714.755n 0.0v 719.745n 0.0v 719.755n 0.0v 724.745n 0.0v 724.755n 0.0v 729.745n 0.0v 729.755n 0.0v 734.745n 0.0v 734.755n 0.0v 739.745n 0.0v 739.755n 0.0v 744.745n 0.0v 744.755n 0.0v 749.745n 0.0v 749.755n 0.0v 754.745n 0.0v 754.755n 1.1v 759.745n 1.1v 759.755n 1.1v 764.745n 1.1v 764.755n 1.1v 769.745n 1.1v 769.755n 0.0v 774.745n 0.0v 774.755n 1.1v 779.745n 1.1v 779.755n 1.1v 784.745n 1.1v 784.755n 1.1v 789.745n 1.1v 789.755n 1.1v 794.745n 1.1v 794.755n 1.1v 799.745n 1.1v 799.755n 1.1v 804.745n 1.1v 804.755n 0.0v 809.745n 0.0v 809.755n 0.0v 814.745n 0.0v 814.755n 0.0v 819.745n 0.0v 819.755n 0.0v 824.745n 0.0v 824.755n 0.0v 829.745n 0.0v 829.755n 0.0v 834.745n 0.0v 834.755n 1.1v 839.745n 1.1v 839.755n 1.1v 844.745n 1.1v 844.755n 1.1v 849.745n 1.1v 849.755n 1.1v 854.745n 1.1v 854.755n 1.1v 859.745n 1.1v 859.755n 1.1v 864.745n 1.1v 864.755n 1.1v 869.745n 1.1v 869.755n 1.1v 874.745n 1.1v 874.755n 0.0v 879.745n 0.0v 879.755n 0.0v 884.745n 0.0v 884.755n 1.1v 889.745n 1.1v 889.755n 0.0v 894.745n 0.0v 894.755n 0.0v 899.745n 0.0v 899.755n 1.1v 904.745n 1.1v 904.755n 1.1v 909.745n 1.1v 909.755n 0.0v 914.745n 0.0v 914.755n 0.0v 919.745n 0.0v 919.755n 1.1v 924.745n 1.1v 924.755n 1.1v 929.745n 1.1v 929.755n 0.0v 934.745n 0.0v 934.755n 0.0v 939.745n 0.0v 939.755n 0.0v 944.745n 0.0v 944.755n 0.0v 949.745n 0.0v 949.755n 1.1v 954.745n 1.1v 954.755n 0.0v 959.745n 0.0v 959.755n 1.1v 964.745n 1.1v 964.755n 1.1v 969.745n 1.1v 969.755n 1.1v 974.745n 1.1v 974.755n 1.1v 979.745n 1.1v 979.755n 0.0v 984.745n 0.0v 984.755n 1.1v 989.745n 1.1v 989.755n 0.0v 994.745n 0.0v 994.755n 1.1v 999.745n 1.1v 999.755n 0.0v 1004.745n 0.0v 1004.755n 1.1v 1009.745n 1.1v 1009.755n 0.0v 1014.745n 0.0v 1014.755n 1.1v 1019.745n 1.1v 1019.755n 1.1v 1024.745n 1.1v 1024.755n 1.1v )
* (time, data): [(0, 0), (5, 1), (10, 1), (15, 0), (20, 0), (25, 0), (30, 0), (35, 0), (40, 0), (45, 0), (50, 0), (55, 0), (60, 0), (65, 1), (70, 0), (75, 0), (80, 0), (85, 1), (90, 1), (95, 1), (100, 0), (105, 0), (110, 0), (115, 0), (120, 0), (125, 0), (130, 0), (135, 0), (140, 0), (145, 1), (150, 1), (155, 0), (160, 0), (165, 0), (170, 1), (175, 0), (180, 0), (185, 0), (190, 0), (195, 0), (200, 0), (205, 0), (210, 1), (215, 1), (220, 0), (225, 0), (230, 1), (235, 1), (240, 0), (245, 1), (250, 1), (255, 1), (260, 0), (265, 0), (270, 1), (275, 0), (280, 0), (285, 0), (290, 0), (295, 0), (300, 1), (305, 1), (310, 0), (315, 0), (320, 1), (325, 1), (330, 1), (335, 0), (340, 0), (345, 0), (350, 0), (355, 1), (360, 1), (365, 1), (370, 1), (375, 1), (380, 1), (385, 1), (390, 1), (395, 0), (400, 1), (405, 0), (410, 0), (415, 0), (420, 0), (425, 1), (430, 1), (435, 0), (440, 1), (445, 1), (450, 1), (455, 1), (460, 1), (465, 1), (470, 1), (475, 1), (480, 1), (485, 1), (490, 0), (495, 0), (500, 0), (505, 0), (510, 0), (515, 0), (520, 0), (525, 0), (530, 0), (535, 1), (540, 0), (545, 0), (550, 1), (555, 1), (560, 1), (565, 0), (570, 0), (575, 0), (580, 1), (585, 1), (590, 1), (595, 1), (600, 1), (605, 1), (610, 0), (615, 0), (620, 0), (625, 0), (630, 1), (635, 0), (640, 0), (645, 1), (650, 0), (655, 1), (660, 0), (665, 0), (670, 1), (675, 1), (680, 1), (685, 1), (690, 1), (695, 1), (700, 1), (705, 0), (710, 0), (715, 0), (720, 0), (725, 0), (730, 0), (735, 0), (740, 0), (745, 0), (750, 0), (755, 1), (760, 1), (765, 1), (770, 0), (775, 1), (780, 1), (785, 1), (790, 1), (795, 1), (800, 1), (805, 0), (810, 0), (815, 0), (820, 0), (825, 0), (830, 0), (835, 1), (840, 1), (845, 1), (850, 1), (855, 1), (860, 1), (865, 1), (870, 1), (875, 0), (880, 0), (885, 1), (890, 0), (895, 0), (900, 1), (905, 1), (910, 0), (915, 0), (920, 1), (925, 1), (930, 0), (935, 0), (940, 0), (945, 0), (950, 1), (955, 0), (960, 1), (965, 1), (970, 1), (975, 1), (980, 0), (985, 1), (990, 0), (995, 1), (1000, 0), (1005, 1), (1010, 0), (1015, 1), (1020, 1), (1025, 1)]
Va0_6  a0_6  0 PWL (0n 0.0v 4.745n 0.0v 4.755n 1.1v 9.745n 1.1v 9.755n 1.1v 14.745n 1.1v 14.755n 0.0v 19.745n 0.0v 19.755n 0.0v 24.745n 0.0v 24.755n 0.0v 29.745n 0.0v 29.755n 0.0v 34.745n 0.0v 34.755n 0.0v 39.745n 0.0v 39.755n 0.0v 44.745n 0.0v 44.755n 0.0v 49.745n 0.0v 49.755n 0.0v 54.745n 0.0v 54.755n 0.0v 59.745n 0.0v 59.755n 0.0v 64.745n 0.0v 64.755n 1.1v 69.745n 1.1v 69.755n 0.0v 74.745n 0.0v 74.755n 0.0v 79.745n 0.0v 79.755n 0.0v 84.745n 0.0v 84.755n 1.1v 89.745n 1.1v 89.755n 1.1v 94.745n 1.1v 94.755n 1.1v 99.745n 1.1v 99.755n 0.0v 104.745n 0.0v 104.755n 0.0v 109.745n 0.0v 109.755n 0.0v 114.745n 0.0v 114.755n 0.0v 119.745n 0.0v 119.755n 0.0v 124.745n 0.0v 124.755n 0.0v 129.745n 0.0v 129.755n 0.0v 134.745n 0.0v 134.755n 0.0v 139.745n 0.0v 139.755n 0.0v 144.745n 0.0v 144.755n 1.1v 149.745n 1.1v 149.755n 1.1v 154.745n 1.1v 154.755n 0.0v 159.745n 0.0v 159.755n 0.0v 164.745n 0.0v 164.755n 0.0v 169.745n 0.0v 169.755n 1.1v 174.745n 1.1v 174.755n 0.0v 179.745n 0.0v 179.755n 0.0v 184.745n 0.0v 184.755n 0.0v 189.745n 0.0v 189.755n 0.0v 194.745n 0.0v 194.755n 0.0v 199.745n 0.0v 199.755n 0.0v 204.745n 0.0v 204.755n 0.0v 209.745n 0.0v 209.755n 1.1v 214.745n 1.1v 214.755n 1.1v 219.745n 1.1v 219.755n 0.0v 224.745n 0.0v 224.755n 0.0v 229.745n 0.0v 229.755n 1.1v 234.745n 1.1v 234.755n 1.1v 239.745n 1.1v 239.755n 0.0v 244.745n 0.0v 244.755n 1.1v 249.745n 1.1v 249.755n 1.1v 254.745n 1.1v 254.755n 1.1v 259.745n 1.1v 259.755n 0.0v 264.745n 0.0v 264.755n 0.0v 269.745n 0.0v 269.755n 1.1v 274.745n 1.1v 274.755n 0.0v 279.745n 0.0v 279.755n 0.0v 284.745n 0.0v 284.755n 0.0v 289.745n 0.0v 289.755n 0.0v 294.745n 0.0v 294.755n 0.0v 299.745n 0.0v 299.755n 1.1v 304.745n 1.1v 304.755n 1.1v 309.745n 1.1v 309.755n 0.0v 314.745n 0.0v 314.755n 0.0v 319.745n 0.0v 319.755n 1.1v 324.745n 1.1v 324.755n 1.1v 329.745n 1.1v 329.755n 1.1v 334.745n 1.1v 334.755n 0.0v 339.745n 0.0v 339.755n 0.0v 344.745n 0.0v 344.755n 0.0v 349.745n 0.0v 349.755n 0.0v 354.745n 0.0v 354.755n 1.1v 359.745n 1.1v 359.755n 1.1v 364.745n 1.1v 364.755n 1.1v 369.745n 1.1v 369.755n 1.1v 374.745n 1.1v 374.755n 1.1v 379.745n 1.1v 379.755n 1.1v 384.745n 1.1v 384.755n 1.1v 389.745n 1.1v 389.755n 1.1v 394.745n 1.1v 394.755n 0.0v 399.745n 0.0v 399.755n 1.1v 404.745n 1.1v 404.755n 0.0v 409.745n 0.0v 409.755n 0.0v 414.745n 0.0v 414.755n 0.0v 419.745n 0.0v 419.755n 0.0v 424.745n 0.0v 424.755n 1.1v 429.745n 1.1v 429.755n 1.1v 434.745n 1.1v 434.755n 0.0v 439.745n 0.0v 439.755n 1.1v 444.745n 1.1v 444.755n 1.1v 449.745n 1.1v 449.755n 1.1v 454.745n 1.1v 454.755n 1.1v 459.745n 1.1v 459.755n 1.1v 464.745n 1.1v 464.755n 1.1v 469.745n 1.1v 469.755n 1.1v 474.745n 1.1v 474.755n 1.1v 479.745n 1.1v 479.755n 1.1v 484.745n 1.1v 484.755n 1.1v 489.745n 1.1v 489.755n 0.0v 494.745n 0.0v 494.755n 0.0v 499.745n 0.0v 499.755n 0.0v 504.745n 0.0v 504.755n 0.0v 509.745n 0.0v 509.755n 0.0v 514.745n 0.0v 514.755n 0.0v 519.745n 0.0v 519.755n 0.0v 524.745n 0.0v 524.755n 0.0v 529.745n 0.0v 529.755n 0.0v 534.745n 0.0v 534.755n 1.1v 539.745n 1.1v 539.755n 0.0v 544.745n 0.0v 544.755n 0.0v 549.745n 0.0v 549.755n 1.1v 554.745n 1.1v 554.755n 1.1v 559.745n 1.1v 559.755n 1.1v 564.745n 1.1v 564.755n 0.0v 569.745n 0.0v 569.755n 0.0v 574.745n 0.0v 574.755n 0.0v 579.745n 0.0v 579.755n 1.1v 584.745n 1.1v 584.755n 1.1v 589.745n 1.1v 589.755n 1.1v 594.745n 1.1v 594.755n 1.1v 599.745n 1.1v 599.755n 1.1v 604.745n 1.1v 604.755n 1.1v 609.745n 1.1v 609.755n 0.0v 614.745n 0.0v 614.755n 0.0v 619.745n 0.0v 619.755n 0.0v 624.745n 0.0v 624.755n 0.0v 629.745n 0.0v 629.755n 1.1v 634.745n 1.1v 634.755n 0.0v 639.745n 0.0v 639.755n 0.0v 644.745n 0.0v 644.755n 1.1v 649.745n 1.1v 649.755n 0.0v 654.745n 0.0v 654.755n 1.1v 659.745n 1.1v 659.755n 0.0v 664.745n 0.0v 664.755n 0.0v 669.745n 0.0v 669.755n 1.1v 674.745n 1.1v 674.755n 1.1v 679.745n 1.1v 679.755n 1.1v 684.745n 1.1v 684.755n 1.1v 689.745n 1.1v 689.755n 1.1v 694.745n 1.1v 694.755n 1.1v 699.745n 1.1v 699.755n 1.1v 704.745n 1.1v 704.755n 0.0v 709.745n 0.0v 709.755n 0.0v 714.745n 0.0v 714.755n 0.0v 719.745n 0.0v 719.755n 0.0v 724.745n 0.0v 724.755n 0.0v 729.745n 0.0v 729.755n 0.0v 734.745n 0.0v 734.755n 0.0v 739.745n 0.0v 739.755n 0.0v 744.745n 0.0v 744.755n 0.0v 749.745n 0.0v 749.755n 0.0v 754.745n 0.0v 754.755n 1.1v 759.745n 1.1v 759.755n 1.1v 764.745n 1.1v 764.755n 1.1v 769.745n 1.1v 769.755n 0.0v 774.745n 0.0v 774.755n 1.1v 779.745n 1.1v 779.755n 1.1v 784.745n 1.1v 784.755n 1.1v 789.745n 1.1v 789.755n 1.1v 794.745n 1.1v 794.755n 1.1v 799.745n 1.1v 799.755n 1.1v 804.745n 1.1v 804.755n 0.0v 809.745n 0.0v 809.755n 0.0v 814.745n 0.0v 814.755n 0.0v 819.745n 0.0v 819.755n 0.0v 824.745n 0.0v 824.755n 0.0v 829.745n 0.0v 829.755n 0.0v 834.745n 0.0v 834.755n 1.1v 839.745n 1.1v 839.755n 1.1v 844.745n 1.1v 844.755n 1.1v 849.745n 1.1v 849.755n 1.1v 854.745n 1.1v 854.755n 1.1v 859.745n 1.1v 859.755n 1.1v 864.745n 1.1v 864.755n 1.1v 869.745n 1.1v 869.755n 1.1v 874.745n 1.1v 874.755n 0.0v 879.745n 0.0v 879.755n 0.0v 884.745n 0.0v 884.755n 1.1v 889.745n 1.1v 889.755n 0.0v 894.745n 0.0v 894.755n 0.0v 899.745n 0.0v 899.755n 1.1v 904.745n 1.1v 904.755n 1.1v 909.745n 1.1v 909.755n 0.0v 914.745n 0.0v 914.755n 0.0v 919.745n 0.0v 919.755n 1.1v 924.745n 1.1v 924.755n 1.1v 929.745n 1.1v 929.755n 0.0v 934.745n 0.0v 934.755n 0.0v 939.745n 0.0v 939.755n 0.0v 944.745n 0.0v 944.755n 0.0v 949.745n 0.0v 949.755n 1.1v 954.745n 1.1v 954.755n 0.0v 959.745n 0.0v 959.755n 1.1v 964.745n 1.1v 964.755n 1.1v 969.745n 1.1v 969.755n 1.1v 974.745n 1.1v 974.755n 1.1v 979.745n 1.1v 979.755n 0.0v 984.745n 0.0v 984.755n 1.1v 989.745n 1.1v 989.755n 0.0v 994.745n 0.0v 994.755n 1.1v 999.745n 1.1v 999.755n 0.0v 1004.745n 0.0v 1004.755n 1.1v 1009.745n 1.1v 1009.755n 0.0v 1014.745n 0.0v 1014.755n 1.1v 1019.745n 1.1v 1019.755n 1.1v 1024.745n 1.1v 1024.755n 1.1v )
* (time, data): [(0, 0), (5, 1), (10, 1), (15, 0), (20, 0), (25, 0), (30, 0), (35, 0), (40, 0), (45, 0), (50, 0), (55, 0), (60, 0), (65, 1), (70, 0), (75, 0), (80, 0), (85, 1), (90, 1), (95, 1), (100, 0), (105, 0), (110, 0), (115, 0), (120, 0), (125, 0), (130, 0), (135, 0), (140, 0), (145, 1), (150, 1), (155, 0), (160, 0), (165, 0), (170, 1), (175, 0), (180, 0), (185, 0), (190, 0), (195, 0), (200, 0), (205, 0), (210, 1), (215, 1), (220, 0), (225, 0), (230, 1), (235, 1), (240, 0), (245, 1), (250, 1), (255, 1), (260, 0), (265, 0), (270, 1), (275, 0), (280, 0), (285, 0), (290, 0), (295, 0), (300, 1), (305, 1), (310, 0), (315, 0), (320, 1), (325, 1), (330, 1), (335, 0), (340, 0), (345, 0), (350, 0), (355, 1), (360, 1), (365, 1), (370, 1), (375, 1), (380, 1), (385, 1), (390, 1), (395, 0), (400, 1), (405, 0), (410, 0), (415, 0), (420, 0), (425, 1), (430, 1), (435, 0), (440, 1), (445, 1), (450, 1), (455, 1), (460, 1), (465, 1), (470, 1), (475, 1), (480, 1), (485, 1), (490, 0), (495, 0), (500, 0), (505, 0), (510, 0), (515, 0), (520, 0), (525, 0), (530, 0), (535, 1), (540, 0), (545, 0), (550, 1), (555, 1), (560, 1), (565, 0), (570, 0), (575, 0), (580, 1), (585, 1), (590, 1), (595, 1), (600, 1), (605, 1), (610, 0), (615, 0), (620, 0), (625, 0), (630, 1), (635, 0), (640, 0), (645, 1), (650, 0), (655, 1), (660, 0), (665, 0), (670, 1), (675, 1), (680, 1), (685, 1), (690, 1), (695, 1), (700, 1), (705, 0), (710, 0), (715, 0), (720, 0), (725, 0), (730, 0), (735, 0), (740, 0), (745, 0), (750, 0), (755, 1), (760, 1), (765, 1), (770, 0), (775, 1), (780, 1), (785, 1), (790, 1), (795, 1), (800, 1), (805, 0), (810, 0), (815, 0), (820, 0), (825, 0), (830, 0), (835, 1), (840, 1), (845, 1), (850, 1), (855, 1), (860, 1), (865, 1), (870, 1), (875, 0), (880, 0), (885, 1), (890, 0), (895, 0), (900, 1), (905, 1), (910, 0), (915, 0), (920, 1), (925, 1), (930, 0), (935, 0), (940, 0), (945, 0), (950, 1), (955, 0), (960, 1), (965, 1), (970, 1), (975, 1), (980, 0), (985, 1), (990, 0), (995, 1), (1000, 0), (1005, 1), (1010, 0), (1015, 1), (1020, 1), (1025, 1)]
Va0_7  a0_7  0 PWL (0n 0.0v 4.745n 0.0v 4.755n 1.1v 9.745n 1.1v 9.755n 1.1v 14.745n 1.1v 14.755n 0.0v 19.745n 0.0v 19.755n 0.0v 24.745n 0.0v 24.755n 0.0v 29.745n 0.0v 29.755n 0.0v 34.745n 0.0v 34.755n 0.0v 39.745n 0.0v 39.755n 0.0v 44.745n 0.0v 44.755n 0.0v 49.745n 0.0v 49.755n 0.0v 54.745n 0.0v 54.755n 0.0v 59.745n 0.0v 59.755n 0.0v 64.745n 0.0v 64.755n 1.1v 69.745n 1.1v 69.755n 0.0v 74.745n 0.0v 74.755n 0.0v 79.745n 0.0v 79.755n 0.0v 84.745n 0.0v 84.755n 1.1v 89.745n 1.1v 89.755n 1.1v 94.745n 1.1v 94.755n 1.1v 99.745n 1.1v 99.755n 0.0v 104.745n 0.0v 104.755n 0.0v 109.745n 0.0v 109.755n 0.0v 114.745n 0.0v 114.755n 0.0v 119.745n 0.0v 119.755n 0.0v 124.745n 0.0v 124.755n 0.0v 129.745n 0.0v 129.755n 0.0v 134.745n 0.0v 134.755n 0.0v 139.745n 0.0v 139.755n 0.0v 144.745n 0.0v 144.755n 1.1v 149.745n 1.1v 149.755n 1.1v 154.745n 1.1v 154.755n 0.0v 159.745n 0.0v 159.755n 0.0v 164.745n 0.0v 164.755n 0.0v 169.745n 0.0v 169.755n 1.1v 174.745n 1.1v 174.755n 0.0v 179.745n 0.0v 179.755n 0.0v 184.745n 0.0v 184.755n 0.0v 189.745n 0.0v 189.755n 0.0v 194.745n 0.0v 194.755n 0.0v 199.745n 0.0v 199.755n 0.0v 204.745n 0.0v 204.755n 0.0v 209.745n 0.0v 209.755n 1.1v 214.745n 1.1v 214.755n 1.1v 219.745n 1.1v 219.755n 0.0v 224.745n 0.0v 224.755n 0.0v 229.745n 0.0v 229.755n 1.1v 234.745n 1.1v 234.755n 1.1v 239.745n 1.1v 239.755n 0.0v 244.745n 0.0v 244.755n 1.1v 249.745n 1.1v 249.755n 1.1v 254.745n 1.1v 254.755n 1.1v 259.745n 1.1v 259.755n 0.0v 264.745n 0.0v 264.755n 0.0v 269.745n 0.0v 269.755n 1.1v 274.745n 1.1v 274.755n 0.0v 279.745n 0.0v 279.755n 0.0v 284.745n 0.0v 284.755n 0.0v 289.745n 0.0v 289.755n 0.0v 294.745n 0.0v 294.755n 0.0v 299.745n 0.0v 299.755n 1.1v 304.745n 1.1v 304.755n 1.1v 309.745n 1.1v 309.755n 0.0v 314.745n 0.0v 314.755n 0.0v 319.745n 0.0v 319.755n 1.1v 324.745n 1.1v 324.755n 1.1v 329.745n 1.1v 329.755n 1.1v 334.745n 1.1v 334.755n 0.0v 339.745n 0.0v 339.755n 0.0v 344.745n 0.0v 344.755n 0.0v 349.745n 0.0v 349.755n 0.0v 354.745n 0.0v 354.755n 1.1v 359.745n 1.1v 359.755n 1.1v 364.745n 1.1v 364.755n 1.1v 369.745n 1.1v 369.755n 1.1v 374.745n 1.1v 374.755n 1.1v 379.745n 1.1v 379.755n 1.1v 384.745n 1.1v 384.755n 1.1v 389.745n 1.1v 389.755n 1.1v 394.745n 1.1v 394.755n 0.0v 399.745n 0.0v 399.755n 1.1v 404.745n 1.1v 404.755n 0.0v 409.745n 0.0v 409.755n 0.0v 414.745n 0.0v 414.755n 0.0v 419.745n 0.0v 419.755n 0.0v 424.745n 0.0v 424.755n 1.1v 429.745n 1.1v 429.755n 1.1v 434.745n 1.1v 434.755n 0.0v 439.745n 0.0v 439.755n 1.1v 444.745n 1.1v 444.755n 1.1v 449.745n 1.1v 449.755n 1.1v 454.745n 1.1v 454.755n 1.1v 459.745n 1.1v 459.755n 1.1v 464.745n 1.1v 464.755n 1.1v 469.745n 1.1v 469.755n 1.1v 474.745n 1.1v 474.755n 1.1v 479.745n 1.1v 479.755n 1.1v 484.745n 1.1v 484.755n 1.1v 489.745n 1.1v 489.755n 0.0v 494.745n 0.0v 494.755n 0.0v 499.745n 0.0v 499.755n 0.0v 504.745n 0.0v 504.755n 0.0v 509.745n 0.0v 509.755n 0.0v 514.745n 0.0v 514.755n 0.0v 519.745n 0.0v 519.755n 0.0v 524.745n 0.0v 524.755n 0.0v 529.745n 0.0v 529.755n 0.0v 534.745n 0.0v 534.755n 1.1v 539.745n 1.1v 539.755n 0.0v 544.745n 0.0v 544.755n 0.0v 549.745n 0.0v 549.755n 1.1v 554.745n 1.1v 554.755n 1.1v 559.745n 1.1v 559.755n 1.1v 564.745n 1.1v 564.755n 0.0v 569.745n 0.0v 569.755n 0.0v 574.745n 0.0v 574.755n 0.0v 579.745n 0.0v 579.755n 1.1v 584.745n 1.1v 584.755n 1.1v 589.745n 1.1v 589.755n 1.1v 594.745n 1.1v 594.755n 1.1v 599.745n 1.1v 599.755n 1.1v 604.745n 1.1v 604.755n 1.1v 609.745n 1.1v 609.755n 0.0v 614.745n 0.0v 614.755n 0.0v 619.745n 0.0v 619.755n 0.0v 624.745n 0.0v 624.755n 0.0v 629.745n 0.0v 629.755n 1.1v 634.745n 1.1v 634.755n 0.0v 639.745n 0.0v 639.755n 0.0v 644.745n 0.0v 644.755n 1.1v 649.745n 1.1v 649.755n 0.0v 654.745n 0.0v 654.755n 1.1v 659.745n 1.1v 659.755n 0.0v 664.745n 0.0v 664.755n 0.0v 669.745n 0.0v 669.755n 1.1v 674.745n 1.1v 674.755n 1.1v 679.745n 1.1v 679.755n 1.1v 684.745n 1.1v 684.755n 1.1v 689.745n 1.1v 689.755n 1.1v 694.745n 1.1v 694.755n 1.1v 699.745n 1.1v 699.755n 1.1v 704.745n 1.1v 704.755n 0.0v 709.745n 0.0v 709.755n 0.0v 714.745n 0.0v 714.755n 0.0v 719.745n 0.0v 719.755n 0.0v 724.745n 0.0v 724.755n 0.0v 729.745n 0.0v 729.755n 0.0v 734.745n 0.0v 734.755n 0.0v 739.745n 0.0v 739.755n 0.0v 744.745n 0.0v 744.755n 0.0v 749.745n 0.0v 749.755n 0.0v 754.745n 0.0v 754.755n 1.1v 759.745n 1.1v 759.755n 1.1v 764.745n 1.1v 764.755n 1.1v 769.745n 1.1v 769.755n 0.0v 774.745n 0.0v 774.755n 1.1v 779.745n 1.1v 779.755n 1.1v 784.745n 1.1v 784.755n 1.1v 789.745n 1.1v 789.755n 1.1v 794.745n 1.1v 794.755n 1.1v 799.745n 1.1v 799.755n 1.1v 804.745n 1.1v 804.755n 0.0v 809.745n 0.0v 809.755n 0.0v 814.745n 0.0v 814.755n 0.0v 819.745n 0.0v 819.755n 0.0v 824.745n 0.0v 824.755n 0.0v 829.745n 0.0v 829.755n 0.0v 834.745n 0.0v 834.755n 1.1v 839.745n 1.1v 839.755n 1.1v 844.745n 1.1v 844.755n 1.1v 849.745n 1.1v 849.755n 1.1v 854.745n 1.1v 854.755n 1.1v 859.745n 1.1v 859.755n 1.1v 864.745n 1.1v 864.755n 1.1v 869.745n 1.1v 869.755n 1.1v 874.745n 1.1v 874.755n 0.0v 879.745n 0.0v 879.755n 0.0v 884.745n 0.0v 884.755n 1.1v 889.745n 1.1v 889.755n 0.0v 894.745n 0.0v 894.755n 0.0v 899.745n 0.0v 899.755n 1.1v 904.745n 1.1v 904.755n 1.1v 909.745n 1.1v 909.755n 0.0v 914.745n 0.0v 914.755n 0.0v 919.745n 0.0v 919.755n 1.1v 924.745n 1.1v 924.755n 1.1v 929.745n 1.1v 929.755n 0.0v 934.745n 0.0v 934.755n 0.0v 939.745n 0.0v 939.755n 0.0v 944.745n 0.0v 944.755n 0.0v 949.745n 0.0v 949.755n 1.1v 954.745n 1.1v 954.755n 0.0v 959.745n 0.0v 959.755n 1.1v 964.745n 1.1v 964.755n 1.1v 969.745n 1.1v 969.755n 1.1v 974.745n 1.1v 974.755n 1.1v 979.745n 1.1v 979.755n 0.0v 984.745n 0.0v 984.755n 1.1v 989.745n 1.1v 989.755n 0.0v 994.745n 0.0v 994.755n 1.1v 999.745n 1.1v 999.755n 0.0v 1004.745n 0.0v 1004.755n 1.1v 1009.745n 1.1v 1009.755n 0.0v 1014.745n 0.0v 1014.755n 1.1v 1019.745n 1.1v 1019.755n 1.1v 1024.745n 1.1v 1024.755n 1.1v )
* (time, data): [(0, 0), (5, 1), (10, 1), (15, 0), (20, 0), (25, 0), (30, 0), (35, 0), (40, 0), (45, 0), (50, 0), (55, 0), (60, 0), (65, 1), (70, 0), (75, 0), (80, 0), (85, 1), (90, 1), (95, 1), (100, 0), (105, 0), (110, 0), (115, 0), (120, 0), (125, 0), (130, 0), (135, 0), (140, 0), (145, 1), (150, 1), (155, 0), (160, 0), (165, 0), (170, 1), (175, 0), (180, 0), (185, 0), (190, 0), (195, 0), (200, 0), (205, 0), (210, 1), (215, 1), (220, 0), (225, 0), (230, 1), (235, 1), (240, 0), (245, 1), (250, 1), (255, 1), (260, 0), (265, 0), (270, 1), (275, 0), (280, 0), (285, 0), (290, 0), (295, 0), (300, 1), (305, 1), (310, 0), (315, 0), (320, 1), (325, 1), (330, 1), (335, 0), (340, 0), (345, 0), (350, 0), (355, 1), (360, 1), (365, 1), (370, 1), (375, 1), (380, 1), (385, 1), (390, 1), (395, 0), (400, 1), (405, 0), (410, 0), (415, 0), (420, 0), (425, 1), (430, 1), (435, 0), (440, 1), (445, 1), (450, 1), (455, 1), (460, 1), (465, 1), (470, 1), (475, 1), (480, 1), (485, 1), (490, 0), (495, 0), (500, 0), (505, 0), (510, 0), (515, 0), (520, 0), (525, 0), (530, 0), (535, 1), (540, 0), (545, 0), (550, 1), (555, 1), (560, 1), (565, 0), (570, 0), (575, 0), (580, 1), (585, 1), (590, 1), (595, 1), (600, 1), (605, 1), (610, 0), (615, 0), (620, 0), (625, 0), (630, 1), (635, 0), (640, 0), (645, 1), (650, 0), (655, 1), (660, 0), (665, 0), (670, 1), (675, 1), (680, 1), (685, 1), (690, 1), (695, 1), (700, 1), (705, 0), (710, 0), (715, 0), (720, 0), (725, 0), (730, 0), (735, 0), (740, 0), (745, 0), (750, 0), (755, 1), (760, 1), (765, 1), (770, 0), (775, 1), (780, 1), (785, 1), (790, 1), (795, 1), (800, 1), (805, 0), (810, 0), (815, 0), (820, 0), (825, 0), (830, 0), (835, 1), (840, 1), (845, 1), (850, 1), (855, 1), (860, 1), (865, 1), (870, 1), (875, 0), (880, 0), (885, 1), (890, 0), (895, 0), (900, 1), (905, 1), (910, 0), (915, 0), (920, 1), (925, 1), (930, 0), (935, 0), (940, 0), (945, 0), (950, 1), (955, 0), (960, 1), (965, 1), (970, 1), (975, 1), (980, 0), (985, 1), (990, 0), (995, 1), (1000, 0), (1005, 1), (1010, 0), (1015, 1), (1020, 1), (1025, 1)]
Va0_8  a0_8  0 PWL (0n 0.0v 4.745n 0.0v 4.755n 1.1v 9.745n 1.1v 9.755n 1.1v 14.745n 1.1v 14.755n 0.0v 19.745n 0.0v 19.755n 0.0v 24.745n 0.0v 24.755n 0.0v 29.745n 0.0v 29.755n 0.0v 34.745n 0.0v 34.755n 0.0v 39.745n 0.0v 39.755n 0.0v 44.745n 0.0v 44.755n 0.0v 49.745n 0.0v 49.755n 0.0v 54.745n 0.0v 54.755n 0.0v 59.745n 0.0v 59.755n 0.0v 64.745n 0.0v 64.755n 1.1v 69.745n 1.1v 69.755n 0.0v 74.745n 0.0v 74.755n 0.0v 79.745n 0.0v 79.755n 0.0v 84.745n 0.0v 84.755n 1.1v 89.745n 1.1v 89.755n 1.1v 94.745n 1.1v 94.755n 1.1v 99.745n 1.1v 99.755n 0.0v 104.745n 0.0v 104.755n 0.0v 109.745n 0.0v 109.755n 0.0v 114.745n 0.0v 114.755n 0.0v 119.745n 0.0v 119.755n 0.0v 124.745n 0.0v 124.755n 0.0v 129.745n 0.0v 129.755n 0.0v 134.745n 0.0v 134.755n 0.0v 139.745n 0.0v 139.755n 0.0v 144.745n 0.0v 144.755n 1.1v 149.745n 1.1v 149.755n 1.1v 154.745n 1.1v 154.755n 0.0v 159.745n 0.0v 159.755n 0.0v 164.745n 0.0v 164.755n 0.0v 169.745n 0.0v 169.755n 1.1v 174.745n 1.1v 174.755n 0.0v 179.745n 0.0v 179.755n 0.0v 184.745n 0.0v 184.755n 0.0v 189.745n 0.0v 189.755n 0.0v 194.745n 0.0v 194.755n 0.0v 199.745n 0.0v 199.755n 0.0v 204.745n 0.0v 204.755n 0.0v 209.745n 0.0v 209.755n 1.1v 214.745n 1.1v 214.755n 1.1v 219.745n 1.1v 219.755n 0.0v 224.745n 0.0v 224.755n 0.0v 229.745n 0.0v 229.755n 1.1v 234.745n 1.1v 234.755n 1.1v 239.745n 1.1v 239.755n 0.0v 244.745n 0.0v 244.755n 1.1v 249.745n 1.1v 249.755n 1.1v 254.745n 1.1v 254.755n 1.1v 259.745n 1.1v 259.755n 0.0v 264.745n 0.0v 264.755n 0.0v 269.745n 0.0v 269.755n 1.1v 274.745n 1.1v 274.755n 0.0v 279.745n 0.0v 279.755n 0.0v 284.745n 0.0v 284.755n 0.0v 289.745n 0.0v 289.755n 0.0v 294.745n 0.0v 294.755n 0.0v 299.745n 0.0v 299.755n 1.1v 304.745n 1.1v 304.755n 1.1v 309.745n 1.1v 309.755n 0.0v 314.745n 0.0v 314.755n 0.0v 319.745n 0.0v 319.755n 1.1v 324.745n 1.1v 324.755n 1.1v 329.745n 1.1v 329.755n 1.1v 334.745n 1.1v 334.755n 0.0v 339.745n 0.0v 339.755n 0.0v 344.745n 0.0v 344.755n 0.0v 349.745n 0.0v 349.755n 0.0v 354.745n 0.0v 354.755n 1.1v 359.745n 1.1v 359.755n 1.1v 364.745n 1.1v 364.755n 1.1v 369.745n 1.1v 369.755n 1.1v 374.745n 1.1v 374.755n 1.1v 379.745n 1.1v 379.755n 1.1v 384.745n 1.1v 384.755n 1.1v 389.745n 1.1v 389.755n 1.1v 394.745n 1.1v 394.755n 0.0v 399.745n 0.0v 399.755n 1.1v 404.745n 1.1v 404.755n 0.0v 409.745n 0.0v 409.755n 0.0v 414.745n 0.0v 414.755n 0.0v 419.745n 0.0v 419.755n 0.0v 424.745n 0.0v 424.755n 1.1v 429.745n 1.1v 429.755n 1.1v 434.745n 1.1v 434.755n 0.0v 439.745n 0.0v 439.755n 1.1v 444.745n 1.1v 444.755n 1.1v 449.745n 1.1v 449.755n 1.1v 454.745n 1.1v 454.755n 1.1v 459.745n 1.1v 459.755n 1.1v 464.745n 1.1v 464.755n 1.1v 469.745n 1.1v 469.755n 1.1v 474.745n 1.1v 474.755n 1.1v 479.745n 1.1v 479.755n 1.1v 484.745n 1.1v 484.755n 1.1v 489.745n 1.1v 489.755n 0.0v 494.745n 0.0v 494.755n 0.0v 499.745n 0.0v 499.755n 0.0v 504.745n 0.0v 504.755n 0.0v 509.745n 0.0v 509.755n 0.0v 514.745n 0.0v 514.755n 0.0v 519.745n 0.0v 519.755n 0.0v 524.745n 0.0v 524.755n 0.0v 529.745n 0.0v 529.755n 0.0v 534.745n 0.0v 534.755n 1.1v 539.745n 1.1v 539.755n 0.0v 544.745n 0.0v 544.755n 0.0v 549.745n 0.0v 549.755n 1.1v 554.745n 1.1v 554.755n 1.1v 559.745n 1.1v 559.755n 1.1v 564.745n 1.1v 564.755n 0.0v 569.745n 0.0v 569.755n 0.0v 574.745n 0.0v 574.755n 0.0v 579.745n 0.0v 579.755n 1.1v 584.745n 1.1v 584.755n 1.1v 589.745n 1.1v 589.755n 1.1v 594.745n 1.1v 594.755n 1.1v 599.745n 1.1v 599.755n 1.1v 604.745n 1.1v 604.755n 1.1v 609.745n 1.1v 609.755n 0.0v 614.745n 0.0v 614.755n 0.0v 619.745n 0.0v 619.755n 0.0v 624.745n 0.0v 624.755n 0.0v 629.745n 0.0v 629.755n 1.1v 634.745n 1.1v 634.755n 0.0v 639.745n 0.0v 639.755n 0.0v 644.745n 0.0v 644.755n 1.1v 649.745n 1.1v 649.755n 0.0v 654.745n 0.0v 654.755n 1.1v 659.745n 1.1v 659.755n 0.0v 664.745n 0.0v 664.755n 0.0v 669.745n 0.0v 669.755n 1.1v 674.745n 1.1v 674.755n 1.1v 679.745n 1.1v 679.755n 1.1v 684.745n 1.1v 684.755n 1.1v 689.745n 1.1v 689.755n 1.1v 694.745n 1.1v 694.755n 1.1v 699.745n 1.1v 699.755n 1.1v 704.745n 1.1v 704.755n 0.0v 709.745n 0.0v 709.755n 0.0v 714.745n 0.0v 714.755n 0.0v 719.745n 0.0v 719.755n 0.0v 724.745n 0.0v 724.755n 0.0v 729.745n 0.0v 729.755n 0.0v 734.745n 0.0v 734.755n 0.0v 739.745n 0.0v 739.755n 0.0v 744.745n 0.0v 744.755n 0.0v 749.745n 0.0v 749.755n 0.0v 754.745n 0.0v 754.755n 1.1v 759.745n 1.1v 759.755n 1.1v 764.745n 1.1v 764.755n 1.1v 769.745n 1.1v 769.755n 0.0v 774.745n 0.0v 774.755n 1.1v 779.745n 1.1v 779.755n 1.1v 784.745n 1.1v 784.755n 1.1v 789.745n 1.1v 789.755n 1.1v 794.745n 1.1v 794.755n 1.1v 799.745n 1.1v 799.755n 1.1v 804.745n 1.1v 804.755n 0.0v 809.745n 0.0v 809.755n 0.0v 814.745n 0.0v 814.755n 0.0v 819.745n 0.0v 819.755n 0.0v 824.745n 0.0v 824.755n 0.0v 829.745n 0.0v 829.755n 0.0v 834.745n 0.0v 834.755n 1.1v 839.745n 1.1v 839.755n 1.1v 844.745n 1.1v 844.755n 1.1v 849.745n 1.1v 849.755n 1.1v 854.745n 1.1v 854.755n 1.1v 859.745n 1.1v 859.755n 1.1v 864.745n 1.1v 864.755n 1.1v 869.745n 1.1v 869.755n 1.1v 874.745n 1.1v 874.755n 0.0v 879.745n 0.0v 879.755n 0.0v 884.745n 0.0v 884.755n 1.1v 889.745n 1.1v 889.755n 0.0v 894.745n 0.0v 894.755n 0.0v 899.745n 0.0v 899.755n 1.1v 904.745n 1.1v 904.755n 1.1v 909.745n 1.1v 909.755n 0.0v 914.745n 0.0v 914.755n 0.0v 919.745n 0.0v 919.755n 1.1v 924.745n 1.1v 924.755n 1.1v 929.745n 1.1v 929.755n 0.0v 934.745n 0.0v 934.755n 0.0v 939.745n 0.0v 939.755n 0.0v 944.745n 0.0v 944.755n 0.0v 949.745n 0.0v 949.755n 1.1v 954.745n 1.1v 954.755n 0.0v 959.745n 0.0v 959.755n 1.1v 964.745n 1.1v 964.755n 1.1v 969.745n 1.1v 969.755n 1.1v 974.745n 1.1v 974.755n 1.1v 979.745n 1.1v 979.755n 0.0v 984.745n 0.0v 984.755n 1.1v 989.745n 1.1v 989.755n 0.0v 994.745n 0.0v 994.755n 1.1v 999.745n 1.1v 999.755n 0.0v 1004.745n 0.0v 1004.755n 1.1v 1009.745n 1.1v 1009.755n 0.0v 1014.745n 0.0v 1014.755n 1.1v 1019.745n 1.1v 1019.755n 1.1v 1024.745n 1.1v 1024.755n 1.1v )
* (time, data): [(0, 0), (5, 1), (10, 1), (15, 0), (20, 0), (25, 0), (30, 0), (35, 0), (40, 0), (45, 0), (50, 0), (55, 0), (60, 0), (65, 1), (70, 0), (75, 0), (80, 0), (85, 1), (90, 1), (95, 1), (100, 0), (105, 0), (110, 0), (115, 0), (120, 0), (125, 0), (130, 0), (135, 0), (140, 0), (145, 1), (150, 1), (155, 0), (160, 0), (165, 0), (170, 1), (175, 0), (180, 0), (185, 0), (190, 0), (195, 0), (200, 0), (205, 0), (210, 1), (215, 1), (220, 0), (225, 0), (230, 1), (235, 1), (240, 0), (245, 1), (250, 1), (255, 1), (260, 0), (265, 0), (270, 1), (275, 0), (280, 0), (285, 0), (290, 0), (295, 0), (300, 1), (305, 1), (310, 0), (315, 0), (320, 1), (325, 1), (330, 1), (335, 0), (340, 0), (345, 0), (350, 0), (355, 1), (360, 1), (365, 1), (370, 1), (375, 1), (380, 1), (385, 1), (390, 1), (395, 0), (400, 1), (405, 0), (410, 0), (415, 0), (420, 0), (425, 1), (430, 1), (435, 0), (440, 1), (445, 1), (450, 1), (455, 1), (460, 1), (465, 1), (470, 1), (475, 1), (480, 1), (485, 1), (490, 0), (495, 0), (500, 0), (505, 0), (510, 0), (515, 0), (520, 0), (525, 0), (530, 0), (535, 1), (540, 0), (545, 0), (550, 1), (555, 1), (560, 1), (565, 0), (570, 0), (575, 0), (580, 1), (585, 1), (590, 1), (595, 1), (600, 1), (605, 1), (610, 0), (615, 0), (620, 0), (625, 0), (630, 1), (635, 0), (640, 0), (645, 1), (650, 0), (655, 1), (660, 0), (665, 0), (670, 1), (675, 1), (680, 1), (685, 1), (690, 1), (695, 1), (700, 1), (705, 0), (710, 0), (715, 0), (720, 0), (725, 0), (730, 0), (735, 0), (740, 0), (745, 0), (750, 0), (755, 1), (760, 1), (765, 1), (770, 0), (775, 1), (780, 1), (785, 1), (790, 1), (795, 1), (800, 1), (805, 0), (810, 0), (815, 0), (820, 0), (825, 0), (830, 0), (835, 1), (840, 1), (845, 1), (850, 1), (855, 1), (860, 1), (865, 1), (870, 1), (875, 0), (880, 0), (885, 1), (890, 0), (895, 0), (900, 1), (905, 1), (910, 0), (915, 0), (920, 1), (925, 1), (930, 0), (935, 0), (940, 0), (945, 0), (950, 1), (955, 0), (960, 1), (965, 1), (970, 1), (975, 1), (980, 0), (985, 1), (990, 0), (995, 1), (1000, 0), (1005, 1), (1010, 0), (1015, 1), (1020, 1), (1025, 1)]
Va0_9  a0_9  0 PWL (0n 0.0v 4.745n 0.0v 4.755n 1.1v 9.745n 1.1v 9.755n 1.1v 14.745n 1.1v 14.755n 0.0v 19.745n 0.0v 19.755n 0.0v 24.745n 0.0v 24.755n 0.0v 29.745n 0.0v 29.755n 0.0v 34.745n 0.0v 34.755n 0.0v 39.745n 0.0v 39.755n 0.0v 44.745n 0.0v 44.755n 0.0v 49.745n 0.0v 49.755n 0.0v 54.745n 0.0v 54.755n 0.0v 59.745n 0.0v 59.755n 0.0v 64.745n 0.0v 64.755n 1.1v 69.745n 1.1v 69.755n 0.0v 74.745n 0.0v 74.755n 0.0v 79.745n 0.0v 79.755n 0.0v 84.745n 0.0v 84.755n 1.1v 89.745n 1.1v 89.755n 1.1v 94.745n 1.1v 94.755n 1.1v 99.745n 1.1v 99.755n 0.0v 104.745n 0.0v 104.755n 0.0v 109.745n 0.0v 109.755n 0.0v 114.745n 0.0v 114.755n 0.0v 119.745n 0.0v 119.755n 0.0v 124.745n 0.0v 124.755n 0.0v 129.745n 0.0v 129.755n 0.0v 134.745n 0.0v 134.755n 0.0v 139.745n 0.0v 139.755n 0.0v 144.745n 0.0v 144.755n 1.1v 149.745n 1.1v 149.755n 1.1v 154.745n 1.1v 154.755n 0.0v 159.745n 0.0v 159.755n 0.0v 164.745n 0.0v 164.755n 0.0v 169.745n 0.0v 169.755n 1.1v 174.745n 1.1v 174.755n 0.0v 179.745n 0.0v 179.755n 0.0v 184.745n 0.0v 184.755n 0.0v 189.745n 0.0v 189.755n 0.0v 194.745n 0.0v 194.755n 0.0v 199.745n 0.0v 199.755n 0.0v 204.745n 0.0v 204.755n 0.0v 209.745n 0.0v 209.755n 1.1v 214.745n 1.1v 214.755n 1.1v 219.745n 1.1v 219.755n 0.0v 224.745n 0.0v 224.755n 0.0v 229.745n 0.0v 229.755n 1.1v 234.745n 1.1v 234.755n 1.1v 239.745n 1.1v 239.755n 0.0v 244.745n 0.0v 244.755n 1.1v 249.745n 1.1v 249.755n 1.1v 254.745n 1.1v 254.755n 1.1v 259.745n 1.1v 259.755n 0.0v 264.745n 0.0v 264.755n 0.0v 269.745n 0.0v 269.755n 1.1v 274.745n 1.1v 274.755n 0.0v 279.745n 0.0v 279.755n 0.0v 284.745n 0.0v 284.755n 0.0v 289.745n 0.0v 289.755n 0.0v 294.745n 0.0v 294.755n 0.0v 299.745n 0.0v 299.755n 1.1v 304.745n 1.1v 304.755n 1.1v 309.745n 1.1v 309.755n 0.0v 314.745n 0.0v 314.755n 0.0v 319.745n 0.0v 319.755n 1.1v 324.745n 1.1v 324.755n 1.1v 329.745n 1.1v 329.755n 1.1v 334.745n 1.1v 334.755n 0.0v 339.745n 0.0v 339.755n 0.0v 344.745n 0.0v 344.755n 0.0v 349.745n 0.0v 349.755n 0.0v 354.745n 0.0v 354.755n 1.1v 359.745n 1.1v 359.755n 1.1v 364.745n 1.1v 364.755n 1.1v 369.745n 1.1v 369.755n 1.1v 374.745n 1.1v 374.755n 1.1v 379.745n 1.1v 379.755n 1.1v 384.745n 1.1v 384.755n 1.1v 389.745n 1.1v 389.755n 1.1v 394.745n 1.1v 394.755n 0.0v 399.745n 0.0v 399.755n 1.1v 404.745n 1.1v 404.755n 0.0v 409.745n 0.0v 409.755n 0.0v 414.745n 0.0v 414.755n 0.0v 419.745n 0.0v 419.755n 0.0v 424.745n 0.0v 424.755n 1.1v 429.745n 1.1v 429.755n 1.1v 434.745n 1.1v 434.755n 0.0v 439.745n 0.0v 439.755n 1.1v 444.745n 1.1v 444.755n 1.1v 449.745n 1.1v 449.755n 1.1v 454.745n 1.1v 454.755n 1.1v 459.745n 1.1v 459.755n 1.1v 464.745n 1.1v 464.755n 1.1v 469.745n 1.1v 469.755n 1.1v 474.745n 1.1v 474.755n 1.1v 479.745n 1.1v 479.755n 1.1v 484.745n 1.1v 484.755n 1.1v 489.745n 1.1v 489.755n 0.0v 494.745n 0.0v 494.755n 0.0v 499.745n 0.0v 499.755n 0.0v 504.745n 0.0v 504.755n 0.0v 509.745n 0.0v 509.755n 0.0v 514.745n 0.0v 514.755n 0.0v 519.745n 0.0v 519.755n 0.0v 524.745n 0.0v 524.755n 0.0v 529.745n 0.0v 529.755n 0.0v 534.745n 0.0v 534.755n 1.1v 539.745n 1.1v 539.755n 0.0v 544.745n 0.0v 544.755n 0.0v 549.745n 0.0v 549.755n 1.1v 554.745n 1.1v 554.755n 1.1v 559.745n 1.1v 559.755n 1.1v 564.745n 1.1v 564.755n 0.0v 569.745n 0.0v 569.755n 0.0v 574.745n 0.0v 574.755n 0.0v 579.745n 0.0v 579.755n 1.1v 584.745n 1.1v 584.755n 1.1v 589.745n 1.1v 589.755n 1.1v 594.745n 1.1v 594.755n 1.1v 599.745n 1.1v 599.755n 1.1v 604.745n 1.1v 604.755n 1.1v 609.745n 1.1v 609.755n 0.0v 614.745n 0.0v 614.755n 0.0v 619.745n 0.0v 619.755n 0.0v 624.745n 0.0v 624.755n 0.0v 629.745n 0.0v 629.755n 1.1v 634.745n 1.1v 634.755n 0.0v 639.745n 0.0v 639.755n 0.0v 644.745n 0.0v 644.755n 1.1v 649.745n 1.1v 649.755n 0.0v 654.745n 0.0v 654.755n 1.1v 659.745n 1.1v 659.755n 0.0v 664.745n 0.0v 664.755n 0.0v 669.745n 0.0v 669.755n 1.1v 674.745n 1.1v 674.755n 1.1v 679.745n 1.1v 679.755n 1.1v 684.745n 1.1v 684.755n 1.1v 689.745n 1.1v 689.755n 1.1v 694.745n 1.1v 694.755n 1.1v 699.745n 1.1v 699.755n 1.1v 704.745n 1.1v 704.755n 0.0v 709.745n 0.0v 709.755n 0.0v 714.745n 0.0v 714.755n 0.0v 719.745n 0.0v 719.755n 0.0v 724.745n 0.0v 724.755n 0.0v 729.745n 0.0v 729.755n 0.0v 734.745n 0.0v 734.755n 0.0v 739.745n 0.0v 739.755n 0.0v 744.745n 0.0v 744.755n 0.0v 749.745n 0.0v 749.755n 0.0v 754.745n 0.0v 754.755n 1.1v 759.745n 1.1v 759.755n 1.1v 764.745n 1.1v 764.755n 1.1v 769.745n 1.1v 769.755n 0.0v 774.745n 0.0v 774.755n 1.1v 779.745n 1.1v 779.755n 1.1v 784.745n 1.1v 784.755n 1.1v 789.745n 1.1v 789.755n 1.1v 794.745n 1.1v 794.755n 1.1v 799.745n 1.1v 799.755n 1.1v 804.745n 1.1v 804.755n 0.0v 809.745n 0.0v 809.755n 0.0v 814.745n 0.0v 814.755n 0.0v 819.745n 0.0v 819.755n 0.0v 824.745n 0.0v 824.755n 0.0v 829.745n 0.0v 829.755n 0.0v 834.745n 0.0v 834.755n 1.1v 839.745n 1.1v 839.755n 1.1v 844.745n 1.1v 844.755n 1.1v 849.745n 1.1v 849.755n 1.1v 854.745n 1.1v 854.755n 1.1v 859.745n 1.1v 859.755n 1.1v 864.745n 1.1v 864.755n 1.1v 869.745n 1.1v 869.755n 1.1v 874.745n 1.1v 874.755n 0.0v 879.745n 0.0v 879.755n 0.0v 884.745n 0.0v 884.755n 1.1v 889.745n 1.1v 889.755n 0.0v 894.745n 0.0v 894.755n 0.0v 899.745n 0.0v 899.755n 1.1v 904.745n 1.1v 904.755n 1.1v 909.745n 1.1v 909.755n 0.0v 914.745n 0.0v 914.755n 0.0v 919.745n 0.0v 919.755n 1.1v 924.745n 1.1v 924.755n 1.1v 929.745n 1.1v 929.755n 0.0v 934.745n 0.0v 934.755n 0.0v 939.745n 0.0v 939.755n 0.0v 944.745n 0.0v 944.755n 0.0v 949.745n 0.0v 949.755n 1.1v 954.745n 1.1v 954.755n 0.0v 959.745n 0.0v 959.755n 1.1v 964.745n 1.1v 964.755n 1.1v 969.745n 1.1v 969.755n 1.1v 974.745n 1.1v 974.755n 1.1v 979.745n 1.1v 979.755n 0.0v 984.745n 0.0v 984.755n 1.1v 989.745n 1.1v 989.755n 0.0v 994.745n 0.0v 994.755n 1.1v 999.745n 1.1v 999.755n 0.0v 1004.745n 0.0v 1004.755n 1.1v 1009.745n 1.1v 1009.755n 0.0v 1014.745n 0.0v 1014.755n 1.1v 1019.745n 1.1v 1019.755n 1.1v 1024.745n 1.1v 1024.755n 1.1v )
* (time, data): [(0, 0), (5, 1), (10, 1), (15, 0), (20, 0), (25, 0), (30, 0), (35, 0), (40, 0), (45, 0), (50, 0), (55, 0), (60, 0), (65, 1), (70, 0), (75, 0), (80, 0), (85, 1), (90, 1), (95, 1), (100, 0), (105, 0), (110, 0), (115, 0), (120, 0), (125, 0), (130, 0), (135, 0), (140, 0), (145, 1), (150, 1), (155, 0), (160, 0), (165, 0), (170, 1), (175, 0), (180, 0), (185, 0), (190, 0), (195, 0), (200, 0), (205, 0), (210, 1), (215, 1), (220, 0), (225, 0), (230, 1), (235, 1), (240, 0), (245, 1), (250, 1), (255, 1), (260, 0), (265, 0), (270, 1), (275, 0), (280, 0), (285, 0), (290, 0), (295, 0), (300, 1), (305, 1), (310, 0), (315, 0), (320, 1), (325, 1), (330, 1), (335, 0), (340, 0), (345, 0), (350, 0), (355, 1), (360, 1), (365, 1), (370, 1), (375, 1), (380, 1), (385, 1), (390, 1), (395, 0), (400, 1), (405, 0), (410, 0), (415, 0), (420, 0), (425, 1), (430, 1), (435, 0), (440, 1), (445, 1), (450, 1), (455, 1), (460, 1), (465, 1), (470, 1), (475, 1), (480, 1), (485, 1), (490, 0), (495, 0), (500, 0), (505, 0), (510, 0), (515, 0), (520, 0), (525, 0), (530, 0), (535, 1), (540, 0), (545, 0), (550, 1), (555, 1), (560, 1), (565, 0), (570, 0), (575, 0), (580, 1), (585, 1), (590, 1), (595, 1), (600, 1), (605, 1), (610, 0), (615, 0), (620, 0), (625, 0), (630, 1), (635, 0), (640, 0), (645, 1), (650, 0), (655, 1), (660, 0), (665, 0), (670, 1), (675, 1), (680, 1), (685, 1), (690, 1), (695, 1), (700, 1), (705, 0), (710, 0), (715, 0), (720, 0), (725, 0), (730, 0), (735, 0), (740, 0), (745, 0), (750, 0), (755, 1), (760, 1), (765, 1), (770, 0), (775, 1), (780, 1), (785, 1), (790, 1), (795, 1), (800, 1), (805, 0), (810, 0), (815, 0), (820, 0), (825, 0), (830, 0), (835, 1), (840, 1), (845, 1), (850, 1), (855, 1), (860, 1), (865, 1), (870, 1), (875, 0), (880, 0), (885, 1), (890, 0), (895, 0), (900, 1), (905, 1), (910, 0), (915, 0), (920, 1), (925, 1), (930, 0), (935, 0), (940, 0), (945, 0), (950, 1), (955, 0), (960, 1), (965, 1), (970, 1), (975, 1), (980, 0), (985, 1), (990, 0), (995, 1), (1000, 0), (1005, 1), (1010, 0), (1015, 1), (1020, 1), (1025, 1)]
Va0_10  a0_10  0 PWL (0n 0.0v 4.745n 0.0v 4.755n 1.1v 9.745n 1.1v 9.755n 1.1v 14.745n 1.1v 14.755n 0.0v 19.745n 0.0v 19.755n 0.0v 24.745n 0.0v 24.755n 0.0v 29.745n 0.0v 29.755n 0.0v 34.745n 0.0v 34.755n 0.0v 39.745n 0.0v 39.755n 0.0v 44.745n 0.0v 44.755n 0.0v 49.745n 0.0v 49.755n 0.0v 54.745n 0.0v 54.755n 0.0v 59.745n 0.0v 59.755n 0.0v 64.745n 0.0v 64.755n 1.1v 69.745n 1.1v 69.755n 0.0v 74.745n 0.0v 74.755n 0.0v 79.745n 0.0v 79.755n 0.0v 84.745n 0.0v 84.755n 1.1v 89.745n 1.1v 89.755n 1.1v 94.745n 1.1v 94.755n 1.1v 99.745n 1.1v 99.755n 0.0v 104.745n 0.0v 104.755n 0.0v 109.745n 0.0v 109.755n 0.0v 114.745n 0.0v 114.755n 0.0v 119.745n 0.0v 119.755n 0.0v 124.745n 0.0v 124.755n 0.0v 129.745n 0.0v 129.755n 0.0v 134.745n 0.0v 134.755n 0.0v 139.745n 0.0v 139.755n 0.0v 144.745n 0.0v 144.755n 1.1v 149.745n 1.1v 149.755n 1.1v 154.745n 1.1v 154.755n 0.0v 159.745n 0.0v 159.755n 0.0v 164.745n 0.0v 164.755n 0.0v 169.745n 0.0v 169.755n 1.1v 174.745n 1.1v 174.755n 0.0v 179.745n 0.0v 179.755n 0.0v 184.745n 0.0v 184.755n 0.0v 189.745n 0.0v 189.755n 0.0v 194.745n 0.0v 194.755n 0.0v 199.745n 0.0v 199.755n 0.0v 204.745n 0.0v 204.755n 0.0v 209.745n 0.0v 209.755n 1.1v 214.745n 1.1v 214.755n 1.1v 219.745n 1.1v 219.755n 0.0v 224.745n 0.0v 224.755n 0.0v 229.745n 0.0v 229.755n 1.1v 234.745n 1.1v 234.755n 1.1v 239.745n 1.1v 239.755n 0.0v 244.745n 0.0v 244.755n 1.1v 249.745n 1.1v 249.755n 1.1v 254.745n 1.1v 254.755n 1.1v 259.745n 1.1v 259.755n 0.0v 264.745n 0.0v 264.755n 0.0v 269.745n 0.0v 269.755n 1.1v 274.745n 1.1v 274.755n 0.0v 279.745n 0.0v 279.755n 0.0v 284.745n 0.0v 284.755n 0.0v 289.745n 0.0v 289.755n 0.0v 294.745n 0.0v 294.755n 0.0v 299.745n 0.0v 299.755n 1.1v 304.745n 1.1v 304.755n 1.1v 309.745n 1.1v 309.755n 0.0v 314.745n 0.0v 314.755n 0.0v 319.745n 0.0v 319.755n 1.1v 324.745n 1.1v 324.755n 1.1v 329.745n 1.1v 329.755n 1.1v 334.745n 1.1v 334.755n 0.0v 339.745n 0.0v 339.755n 0.0v 344.745n 0.0v 344.755n 0.0v 349.745n 0.0v 349.755n 0.0v 354.745n 0.0v 354.755n 1.1v 359.745n 1.1v 359.755n 1.1v 364.745n 1.1v 364.755n 1.1v 369.745n 1.1v 369.755n 1.1v 374.745n 1.1v 374.755n 1.1v 379.745n 1.1v 379.755n 1.1v 384.745n 1.1v 384.755n 1.1v 389.745n 1.1v 389.755n 1.1v 394.745n 1.1v 394.755n 0.0v 399.745n 0.0v 399.755n 1.1v 404.745n 1.1v 404.755n 0.0v 409.745n 0.0v 409.755n 0.0v 414.745n 0.0v 414.755n 0.0v 419.745n 0.0v 419.755n 0.0v 424.745n 0.0v 424.755n 1.1v 429.745n 1.1v 429.755n 1.1v 434.745n 1.1v 434.755n 0.0v 439.745n 0.0v 439.755n 1.1v 444.745n 1.1v 444.755n 1.1v 449.745n 1.1v 449.755n 1.1v 454.745n 1.1v 454.755n 1.1v 459.745n 1.1v 459.755n 1.1v 464.745n 1.1v 464.755n 1.1v 469.745n 1.1v 469.755n 1.1v 474.745n 1.1v 474.755n 1.1v 479.745n 1.1v 479.755n 1.1v 484.745n 1.1v 484.755n 1.1v 489.745n 1.1v 489.755n 0.0v 494.745n 0.0v 494.755n 0.0v 499.745n 0.0v 499.755n 0.0v 504.745n 0.0v 504.755n 0.0v 509.745n 0.0v 509.755n 0.0v 514.745n 0.0v 514.755n 0.0v 519.745n 0.0v 519.755n 0.0v 524.745n 0.0v 524.755n 0.0v 529.745n 0.0v 529.755n 0.0v 534.745n 0.0v 534.755n 1.1v 539.745n 1.1v 539.755n 0.0v 544.745n 0.0v 544.755n 0.0v 549.745n 0.0v 549.755n 1.1v 554.745n 1.1v 554.755n 1.1v 559.745n 1.1v 559.755n 1.1v 564.745n 1.1v 564.755n 0.0v 569.745n 0.0v 569.755n 0.0v 574.745n 0.0v 574.755n 0.0v 579.745n 0.0v 579.755n 1.1v 584.745n 1.1v 584.755n 1.1v 589.745n 1.1v 589.755n 1.1v 594.745n 1.1v 594.755n 1.1v 599.745n 1.1v 599.755n 1.1v 604.745n 1.1v 604.755n 1.1v 609.745n 1.1v 609.755n 0.0v 614.745n 0.0v 614.755n 0.0v 619.745n 0.0v 619.755n 0.0v 624.745n 0.0v 624.755n 0.0v 629.745n 0.0v 629.755n 1.1v 634.745n 1.1v 634.755n 0.0v 639.745n 0.0v 639.755n 0.0v 644.745n 0.0v 644.755n 1.1v 649.745n 1.1v 649.755n 0.0v 654.745n 0.0v 654.755n 1.1v 659.745n 1.1v 659.755n 0.0v 664.745n 0.0v 664.755n 0.0v 669.745n 0.0v 669.755n 1.1v 674.745n 1.1v 674.755n 1.1v 679.745n 1.1v 679.755n 1.1v 684.745n 1.1v 684.755n 1.1v 689.745n 1.1v 689.755n 1.1v 694.745n 1.1v 694.755n 1.1v 699.745n 1.1v 699.755n 1.1v 704.745n 1.1v 704.755n 0.0v 709.745n 0.0v 709.755n 0.0v 714.745n 0.0v 714.755n 0.0v 719.745n 0.0v 719.755n 0.0v 724.745n 0.0v 724.755n 0.0v 729.745n 0.0v 729.755n 0.0v 734.745n 0.0v 734.755n 0.0v 739.745n 0.0v 739.755n 0.0v 744.745n 0.0v 744.755n 0.0v 749.745n 0.0v 749.755n 0.0v 754.745n 0.0v 754.755n 1.1v 759.745n 1.1v 759.755n 1.1v 764.745n 1.1v 764.755n 1.1v 769.745n 1.1v 769.755n 0.0v 774.745n 0.0v 774.755n 1.1v 779.745n 1.1v 779.755n 1.1v 784.745n 1.1v 784.755n 1.1v 789.745n 1.1v 789.755n 1.1v 794.745n 1.1v 794.755n 1.1v 799.745n 1.1v 799.755n 1.1v 804.745n 1.1v 804.755n 0.0v 809.745n 0.0v 809.755n 0.0v 814.745n 0.0v 814.755n 0.0v 819.745n 0.0v 819.755n 0.0v 824.745n 0.0v 824.755n 0.0v 829.745n 0.0v 829.755n 0.0v 834.745n 0.0v 834.755n 1.1v 839.745n 1.1v 839.755n 1.1v 844.745n 1.1v 844.755n 1.1v 849.745n 1.1v 849.755n 1.1v 854.745n 1.1v 854.755n 1.1v 859.745n 1.1v 859.755n 1.1v 864.745n 1.1v 864.755n 1.1v 869.745n 1.1v 869.755n 1.1v 874.745n 1.1v 874.755n 0.0v 879.745n 0.0v 879.755n 0.0v 884.745n 0.0v 884.755n 1.1v 889.745n 1.1v 889.755n 0.0v 894.745n 0.0v 894.755n 0.0v 899.745n 0.0v 899.755n 1.1v 904.745n 1.1v 904.755n 1.1v 909.745n 1.1v 909.755n 0.0v 914.745n 0.0v 914.755n 0.0v 919.745n 0.0v 919.755n 1.1v 924.745n 1.1v 924.755n 1.1v 929.745n 1.1v 929.755n 0.0v 934.745n 0.0v 934.755n 0.0v 939.745n 0.0v 939.755n 0.0v 944.745n 0.0v 944.755n 0.0v 949.745n 0.0v 949.755n 1.1v 954.745n 1.1v 954.755n 0.0v 959.745n 0.0v 959.755n 1.1v 964.745n 1.1v 964.755n 1.1v 969.745n 1.1v 969.755n 1.1v 974.745n 1.1v 974.755n 1.1v 979.745n 1.1v 979.755n 0.0v 984.745n 0.0v 984.755n 1.1v 989.745n 1.1v 989.755n 0.0v 994.745n 0.0v 994.755n 1.1v 999.745n 1.1v 999.755n 0.0v 1004.745n 0.0v 1004.755n 1.1v 1009.745n 1.1v 1009.755n 0.0v 1014.745n 0.0v 1014.755n 1.1v 1019.745n 1.1v 1019.755n 1.1v 1024.745n 1.1v 1024.755n 1.1v )

 * Generation of control signals
* (time, data): [(0, 1), (5, 0), (10, 0), (15, 0), (20, 0), (25, 0), (30, 1), (35, 1), (40, 1), (45, 0), (50, 0), (55, 1), (60, 0), (65, 0), (70, 0), (75, 1), (80, 0), (85, 0), (90, 1), (95, 1), (100, 0), (105, 0), (110, 1), (115, 0), (120, 0), (125, 1), (130, 0), (135, 1), (140, 0), (145, 0), (150, 1), (155, 0), (160, 0), (165, 0), (170, 0), (175, 0), (180, 0), (185, 0), (190, 0), (195, 1), (200, 1), (205, 0), (210, 0), (215, 0), (220, 0), (225, 1), (230, 0), (235, 0), (240, 0), (245, 0), (250, 0), (255, 0), (260, 0), (265, 1), (270, 0), (275, 0), (280, 0), (285, 1), (290, 0), (295, 0), (300, 0), (305, 1), (310, 0), (315, 0), (320, 0), (325, 0), (330, 0), (335, 0), (340, 0), (345, 1), (350, 0), (355, 0), (360, 0), (365, 0), (370, 1), (375, 1), (380, 0), (385, 0), (390, 1), (395, 0), (400, 0), (405, 0), (410, 0), (415, 0), (420, 0), (425, 0), (430, 1), (435, 0), (440, 0), (445, 0), (450, 0), (455, 0), (460, 1), (465, 0), (470, 0), (475, 1), (480, 1), (485, 1), (490, 0), (495, 0), (500, 0), (505, 0), (510, 0), (515, 0), (520, 0), (525, 0), (530, 1), (535, 0), (540, 0), (545, 0), (550, 0), (555, 1), (560, 0), (565, 0), (570, 0), (575, 0), (580, 0), (585, 0), (590, 0), (595, 0), (600, 0), (605, 0), (610, 0), (615, 0), (620, 1), (625, 0), (630, 0), (635, 0), (640, 1), (645, 0), (650, 0), (655, 0), (660, 0), (665, 0), (670, 0), (675, 1), (680, 1), (685, 1), (690, 0), (695, 0), (700, 0), (705, 0), (710, 0), (715, 0), (720, 0), (725, 0), (730, 0), (735, 0), (740, 1), (745, 0), (750, 1), (755, 0), (760, 0), (765, 0), (770, 0), (775, 0), (780, 0), (785, 0), (790, 0), (795, 1), (800, 1), (805, 0), (810, 0), (815, 0), (820, 0), (825, 1), (830, 0), (835, 0), (840, 1), (845, 0), (850, 1), (855, 0), (860, 0), (865, 1), (870, 0), (875, 0), (880, 0), (885, 0), (890, 0), (895, 1), (900, 0), (905, 0), (910, 0), (915, 1), (920, 0), (925, 0), (930, 0), (935, 0), (940, 0), (945, 0), (950, 0), (955, 0), (960, 0), (965, 0), (970, 0), (975, 0), (980, 0), (985, 0), (990, 0), (995, 0), (1000, 0), (1005, 0), (1010, 0), (1015, 0), (1020, 0), (1025, 1)]
VCSB0 CSB0 0 PWL (0n 1.1v 4.745n 1.1v 4.755n 0.0v 9.745n 0.0v 9.755n 0.0v 14.745n 0.0v 14.755n 0.0v 19.745n 0.0v 19.755n 0.0v 24.745n 0.0v 24.755n 0.0v 29.745n 0.0v 29.755n 1.1v 34.745n 1.1v 34.755n 1.1v 39.745n 1.1v 39.755n 1.1v 44.745n 1.1v 44.755n 0.0v 49.745n 0.0v 49.755n 0.0v 54.745n 0.0v 54.755n 1.1v 59.745n 1.1v 59.755n 0.0v 64.745n 0.0v 64.755n 0.0v 69.745n 0.0v 69.755n 0.0v 74.745n 0.0v 74.755n 1.1v 79.745n 1.1v 79.755n 0.0v 84.745n 0.0v 84.755n 0.0v 89.745n 0.0v 89.755n 1.1v 94.745n 1.1v 94.755n 1.1v 99.745n 1.1v 99.755n 0.0v 104.745n 0.0v 104.755n 0.0v 109.745n 0.0v 109.755n 1.1v 114.745n 1.1v 114.755n 0.0v 119.745n 0.0v 119.755n 0.0v 124.745n 0.0v 124.755n 1.1v 129.745n 1.1v 129.755n 0.0v 134.745n 0.0v 134.755n 1.1v 139.745n 1.1v 139.755n 0.0v 144.745n 0.0v 144.755n 0.0v 149.745n 0.0v 149.755n 1.1v 154.745n 1.1v 154.755n 0.0v 159.745n 0.0v 159.755n 0.0v 164.745n 0.0v 164.755n 0.0v 169.745n 0.0v 169.755n 0.0v 174.745n 0.0v 174.755n 0.0v 179.745n 0.0v 179.755n 0.0v 184.745n 0.0v 184.755n 0.0v 189.745n 0.0v 189.755n 0.0v 194.745n 0.0v 194.755n 1.1v 199.745n 1.1v 199.755n 1.1v 204.745n 1.1v 204.755n 0.0v 209.745n 0.0v 209.755n 0.0v 214.745n 0.0v 214.755n 0.0v 219.745n 0.0v 219.755n 0.0v 224.745n 0.0v 224.755n 1.1v 229.745n 1.1v 229.755n 0.0v 234.745n 0.0v 234.755n 0.0v 239.745n 0.0v 239.755n 0.0v 244.745n 0.0v 244.755n 0.0v 249.745n 0.0v 249.755n 0.0v 254.745n 0.0v 254.755n 0.0v 259.745n 0.0v 259.755n 0.0v 264.745n 0.0v 264.755n 1.1v 269.745n 1.1v 269.755n 0.0v 274.745n 0.0v 274.755n 0.0v 279.745n 0.0v 279.755n 0.0v 284.745n 0.0v 284.755n 1.1v 289.745n 1.1v 289.755n 0.0v 294.745n 0.0v 294.755n 0.0v 299.745n 0.0v 299.755n 0.0v 304.745n 0.0v 304.755n 1.1v 309.745n 1.1v 309.755n 0.0v 314.745n 0.0v 314.755n 0.0v 319.745n 0.0v 319.755n 0.0v 324.745n 0.0v 324.755n 0.0v 329.745n 0.0v 329.755n 0.0v 334.745n 0.0v 334.755n 0.0v 339.745n 0.0v 339.755n 0.0v 344.745n 0.0v 344.755n 1.1v 349.745n 1.1v 349.755n 0.0v 354.745n 0.0v 354.755n 0.0v 359.745n 0.0v 359.755n 0.0v 364.745n 0.0v 364.755n 0.0v 369.745n 0.0v 369.755n 1.1v 374.745n 1.1v 374.755n 1.1v 379.745n 1.1v 379.755n 0.0v 384.745n 0.0v 384.755n 0.0v 389.745n 0.0v 389.755n 1.1v 394.745n 1.1v 394.755n 0.0v 399.745n 0.0v 399.755n 0.0v 404.745n 0.0v 404.755n 0.0v 409.745n 0.0v 409.755n 0.0v 414.745n 0.0v 414.755n 0.0v 419.745n 0.0v 419.755n 0.0v 424.745n 0.0v 424.755n 0.0v 429.745n 0.0v 429.755n 1.1v 434.745n 1.1v 434.755n 0.0v 439.745n 0.0v 439.755n 0.0v 444.745n 0.0v 444.755n 0.0v 449.745n 0.0v 449.755n 0.0v 454.745n 0.0v 454.755n 0.0v 459.745n 0.0v 459.755n 1.1v 464.745n 1.1v 464.755n 0.0v 469.745n 0.0v 469.755n 0.0v 474.745n 0.0v 474.755n 1.1v 479.745n 1.1v 479.755n 1.1v 484.745n 1.1v 484.755n 1.1v 489.745n 1.1v 489.755n 0.0v 494.745n 0.0v 494.755n 0.0v 499.745n 0.0v 499.755n 0.0v 504.745n 0.0v 504.755n 0.0v 509.745n 0.0v 509.755n 0.0v 514.745n 0.0v 514.755n 0.0v 519.745n 0.0v 519.755n 0.0v 524.745n 0.0v 524.755n 0.0v 529.745n 0.0v 529.755n 1.1v 534.745n 1.1v 534.755n 0.0v 539.745n 0.0v 539.755n 0.0v 544.745n 0.0v 544.755n 0.0v 549.745n 0.0v 549.755n 0.0v 554.745n 0.0v 554.755n 1.1v 559.745n 1.1v 559.755n 0.0v 564.745n 0.0v 564.755n 0.0v 569.745n 0.0v 569.755n 0.0v 574.745n 0.0v 574.755n 0.0v 579.745n 0.0v 579.755n 0.0v 584.745n 0.0v 584.755n 0.0v 589.745n 0.0v 589.755n 0.0v 594.745n 0.0v 594.755n 0.0v 599.745n 0.0v 599.755n 0.0v 604.745n 0.0v 604.755n 0.0v 609.745n 0.0v 609.755n 0.0v 614.745n 0.0v 614.755n 0.0v 619.745n 0.0v 619.755n 1.1v 624.745n 1.1v 624.755n 0.0v 629.745n 0.0v 629.755n 0.0v 634.745n 0.0v 634.755n 0.0v 639.745n 0.0v 639.755n 1.1v 644.745n 1.1v 644.755n 0.0v 649.745n 0.0v 649.755n 0.0v 654.745n 0.0v 654.755n 0.0v 659.745n 0.0v 659.755n 0.0v 664.745n 0.0v 664.755n 0.0v 669.745n 0.0v 669.755n 0.0v 674.745n 0.0v 674.755n 1.1v 679.745n 1.1v 679.755n 1.1v 684.745n 1.1v 684.755n 1.1v 689.745n 1.1v 689.755n 0.0v 694.745n 0.0v 694.755n 0.0v 699.745n 0.0v 699.755n 0.0v 704.745n 0.0v 704.755n 0.0v 709.745n 0.0v 709.755n 0.0v 714.745n 0.0v 714.755n 0.0v 719.745n 0.0v 719.755n 0.0v 724.745n 0.0v 724.755n 0.0v 729.745n 0.0v 729.755n 0.0v 734.745n 0.0v 734.755n 0.0v 739.745n 0.0v 739.755n 1.1v 744.745n 1.1v 744.755n 0.0v 749.745n 0.0v 749.755n 1.1v 754.745n 1.1v 754.755n 0.0v 759.745n 0.0v 759.755n 0.0v 764.745n 0.0v 764.755n 0.0v 769.745n 0.0v 769.755n 0.0v 774.745n 0.0v 774.755n 0.0v 779.745n 0.0v 779.755n 0.0v 784.745n 0.0v 784.755n 0.0v 789.745n 0.0v 789.755n 0.0v 794.745n 0.0v 794.755n 1.1v 799.745n 1.1v 799.755n 1.1v 804.745n 1.1v 804.755n 0.0v 809.745n 0.0v 809.755n 0.0v 814.745n 0.0v 814.755n 0.0v 819.745n 0.0v 819.755n 0.0v 824.745n 0.0v 824.755n 1.1v 829.745n 1.1v 829.755n 0.0v 834.745n 0.0v 834.755n 0.0v 839.745n 0.0v 839.755n 1.1v 844.745n 1.1v 844.755n 0.0v 849.745n 0.0v 849.755n 1.1v 854.745n 1.1v 854.755n 0.0v 859.745n 0.0v 859.755n 0.0v 864.745n 0.0v 864.755n 1.1v 869.745n 1.1v 869.755n 0.0v 874.745n 0.0v 874.755n 0.0v 879.745n 0.0v 879.755n 0.0v 884.745n 0.0v 884.755n 0.0v 889.745n 0.0v 889.755n 0.0v 894.745n 0.0v 894.755n 1.1v 899.745n 1.1v 899.755n 0.0v 904.745n 0.0v 904.755n 0.0v 909.745n 0.0v 909.755n 0.0v 914.745n 0.0v 914.755n 1.1v 919.745n 1.1v 919.755n 0.0v 924.745n 0.0v 924.755n 0.0v 929.745n 0.0v 929.755n 0.0v 934.745n 0.0v 934.755n 0.0v 939.745n 0.0v 939.755n 0.0v 944.745n 0.0v 944.755n 0.0v 949.745n 0.0v 949.755n 0.0v 954.745n 0.0v 954.755n 0.0v 959.745n 0.0v 959.755n 0.0v 964.745n 0.0v 964.755n 0.0v 969.745n 0.0v 969.755n 0.0v 974.745n 0.0v 974.755n 0.0v 979.745n 0.0v 979.755n 0.0v 984.745n 0.0v 984.755n 0.0v 989.745n 0.0v 989.755n 0.0v 994.745n 0.0v 994.755n 0.0v 999.745n 0.0v 999.755n 0.0v 1004.745n 0.0v 1004.755n 0.0v 1009.745n 0.0v 1009.755n 0.0v 1014.745n 0.0v 1014.755n 0.0v 1019.745n 0.0v 1019.755n 0.0v 1024.745n 0.0v 1024.755n 1.1v )
* (time, data): [(0, 1), (5, 0), (10, 0), (15, 0), (20, 1), (25, 1), (30, 1), (35, 1), (40, 1), (45, 1), (50, 0), (55, 1), (60, 1), (65, 1), (70, 0), (75, 1), (80, 1), (85, 0), (90, 1), (95, 1), (100, 0), (105, 1), (110, 1), (115, 0), (120, 1), (125, 1), (130, 1), (135, 1), (140, 0), (145, 0), (150, 1), (155, 1), (160, 1), (165, 1), (170, 1), (175, 1), (180, 0), (185, 1), (190, 1), (195, 1), (200, 1), (205, 0), (210, 0), (215, 1), (220, 0), (225, 1), (230, 1), (235, 1), (240, 0), (245, 1), (250, 1), (255, 1), (260, 1), (265, 1), (270, 0), (275, 1), (280, 0), (285, 1), (290, 0), (295, 0), (300, 0), (305, 1), (310, 1), (315, 0), (320, 0), (325, 0), (330, 0), (335, 0), (340, 0), (345, 1), (350, 1), (355, 1), (360, 1), (365, 1), (370, 1), (375, 1), (380, 1), (385, 0), (390, 1), (395, 0), (400, 1), (405, 0), (410, 0), (415, 1), (420, 1), (425, 0), (430, 1), (435, 0), (440, 1), (445, 0), (450, 0), (455, 0), (460, 1), (465, 1), (470, 1), (475, 1), (480, 1), (485, 1), (490, 0), (495, 1), (500, 1), (505, 1), (510, 0), (515, 0), (520, 1), (525, 1), (530, 1), (535, 0), (540, 0), (545, 0), (550, 0), (555, 1), (560, 1), (565, 1), (570, 0), (575, 0), (580, 0), (585, 0), (590, 0), (595, 0), (600, 0), (605, 0), (610, 1), (615, 0), (620, 1), (625, 0), (630, 1), (635, 1), (640, 1), (645, 0), (650, 1), (655, 1), (660, 1), (665, 0), (670, 0), (675, 1), (680, 1), (685, 1), (690, 0), (695, 0), (700, 0), (705, 0), (710, 0), (715, 1), (720, 1), (725, 1), (730, 1), (735, 0), (740, 1), (745, 0), (750, 1), (755, 0), (760, 1), (765, 0), (770, 1), (775, 1), (780, 1), (785, 0), (790, 1), (795, 1), (800, 1), (805, 1), (810, 0), (815, 0), (820, 0), (825, 1), (830, 1), (835, 0), (840, 1), (845, 1), (850, 1), (855, 1), (860, 0), (865, 1), (870, 1), (875, 1), (880, 1), (885, 1), (890, 0), (895, 1), (900, 0), (905, 0), (910, 0), (915, 1), (920, 0), (925, 1), (930, 0), (935, 0), (940, 0), (945, 1), (950, 0), (955, 0), (960, 0), (965, 0), (970, 0), (975, 1), (980, 1), (985, 0), (990, 0), (995, 0), (1000, 0), (1005, 1), (1010, 0), (1015, 1), (1020, 1), (1025, 1)]
VWEB0 WEB0 0 PWL (0n 1.1v 4.745n 1.1v 4.755n 0.0v 9.745n 0.0v 9.755n 0.0v 14.745n 0.0v 14.755n 0.0v 19.745n 0.0v 19.755n 1.1v 24.745n 1.1v 24.755n 1.1v 29.745n 1.1v 29.755n 1.1v 34.745n 1.1v 34.755n 1.1v 39.745n 1.1v 39.755n 1.1v 44.745n 1.1v 44.755n 1.1v 49.745n 1.1v 49.755n 0.0v 54.745n 0.0v 54.755n 1.1v 59.745n 1.1v 59.755n 1.1v 64.745n 1.1v 64.755n 1.1v 69.745n 1.1v 69.755n 0.0v 74.745n 0.0v 74.755n 1.1v 79.745n 1.1v 79.755n 1.1v 84.745n 1.1v 84.755n 0.0v 89.745n 0.0v 89.755n 1.1v 94.745n 1.1v 94.755n 1.1v 99.745n 1.1v 99.755n 0.0v 104.745n 0.0v 104.755n 1.1v 109.745n 1.1v 109.755n 1.1v 114.745n 1.1v 114.755n 0.0v 119.745n 0.0v 119.755n 1.1v 124.745n 1.1v 124.755n 1.1v 129.745n 1.1v 129.755n 1.1v 134.745n 1.1v 134.755n 1.1v 139.745n 1.1v 139.755n 0.0v 144.745n 0.0v 144.755n 0.0v 149.745n 0.0v 149.755n 1.1v 154.745n 1.1v 154.755n 1.1v 159.745n 1.1v 159.755n 1.1v 164.745n 1.1v 164.755n 1.1v 169.745n 1.1v 169.755n 1.1v 174.745n 1.1v 174.755n 1.1v 179.745n 1.1v 179.755n 0.0v 184.745n 0.0v 184.755n 1.1v 189.745n 1.1v 189.755n 1.1v 194.745n 1.1v 194.755n 1.1v 199.745n 1.1v 199.755n 1.1v 204.745n 1.1v 204.755n 0.0v 209.745n 0.0v 209.755n 0.0v 214.745n 0.0v 214.755n 1.1v 219.745n 1.1v 219.755n 0.0v 224.745n 0.0v 224.755n 1.1v 229.745n 1.1v 229.755n 1.1v 234.745n 1.1v 234.755n 1.1v 239.745n 1.1v 239.755n 0.0v 244.745n 0.0v 244.755n 1.1v 249.745n 1.1v 249.755n 1.1v 254.745n 1.1v 254.755n 1.1v 259.745n 1.1v 259.755n 1.1v 264.745n 1.1v 264.755n 1.1v 269.745n 1.1v 269.755n 0.0v 274.745n 0.0v 274.755n 1.1v 279.745n 1.1v 279.755n 0.0v 284.745n 0.0v 284.755n 1.1v 289.745n 1.1v 289.755n 0.0v 294.745n 0.0v 294.755n 0.0v 299.745n 0.0v 299.755n 0.0v 304.745n 0.0v 304.755n 1.1v 309.745n 1.1v 309.755n 1.1v 314.745n 1.1v 314.755n 0.0v 319.745n 0.0v 319.755n 0.0v 324.745n 0.0v 324.755n 0.0v 329.745n 0.0v 329.755n 0.0v 334.745n 0.0v 334.755n 0.0v 339.745n 0.0v 339.755n 0.0v 344.745n 0.0v 344.755n 1.1v 349.745n 1.1v 349.755n 1.1v 354.745n 1.1v 354.755n 1.1v 359.745n 1.1v 359.755n 1.1v 364.745n 1.1v 364.755n 1.1v 369.745n 1.1v 369.755n 1.1v 374.745n 1.1v 374.755n 1.1v 379.745n 1.1v 379.755n 1.1v 384.745n 1.1v 384.755n 0.0v 389.745n 0.0v 389.755n 1.1v 394.745n 1.1v 394.755n 0.0v 399.745n 0.0v 399.755n 1.1v 404.745n 1.1v 404.755n 0.0v 409.745n 0.0v 409.755n 0.0v 414.745n 0.0v 414.755n 1.1v 419.745n 1.1v 419.755n 1.1v 424.745n 1.1v 424.755n 0.0v 429.745n 0.0v 429.755n 1.1v 434.745n 1.1v 434.755n 0.0v 439.745n 0.0v 439.755n 1.1v 444.745n 1.1v 444.755n 0.0v 449.745n 0.0v 449.755n 0.0v 454.745n 0.0v 454.755n 0.0v 459.745n 0.0v 459.755n 1.1v 464.745n 1.1v 464.755n 1.1v 469.745n 1.1v 469.755n 1.1v 474.745n 1.1v 474.755n 1.1v 479.745n 1.1v 479.755n 1.1v 484.745n 1.1v 484.755n 1.1v 489.745n 1.1v 489.755n 0.0v 494.745n 0.0v 494.755n 1.1v 499.745n 1.1v 499.755n 1.1v 504.745n 1.1v 504.755n 1.1v 509.745n 1.1v 509.755n 0.0v 514.745n 0.0v 514.755n 0.0v 519.745n 0.0v 519.755n 1.1v 524.745n 1.1v 524.755n 1.1v 529.745n 1.1v 529.755n 1.1v 534.745n 1.1v 534.755n 0.0v 539.745n 0.0v 539.755n 0.0v 544.745n 0.0v 544.755n 0.0v 549.745n 0.0v 549.755n 0.0v 554.745n 0.0v 554.755n 1.1v 559.745n 1.1v 559.755n 1.1v 564.745n 1.1v 564.755n 1.1v 569.745n 1.1v 569.755n 0.0v 574.745n 0.0v 574.755n 0.0v 579.745n 0.0v 579.755n 0.0v 584.745n 0.0v 584.755n 0.0v 589.745n 0.0v 589.755n 0.0v 594.745n 0.0v 594.755n 0.0v 599.745n 0.0v 599.755n 0.0v 604.745n 0.0v 604.755n 0.0v 609.745n 0.0v 609.755n 1.1v 614.745n 1.1v 614.755n 0.0v 619.745n 0.0v 619.755n 1.1v 624.745n 1.1v 624.755n 0.0v 629.745n 0.0v 629.755n 1.1v 634.745n 1.1v 634.755n 1.1v 639.745n 1.1v 639.755n 1.1v 644.745n 1.1v 644.755n 0.0v 649.745n 0.0v 649.755n 1.1v 654.745n 1.1v 654.755n 1.1v 659.745n 1.1v 659.755n 1.1v 664.745n 1.1v 664.755n 0.0v 669.745n 0.0v 669.755n 0.0v 674.745n 0.0v 674.755n 1.1v 679.745n 1.1v 679.755n 1.1v 684.745n 1.1v 684.755n 1.1v 689.745n 1.1v 689.755n 0.0v 694.745n 0.0v 694.755n 0.0v 699.745n 0.0v 699.755n 0.0v 704.745n 0.0v 704.755n 0.0v 709.745n 0.0v 709.755n 0.0v 714.745n 0.0v 714.755n 1.1v 719.745n 1.1v 719.755n 1.1v 724.745n 1.1v 724.755n 1.1v 729.745n 1.1v 729.755n 1.1v 734.745n 1.1v 734.755n 0.0v 739.745n 0.0v 739.755n 1.1v 744.745n 1.1v 744.755n 0.0v 749.745n 0.0v 749.755n 1.1v 754.745n 1.1v 754.755n 0.0v 759.745n 0.0v 759.755n 1.1v 764.745n 1.1v 764.755n 0.0v 769.745n 0.0v 769.755n 1.1v 774.745n 1.1v 774.755n 1.1v 779.745n 1.1v 779.755n 1.1v 784.745n 1.1v 784.755n 0.0v 789.745n 0.0v 789.755n 1.1v 794.745n 1.1v 794.755n 1.1v 799.745n 1.1v 799.755n 1.1v 804.745n 1.1v 804.755n 1.1v 809.745n 1.1v 809.755n 0.0v 814.745n 0.0v 814.755n 0.0v 819.745n 0.0v 819.755n 0.0v 824.745n 0.0v 824.755n 1.1v 829.745n 1.1v 829.755n 1.1v 834.745n 1.1v 834.755n 0.0v 839.745n 0.0v 839.755n 1.1v 844.745n 1.1v 844.755n 1.1v 849.745n 1.1v 849.755n 1.1v 854.745n 1.1v 854.755n 1.1v 859.745n 1.1v 859.755n 0.0v 864.745n 0.0v 864.755n 1.1v 869.745n 1.1v 869.755n 1.1v 874.745n 1.1v 874.755n 1.1v 879.745n 1.1v 879.755n 1.1v 884.745n 1.1v 884.755n 1.1v 889.745n 1.1v 889.755n 0.0v 894.745n 0.0v 894.755n 1.1v 899.745n 1.1v 899.755n 0.0v 904.745n 0.0v 904.755n 0.0v 909.745n 0.0v 909.755n 0.0v 914.745n 0.0v 914.755n 1.1v 919.745n 1.1v 919.755n 0.0v 924.745n 0.0v 924.755n 1.1v 929.745n 1.1v 929.755n 0.0v 934.745n 0.0v 934.755n 0.0v 939.745n 0.0v 939.755n 0.0v 944.745n 0.0v 944.755n 1.1v 949.745n 1.1v 949.755n 0.0v 954.745n 0.0v 954.755n 0.0v 959.745n 0.0v 959.755n 0.0v 964.745n 0.0v 964.755n 0.0v 969.745n 0.0v 969.755n 0.0v 974.745n 0.0v 974.755n 1.1v 979.745n 1.1v 979.755n 1.1v 984.745n 1.1v 984.755n 0.0v 989.745n 0.0v 989.755n 0.0v 994.745n 0.0v 994.755n 0.0v 999.745n 0.0v 999.755n 0.0v 1004.745n 0.0v 1004.755n 1.1v 1009.745n 1.1v 1009.755n 0.0v 1014.745n 0.0v 1014.755n 1.1v 1019.745n 1.1v 1019.755n 1.1v 1024.745n 1.1v 1024.755n 1.1v )

* Generation of wmask signals
* (time, data): [(0, 0), (5, 1), (10, 1), (15, 1), (20, 1), (25, 1), (30, 1), (35, 1), (40, 1), (45, 1), (50, 1), (55, 1), (60, 1), (65, 1), (70, 1), (75, 1), (80, 1), (85, 0), (90, 0), (95, 0), (100, 1), (105, 1), (110, 1), (115, 0), (120, 0), (125, 0), (130, 0), (135, 0), (140, 1), (145, 1), (150, 1), (155, 1), (160, 1), (165, 1), (170, 1), (175, 1), (180, 1), (185, 1), (190, 1), (195, 1), (200, 1), (205, 1), (210, 1), (215, 1), (220, 0), (225, 0), (230, 0), (235, 0), (240, 1), (245, 1), (250, 1), (255, 1), (260, 1), (265, 1), (270, 0), (275, 0), (280, 1), (285, 1), (290, 0), (295, 1), (300, 0), (305, 0), (310, 0), (315, 1), (320, 1), (325, 0), (330, 0), (335, 1), (340, 0), (345, 0), (350, 0), (355, 0), (360, 0), (365, 0), (370, 0), (375, 0), (380, 0), (385, 1), (390, 1), (395, 1), (400, 1), (405, 1), (410, 1), (415, 1), (420, 1), (425, 1), (430, 1), (435, 1), (440, 1), (445, 1), (450, 0), (455, 1), (460, 1), (465, 1), (470, 1), (475, 1), (480, 1), (485, 1), (490, 1), (495, 1), (500, 1), (505, 1), (510, 1), (515, 1), (520, 1), (525, 1), (530, 1), (535, 1), (540, 1), (545, 1), (550, 1), (555, 1), (560, 1), (565, 1), (570, 0), (575, 0), (580, 0), (585, 1), (590, 0), (595, 1), (600, 1), (605, 1), (610, 1), (615, 1), (620, 1), (625, 1), (630, 1), (635, 1), (640, 1), (645, 1), (650, 1), (655, 1), (660, 1), (665, 0), (670, 0), (675, 0), (680, 0), (685, 0), (690, 0), (695, 1), (700, 0), (705, 1), (710, 0), (715, 0), (720, 0), (725, 0), (730, 0), (735, 0), (740, 0), (745, 0), (750, 0), (755, 0), (760, 0), (765, 1), (770, 1), (775, 1), (780, 1), (785, 0), (790, 0), (795, 0), (800, 0), (805, 0), (810, 1), (815, 1), (820, 1), (825, 1), (830, 1), (835, 1), (840, 1), (845, 1), (850, 1), (855, 1), (860, 1), (865, 1), (870, 1), (875, 1), (880, 1), (885, 1), (890, 1), (895, 1), (900, 0), (905, 1), (910, 1), (915, 1), (920, 1), (925, 1), (930, 1), (935, 1), (940, 1), (945, 1), (950, 1), (955, 1), (960, 1), (965, 0), (970, 1), (975, 1), (980, 1), (985, 1), (990, 1), (995, 0), (1000, 1), (1005, 1), (1010, 1), (1015, 1), (1020, 1), (1025, 1)]
VWMASK0_0  WMASK0_0  0 PWL (0n 0.0v 4.745n 0.0v 4.755n 1.1v 9.745n 1.1v 9.755n 1.1v 14.745n 1.1v 14.755n 1.1v 19.745n 1.1v 19.755n 1.1v 24.745n 1.1v 24.755n 1.1v 29.745n 1.1v 29.755n 1.1v 34.745n 1.1v 34.755n 1.1v 39.745n 1.1v 39.755n 1.1v 44.745n 1.1v 44.755n 1.1v 49.745n 1.1v 49.755n 1.1v 54.745n 1.1v 54.755n 1.1v 59.745n 1.1v 59.755n 1.1v 64.745n 1.1v 64.755n 1.1v 69.745n 1.1v 69.755n 1.1v 74.745n 1.1v 74.755n 1.1v 79.745n 1.1v 79.755n 1.1v 84.745n 1.1v 84.755n 0.0v 89.745n 0.0v 89.755n 0.0v 94.745n 0.0v 94.755n 0.0v 99.745n 0.0v 99.755n 1.1v 104.745n 1.1v 104.755n 1.1v 109.745n 1.1v 109.755n 1.1v 114.745n 1.1v 114.755n 0.0v 119.745n 0.0v 119.755n 0.0v 124.745n 0.0v 124.755n 0.0v 129.745n 0.0v 129.755n 0.0v 134.745n 0.0v 134.755n 0.0v 139.745n 0.0v 139.755n 1.1v 144.745n 1.1v 144.755n 1.1v 149.745n 1.1v 149.755n 1.1v 154.745n 1.1v 154.755n 1.1v 159.745n 1.1v 159.755n 1.1v 164.745n 1.1v 164.755n 1.1v 169.745n 1.1v 169.755n 1.1v 174.745n 1.1v 174.755n 1.1v 179.745n 1.1v 179.755n 1.1v 184.745n 1.1v 184.755n 1.1v 189.745n 1.1v 189.755n 1.1v 194.745n 1.1v 194.755n 1.1v 199.745n 1.1v 199.755n 1.1v 204.745n 1.1v 204.755n 1.1v 209.745n 1.1v 209.755n 1.1v 214.745n 1.1v 214.755n 1.1v 219.745n 1.1v 219.755n 0.0v 224.745n 0.0v 224.755n 0.0v 229.745n 0.0v 229.755n 0.0v 234.745n 0.0v 234.755n 0.0v 239.745n 0.0v 239.755n 1.1v 244.745n 1.1v 244.755n 1.1v 249.745n 1.1v 249.755n 1.1v 254.745n 1.1v 254.755n 1.1v 259.745n 1.1v 259.755n 1.1v 264.745n 1.1v 264.755n 1.1v 269.745n 1.1v 269.755n 0.0v 274.745n 0.0v 274.755n 0.0v 279.745n 0.0v 279.755n 1.1v 284.745n 1.1v 284.755n 1.1v 289.745n 1.1v 289.755n 0.0v 294.745n 0.0v 294.755n 1.1v 299.745n 1.1v 299.755n 0.0v 304.745n 0.0v 304.755n 0.0v 309.745n 0.0v 309.755n 0.0v 314.745n 0.0v 314.755n 1.1v 319.745n 1.1v 319.755n 1.1v 324.745n 1.1v 324.755n 0.0v 329.745n 0.0v 329.755n 0.0v 334.745n 0.0v 334.755n 1.1v 339.745n 1.1v 339.755n 0.0v 344.745n 0.0v 344.755n 0.0v 349.745n 0.0v 349.755n 0.0v 354.745n 0.0v 354.755n 0.0v 359.745n 0.0v 359.755n 0.0v 364.745n 0.0v 364.755n 0.0v 369.745n 0.0v 369.755n 0.0v 374.745n 0.0v 374.755n 0.0v 379.745n 0.0v 379.755n 0.0v 384.745n 0.0v 384.755n 1.1v 389.745n 1.1v 389.755n 1.1v 394.745n 1.1v 394.755n 1.1v 399.745n 1.1v 399.755n 1.1v 404.745n 1.1v 404.755n 1.1v 409.745n 1.1v 409.755n 1.1v 414.745n 1.1v 414.755n 1.1v 419.745n 1.1v 419.755n 1.1v 424.745n 1.1v 424.755n 1.1v 429.745n 1.1v 429.755n 1.1v 434.745n 1.1v 434.755n 1.1v 439.745n 1.1v 439.755n 1.1v 444.745n 1.1v 444.755n 1.1v 449.745n 1.1v 449.755n 0.0v 454.745n 0.0v 454.755n 1.1v 459.745n 1.1v 459.755n 1.1v 464.745n 1.1v 464.755n 1.1v 469.745n 1.1v 469.755n 1.1v 474.745n 1.1v 474.755n 1.1v 479.745n 1.1v 479.755n 1.1v 484.745n 1.1v 484.755n 1.1v 489.745n 1.1v 489.755n 1.1v 494.745n 1.1v 494.755n 1.1v 499.745n 1.1v 499.755n 1.1v 504.745n 1.1v 504.755n 1.1v 509.745n 1.1v 509.755n 1.1v 514.745n 1.1v 514.755n 1.1v 519.745n 1.1v 519.755n 1.1v 524.745n 1.1v 524.755n 1.1v 529.745n 1.1v 529.755n 1.1v 534.745n 1.1v 534.755n 1.1v 539.745n 1.1v 539.755n 1.1v 544.745n 1.1v 544.755n 1.1v 549.745n 1.1v 549.755n 1.1v 554.745n 1.1v 554.755n 1.1v 559.745n 1.1v 559.755n 1.1v 564.745n 1.1v 564.755n 1.1v 569.745n 1.1v 569.755n 0.0v 574.745n 0.0v 574.755n 0.0v 579.745n 0.0v 579.755n 0.0v 584.745n 0.0v 584.755n 1.1v 589.745n 1.1v 589.755n 0.0v 594.745n 0.0v 594.755n 1.1v 599.745n 1.1v 599.755n 1.1v 604.745n 1.1v 604.755n 1.1v 609.745n 1.1v 609.755n 1.1v 614.745n 1.1v 614.755n 1.1v 619.745n 1.1v 619.755n 1.1v 624.745n 1.1v 624.755n 1.1v 629.745n 1.1v 629.755n 1.1v 634.745n 1.1v 634.755n 1.1v 639.745n 1.1v 639.755n 1.1v 644.745n 1.1v 644.755n 1.1v 649.745n 1.1v 649.755n 1.1v 654.745n 1.1v 654.755n 1.1v 659.745n 1.1v 659.755n 1.1v 664.745n 1.1v 664.755n 0.0v 669.745n 0.0v 669.755n 0.0v 674.745n 0.0v 674.755n 0.0v 679.745n 0.0v 679.755n 0.0v 684.745n 0.0v 684.755n 0.0v 689.745n 0.0v 689.755n 0.0v 694.745n 0.0v 694.755n 1.1v 699.745n 1.1v 699.755n 0.0v 704.745n 0.0v 704.755n 1.1v 709.745n 1.1v 709.755n 0.0v 714.745n 0.0v 714.755n 0.0v 719.745n 0.0v 719.755n 0.0v 724.745n 0.0v 724.755n 0.0v 729.745n 0.0v 729.755n 0.0v 734.745n 0.0v 734.755n 0.0v 739.745n 0.0v 739.755n 0.0v 744.745n 0.0v 744.755n 0.0v 749.745n 0.0v 749.755n 0.0v 754.745n 0.0v 754.755n 0.0v 759.745n 0.0v 759.755n 0.0v 764.745n 0.0v 764.755n 1.1v 769.745n 1.1v 769.755n 1.1v 774.745n 1.1v 774.755n 1.1v 779.745n 1.1v 779.755n 1.1v 784.745n 1.1v 784.755n 0.0v 789.745n 0.0v 789.755n 0.0v 794.745n 0.0v 794.755n 0.0v 799.745n 0.0v 799.755n 0.0v 804.745n 0.0v 804.755n 0.0v 809.745n 0.0v 809.755n 1.1v 814.745n 1.1v 814.755n 1.1v 819.745n 1.1v 819.755n 1.1v 824.745n 1.1v 824.755n 1.1v 829.745n 1.1v 829.755n 1.1v 834.745n 1.1v 834.755n 1.1v 839.745n 1.1v 839.755n 1.1v 844.745n 1.1v 844.755n 1.1v 849.745n 1.1v 849.755n 1.1v 854.745n 1.1v 854.755n 1.1v 859.745n 1.1v 859.755n 1.1v 864.745n 1.1v 864.755n 1.1v 869.745n 1.1v 869.755n 1.1v 874.745n 1.1v 874.755n 1.1v 879.745n 1.1v 879.755n 1.1v 884.745n 1.1v 884.755n 1.1v 889.745n 1.1v 889.755n 1.1v 894.745n 1.1v 894.755n 1.1v 899.745n 1.1v 899.755n 0.0v 904.745n 0.0v 904.755n 1.1v 909.745n 1.1v 909.755n 1.1v 914.745n 1.1v 914.755n 1.1v 919.745n 1.1v 919.755n 1.1v 924.745n 1.1v 924.755n 1.1v 929.745n 1.1v 929.755n 1.1v 934.745n 1.1v 934.755n 1.1v 939.745n 1.1v 939.755n 1.1v 944.745n 1.1v 944.755n 1.1v 949.745n 1.1v 949.755n 1.1v 954.745n 1.1v 954.755n 1.1v 959.745n 1.1v 959.755n 1.1v 964.745n 1.1v 964.755n 0.0v 969.745n 0.0v 969.755n 1.1v 974.745n 1.1v 974.755n 1.1v 979.745n 1.1v 979.755n 1.1v 984.745n 1.1v 984.755n 1.1v 989.745n 1.1v 989.755n 1.1v 994.745n 1.1v 994.755n 0.0v 999.745n 0.0v 999.755n 1.1v 1004.745n 1.1v 1004.755n 1.1v 1009.745n 1.1v 1009.755n 1.1v 1014.745n 1.1v 1014.755n 1.1v 1019.745n 1.1v 1019.755n 1.1v 1024.745n 1.1v 1024.755n 1.1v )
* (time, data): [(0, 0), (5, 1), (10, 1), (15, 1), (20, 1), (25, 1), (30, 1), (35, 1), (40, 1), (45, 1), (50, 1), (55, 1), (60, 1), (65, 1), (70, 1), (75, 1), (80, 1), (85, 1), (90, 1), (95, 1), (100, 1), (105, 1), (110, 1), (115, 1), (120, 1), (125, 1), (130, 1), (135, 1), (140, 1), (145, 0), (150, 0), (155, 0), (160, 0), (165, 0), (170, 0), (175, 0), (180, 0), (185, 0), (190, 0), (195, 0), (200, 0), (205, 0), (210, 1), (215, 1), (220, 1), (225, 1), (230, 1), (235, 1), (240, 1), (245, 1), (250, 1), (255, 1), (260, 1), (265, 1), (270, 1), (275, 1), (280, 1), (285, 1), (290, 1), (295, 1), (300, 0), (305, 0), (310, 0), (315, 1), (320, 1), (325, 0), (330, 0), (335, 1), (340, 1), (345, 1), (350, 1), (355, 1), (360, 1), (365, 1), (370, 1), (375, 1), (380, 1), (385, 1), (390, 1), (395, 0), (400, 0), (405, 1), (410, 1), (415, 1), (420, 1), (425, 0), (430, 0), (435, 1), (440, 1), (445, 1), (450, 1), (455, 1), (460, 1), (465, 1), (470, 1), (475, 1), (480, 1), (485, 1), (490, 1), (495, 1), (500, 1), (505, 1), (510, 1), (515, 1), (520, 1), (525, 1), (530, 1), (535, 1), (540, 1), (545, 0), (550, 1), (555, 1), (560, 1), (565, 1), (570, 0), (575, 1), (580, 1), (585, 1), (590, 1), (595, 1), (600, 1), (605, 0), (610, 0), (615, 0), (620, 0), (625, 0), (630, 0), (635, 0), (640, 0), (645, 1), (650, 1), (655, 1), (660, 1), (665, 1), (670, 1), (675, 1), (680, 1), (685, 1), (690, 0), (695, 1), (700, 1), (705, 1), (710, 1), (715, 1), (720, 1), (725, 1), (730, 1), (735, 1), (740, 1), (745, 1), (750, 1), (755, 1), (760, 1), (765, 0), (770, 0), (775, 0), (780, 0), (785, 1), (790, 1), (795, 1), (800, 1), (805, 1), (810, 0), (815, 1), (820, 1), (825, 1), (830, 1), (835, 1), (840, 1), (845, 1), (850, 1), (855, 1), (860, 1), (865, 1), (870, 1), (875, 1), (880, 1), (885, 1), (890, 1), (895, 1), (900, 1), (905, 1), (910, 1), (915, 1), (920, 1), (925, 1), (930, 1), (935, 1), (940, 1), (945, 1), (950, 1), (955, 0), (960, 1), (965, 1), (970, 1), (975, 1), (980, 1), (985, 1), (990, 1), (995, 1), (1000, 1), (1005, 1), (1010, 1), (1015, 1), (1020, 1), (1025, 1)]
VWMASK0_1  WMASK0_1  0 PWL (0n 0.0v 4.745n 0.0v 4.755n 1.1v 9.745n 1.1v 9.755n 1.1v 14.745n 1.1v 14.755n 1.1v 19.745n 1.1v 19.755n 1.1v 24.745n 1.1v 24.755n 1.1v 29.745n 1.1v 29.755n 1.1v 34.745n 1.1v 34.755n 1.1v 39.745n 1.1v 39.755n 1.1v 44.745n 1.1v 44.755n 1.1v 49.745n 1.1v 49.755n 1.1v 54.745n 1.1v 54.755n 1.1v 59.745n 1.1v 59.755n 1.1v 64.745n 1.1v 64.755n 1.1v 69.745n 1.1v 69.755n 1.1v 74.745n 1.1v 74.755n 1.1v 79.745n 1.1v 79.755n 1.1v 84.745n 1.1v 84.755n 1.1v 89.745n 1.1v 89.755n 1.1v 94.745n 1.1v 94.755n 1.1v 99.745n 1.1v 99.755n 1.1v 104.745n 1.1v 104.755n 1.1v 109.745n 1.1v 109.755n 1.1v 114.745n 1.1v 114.755n 1.1v 119.745n 1.1v 119.755n 1.1v 124.745n 1.1v 124.755n 1.1v 129.745n 1.1v 129.755n 1.1v 134.745n 1.1v 134.755n 1.1v 139.745n 1.1v 139.755n 1.1v 144.745n 1.1v 144.755n 0.0v 149.745n 0.0v 149.755n 0.0v 154.745n 0.0v 154.755n 0.0v 159.745n 0.0v 159.755n 0.0v 164.745n 0.0v 164.755n 0.0v 169.745n 0.0v 169.755n 0.0v 174.745n 0.0v 174.755n 0.0v 179.745n 0.0v 179.755n 0.0v 184.745n 0.0v 184.755n 0.0v 189.745n 0.0v 189.755n 0.0v 194.745n 0.0v 194.755n 0.0v 199.745n 0.0v 199.755n 0.0v 204.745n 0.0v 204.755n 0.0v 209.745n 0.0v 209.755n 1.1v 214.745n 1.1v 214.755n 1.1v 219.745n 1.1v 219.755n 1.1v 224.745n 1.1v 224.755n 1.1v 229.745n 1.1v 229.755n 1.1v 234.745n 1.1v 234.755n 1.1v 239.745n 1.1v 239.755n 1.1v 244.745n 1.1v 244.755n 1.1v 249.745n 1.1v 249.755n 1.1v 254.745n 1.1v 254.755n 1.1v 259.745n 1.1v 259.755n 1.1v 264.745n 1.1v 264.755n 1.1v 269.745n 1.1v 269.755n 1.1v 274.745n 1.1v 274.755n 1.1v 279.745n 1.1v 279.755n 1.1v 284.745n 1.1v 284.755n 1.1v 289.745n 1.1v 289.755n 1.1v 294.745n 1.1v 294.755n 1.1v 299.745n 1.1v 299.755n 0.0v 304.745n 0.0v 304.755n 0.0v 309.745n 0.0v 309.755n 0.0v 314.745n 0.0v 314.755n 1.1v 319.745n 1.1v 319.755n 1.1v 324.745n 1.1v 324.755n 0.0v 329.745n 0.0v 329.755n 0.0v 334.745n 0.0v 334.755n 1.1v 339.745n 1.1v 339.755n 1.1v 344.745n 1.1v 344.755n 1.1v 349.745n 1.1v 349.755n 1.1v 354.745n 1.1v 354.755n 1.1v 359.745n 1.1v 359.755n 1.1v 364.745n 1.1v 364.755n 1.1v 369.745n 1.1v 369.755n 1.1v 374.745n 1.1v 374.755n 1.1v 379.745n 1.1v 379.755n 1.1v 384.745n 1.1v 384.755n 1.1v 389.745n 1.1v 389.755n 1.1v 394.745n 1.1v 394.755n 0.0v 399.745n 0.0v 399.755n 0.0v 404.745n 0.0v 404.755n 1.1v 409.745n 1.1v 409.755n 1.1v 414.745n 1.1v 414.755n 1.1v 419.745n 1.1v 419.755n 1.1v 424.745n 1.1v 424.755n 0.0v 429.745n 0.0v 429.755n 0.0v 434.745n 0.0v 434.755n 1.1v 439.745n 1.1v 439.755n 1.1v 444.745n 1.1v 444.755n 1.1v 449.745n 1.1v 449.755n 1.1v 454.745n 1.1v 454.755n 1.1v 459.745n 1.1v 459.755n 1.1v 464.745n 1.1v 464.755n 1.1v 469.745n 1.1v 469.755n 1.1v 474.745n 1.1v 474.755n 1.1v 479.745n 1.1v 479.755n 1.1v 484.745n 1.1v 484.755n 1.1v 489.745n 1.1v 489.755n 1.1v 494.745n 1.1v 494.755n 1.1v 499.745n 1.1v 499.755n 1.1v 504.745n 1.1v 504.755n 1.1v 509.745n 1.1v 509.755n 1.1v 514.745n 1.1v 514.755n 1.1v 519.745n 1.1v 519.755n 1.1v 524.745n 1.1v 524.755n 1.1v 529.745n 1.1v 529.755n 1.1v 534.745n 1.1v 534.755n 1.1v 539.745n 1.1v 539.755n 1.1v 544.745n 1.1v 544.755n 0.0v 549.745n 0.0v 549.755n 1.1v 554.745n 1.1v 554.755n 1.1v 559.745n 1.1v 559.755n 1.1v 564.745n 1.1v 564.755n 1.1v 569.745n 1.1v 569.755n 0.0v 574.745n 0.0v 574.755n 1.1v 579.745n 1.1v 579.755n 1.1v 584.745n 1.1v 584.755n 1.1v 589.745n 1.1v 589.755n 1.1v 594.745n 1.1v 594.755n 1.1v 599.745n 1.1v 599.755n 1.1v 604.745n 1.1v 604.755n 0.0v 609.745n 0.0v 609.755n 0.0v 614.745n 0.0v 614.755n 0.0v 619.745n 0.0v 619.755n 0.0v 624.745n 0.0v 624.755n 0.0v 629.745n 0.0v 629.755n 0.0v 634.745n 0.0v 634.755n 0.0v 639.745n 0.0v 639.755n 0.0v 644.745n 0.0v 644.755n 1.1v 649.745n 1.1v 649.755n 1.1v 654.745n 1.1v 654.755n 1.1v 659.745n 1.1v 659.755n 1.1v 664.745n 1.1v 664.755n 1.1v 669.745n 1.1v 669.755n 1.1v 674.745n 1.1v 674.755n 1.1v 679.745n 1.1v 679.755n 1.1v 684.745n 1.1v 684.755n 1.1v 689.745n 1.1v 689.755n 0.0v 694.745n 0.0v 694.755n 1.1v 699.745n 1.1v 699.755n 1.1v 704.745n 1.1v 704.755n 1.1v 709.745n 1.1v 709.755n 1.1v 714.745n 1.1v 714.755n 1.1v 719.745n 1.1v 719.755n 1.1v 724.745n 1.1v 724.755n 1.1v 729.745n 1.1v 729.755n 1.1v 734.745n 1.1v 734.755n 1.1v 739.745n 1.1v 739.755n 1.1v 744.745n 1.1v 744.755n 1.1v 749.745n 1.1v 749.755n 1.1v 754.745n 1.1v 754.755n 1.1v 759.745n 1.1v 759.755n 1.1v 764.745n 1.1v 764.755n 0.0v 769.745n 0.0v 769.755n 0.0v 774.745n 0.0v 774.755n 0.0v 779.745n 0.0v 779.755n 0.0v 784.745n 0.0v 784.755n 1.1v 789.745n 1.1v 789.755n 1.1v 794.745n 1.1v 794.755n 1.1v 799.745n 1.1v 799.755n 1.1v 804.745n 1.1v 804.755n 1.1v 809.745n 1.1v 809.755n 0.0v 814.745n 0.0v 814.755n 1.1v 819.745n 1.1v 819.755n 1.1v 824.745n 1.1v 824.755n 1.1v 829.745n 1.1v 829.755n 1.1v 834.745n 1.1v 834.755n 1.1v 839.745n 1.1v 839.755n 1.1v 844.745n 1.1v 844.755n 1.1v 849.745n 1.1v 849.755n 1.1v 854.745n 1.1v 854.755n 1.1v 859.745n 1.1v 859.755n 1.1v 864.745n 1.1v 864.755n 1.1v 869.745n 1.1v 869.755n 1.1v 874.745n 1.1v 874.755n 1.1v 879.745n 1.1v 879.755n 1.1v 884.745n 1.1v 884.755n 1.1v 889.745n 1.1v 889.755n 1.1v 894.745n 1.1v 894.755n 1.1v 899.745n 1.1v 899.755n 1.1v 904.745n 1.1v 904.755n 1.1v 909.745n 1.1v 909.755n 1.1v 914.745n 1.1v 914.755n 1.1v 919.745n 1.1v 919.755n 1.1v 924.745n 1.1v 924.755n 1.1v 929.745n 1.1v 929.755n 1.1v 934.745n 1.1v 934.755n 1.1v 939.745n 1.1v 939.755n 1.1v 944.745n 1.1v 944.755n 1.1v 949.745n 1.1v 949.755n 1.1v 954.745n 1.1v 954.755n 0.0v 959.745n 0.0v 959.755n 1.1v 964.745n 1.1v 964.755n 1.1v 969.745n 1.1v 969.755n 1.1v 974.745n 1.1v 974.755n 1.1v 979.745n 1.1v 979.755n 1.1v 984.745n 1.1v 984.755n 1.1v 989.745n 1.1v 989.755n 1.1v 994.745n 1.1v 994.755n 1.1v 999.745n 1.1v 999.755n 1.1v 1004.745n 1.1v 1004.755n 1.1v 1009.745n 1.1v 1009.755n 1.1v 1014.745n 1.1v 1014.755n 1.1v 1019.745n 1.1v 1019.755n 1.1v 1024.745n 1.1v 1024.755n 1.1v )
* (time, data): [(0, 0), (5, 1), (10, 1), (15, 1), (20, 1), (25, 1), (30, 1), (35, 1), (40, 1), (45, 1), (50, 1), (55, 1), (60, 1), (65, 1), (70, 1), (75, 1), (80, 1), (85, 0), (90, 0), (95, 0), (100, 1), (105, 1), (110, 1), (115, 0), (120, 0), (125, 0), (130, 0), (135, 0), (140, 1), (145, 1), (150, 1), (155, 1), (160, 1), (165, 1), (170, 1), (175, 1), (180, 1), (185, 1), (190, 1), (195, 1), (200, 1), (205, 1), (210, 0), (215, 0), (220, 0), (225, 0), (230, 0), (235, 0), (240, 1), (245, 1), (250, 1), (255, 1), (260, 1), (265, 1), (270, 0), (275, 0), (280, 0), (285, 0), (290, 0), (295, 1), (300, 0), (305, 0), (310, 0), (315, 1), (320, 0), (325, 1), (330, 0), (335, 0), (340, 1), (345, 1), (350, 1), (355, 1), (360, 1), (365, 1), (370, 1), (375, 1), (380, 1), (385, 1), (390, 1), (395, 1), (400, 1), (405, 1), (410, 1), (415, 1), (420, 1), (425, 0), (430, 0), (435, 1), (440, 1), (445, 1), (450, 0), (455, 1), (460, 1), (465, 1), (470, 1), (475, 1), (480, 1), (485, 1), (490, 1), (495, 1), (500, 1), (505, 1), (510, 1), (515, 1), (520, 1), (525, 1), (530, 1), (535, 1), (540, 1), (545, 1), (550, 1), (555, 1), (560, 1), (565, 1), (570, 0), (575, 1), (580, 0), (585, 1), (590, 0), (595, 1), (600, 1), (605, 0), (610, 0), (615, 1), (620, 1), (625, 0), (630, 0), (635, 0), (640, 0), (645, 0), (650, 0), (655, 0), (660, 0), (665, 1), (670, 1), (675, 1), (680, 1), (685, 1), (690, 1), (695, 1), (700, 1), (705, 1), (710, 1), (715, 1), (720, 1), (725, 1), (730, 1), (735, 1), (740, 1), (745, 1), (750, 1), (755, 0), (760, 0), (765, 0), (770, 0), (775, 0), (780, 0), (785, 0), (790, 0), (795, 0), (800, 0), (805, 0), (810, 0), (815, 1), (820, 1), (825, 1), (830, 1), (835, 1), (840, 1), (845, 1), (850, 1), (855, 1), (860, 1), (865, 1), (870, 1), (875, 1), (880, 1), (885, 1), (890, 1), (895, 1), (900, 1), (905, 1), (910, 1), (915, 1), (920, 1), (925, 1), (930, 1), (935, 1), (940, 1), (945, 1), (950, 1), (955, 0), (960, 1), (965, 0), (970, 1), (975, 1), (980, 1), (985, 1), (990, 1), (995, 1), (1000, 1), (1005, 1), (1010, 1), (1015, 1), (1020, 1), (1025, 1)]
VWMASK0_2  WMASK0_2  0 PWL (0n 0.0v 4.745n 0.0v 4.755n 1.1v 9.745n 1.1v 9.755n 1.1v 14.745n 1.1v 14.755n 1.1v 19.745n 1.1v 19.755n 1.1v 24.745n 1.1v 24.755n 1.1v 29.745n 1.1v 29.755n 1.1v 34.745n 1.1v 34.755n 1.1v 39.745n 1.1v 39.755n 1.1v 44.745n 1.1v 44.755n 1.1v 49.745n 1.1v 49.755n 1.1v 54.745n 1.1v 54.755n 1.1v 59.745n 1.1v 59.755n 1.1v 64.745n 1.1v 64.755n 1.1v 69.745n 1.1v 69.755n 1.1v 74.745n 1.1v 74.755n 1.1v 79.745n 1.1v 79.755n 1.1v 84.745n 1.1v 84.755n 0.0v 89.745n 0.0v 89.755n 0.0v 94.745n 0.0v 94.755n 0.0v 99.745n 0.0v 99.755n 1.1v 104.745n 1.1v 104.755n 1.1v 109.745n 1.1v 109.755n 1.1v 114.745n 1.1v 114.755n 0.0v 119.745n 0.0v 119.755n 0.0v 124.745n 0.0v 124.755n 0.0v 129.745n 0.0v 129.755n 0.0v 134.745n 0.0v 134.755n 0.0v 139.745n 0.0v 139.755n 1.1v 144.745n 1.1v 144.755n 1.1v 149.745n 1.1v 149.755n 1.1v 154.745n 1.1v 154.755n 1.1v 159.745n 1.1v 159.755n 1.1v 164.745n 1.1v 164.755n 1.1v 169.745n 1.1v 169.755n 1.1v 174.745n 1.1v 174.755n 1.1v 179.745n 1.1v 179.755n 1.1v 184.745n 1.1v 184.755n 1.1v 189.745n 1.1v 189.755n 1.1v 194.745n 1.1v 194.755n 1.1v 199.745n 1.1v 199.755n 1.1v 204.745n 1.1v 204.755n 1.1v 209.745n 1.1v 209.755n 0.0v 214.745n 0.0v 214.755n 0.0v 219.745n 0.0v 219.755n 0.0v 224.745n 0.0v 224.755n 0.0v 229.745n 0.0v 229.755n 0.0v 234.745n 0.0v 234.755n 0.0v 239.745n 0.0v 239.755n 1.1v 244.745n 1.1v 244.755n 1.1v 249.745n 1.1v 249.755n 1.1v 254.745n 1.1v 254.755n 1.1v 259.745n 1.1v 259.755n 1.1v 264.745n 1.1v 264.755n 1.1v 269.745n 1.1v 269.755n 0.0v 274.745n 0.0v 274.755n 0.0v 279.745n 0.0v 279.755n 0.0v 284.745n 0.0v 284.755n 0.0v 289.745n 0.0v 289.755n 0.0v 294.745n 0.0v 294.755n 1.1v 299.745n 1.1v 299.755n 0.0v 304.745n 0.0v 304.755n 0.0v 309.745n 0.0v 309.755n 0.0v 314.745n 0.0v 314.755n 1.1v 319.745n 1.1v 319.755n 0.0v 324.745n 0.0v 324.755n 1.1v 329.745n 1.1v 329.755n 0.0v 334.745n 0.0v 334.755n 0.0v 339.745n 0.0v 339.755n 1.1v 344.745n 1.1v 344.755n 1.1v 349.745n 1.1v 349.755n 1.1v 354.745n 1.1v 354.755n 1.1v 359.745n 1.1v 359.755n 1.1v 364.745n 1.1v 364.755n 1.1v 369.745n 1.1v 369.755n 1.1v 374.745n 1.1v 374.755n 1.1v 379.745n 1.1v 379.755n 1.1v 384.745n 1.1v 384.755n 1.1v 389.745n 1.1v 389.755n 1.1v 394.745n 1.1v 394.755n 1.1v 399.745n 1.1v 399.755n 1.1v 404.745n 1.1v 404.755n 1.1v 409.745n 1.1v 409.755n 1.1v 414.745n 1.1v 414.755n 1.1v 419.745n 1.1v 419.755n 1.1v 424.745n 1.1v 424.755n 0.0v 429.745n 0.0v 429.755n 0.0v 434.745n 0.0v 434.755n 1.1v 439.745n 1.1v 439.755n 1.1v 444.745n 1.1v 444.755n 1.1v 449.745n 1.1v 449.755n 0.0v 454.745n 0.0v 454.755n 1.1v 459.745n 1.1v 459.755n 1.1v 464.745n 1.1v 464.755n 1.1v 469.745n 1.1v 469.755n 1.1v 474.745n 1.1v 474.755n 1.1v 479.745n 1.1v 479.755n 1.1v 484.745n 1.1v 484.755n 1.1v 489.745n 1.1v 489.755n 1.1v 494.745n 1.1v 494.755n 1.1v 499.745n 1.1v 499.755n 1.1v 504.745n 1.1v 504.755n 1.1v 509.745n 1.1v 509.755n 1.1v 514.745n 1.1v 514.755n 1.1v 519.745n 1.1v 519.755n 1.1v 524.745n 1.1v 524.755n 1.1v 529.745n 1.1v 529.755n 1.1v 534.745n 1.1v 534.755n 1.1v 539.745n 1.1v 539.755n 1.1v 544.745n 1.1v 544.755n 1.1v 549.745n 1.1v 549.755n 1.1v 554.745n 1.1v 554.755n 1.1v 559.745n 1.1v 559.755n 1.1v 564.745n 1.1v 564.755n 1.1v 569.745n 1.1v 569.755n 0.0v 574.745n 0.0v 574.755n 1.1v 579.745n 1.1v 579.755n 0.0v 584.745n 0.0v 584.755n 1.1v 589.745n 1.1v 589.755n 0.0v 594.745n 0.0v 594.755n 1.1v 599.745n 1.1v 599.755n 1.1v 604.745n 1.1v 604.755n 0.0v 609.745n 0.0v 609.755n 0.0v 614.745n 0.0v 614.755n 1.1v 619.745n 1.1v 619.755n 1.1v 624.745n 1.1v 624.755n 0.0v 629.745n 0.0v 629.755n 0.0v 634.745n 0.0v 634.755n 0.0v 639.745n 0.0v 639.755n 0.0v 644.745n 0.0v 644.755n 0.0v 649.745n 0.0v 649.755n 0.0v 654.745n 0.0v 654.755n 0.0v 659.745n 0.0v 659.755n 0.0v 664.745n 0.0v 664.755n 1.1v 669.745n 1.1v 669.755n 1.1v 674.745n 1.1v 674.755n 1.1v 679.745n 1.1v 679.755n 1.1v 684.745n 1.1v 684.755n 1.1v 689.745n 1.1v 689.755n 1.1v 694.745n 1.1v 694.755n 1.1v 699.745n 1.1v 699.755n 1.1v 704.745n 1.1v 704.755n 1.1v 709.745n 1.1v 709.755n 1.1v 714.745n 1.1v 714.755n 1.1v 719.745n 1.1v 719.755n 1.1v 724.745n 1.1v 724.755n 1.1v 729.745n 1.1v 729.755n 1.1v 734.745n 1.1v 734.755n 1.1v 739.745n 1.1v 739.755n 1.1v 744.745n 1.1v 744.755n 1.1v 749.745n 1.1v 749.755n 1.1v 754.745n 1.1v 754.755n 0.0v 759.745n 0.0v 759.755n 0.0v 764.745n 0.0v 764.755n 0.0v 769.745n 0.0v 769.755n 0.0v 774.745n 0.0v 774.755n 0.0v 779.745n 0.0v 779.755n 0.0v 784.745n 0.0v 784.755n 0.0v 789.745n 0.0v 789.755n 0.0v 794.745n 0.0v 794.755n 0.0v 799.745n 0.0v 799.755n 0.0v 804.745n 0.0v 804.755n 0.0v 809.745n 0.0v 809.755n 0.0v 814.745n 0.0v 814.755n 1.1v 819.745n 1.1v 819.755n 1.1v 824.745n 1.1v 824.755n 1.1v 829.745n 1.1v 829.755n 1.1v 834.745n 1.1v 834.755n 1.1v 839.745n 1.1v 839.755n 1.1v 844.745n 1.1v 844.755n 1.1v 849.745n 1.1v 849.755n 1.1v 854.745n 1.1v 854.755n 1.1v 859.745n 1.1v 859.755n 1.1v 864.745n 1.1v 864.755n 1.1v 869.745n 1.1v 869.755n 1.1v 874.745n 1.1v 874.755n 1.1v 879.745n 1.1v 879.755n 1.1v 884.745n 1.1v 884.755n 1.1v 889.745n 1.1v 889.755n 1.1v 894.745n 1.1v 894.755n 1.1v 899.745n 1.1v 899.755n 1.1v 904.745n 1.1v 904.755n 1.1v 909.745n 1.1v 909.755n 1.1v 914.745n 1.1v 914.755n 1.1v 919.745n 1.1v 919.755n 1.1v 924.745n 1.1v 924.755n 1.1v 929.745n 1.1v 929.755n 1.1v 934.745n 1.1v 934.755n 1.1v 939.745n 1.1v 939.755n 1.1v 944.745n 1.1v 944.755n 1.1v 949.745n 1.1v 949.755n 1.1v 954.745n 1.1v 954.755n 0.0v 959.745n 0.0v 959.755n 1.1v 964.745n 1.1v 964.755n 0.0v 969.745n 0.0v 969.755n 1.1v 974.745n 1.1v 974.755n 1.1v 979.745n 1.1v 979.755n 1.1v 984.745n 1.1v 984.755n 1.1v 989.745n 1.1v 989.755n 1.1v 994.745n 1.1v 994.755n 1.1v 999.745n 1.1v 999.755n 1.1v 1004.745n 1.1v 1004.755n 1.1v 1009.745n 1.1v 1009.755n 1.1v 1014.745n 1.1v 1014.755n 1.1v 1019.745n 1.1v 1019.755n 1.1v 1024.745n 1.1v 1024.755n 1.1v )
* (time, data): [(0, 0), (5, 1), (10, 1), (15, 1), (20, 1), (25, 1), (30, 1), (35, 1), (40, 1), (45, 1), (50, 1), (55, 1), (60, 1), (65, 1), (70, 1), (75, 1), (80, 1), (85, 1), (90, 1), (95, 1), (100, 1), (105, 1), (110, 1), (115, 0), (120, 0), (125, 0), (130, 0), (135, 0), (140, 1), (145, 1), (150, 1), (155, 1), (160, 1), (165, 1), (170, 1), (175, 1), (180, 1), (185, 1), (190, 1), (195, 1), (200, 1), (205, 1), (210, 0), (215, 0), (220, 0), (225, 0), (230, 0), (235, 0), (240, 1), (245, 1), (250, 1), (255, 1), (260, 1), (265, 1), (270, 1), (275, 1), (280, 0), (285, 0), (290, 0), (295, 0), (300, 1), (305, 1), (310, 1), (315, 1), (320, 1), (325, 0), (330, 1), (335, 0), (340, 1), (345, 1), (350, 1), (355, 1), (360, 1), (365, 1), (370, 1), (375, 1), (380, 1), (385, 1), (390, 1), (395, 0), (400, 0), (405, 1), (410, 1), (415, 1), (420, 1), (425, 0), (430, 0), (435, 1), (440, 1), (445, 1), (450, 0), (455, 1), (460, 1), (465, 1), (470, 1), (475, 1), (480, 1), (485, 1), (490, 1), (495, 1), (500, 1), (505, 1), (510, 0), (515, 1), (520, 1), (525, 1), (530, 1), (535, 1), (540, 1), (545, 0), (550, 0), (555, 0), (560, 0), (565, 0), (570, 1), (575, 0), (580, 1), (585, 1), (590, 1), (595, 1), (600, 1), (605, 1), (610, 1), (615, 1), (620, 1), (625, 0), (630, 0), (635, 0), (640, 0), (645, 0), (650, 0), (655, 0), (660, 0), (665, 0), (670, 0), (675, 0), (680, 0), (685, 0), (690, 1), (695, 0), (700, 0), (705, 1), (710, 1), (715, 1), (720, 1), (725, 1), (730, 1), (735, 0), (740, 0), (745, 0), (750, 0), (755, 1), (760, 1), (765, 0), (770, 0), (775, 0), (780, 0), (785, 0), (790, 0), (795, 0), (800, 0), (805, 0), (810, 1), (815, 1), (820, 1), (825, 1), (830, 1), (835, 1), (840, 1), (845, 1), (850, 1), (855, 1), (860, 1), (865, 1), (870, 1), (875, 1), (880, 1), (885, 1), (890, 1), (895, 1), (900, 0), (905, 1), (910, 1), (915, 1), (920, 1), (925, 1), (930, 0), (935, 1), (940, 1), (945, 1), (950, 1), (955, 1), (960, 1), (965, 1), (970, 1), (975, 1), (980, 1), (985, 1), (990, 1), (995, 1), (1000, 1), (1005, 1), (1010, 1), (1015, 1), (1020, 1), (1025, 1)]
VWMASK0_3  WMASK0_3  0 PWL (0n 0.0v 4.745n 0.0v 4.755n 1.1v 9.745n 1.1v 9.755n 1.1v 14.745n 1.1v 14.755n 1.1v 19.745n 1.1v 19.755n 1.1v 24.745n 1.1v 24.755n 1.1v 29.745n 1.1v 29.755n 1.1v 34.745n 1.1v 34.755n 1.1v 39.745n 1.1v 39.755n 1.1v 44.745n 1.1v 44.755n 1.1v 49.745n 1.1v 49.755n 1.1v 54.745n 1.1v 54.755n 1.1v 59.745n 1.1v 59.755n 1.1v 64.745n 1.1v 64.755n 1.1v 69.745n 1.1v 69.755n 1.1v 74.745n 1.1v 74.755n 1.1v 79.745n 1.1v 79.755n 1.1v 84.745n 1.1v 84.755n 1.1v 89.745n 1.1v 89.755n 1.1v 94.745n 1.1v 94.755n 1.1v 99.745n 1.1v 99.755n 1.1v 104.745n 1.1v 104.755n 1.1v 109.745n 1.1v 109.755n 1.1v 114.745n 1.1v 114.755n 0.0v 119.745n 0.0v 119.755n 0.0v 124.745n 0.0v 124.755n 0.0v 129.745n 0.0v 129.755n 0.0v 134.745n 0.0v 134.755n 0.0v 139.745n 0.0v 139.755n 1.1v 144.745n 1.1v 144.755n 1.1v 149.745n 1.1v 149.755n 1.1v 154.745n 1.1v 154.755n 1.1v 159.745n 1.1v 159.755n 1.1v 164.745n 1.1v 164.755n 1.1v 169.745n 1.1v 169.755n 1.1v 174.745n 1.1v 174.755n 1.1v 179.745n 1.1v 179.755n 1.1v 184.745n 1.1v 184.755n 1.1v 189.745n 1.1v 189.755n 1.1v 194.745n 1.1v 194.755n 1.1v 199.745n 1.1v 199.755n 1.1v 204.745n 1.1v 204.755n 1.1v 209.745n 1.1v 209.755n 0.0v 214.745n 0.0v 214.755n 0.0v 219.745n 0.0v 219.755n 0.0v 224.745n 0.0v 224.755n 0.0v 229.745n 0.0v 229.755n 0.0v 234.745n 0.0v 234.755n 0.0v 239.745n 0.0v 239.755n 1.1v 244.745n 1.1v 244.755n 1.1v 249.745n 1.1v 249.755n 1.1v 254.745n 1.1v 254.755n 1.1v 259.745n 1.1v 259.755n 1.1v 264.745n 1.1v 264.755n 1.1v 269.745n 1.1v 269.755n 1.1v 274.745n 1.1v 274.755n 1.1v 279.745n 1.1v 279.755n 0.0v 284.745n 0.0v 284.755n 0.0v 289.745n 0.0v 289.755n 0.0v 294.745n 0.0v 294.755n 0.0v 299.745n 0.0v 299.755n 1.1v 304.745n 1.1v 304.755n 1.1v 309.745n 1.1v 309.755n 1.1v 314.745n 1.1v 314.755n 1.1v 319.745n 1.1v 319.755n 1.1v 324.745n 1.1v 324.755n 0.0v 329.745n 0.0v 329.755n 1.1v 334.745n 1.1v 334.755n 0.0v 339.745n 0.0v 339.755n 1.1v 344.745n 1.1v 344.755n 1.1v 349.745n 1.1v 349.755n 1.1v 354.745n 1.1v 354.755n 1.1v 359.745n 1.1v 359.755n 1.1v 364.745n 1.1v 364.755n 1.1v 369.745n 1.1v 369.755n 1.1v 374.745n 1.1v 374.755n 1.1v 379.745n 1.1v 379.755n 1.1v 384.745n 1.1v 384.755n 1.1v 389.745n 1.1v 389.755n 1.1v 394.745n 1.1v 394.755n 0.0v 399.745n 0.0v 399.755n 0.0v 404.745n 0.0v 404.755n 1.1v 409.745n 1.1v 409.755n 1.1v 414.745n 1.1v 414.755n 1.1v 419.745n 1.1v 419.755n 1.1v 424.745n 1.1v 424.755n 0.0v 429.745n 0.0v 429.755n 0.0v 434.745n 0.0v 434.755n 1.1v 439.745n 1.1v 439.755n 1.1v 444.745n 1.1v 444.755n 1.1v 449.745n 1.1v 449.755n 0.0v 454.745n 0.0v 454.755n 1.1v 459.745n 1.1v 459.755n 1.1v 464.745n 1.1v 464.755n 1.1v 469.745n 1.1v 469.755n 1.1v 474.745n 1.1v 474.755n 1.1v 479.745n 1.1v 479.755n 1.1v 484.745n 1.1v 484.755n 1.1v 489.745n 1.1v 489.755n 1.1v 494.745n 1.1v 494.755n 1.1v 499.745n 1.1v 499.755n 1.1v 504.745n 1.1v 504.755n 1.1v 509.745n 1.1v 509.755n 0.0v 514.745n 0.0v 514.755n 1.1v 519.745n 1.1v 519.755n 1.1v 524.745n 1.1v 524.755n 1.1v 529.745n 1.1v 529.755n 1.1v 534.745n 1.1v 534.755n 1.1v 539.745n 1.1v 539.755n 1.1v 544.745n 1.1v 544.755n 0.0v 549.745n 0.0v 549.755n 0.0v 554.745n 0.0v 554.755n 0.0v 559.745n 0.0v 559.755n 0.0v 564.745n 0.0v 564.755n 0.0v 569.745n 0.0v 569.755n 1.1v 574.745n 1.1v 574.755n 0.0v 579.745n 0.0v 579.755n 1.1v 584.745n 1.1v 584.755n 1.1v 589.745n 1.1v 589.755n 1.1v 594.745n 1.1v 594.755n 1.1v 599.745n 1.1v 599.755n 1.1v 604.745n 1.1v 604.755n 1.1v 609.745n 1.1v 609.755n 1.1v 614.745n 1.1v 614.755n 1.1v 619.745n 1.1v 619.755n 1.1v 624.745n 1.1v 624.755n 0.0v 629.745n 0.0v 629.755n 0.0v 634.745n 0.0v 634.755n 0.0v 639.745n 0.0v 639.755n 0.0v 644.745n 0.0v 644.755n 0.0v 649.745n 0.0v 649.755n 0.0v 654.745n 0.0v 654.755n 0.0v 659.745n 0.0v 659.755n 0.0v 664.745n 0.0v 664.755n 0.0v 669.745n 0.0v 669.755n 0.0v 674.745n 0.0v 674.755n 0.0v 679.745n 0.0v 679.755n 0.0v 684.745n 0.0v 684.755n 0.0v 689.745n 0.0v 689.755n 1.1v 694.745n 1.1v 694.755n 0.0v 699.745n 0.0v 699.755n 0.0v 704.745n 0.0v 704.755n 1.1v 709.745n 1.1v 709.755n 1.1v 714.745n 1.1v 714.755n 1.1v 719.745n 1.1v 719.755n 1.1v 724.745n 1.1v 724.755n 1.1v 729.745n 1.1v 729.755n 1.1v 734.745n 1.1v 734.755n 0.0v 739.745n 0.0v 739.755n 0.0v 744.745n 0.0v 744.755n 0.0v 749.745n 0.0v 749.755n 0.0v 754.745n 0.0v 754.755n 1.1v 759.745n 1.1v 759.755n 1.1v 764.745n 1.1v 764.755n 0.0v 769.745n 0.0v 769.755n 0.0v 774.745n 0.0v 774.755n 0.0v 779.745n 0.0v 779.755n 0.0v 784.745n 0.0v 784.755n 0.0v 789.745n 0.0v 789.755n 0.0v 794.745n 0.0v 794.755n 0.0v 799.745n 0.0v 799.755n 0.0v 804.745n 0.0v 804.755n 0.0v 809.745n 0.0v 809.755n 1.1v 814.745n 1.1v 814.755n 1.1v 819.745n 1.1v 819.755n 1.1v 824.745n 1.1v 824.755n 1.1v 829.745n 1.1v 829.755n 1.1v 834.745n 1.1v 834.755n 1.1v 839.745n 1.1v 839.755n 1.1v 844.745n 1.1v 844.755n 1.1v 849.745n 1.1v 849.755n 1.1v 854.745n 1.1v 854.755n 1.1v 859.745n 1.1v 859.755n 1.1v 864.745n 1.1v 864.755n 1.1v 869.745n 1.1v 869.755n 1.1v 874.745n 1.1v 874.755n 1.1v 879.745n 1.1v 879.755n 1.1v 884.745n 1.1v 884.755n 1.1v 889.745n 1.1v 889.755n 1.1v 894.745n 1.1v 894.755n 1.1v 899.745n 1.1v 899.755n 0.0v 904.745n 0.0v 904.755n 1.1v 909.745n 1.1v 909.755n 1.1v 914.745n 1.1v 914.755n 1.1v 919.745n 1.1v 919.755n 1.1v 924.745n 1.1v 924.755n 1.1v 929.745n 1.1v 929.755n 0.0v 934.745n 0.0v 934.755n 1.1v 939.745n 1.1v 939.755n 1.1v 944.745n 1.1v 944.755n 1.1v 949.745n 1.1v 949.755n 1.1v 954.745n 1.1v 954.755n 1.1v 959.745n 1.1v 959.755n 1.1v 964.745n 1.1v 964.755n 1.1v 969.745n 1.1v 969.755n 1.1v 974.745n 1.1v 974.755n 1.1v 979.745n 1.1v 979.755n 1.1v 984.745n 1.1v 984.755n 1.1v 989.745n 1.1v 989.755n 1.1v 994.745n 1.1v 994.755n 1.1v 999.745n 1.1v 999.755n 1.1v 1004.745n 1.1v 1004.755n 1.1v 1009.745n 1.1v 1009.755n 1.1v 1014.745n 1.1v 1014.755n 1.1v 1019.745n 1.1v 1019.755n 1.1v 1024.745n 1.1v 1024.755n 1.1v )
* PULSE: period=5
Vclk0 clk0 0 PULSE (0 1.1 4.995n 0.01n 0.01n 2.49n 5n)

 * Generation of dout measurements
* CHECK dout0_0 vdout0_0ck4 = 1.1 time = 25
* CHECK dout0_1 vdout0_1ck4 = 1.1 time = 25
* CHECK dout0_2 vdout0_2ck4 = 0 time = 25
* CHECK dout0_3 vdout0_3ck4 = 0 time = 25
* CHECK dout0_4 vdout0_4ck4 = 0 time = 25
* CHECK dout0_5 vdout0_5ck4 = 0 time = 25
* CHECK dout0_6 vdout0_6ck4 = 1.1 time = 25
* CHECK dout0_7 vdout0_7ck4 = 1.1 time = 25
* CHECK dout0_8 vdout0_8ck4 = 0 time = 25
* CHECK dout0_9 vdout0_9ck4 = 0 time = 25
* CHECK dout0_10 vdout0_10ck4 = 0 time = 25
* CHECK dout0_11 vdout0_11ck4 = 1.1 time = 25
* CHECK dout0_12 vdout0_12ck4 = 1.1 time = 25
* CHECK dout0_13 vdout0_13ck4 = 0 time = 25
* CHECK dout0_14 vdout0_14ck4 = 0 time = 25
* CHECK dout0_15 vdout0_15ck4 = 0 time = 25
* CHECK dout0_16 vdout0_16ck4 = 1.1 time = 25
* CHECK dout0_17 vdout0_17ck4 = 1.1 time = 25
* CHECK dout0_18 vdout0_18ck4 = 1.1 time = 25
* CHECK dout0_19 vdout0_19ck4 = 0 time = 25
* CHECK dout0_20 vdout0_20ck4 = 1.1 time = 25
* CHECK dout0_21 vdout0_21ck4 = 0 time = 25
* CHECK dout0_22 vdout0_22ck4 = 0 time = 25
* CHECK dout0_23 vdout0_23ck4 = 0 time = 25
* CHECK dout0_24 vdout0_24ck4 = 1.1 time = 25
* CHECK dout0_25 vdout0_25ck4 = 1.1 time = 25
* CHECK dout0_26 vdout0_26ck4 = 0 time = 25
* CHECK dout0_27 vdout0_27ck4 = 0 time = 25
* CHECK dout0_28 vdout0_28ck4 = 1.1 time = 25
* CHECK dout0_29 vdout0_29ck4 = 1.1 time = 25
* CHECK dout0_30 vdout0_30ck4 = 0 time = 25
* CHECK dout0_31 vdout0_31ck4 = 1.1 time = 25
* CHECK dout0_0 vdout0_0ck5 = 1.1 time = 30
* CHECK dout0_1 vdout0_1ck5 = 1.1 time = 30
* CHECK dout0_2 vdout0_2ck5 = 0 time = 30
* CHECK dout0_3 vdout0_3ck5 = 0 time = 30
* CHECK dout0_4 vdout0_4ck5 = 0 time = 30
* CHECK dout0_5 vdout0_5ck5 = 0 time = 30
* CHECK dout0_6 vdout0_6ck5 = 1.1 time = 30
* CHECK dout0_7 vdout0_7ck5 = 1.1 time = 30
* CHECK dout0_8 vdout0_8ck5 = 0 time = 30
* CHECK dout0_9 vdout0_9ck5 = 0 time = 30
* CHECK dout0_10 vdout0_10ck5 = 0 time = 30
* CHECK dout0_11 vdout0_11ck5 = 1.1 time = 30
* CHECK dout0_12 vdout0_12ck5 = 1.1 time = 30
* CHECK dout0_13 vdout0_13ck5 = 0 time = 30
* CHECK dout0_14 vdout0_14ck5 = 0 time = 30
* CHECK dout0_15 vdout0_15ck5 = 0 time = 30
* CHECK dout0_16 vdout0_16ck5 = 1.1 time = 30
* CHECK dout0_17 vdout0_17ck5 = 1.1 time = 30
* CHECK dout0_18 vdout0_18ck5 = 1.1 time = 30
* CHECK dout0_19 vdout0_19ck5 = 0 time = 30
* CHECK dout0_20 vdout0_20ck5 = 1.1 time = 30
* CHECK dout0_21 vdout0_21ck5 = 0 time = 30
* CHECK dout0_22 vdout0_22ck5 = 0 time = 30
* CHECK dout0_23 vdout0_23ck5 = 0 time = 30
* CHECK dout0_24 vdout0_24ck5 = 1.1 time = 30
* CHECK dout0_25 vdout0_25ck5 = 1.1 time = 30
* CHECK dout0_26 vdout0_26ck5 = 0 time = 30
* CHECK dout0_27 vdout0_27ck5 = 0 time = 30
* CHECK dout0_28 vdout0_28ck5 = 1.1 time = 30
* CHECK dout0_29 vdout0_29ck5 = 1.1 time = 30
* CHECK dout0_30 vdout0_30ck5 = 0 time = 30
* CHECK dout0_31 vdout0_31ck5 = 1.1 time = 30
* CHECK dout0_0 vdout0_0ck9 = 1.1 time = 50
* CHECK dout0_1 vdout0_1ck9 = 1.1 time = 50
* CHECK dout0_2 vdout0_2ck9 = 0 time = 50
* CHECK dout0_3 vdout0_3ck9 = 0 time = 50
* CHECK dout0_4 vdout0_4ck9 = 0 time = 50
* CHECK dout0_5 vdout0_5ck9 = 0 time = 50
* CHECK dout0_6 vdout0_6ck9 = 1.1 time = 50
* CHECK dout0_7 vdout0_7ck9 = 1.1 time = 50
* CHECK dout0_8 vdout0_8ck9 = 0 time = 50
* CHECK dout0_9 vdout0_9ck9 = 0 time = 50
* CHECK dout0_10 vdout0_10ck9 = 0 time = 50
* CHECK dout0_11 vdout0_11ck9 = 1.1 time = 50
* CHECK dout0_12 vdout0_12ck9 = 1.1 time = 50
* CHECK dout0_13 vdout0_13ck9 = 0 time = 50
* CHECK dout0_14 vdout0_14ck9 = 0 time = 50
* CHECK dout0_15 vdout0_15ck9 = 0 time = 50
* CHECK dout0_16 vdout0_16ck9 = 1.1 time = 50
* CHECK dout0_17 vdout0_17ck9 = 1.1 time = 50
* CHECK dout0_18 vdout0_18ck9 = 1.1 time = 50
* CHECK dout0_19 vdout0_19ck9 = 0 time = 50
* CHECK dout0_20 vdout0_20ck9 = 1.1 time = 50
* CHECK dout0_21 vdout0_21ck9 = 0 time = 50
* CHECK dout0_22 vdout0_22ck9 = 0 time = 50
* CHECK dout0_23 vdout0_23ck9 = 0 time = 50
* CHECK dout0_24 vdout0_24ck9 = 1.1 time = 50
* CHECK dout0_25 vdout0_25ck9 = 1.1 time = 50
* CHECK dout0_26 vdout0_26ck9 = 0 time = 50
* CHECK dout0_27 vdout0_27ck9 = 0 time = 50
* CHECK dout0_28 vdout0_28ck9 = 1.1 time = 50
* CHECK dout0_29 vdout0_29ck9 = 1.1 time = 50
* CHECK dout0_30 vdout0_30ck9 = 0 time = 50
* CHECK dout0_31 vdout0_31ck9 = 1.1 time = 50
* CHECK dout0_0 vdout0_0ck12 = 1.1 time = 65
* CHECK dout0_1 vdout0_1ck12 = 0 time = 65
* CHECK dout0_2 vdout0_2ck12 = 1.1 time = 65
* CHECK dout0_3 vdout0_3ck12 = 0 time = 65
* CHECK dout0_4 vdout0_4ck12 = 0 time = 65
* CHECK dout0_5 vdout0_5ck12 = 1.1 time = 65
* CHECK dout0_6 vdout0_6ck12 = 1.1 time = 65
* CHECK dout0_7 vdout0_7ck12 = 1.1 time = 65
* CHECK dout0_8 vdout0_8ck12 = 1.1 time = 65
* CHECK dout0_9 vdout0_9ck12 = 1.1 time = 65
* CHECK dout0_10 vdout0_10ck12 = 1.1 time = 65
* CHECK dout0_11 vdout0_11ck12 = 0 time = 65
* CHECK dout0_12 vdout0_12ck12 = 1.1 time = 65
* CHECK dout0_13 vdout0_13ck12 = 0 time = 65
* CHECK dout0_14 vdout0_14ck12 = 1.1 time = 65
* CHECK dout0_15 vdout0_15ck12 = 0 time = 65
* CHECK dout0_16 vdout0_16ck12 = 1.1 time = 65
* CHECK dout0_17 vdout0_17ck12 = 0 time = 65
* CHECK dout0_18 vdout0_18ck12 = 1.1 time = 65
* CHECK dout0_19 vdout0_19ck12 = 1.1 time = 65
* CHECK dout0_20 vdout0_20ck12 = 1.1 time = 65
* CHECK dout0_21 vdout0_21ck12 = 0 time = 65
* CHECK dout0_22 vdout0_22ck12 = 0 time = 65
* CHECK dout0_23 vdout0_23ck12 = 0 time = 65
* CHECK dout0_24 vdout0_24ck12 = 1.1 time = 65
* CHECK dout0_25 vdout0_25ck12 = 0 time = 65
* CHECK dout0_26 vdout0_26ck12 = 1.1 time = 65
* CHECK dout0_27 vdout0_27ck12 = 1.1 time = 65
* CHECK dout0_28 vdout0_28ck12 = 0 time = 65
* CHECK dout0_29 vdout0_29ck12 = 1.1 time = 65
* CHECK dout0_30 vdout0_30ck12 = 0 time = 65
* CHECK dout0_31 vdout0_31ck12 = 1.1 time = 65
* CHECK dout0_0 vdout0_0ck13 = 0 time = 70
* CHECK dout0_1 vdout0_1ck13 = 1.1 time = 70
* CHECK dout0_2 vdout0_2ck13 = 0 time = 70
* CHECK dout0_3 vdout0_3ck13 = 0 time = 70
* CHECK dout0_4 vdout0_4ck13 = 0 time = 70
* CHECK dout0_5 vdout0_5ck13 = 1.1 time = 70
* CHECK dout0_6 vdout0_6ck13 = 0 time = 70
* CHECK dout0_7 vdout0_7ck13 = 0 time = 70
* CHECK dout0_8 vdout0_8ck13 = 0 time = 70
* CHECK dout0_9 vdout0_9ck13 = 0 time = 70
* CHECK dout0_10 vdout0_10ck13 = 1.1 time = 70
* CHECK dout0_11 vdout0_11ck13 = 0 time = 70
* CHECK dout0_12 vdout0_12ck13 = 0 time = 70
* CHECK dout0_13 vdout0_13ck13 = 1.1 time = 70
* CHECK dout0_14 vdout0_14ck13 = 1.1 time = 70
* CHECK dout0_15 vdout0_15ck13 = 1.1 time = 70
* CHECK dout0_16 vdout0_16ck13 = 1.1 time = 70
* CHECK dout0_17 vdout0_17ck13 = 0 time = 70
* CHECK dout0_18 vdout0_18ck13 = 1.1 time = 70
* CHECK dout0_19 vdout0_19ck13 = 0 time = 70
* CHECK dout0_20 vdout0_20ck13 = 0 time = 70
* CHECK dout0_21 vdout0_21ck13 = 0 time = 70
* CHECK dout0_22 vdout0_22ck13 = 0 time = 70
* CHECK dout0_23 vdout0_23ck13 = 0 time = 70
* CHECK dout0_24 vdout0_24ck13 = 0 time = 70
* CHECK dout0_25 vdout0_25ck13 = 1.1 time = 70
* CHECK dout0_26 vdout0_26ck13 = 0 time = 70
* CHECK dout0_27 vdout0_27ck13 = 1.1 time = 70
* CHECK dout0_28 vdout0_28ck13 = 1.1 time = 70
* CHECK dout0_29 vdout0_29ck13 = 0 time = 70
* CHECK dout0_30 vdout0_30ck13 = 0 time = 70
* CHECK dout0_31 vdout0_31ck13 = 1.1 time = 70
* CHECK dout0_0 vdout0_0ck16 = 0 time = 85
* CHECK dout0_1 vdout0_1ck16 = 1.1 time = 85
* CHECK dout0_2 vdout0_2ck16 = 0 time = 85
* CHECK dout0_3 vdout0_3ck16 = 0 time = 85
* CHECK dout0_4 vdout0_4ck16 = 0 time = 85
* CHECK dout0_5 vdout0_5ck16 = 1.1 time = 85
* CHECK dout0_6 vdout0_6ck16 = 0 time = 85
* CHECK dout0_7 vdout0_7ck16 = 1.1 time = 85
* CHECK dout0_8 vdout0_8ck16 = 0 time = 85
* CHECK dout0_9 vdout0_9ck16 = 0 time = 85
* CHECK dout0_10 vdout0_10ck16 = 0 time = 85
* CHECK dout0_11 vdout0_11ck16 = 1.1 time = 85
* CHECK dout0_12 vdout0_12ck16 = 1.1 time = 85
* CHECK dout0_13 vdout0_13ck16 = 1.1 time = 85
* CHECK dout0_14 vdout0_14ck16 = 0 time = 85
* CHECK dout0_15 vdout0_15ck16 = 0 time = 85
* CHECK dout0_16 vdout0_16ck16 = 0 time = 85
* CHECK dout0_17 vdout0_17ck16 = 0 time = 85
* CHECK dout0_18 vdout0_18ck16 = 1.1 time = 85
* CHECK dout0_19 vdout0_19ck16 = 1.1 time = 85
* CHECK dout0_20 vdout0_20ck16 = 1.1 time = 85
* CHECK dout0_21 vdout0_21ck16 = 0 time = 85
* CHECK dout0_22 vdout0_22ck16 = 0 time = 85
* CHECK dout0_23 vdout0_23ck16 = 1.1 time = 85
* CHECK dout0_24 vdout0_24ck16 = 1.1 time = 85
* CHECK dout0_25 vdout0_25ck16 = 0 time = 85
* CHECK dout0_26 vdout0_26ck16 = 0 time = 85
* CHECK dout0_27 vdout0_27ck16 = 1.1 time = 85
* CHECK dout0_28 vdout0_28ck16 = 1.1 time = 85
* CHECK dout0_29 vdout0_29ck16 = 1.1 time = 85
* CHECK dout0_30 vdout0_30ck16 = 1.1 time = 85
* CHECK dout0_31 vdout0_31ck16 = 0 time = 85
* CHECK dout0_0 vdout0_0ck21 = 0 time = 110
* CHECK dout0_1 vdout0_1ck21 = 0 time = 110
* CHECK dout0_2 vdout0_2ck21 = 0 time = 110
* CHECK dout0_3 vdout0_3ck21 = 1.1 time = 110
* CHECK dout0_4 vdout0_4ck21 = 1.1 time = 110
* CHECK dout0_5 vdout0_5ck21 = 1.1 time = 110
* CHECK dout0_6 vdout0_6ck21 = 0 time = 110
* CHECK dout0_7 vdout0_7ck21 = 1.1 time = 110
* CHECK dout0_8 vdout0_8ck21 = 1.1 time = 110
* CHECK dout0_9 vdout0_9ck21 = 1.1 time = 110
* CHECK dout0_10 vdout0_10ck21 = 1.1 time = 110
* CHECK dout0_11 vdout0_11ck21 = 0 time = 110
* CHECK dout0_12 vdout0_12ck21 = 0 time = 110
* CHECK dout0_13 vdout0_13ck21 = 0 time = 110
* CHECK dout0_14 vdout0_14ck21 = 0 time = 110
* CHECK dout0_15 vdout0_15ck21 = 1.1 time = 110
* CHECK dout0_16 vdout0_16ck21 = 0 time = 110
* CHECK dout0_17 vdout0_17ck21 = 1.1 time = 110
* CHECK dout0_18 vdout0_18ck21 = 1.1 time = 110
* CHECK dout0_19 vdout0_19ck21 = 0 time = 110
* CHECK dout0_20 vdout0_20ck21 = 0 time = 110
* CHECK dout0_21 vdout0_21ck21 = 0 time = 110
* CHECK dout0_22 vdout0_22ck21 = 0 time = 110
* CHECK dout0_23 vdout0_23ck21 = 0 time = 110
* CHECK dout0_24 vdout0_24ck21 = 1.1 time = 110
* CHECK dout0_25 vdout0_25ck21 = 0 time = 110
* CHECK dout0_26 vdout0_26ck21 = 1.1 time = 110
* CHECK dout0_27 vdout0_27ck21 = 1.1 time = 110
* CHECK dout0_28 vdout0_28ck21 = 0 time = 110
* CHECK dout0_29 vdout0_29ck21 = 0 time = 110
* CHECK dout0_30 vdout0_30ck21 = 1.1 time = 110
* CHECK dout0_31 vdout0_31ck21 = 0 time = 110
* CHECK dout0_0 vdout0_0ck24 = 0 time = 125
* CHECK dout0_1 vdout0_1ck24 = 0 time = 125
* CHECK dout0_2 vdout0_2ck24 = 0 time = 125
* CHECK dout0_3 vdout0_3ck24 = 1.1 time = 125
* CHECK dout0_4 vdout0_4ck24 = 1.1 time = 125
* CHECK dout0_5 vdout0_5ck24 = 1.1 time = 125
* CHECK dout0_6 vdout0_6ck24 = 0 time = 125
* CHECK dout0_7 vdout0_7ck24 = 1.1 time = 125
* CHECK dout0_8 vdout0_8ck24 = 0 time = 125
* CHECK dout0_9 vdout0_9ck24 = 1.1 time = 125
* CHECK dout0_10 vdout0_10ck24 = 1.1 time = 125
* CHECK dout0_11 vdout0_11ck24 = 1.1 time = 125
* CHECK dout0_12 vdout0_12ck24 = 0 time = 125
* CHECK dout0_13 vdout0_13ck24 = 1.1 time = 125
* CHECK dout0_14 vdout0_14ck24 = 0 time = 125
* CHECK dout0_15 vdout0_15ck24 = 1.1 time = 125
* CHECK dout0_16 vdout0_16ck24 = 0 time = 125
* CHECK dout0_17 vdout0_17ck24 = 1.1 time = 125
* CHECK dout0_18 vdout0_18ck24 = 1.1 time = 125
* CHECK dout0_19 vdout0_19ck24 = 0 time = 125
* CHECK dout0_20 vdout0_20ck24 = 0 time = 125
* CHECK dout0_21 vdout0_21ck24 = 0 time = 125
* CHECK dout0_22 vdout0_22ck24 = 0 time = 125
* CHECK dout0_23 vdout0_23ck24 = 0 time = 125
* CHECK dout0_24 vdout0_24ck24 = 1.1 time = 125
* CHECK dout0_25 vdout0_25ck24 = 0 time = 125
* CHECK dout0_26 vdout0_26ck24 = 1.1 time = 125
* CHECK dout0_27 vdout0_27ck24 = 1.1 time = 125
* CHECK dout0_28 vdout0_28ck24 = 0 time = 125
* CHECK dout0_29 vdout0_29ck24 = 0 time = 125
* CHECK dout0_30 vdout0_30ck24 = 1.1 time = 125
* CHECK dout0_31 vdout0_31ck24 = 0 time = 125
* CHECK dout0_0 vdout0_0ck26 = 0 time = 135
* CHECK dout0_1 vdout0_1ck26 = 0 time = 135
* CHECK dout0_2 vdout0_2ck26 = 0 time = 135
* CHECK dout0_3 vdout0_3ck26 = 1.1 time = 135
* CHECK dout0_4 vdout0_4ck26 = 1.1 time = 135
* CHECK dout0_5 vdout0_5ck26 = 1.1 time = 135
* CHECK dout0_6 vdout0_6ck26 = 0 time = 135
* CHECK dout0_7 vdout0_7ck26 = 1.1 time = 135
* CHECK dout0_8 vdout0_8ck26 = 0 time = 135
* CHECK dout0_9 vdout0_9ck26 = 1.1 time = 135
* CHECK dout0_10 vdout0_10ck26 = 1.1 time = 135
* CHECK dout0_11 vdout0_11ck26 = 1.1 time = 135
* CHECK dout0_12 vdout0_12ck26 = 0 time = 135
* CHECK dout0_13 vdout0_13ck26 = 1.1 time = 135
* CHECK dout0_14 vdout0_14ck26 = 0 time = 135
* CHECK dout0_15 vdout0_15ck26 = 1.1 time = 135
* CHECK dout0_16 vdout0_16ck26 = 0 time = 135
* CHECK dout0_17 vdout0_17ck26 = 1.1 time = 135
* CHECK dout0_18 vdout0_18ck26 = 1.1 time = 135
* CHECK dout0_19 vdout0_19ck26 = 0 time = 135
* CHECK dout0_20 vdout0_20ck26 = 0 time = 135
* CHECK dout0_21 vdout0_21ck26 = 0 time = 135
* CHECK dout0_22 vdout0_22ck26 = 0 time = 135
* CHECK dout0_23 vdout0_23ck26 = 0 time = 135
* CHECK dout0_24 vdout0_24ck26 = 1.1 time = 135
* CHECK dout0_25 vdout0_25ck26 = 0 time = 135
* CHECK dout0_26 vdout0_26ck26 = 1.1 time = 135
* CHECK dout0_27 vdout0_27ck26 = 1.1 time = 135
* CHECK dout0_28 vdout0_28ck26 = 0 time = 135
* CHECK dout0_29 vdout0_29ck26 = 0 time = 135
* CHECK dout0_30 vdout0_30ck26 = 1.1 time = 135
* CHECK dout0_31 vdout0_31ck26 = 0 time = 135
* CHECK dout0_0 vdout0_0ck31 = 0 time = 160
* CHECK dout0_1 vdout0_1ck31 = 1.1 time = 160
* CHECK dout0_2 vdout0_2ck31 = 0 time = 160
* CHECK dout0_3 vdout0_3ck31 = 0 time = 160
* CHECK dout0_4 vdout0_4ck31 = 0 time = 160
* CHECK dout0_5 vdout0_5ck31 = 0 time = 160
* CHECK dout0_6 vdout0_6ck31 = 0 time = 160
* CHECK dout0_7 vdout0_7ck31 = 1.1 time = 160
* CHECK dout0_8 vdout0_8ck31 = 0 time = 160
* CHECK dout0_9 vdout0_9ck31 = 1.1 time = 160
* CHECK dout0_10 vdout0_10ck31 = 0 time = 160
* CHECK dout0_11 vdout0_11ck31 = 0 time = 160
* CHECK dout0_12 vdout0_12ck31 = 1.1 time = 160
* CHECK dout0_13 vdout0_13ck31 = 0 time = 160
* CHECK dout0_14 vdout0_14ck31 = 1.1 time = 160
* CHECK dout0_15 vdout0_15ck31 = 0 time = 160
* CHECK dout0_16 vdout0_16ck31 = 0 time = 160
* CHECK dout0_17 vdout0_17ck31 = 1.1 time = 160
* CHECK dout0_18 vdout0_18ck31 = 1.1 time = 160
* CHECK dout0_19 vdout0_19ck31 = 1.1 time = 160
* CHECK dout0_20 vdout0_20ck31 = 0 time = 160
* CHECK dout0_21 vdout0_21ck31 = 0 time = 160
* CHECK dout0_22 vdout0_22ck31 = 1.1 time = 160
* CHECK dout0_23 vdout0_23ck31 = 1.1 time = 160
* CHECK dout0_24 vdout0_24ck31 = 0 time = 160
* CHECK dout0_25 vdout0_25ck31 = 0 time = 160
* CHECK dout0_26 vdout0_26ck31 = 0 time = 160
* CHECK dout0_27 vdout0_27ck31 = 0 time = 160
* CHECK dout0_28 vdout0_28ck31 = 1.1 time = 160
* CHECK dout0_29 vdout0_29ck31 = 1.1 time = 160
* CHECK dout0_30 vdout0_30ck31 = 1.1 time = 160
* CHECK dout0_31 vdout0_31ck31 = 1.1 time = 160
* CHECK dout0_0 vdout0_0ck32 = 0 time = 165
* CHECK dout0_1 vdout0_1ck32 = 1.1 time = 165
* CHECK dout0_2 vdout0_2ck32 = 0 time = 165
* CHECK dout0_3 vdout0_3ck32 = 0 time = 165
* CHECK dout0_4 vdout0_4ck32 = 0 time = 165
* CHECK dout0_5 vdout0_5ck32 = 0 time = 165
* CHECK dout0_6 vdout0_6ck32 = 0 time = 165
* CHECK dout0_7 vdout0_7ck32 = 1.1 time = 165
* CHECK dout0_8 vdout0_8ck32 = 0 time = 165
* CHECK dout0_9 vdout0_9ck32 = 1.1 time = 165
* CHECK dout0_10 vdout0_10ck32 = 0 time = 165
* CHECK dout0_11 vdout0_11ck32 = 0 time = 165
* CHECK dout0_12 vdout0_12ck32 = 1.1 time = 165
* CHECK dout0_13 vdout0_13ck32 = 0 time = 165
* CHECK dout0_14 vdout0_14ck32 = 1.1 time = 165
* CHECK dout0_15 vdout0_15ck32 = 0 time = 165
* CHECK dout0_16 vdout0_16ck32 = 0 time = 165
* CHECK dout0_17 vdout0_17ck32 = 1.1 time = 165
* CHECK dout0_18 vdout0_18ck32 = 1.1 time = 165
* CHECK dout0_19 vdout0_19ck32 = 1.1 time = 165
* CHECK dout0_20 vdout0_20ck32 = 0 time = 165
* CHECK dout0_21 vdout0_21ck32 = 0 time = 165
* CHECK dout0_22 vdout0_22ck32 = 1.1 time = 165
* CHECK dout0_23 vdout0_23ck32 = 1.1 time = 165
* CHECK dout0_24 vdout0_24ck32 = 0 time = 165
* CHECK dout0_25 vdout0_25ck32 = 0 time = 165
* CHECK dout0_26 vdout0_26ck32 = 0 time = 165
* CHECK dout0_27 vdout0_27ck32 = 0 time = 165
* CHECK dout0_28 vdout0_28ck32 = 1.1 time = 165
* CHECK dout0_29 vdout0_29ck32 = 1.1 time = 165
* CHECK dout0_30 vdout0_30ck32 = 1.1 time = 165
* CHECK dout0_31 vdout0_31ck32 = 1.1 time = 165
* CHECK dout0_0 vdout0_0ck33 = 0 time = 170
* CHECK dout0_1 vdout0_1ck33 = 1.1 time = 170
* CHECK dout0_2 vdout0_2ck33 = 0 time = 170
* CHECK dout0_3 vdout0_3ck33 = 0 time = 170
* CHECK dout0_4 vdout0_4ck33 = 0 time = 170
* CHECK dout0_5 vdout0_5ck33 = 0 time = 170
* CHECK dout0_6 vdout0_6ck33 = 0 time = 170
* CHECK dout0_7 vdout0_7ck33 = 1.1 time = 170
* CHECK dout0_8 vdout0_8ck33 = 0 time = 170
* CHECK dout0_9 vdout0_9ck33 = 1.1 time = 170
* CHECK dout0_10 vdout0_10ck33 = 0 time = 170
* CHECK dout0_11 vdout0_11ck33 = 0 time = 170
* CHECK dout0_12 vdout0_12ck33 = 1.1 time = 170
* CHECK dout0_13 vdout0_13ck33 = 0 time = 170
* CHECK dout0_14 vdout0_14ck33 = 1.1 time = 170
* CHECK dout0_15 vdout0_15ck33 = 0 time = 170
* CHECK dout0_16 vdout0_16ck33 = 0 time = 170
* CHECK dout0_17 vdout0_17ck33 = 1.1 time = 170
* CHECK dout0_18 vdout0_18ck33 = 1.1 time = 170
* CHECK dout0_19 vdout0_19ck33 = 1.1 time = 170
* CHECK dout0_20 vdout0_20ck33 = 0 time = 170
* CHECK dout0_21 vdout0_21ck33 = 0 time = 170
* CHECK dout0_22 vdout0_22ck33 = 1.1 time = 170
* CHECK dout0_23 vdout0_23ck33 = 1.1 time = 170
* CHECK dout0_24 vdout0_24ck33 = 0 time = 170
* CHECK dout0_25 vdout0_25ck33 = 0 time = 170
* CHECK dout0_26 vdout0_26ck33 = 0 time = 170
* CHECK dout0_27 vdout0_27ck33 = 0 time = 170
* CHECK dout0_28 vdout0_28ck33 = 1.1 time = 170
* CHECK dout0_29 vdout0_29ck33 = 1.1 time = 170
* CHECK dout0_30 vdout0_30ck33 = 1.1 time = 170
* CHECK dout0_31 vdout0_31ck33 = 1.1 time = 170
* CHECK dout0_0 vdout0_0ck34 = 0 time = 175
* CHECK dout0_1 vdout0_1ck34 = 0 time = 175
* CHECK dout0_2 vdout0_2ck34 = 1.1 time = 175
* CHECK dout0_3 vdout0_3ck34 = 1.1 time = 175
* CHECK dout0_4 vdout0_4ck34 = 0 time = 175
* CHECK dout0_5 vdout0_5ck34 = 1.1 time = 175
* CHECK dout0_6 vdout0_6ck34 = 0 time = 175
* CHECK dout0_7 vdout0_7ck34 = 0 time = 175
* CHECK dout0_8 vdout0_8ck34 = 1.1 time = 175
* CHECK dout0_9 vdout0_9ck34 = 1.1 time = 175
* CHECK dout0_10 vdout0_10ck34 = 1.1 time = 175
* CHECK dout0_11 vdout0_11ck34 = 1.1 time = 175
* CHECK dout0_12 vdout0_12ck34 = 0 time = 175
* CHECK dout0_13 vdout0_13ck34 = 1.1 time = 175
* CHECK dout0_14 vdout0_14ck34 = 1.1 time = 175
* CHECK dout0_15 vdout0_15ck34 = 0 time = 175
* CHECK dout0_16 vdout0_16ck34 = 1.1 time = 175
* CHECK dout0_17 vdout0_17ck34 = 1.1 time = 175
* CHECK dout0_18 vdout0_18ck34 = 0 time = 175
* CHECK dout0_19 vdout0_19ck34 = 1.1 time = 175
* CHECK dout0_20 vdout0_20ck34 = 1.1 time = 175
* CHECK dout0_21 vdout0_21ck34 = 0 time = 175
* CHECK dout0_22 vdout0_22ck34 = 0 time = 175
* CHECK dout0_23 vdout0_23ck34 = 1.1 time = 175
* CHECK dout0_24 vdout0_24ck34 = 0 time = 175
* CHECK dout0_25 vdout0_25ck34 = 1.1 time = 175
* CHECK dout0_26 vdout0_26ck34 = 1.1 time = 175
* CHECK dout0_27 vdout0_27ck34 = 0 time = 175
* CHECK dout0_28 vdout0_28ck34 = 0 time = 175
* CHECK dout0_29 vdout0_29ck34 = 0 time = 175
* CHECK dout0_30 vdout0_30ck34 = 1.1 time = 175
* CHECK dout0_31 vdout0_31ck34 = 0 time = 175
* CHECK dout0_0 vdout0_0ck35 = 0 time = 180
* CHECK dout0_1 vdout0_1ck35 = 1.1 time = 180
* CHECK dout0_2 vdout0_2ck35 = 0 time = 180
* CHECK dout0_3 vdout0_3ck35 = 0 time = 180
* CHECK dout0_4 vdout0_4ck35 = 0 time = 180
* CHECK dout0_5 vdout0_5ck35 = 0 time = 180
* CHECK dout0_6 vdout0_6ck35 = 0 time = 180
* CHECK dout0_7 vdout0_7ck35 = 1.1 time = 180
* CHECK dout0_8 vdout0_8ck35 = 0 time = 180
* CHECK dout0_9 vdout0_9ck35 = 1.1 time = 180
* CHECK dout0_10 vdout0_10ck35 = 0 time = 180
* CHECK dout0_11 vdout0_11ck35 = 0 time = 180
* CHECK dout0_12 vdout0_12ck35 = 1.1 time = 180
* CHECK dout0_13 vdout0_13ck35 = 0 time = 180
* CHECK dout0_14 vdout0_14ck35 = 1.1 time = 180
* CHECK dout0_15 vdout0_15ck35 = 0 time = 180
* CHECK dout0_16 vdout0_16ck35 = 0 time = 180
* CHECK dout0_17 vdout0_17ck35 = 1.1 time = 180
* CHECK dout0_18 vdout0_18ck35 = 1.1 time = 180
* CHECK dout0_19 vdout0_19ck35 = 1.1 time = 180
* CHECK dout0_20 vdout0_20ck35 = 0 time = 180
* CHECK dout0_21 vdout0_21ck35 = 0 time = 180
* CHECK dout0_22 vdout0_22ck35 = 1.1 time = 180
* CHECK dout0_23 vdout0_23ck35 = 1.1 time = 180
* CHECK dout0_24 vdout0_24ck35 = 0 time = 180
* CHECK dout0_25 vdout0_25ck35 = 0 time = 180
* CHECK dout0_26 vdout0_26ck35 = 0 time = 180
* CHECK dout0_27 vdout0_27ck35 = 0 time = 180
* CHECK dout0_28 vdout0_28ck35 = 1.1 time = 180
* CHECK dout0_29 vdout0_29ck35 = 1.1 time = 180
* CHECK dout0_30 vdout0_30ck35 = 1.1 time = 180
* CHECK dout0_31 vdout0_31ck35 = 1.1 time = 180
* CHECK dout0_0 vdout0_0ck37 = 1.1 time = 190
* CHECK dout0_1 vdout0_1ck37 = 0 time = 190
* CHECK dout0_2 vdout0_2ck37 = 0 time = 190
* CHECK dout0_3 vdout0_3ck37 = 0 time = 190
* CHECK dout0_4 vdout0_4ck37 = 1.1 time = 190
* CHECK dout0_5 vdout0_5ck37 = 1.1 time = 190
* CHECK dout0_6 vdout0_6ck37 = 1.1 time = 190
* CHECK dout0_7 vdout0_7ck37 = 1.1 time = 190
* CHECK dout0_8 vdout0_8ck37 = 0 time = 190
* CHECK dout0_9 vdout0_9ck37 = 1.1 time = 190
* CHECK dout0_10 vdout0_10ck37 = 0 time = 190
* CHECK dout0_11 vdout0_11ck37 = 0 time = 190
* CHECK dout0_12 vdout0_12ck37 = 1.1 time = 190
* CHECK dout0_13 vdout0_13ck37 = 0 time = 190
* CHECK dout0_14 vdout0_14ck37 = 1.1 time = 190
* CHECK dout0_15 vdout0_15ck37 = 0 time = 190
* CHECK dout0_16 vdout0_16ck37 = 0 time = 190
* CHECK dout0_17 vdout0_17ck37 = 0 time = 190
* CHECK dout0_18 vdout0_18ck37 = 0 time = 190
* CHECK dout0_19 vdout0_19ck37 = 1.1 time = 190
* CHECK dout0_20 vdout0_20ck37 = 0 time = 190
* CHECK dout0_21 vdout0_21ck37 = 1.1 time = 190
* CHECK dout0_22 vdout0_22ck37 = 0 time = 190
* CHECK dout0_23 vdout0_23ck37 = 0 time = 190
* CHECK dout0_24 vdout0_24ck37 = 1.1 time = 190
* CHECK dout0_25 vdout0_25ck37 = 0 time = 190
* CHECK dout0_26 vdout0_26ck37 = 1.1 time = 190
* CHECK dout0_27 vdout0_27ck37 = 0 time = 190
* CHECK dout0_28 vdout0_28ck37 = 1.1 time = 190
* CHECK dout0_29 vdout0_29ck37 = 0 time = 190
* CHECK dout0_30 vdout0_30ck37 = 1.1 time = 190
* CHECK dout0_31 vdout0_31ck37 = 1.1 time = 190
* CHECK dout0_0 vdout0_0ck38 = 1.1 time = 195
* CHECK dout0_1 vdout0_1ck38 = 0 time = 195
* CHECK dout0_2 vdout0_2ck38 = 0 time = 195
* CHECK dout0_3 vdout0_3ck38 = 0 time = 195
* CHECK dout0_4 vdout0_4ck38 = 1.1 time = 195
* CHECK dout0_5 vdout0_5ck38 = 1.1 time = 195
* CHECK dout0_6 vdout0_6ck38 = 1.1 time = 195
* CHECK dout0_7 vdout0_7ck38 = 1.1 time = 195
* CHECK dout0_8 vdout0_8ck38 = 0 time = 195
* CHECK dout0_9 vdout0_9ck38 = 1.1 time = 195
* CHECK dout0_10 vdout0_10ck38 = 0 time = 195
* CHECK dout0_11 vdout0_11ck38 = 0 time = 195
* CHECK dout0_12 vdout0_12ck38 = 1.1 time = 195
* CHECK dout0_13 vdout0_13ck38 = 0 time = 195
* CHECK dout0_14 vdout0_14ck38 = 1.1 time = 195
* CHECK dout0_15 vdout0_15ck38 = 0 time = 195
* CHECK dout0_16 vdout0_16ck38 = 0 time = 195
* CHECK dout0_17 vdout0_17ck38 = 0 time = 195
* CHECK dout0_18 vdout0_18ck38 = 0 time = 195
* CHECK dout0_19 vdout0_19ck38 = 1.1 time = 195
* CHECK dout0_20 vdout0_20ck38 = 0 time = 195
* CHECK dout0_21 vdout0_21ck38 = 1.1 time = 195
* CHECK dout0_22 vdout0_22ck38 = 0 time = 195
* CHECK dout0_23 vdout0_23ck38 = 0 time = 195
* CHECK dout0_24 vdout0_24ck38 = 1.1 time = 195
* CHECK dout0_25 vdout0_25ck38 = 0 time = 195
* CHECK dout0_26 vdout0_26ck38 = 1.1 time = 195
* CHECK dout0_27 vdout0_27ck38 = 0 time = 195
* CHECK dout0_28 vdout0_28ck38 = 1.1 time = 195
* CHECK dout0_29 vdout0_29ck38 = 0 time = 195
* CHECK dout0_30 vdout0_30ck38 = 1.1 time = 195
* CHECK dout0_31 vdout0_31ck38 = 1.1 time = 195
* CHECK dout0_0 vdout0_0ck43 = 1.1 time = 220
* CHECK dout0_1 vdout0_1ck43 = 0 time = 220
* CHECK dout0_2 vdout0_2ck43 = 1.1 time = 220
* CHECK dout0_3 vdout0_3ck43 = 1.1 time = 220
* CHECK dout0_4 vdout0_4ck43 = 1.1 time = 220
* CHECK dout0_5 vdout0_5ck43 = 1.1 time = 220
* CHECK dout0_6 vdout0_6ck43 = 0 time = 220
* CHECK dout0_7 vdout0_7ck43 = 0 time = 220
* CHECK dout0_8 vdout0_8ck43 = 0 time = 220
* CHECK dout0_9 vdout0_9ck43 = 0 time = 220
* CHECK dout0_10 vdout0_10ck43 = 1.1 time = 220
* CHECK dout0_11 vdout0_11ck43 = 0 time = 220
* CHECK dout0_12 vdout0_12ck43 = 0 time = 220
* CHECK dout0_13 vdout0_13ck43 = 1.1 time = 220
* CHECK dout0_14 vdout0_14ck43 = 0 time = 220
* CHECK dout0_15 vdout0_15ck43 = 0 time = 220
* CHECK dout0_16 vdout0_16ck43 = 1.1 time = 220
* CHECK dout0_17 vdout0_17ck43 = 1.1 time = 220
* CHECK dout0_18 vdout0_18ck43 = 0 time = 220
* CHECK dout0_19 vdout0_19ck43 = 1.1 time = 220
* CHECK dout0_20 vdout0_20ck43 = 1.1 time = 220
* CHECK dout0_21 vdout0_21ck43 = 0 time = 220
* CHECK dout0_22 vdout0_22ck43 = 0 time = 220
* CHECK dout0_23 vdout0_23ck43 = 1.1 time = 220
* CHECK dout0_24 vdout0_24ck43 = 0 time = 220
* CHECK dout0_25 vdout0_25ck43 = 1.1 time = 220
* CHECK dout0_26 vdout0_26ck43 = 1.1 time = 220
* CHECK dout0_27 vdout0_27ck43 = 0 time = 220
* CHECK dout0_28 vdout0_28ck43 = 0 time = 220
* CHECK dout0_29 vdout0_29ck43 = 0 time = 220
* CHECK dout0_30 vdout0_30ck43 = 1.1 time = 220
* CHECK dout0_31 vdout0_31ck43 = 0 time = 220
* CHECK dout0_0 vdout0_0ck46 = 1.1 time = 235
* CHECK dout0_1 vdout0_1ck46 = 0 time = 235
* CHECK dout0_2 vdout0_2ck46 = 1.1 time = 235
* CHECK dout0_3 vdout0_3ck46 = 1.1 time = 235
* CHECK dout0_4 vdout0_4ck46 = 1.1 time = 235
* CHECK dout0_5 vdout0_5ck46 = 1.1 time = 235
* CHECK dout0_6 vdout0_6ck46 = 0 time = 235
* CHECK dout0_7 vdout0_7ck46 = 0 time = 235
* CHECK dout0_8 vdout0_8ck46 = 0 time = 235
* CHECK dout0_9 vdout0_9ck46 = 0 time = 235
* CHECK dout0_10 vdout0_10ck46 = 1.1 time = 235
* CHECK dout0_11 vdout0_11ck46 = 0 time = 235
* CHECK dout0_12 vdout0_12ck46 = 0 time = 235
* CHECK dout0_13 vdout0_13ck46 = 1.1 time = 235
* CHECK dout0_14 vdout0_14ck46 = 0 time = 235
* CHECK dout0_15 vdout0_15ck46 = 0 time = 235
* CHECK dout0_16 vdout0_16ck46 = 1.1 time = 235
* CHECK dout0_17 vdout0_17ck46 = 1.1 time = 235
* CHECK dout0_18 vdout0_18ck46 = 0 time = 235
* CHECK dout0_19 vdout0_19ck46 = 1.1 time = 235
* CHECK dout0_20 vdout0_20ck46 = 1.1 time = 235
* CHECK dout0_21 vdout0_21ck46 = 0 time = 235
* CHECK dout0_22 vdout0_22ck46 = 0 time = 235
* CHECK dout0_23 vdout0_23ck46 = 1.1 time = 235
* CHECK dout0_24 vdout0_24ck46 = 0 time = 235
* CHECK dout0_25 vdout0_25ck46 = 1.1 time = 235
* CHECK dout0_26 vdout0_26ck46 = 1.1 time = 235
* CHECK dout0_27 vdout0_27ck46 = 0 time = 235
* CHECK dout0_28 vdout0_28ck46 = 0 time = 235
* CHECK dout0_29 vdout0_29ck46 = 0 time = 235
* CHECK dout0_30 vdout0_30ck46 = 1.1 time = 235
* CHECK dout0_31 vdout0_31ck46 = 0 time = 235
* CHECK dout0_0 vdout0_0ck47 = 1.1 time = 240
* CHECK dout0_1 vdout0_1ck47 = 0 time = 240
* CHECK dout0_2 vdout0_2ck47 = 1.1 time = 240
* CHECK dout0_3 vdout0_3ck47 = 1.1 time = 240
* CHECK dout0_4 vdout0_4ck47 = 1.1 time = 240
* CHECK dout0_5 vdout0_5ck47 = 1.1 time = 240
* CHECK dout0_6 vdout0_6ck47 = 0 time = 240
* CHECK dout0_7 vdout0_7ck47 = 0 time = 240
* CHECK dout0_8 vdout0_8ck47 = 0 time = 240
* CHECK dout0_9 vdout0_9ck47 = 0 time = 240
* CHECK dout0_10 vdout0_10ck47 = 1.1 time = 240
* CHECK dout0_11 vdout0_11ck47 = 0 time = 240
* CHECK dout0_12 vdout0_12ck47 = 0 time = 240
* CHECK dout0_13 vdout0_13ck47 = 1.1 time = 240
* CHECK dout0_14 vdout0_14ck47 = 0 time = 240
* CHECK dout0_15 vdout0_15ck47 = 0 time = 240
* CHECK dout0_16 vdout0_16ck47 = 1.1 time = 240
* CHECK dout0_17 vdout0_17ck47 = 1.1 time = 240
* CHECK dout0_18 vdout0_18ck47 = 0 time = 240
* CHECK dout0_19 vdout0_19ck47 = 1.1 time = 240
* CHECK dout0_20 vdout0_20ck47 = 1.1 time = 240
* CHECK dout0_21 vdout0_21ck47 = 0 time = 240
* CHECK dout0_22 vdout0_22ck47 = 0 time = 240
* CHECK dout0_23 vdout0_23ck47 = 1.1 time = 240
* CHECK dout0_24 vdout0_24ck47 = 0 time = 240
* CHECK dout0_25 vdout0_25ck47 = 1.1 time = 240
* CHECK dout0_26 vdout0_26ck47 = 1.1 time = 240
* CHECK dout0_27 vdout0_27ck47 = 0 time = 240
* CHECK dout0_28 vdout0_28ck47 = 0 time = 240
* CHECK dout0_29 vdout0_29ck47 = 0 time = 240
* CHECK dout0_30 vdout0_30ck47 = 1.1 time = 240
* CHECK dout0_31 vdout0_31ck47 = 0 time = 240
* CHECK dout0_0 vdout0_0ck49 = 1.1 time = 250
* CHECK dout0_1 vdout0_1ck49 = 0 time = 250
* CHECK dout0_2 vdout0_2ck49 = 1.1 time = 250
* CHECK dout0_3 vdout0_3ck49 = 1.1 time = 250
* CHECK dout0_4 vdout0_4ck49 = 1.1 time = 250
* CHECK dout0_5 vdout0_5ck49 = 1.1 time = 250
* CHECK dout0_6 vdout0_6ck49 = 0 time = 250
* CHECK dout0_7 vdout0_7ck49 = 0 time = 250
* CHECK dout0_8 vdout0_8ck49 = 0 time = 250
* CHECK dout0_9 vdout0_9ck49 = 0 time = 250
* CHECK dout0_10 vdout0_10ck49 = 1.1 time = 250
* CHECK dout0_11 vdout0_11ck49 = 0 time = 250
* CHECK dout0_12 vdout0_12ck49 = 0 time = 250
* CHECK dout0_13 vdout0_13ck49 = 1.1 time = 250
* CHECK dout0_14 vdout0_14ck49 = 0 time = 250
* CHECK dout0_15 vdout0_15ck49 = 0 time = 250
* CHECK dout0_16 vdout0_16ck49 = 1.1 time = 250
* CHECK dout0_17 vdout0_17ck49 = 1.1 time = 250
* CHECK dout0_18 vdout0_18ck49 = 0 time = 250
* CHECK dout0_19 vdout0_19ck49 = 1.1 time = 250
* CHECK dout0_20 vdout0_20ck49 = 1.1 time = 250
* CHECK dout0_21 vdout0_21ck49 = 0 time = 250
* CHECK dout0_22 vdout0_22ck49 = 0 time = 250
* CHECK dout0_23 vdout0_23ck49 = 1.1 time = 250
* CHECK dout0_24 vdout0_24ck49 = 0 time = 250
* CHECK dout0_25 vdout0_25ck49 = 1.1 time = 250
* CHECK dout0_26 vdout0_26ck49 = 1.1 time = 250
* CHECK dout0_27 vdout0_27ck49 = 0 time = 250
* CHECK dout0_28 vdout0_28ck49 = 0 time = 250
* CHECK dout0_29 vdout0_29ck49 = 0 time = 250
* CHECK dout0_30 vdout0_30ck49 = 1.1 time = 250
* CHECK dout0_31 vdout0_31ck49 = 0 time = 250
* CHECK dout0_0 vdout0_0ck50 = 1.1 time = 255
* CHECK dout0_1 vdout0_1ck50 = 0 time = 255
* CHECK dout0_2 vdout0_2ck50 = 1.1 time = 255
* CHECK dout0_3 vdout0_3ck50 = 1.1 time = 255
* CHECK dout0_4 vdout0_4ck50 = 1.1 time = 255
* CHECK dout0_5 vdout0_5ck50 = 1.1 time = 255
* CHECK dout0_6 vdout0_6ck50 = 0 time = 255
* CHECK dout0_7 vdout0_7ck50 = 0 time = 255
* CHECK dout0_8 vdout0_8ck50 = 0 time = 255
* CHECK dout0_9 vdout0_9ck50 = 0 time = 255
* CHECK dout0_10 vdout0_10ck50 = 1.1 time = 255
* CHECK dout0_11 vdout0_11ck50 = 0 time = 255
* CHECK dout0_12 vdout0_12ck50 = 0 time = 255
* CHECK dout0_13 vdout0_13ck50 = 1.1 time = 255
* CHECK dout0_14 vdout0_14ck50 = 0 time = 255
* CHECK dout0_15 vdout0_15ck50 = 0 time = 255
* CHECK dout0_16 vdout0_16ck50 = 1.1 time = 255
* CHECK dout0_17 vdout0_17ck50 = 1.1 time = 255
* CHECK dout0_18 vdout0_18ck50 = 0 time = 255
* CHECK dout0_19 vdout0_19ck50 = 1.1 time = 255
* CHECK dout0_20 vdout0_20ck50 = 1.1 time = 255
* CHECK dout0_21 vdout0_21ck50 = 0 time = 255
* CHECK dout0_22 vdout0_22ck50 = 0 time = 255
* CHECK dout0_23 vdout0_23ck50 = 1.1 time = 255
* CHECK dout0_24 vdout0_24ck50 = 0 time = 255
* CHECK dout0_25 vdout0_25ck50 = 1.1 time = 255
* CHECK dout0_26 vdout0_26ck50 = 1.1 time = 255
* CHECK dout0_27 vdout0_27ck50 = 0 time = 255
* CHECK dout0_28 vdout0_28ck50 = 0 time = 255
* CHECK dout0_29 vdout0_29ck50 = 0 time = 255
* CHECK dout0_30 vdout0_30ck50 = 1.1 time = 255
* CHECK dout0_31 vdout0_31ck50 = 0 time = 255
* CHECK dout0_0 vdout0_0ck51 = 1.1 time = 260
* CHECK dout0_1 vdout0_1ck51 = 0 time = 260
* CHECK dout0_2 vdout0_2ck51 = 1.1 time = 260
* CHECK dout0_3 vdout0_3ck51 = 1.1 time = 260
* CHECK dout0_4 vdout0_4ck51 = 1.1 time = 260
* CHECK dout0_5 vdout0_5ck51 = 1.1 time = 260
* CHECK dout0_6 vdout0_6ck51 = 0 time = 260
* CHECK dout0_7 vdout0_7ck51 = 0 time = 260
* CHECK dout0_8 vdout0_8ck51 = 0 time = 260
* CHECK dout0_9 vdout0_9ck51 = 0 time = 260
* CHECK dout0_10 vdout0_10ck51 = 1.1 time = 260
* CHECK dout0_11 vdout0_11ck51 = 0 time = 260
* CHECK dout0_12 vdout0_12ck51 = 0 time = 260
* CHECK dout0_13 vdout0_13ck51 = 1.1 time = 260
* CHECK dout0_14 vdout0_14ck51 = 0 time = 260
* CHECK dout0_15 vdout0_15ck51 = 0 time = 260
* CHECK dout0_16 vdout0_16ck51 = 1.1 time = 260
* CHECK dout0_17 vdout0_17ck51 = 1.1 time = 260
* CHECK dout0_18 vdout0_18ck51 = 0 time = 260
* CHECK dout0_19 vdout0_19ck51 = 1.1 time = 260
* CHECK dout0_20 vdout0_20ck51 = 1.1 time = 260
* CHECK dout0_21 vdout0_21ck51 = 0 time = 260
* CHECK dout0_22 vdout0_22ck51 = 0 time = 260
* CHECK dout0_23 vdout0_23ck51 = 1.1 time = 260
* CHECK dout0_24 vdout0_24ck51 = 0 time = 260
* CHECK dout0_25 vdout0_25ck51 = 1.1 time = 260
* CHECK dout0_26 vdout0_26ck51 = 1.1 time = 260
* CHECK dout0_27 vdout0_27ck51 = 0 time = 260
* CHECK dout0_28 vdout0_28ck51 = 0 time = 260
* CHECK dout0_29 vdout0_29ck51 = 0 time = 260
* CHECK dout0_30 vdout0_30ck51 = 1.1 time = 260
* CHECK dout0_31 vdout0_31ck51 = 0 time = 260
* CHECK dout0_0 vdout0_0ck52 = 0 time = 265
* CHECK dout0_1 vdout0_1ck52 = 0 time = 265
* CHECK dout0_2 vdout0_2ck52 = 0 time = 265
* CHECK dout0_3 vdout0_3ck52 = 1.1 time = 265
* CHECK dout0_4 vdout0_4ck52 = 1.1 time = 265
* CHECK dout0_5 vdout0_5ck52 = 1.1 time = 265
* CHECK dout0_6 vdout0_6ck52 = 1.1 time = 265
* CHECK dout0_7 vdout0_7ck52 = 0 time = 265
* CHECK dout0_8 vdout0_8ck52 = 1.1 time = 265
* CHECK dout0_9 vdout0_9ck52 = 1.1 time = 265
* CHECK dout0_10 vdout0_10ck52 = 1.1 time = 265
* CHECK dout0_11 vdout0_11ck52 = 1.1 time = 265
* CHECK dout0_12 vdout0_12ck52 = 0 time = 265
* CHECK dout0_13 vdout0_13ck52 = 1.1 time = 265
* CHECK dout0_14 vdout0_14ck52 = 1.1 time = 265
* CHECK dout0_15 vdout0_15ck52 = 0 time = 265
* CHECK dout0_16 vdout0_16ck52 = 1.1 time = 265
* CHECK dout0_17 vdout0_17ck52 = 1.1 time = 265
* CHECK dout0_18 vdout0_18ck52 = 1.1 time = 265
* CHECK dout0_19 vdout0_19ck52 = 1.1 time = 265
* CHECK dout0_20 vdout0_20ck52 = 1.1 time = 265
* CHECK dout0_21 vdout0_21ck52 = 1.1 time = 265
* CHECK dout0_22 vdout0_22ck52 = 1.1 time = 265
* CHECK dout0_23 vdout0_23ck52 = 0 time = 265
* CHECK dout0_24 vdout0_24ck52 = 1.1 time = 265
* CHECK dout0_25 vdout0_25ck52 = 0 time = 265
* CHECK dout0_26 vdout0_26ck52 = 1.1 time = 265
* CHECK dout0_27 vdout0_27ck52 = 1.1 time = 265
* CHECK dout0_28 vdout0_28ck52 = 0 time = 265
* CHECK dout0_29 vdout0_29ck52 = 1.1 time = 265
* CHECK dout0_30 vdout0_30ck52 = 1.1 time = 265
* CHECK dout0_31 vdout0_31ck52 = 1.1 time = 265
* CHECK dout0_0 vdout0_0ck55 = 0 time = 280
* CHECK dout0_1 vdout0_1ck55 = 0 time = 280
* CHECK dout0_2 vdout0_2ck55 = 0 time = 280
* CHECK dout0_3 vdout0_3ck55 = 1.1 time = 280
* CHECK dout0_4 vdout0_4ck55 = 1.1 time = 280
* CHECK dout0_5 vdout0_5ck55 = 1.1 time = 280
* CHECK dout0_6 vdout0_6ck55 = 1.1 time = 280
* CHECK dout0_7 vdout0_7ck55 = 0 time = 280
* CHECK dout0_8 vdout0_8ck55 = 1.1 time = 280
* CHECK dout0_9 vdout0_9ck55 = 1.1 time = 280
* CHECK dout0_10 vdout0_10ck55 = 1.1 time = 280
* CHECK dout0_11 vdout0_11ck55 = 1.1 time = 280
* CHECK dout0_12 vdout0_12ck55 = 0 time = 280
* CHECK dout0_13 vdout0_13ck55 = 1.1 time = 280
* CHECK dout0_14 vdout0_14ck55 = 1.1 time = 280
* CHECK dout0_15 vdout0_15ck55 = 0 time = 280
* CHECK dout0_16 vdout0_16ck55 = 1.1 time = 280
* CHECK dout0_17 vdout0_17ck55 = 1.1 time = 280
* CHECK dout0_18 vdout0_18ck55 = 1.1 time = 280
* CHECK dout0_19 vdout0_19ck55 = 1.1 time = 280
* CHECK dout0_20 vdout0_20ck55 = 1.1 time = 280
* CHECK dout0_21 vdout0_21ck55 = 1.1 time = 280
* CHECK dout0_22 vdout0_22ck55 = 1.1 time = 280
* CHECK dout0_23 vdout0_23ck55 = 0 time = 280
* CHECK dout0_24 vdout0_24ck55 = 1.1 time = 280
* CHECK dout0_25 vdout0_25ck55 = 0 time = 280
* CHECK dout0_26 vdout0_26ck55 = 1.1 time = 280
* CHECK dout0_27 vdout0_27ck55 = 1.1 time = 280
* CHECK dout0_28 vdout0_28ck55 = 0 time = 280
* CHECK dout0_29 vdout0_29ck55 = 1.1 time = 280
* CHECK dout0_30 vdout0_30ck55 = 1.1 time = 280
* CHECK dout0_31 vdout0_31ck55 = 1.1 time = 280
* CHECK dout0_0 vdout0_0ck62 = 1.1 time = 315
* CHECK dout0_1 vdout0_1ck62 = 0 time = 315
* CHECK dout0_2 vdout0_2ck62 = 0 time = 315
* CHECK dout0_3 vdout0_3ck62 = 1.1 time = 315
* CHECK dout0_4 vdout0_4ck62 = 1.1 time = 315
* CHECK dout0_5 vdout0_5ck62 = 0 time = 315
* CHECK dout0_6 vdout0_6ck62 = 1.1 time = 315
* CHECK dout0_7 vdout0_7ck62 = 0 time = 315
* CHECK dout0_8 vdout0_8ck62 = 0 time = 315
* CHECK dout0_9 vdout0_9ck62 = 0 time = 315
* CHECK dout0_10 vdout0_10ck62 = 0 time = 315
* CHECK dout0_11 vdout0_11ck62 = 0 time = 315
* CHECK dout0_12 vdout0_12ck62 = 0 time = 315
* CHECK dout0_13 vdout0_13ck62 = 1.1 time = 315
* CHECK dout0_14 vdout0_14ck62 = 0 time = 315
* CHECK dout0_15 vdout0_15ck62 = 1.1 time = 315
* CHECK dout0_16 vdout0_16ck62 = 1.1 time = 315
* CHECK dout0_17 vdout0_17ck62 = 0 time = 315
* CHECK dout0_18 vdout0_18ck62 = 0 time = 315
* CHECK dout0_19 vdout0_19ck62 = 0 time = 315
* CHECK dout0_20 vdout0_20ck62 = 1.1 time = 315
* CHECK dout0_21 vdout0_21ck62 = 0 time = 315
* CHECK dout0_22 vdout0_22ck62 = 1.1 time = 315
* CHECK dout0_23 vdout0_23ck62 = 0 time = 315
* CHECK dout0_24 vdout0_24ck62 = 1.1 time = 315
* CHECK dout0_25 vdout0_25ck62 = 0 time = 315
* CHECK dout0_26 vdout0_26ck62 = 1.1 time = 315
* CHECK dout0_27 vdout0_27ck62 = 1.1 time = 315
* CHECK dout0_28 vdout0_28ck62 = 0 time = 315
* CHECK dout0_29 vdout0_29ck62 = 1.1 time = 315
* CHECK dout0_30 vdout0_30ck62 = 1.1 time = 315
* CHECK dout0_31 vdout0_31ck62 = 1.1 time = 315
* CHECK dout0_0 vdout0_0ck70 = 1.1 time = 355
* CHECK dout0_1 vdout0_1ck70 = 0 time = 355
* CHECK dout0_2 vdout0_2ck70 = 1.1 time = 355
* CHECK dout0_3 vdout0_3ck70 = 0 time = 355
* CHECK dout0_4 vdout0_4ck70 = 0 time = 355
* CHECK dout0_5 vdout0_5ck70 = 1.1 time = 355
* CHECK dout0_6 vdout0_6ck70 = 1.1 time = 355
* CHECK dout0_7 vdout0_7ck70 = 1.1 time = 355
* CHECK dout0_8 vdout0_8ck70 = 1.1 time = 355
* CHECK dout0_9 vdout0_9ck70 = 1.1 time = 355
* CHECK dout0_10 vdout0_10ck70 = 0 time = 355
* CHECK dout0_11 vdout0_11ck70 = 1.1 time = 355
* CHECK dout0_12 vdout0_12ck70 = 1.1 time = 355
* CHECK dout0_13 vdout0_13ck70 = 0 time = 355
* CHECK dout0_14 vdout0_14ck70 = 1.1 time = 355
* CHECK dout0_15 vdout0_15ck70 = 0 time = 355
* CHECK dout0_16 vdout0_16ck70 = 0 time = 355
* CHECK dout0_17 vdout0_17ck70 = 1.1 time = 355
* CHECK dout0_18 vdout0_18ck70 = 0 time = 355
* CHECK dout0_19 vdout0_19ck70 = 1.1 time = 355
* CHECK dout0_20 vdout0_20ck70 = 1.1 time = 355
* CHECK dout0_21 vdout0_21ck70 = 0 time = 355
* CHECK dout0_22 vdout0_22ck70 = 0 time = 355
* CHECK dout0_23 vdout0_23ck70 = 0 time = 355
* CHECK dout0_24 vdout0_24ck70 = 1.1 time = 355
* CHECK dout0_25 vdout0_25ck70 = 1.1 time = 355
* CHECK dout0_26 vdout0_26ck70 = 1.1 time = 355
* CHECK dout0_27 vdout0_27ck70 = 0 time = 355
* CHECK dout0_28 vdout0_28ck70 = 0 time = 355
* CHECK dout0_29 vdout0_29ck70 = 1.1 time = 355
* CHECK dout0_30 vdout0_30ck70 = 1.1 time = 355
* CHECK dout0_31 vdout0_31ck70 = 1.1 time = 355
* CHECK dout0_0 vdout0_0ck71 = 1.1 time = 360
* CHECK dout0_1 vdout0_1ck71 = 0 time = 360
* CHECK dout0_2 vdout0_2ck71 = 1.1 time = 360
* CHECK dout0_3 vdout0_3ck71 = 0 time = 360
* CHECK dout0_4 vdout0_4ck71 = 0 time = 360
* CHECK dout0_5 vdout0_5ck71 = 0 time = 360
* CHECK dout0_6 vdout0_6ck71 = 1.1 time = 360
* CHECK dout0_7 vdout0_7ck71 = 0 time = 360
* CHECK dout0_8 vdout0_8ck71 = 1.1 time = 360
* CHECK dout0_9 vdout0_9ck71 = 0 time = 360
* CHECK dout0_10 vdout0_10ck71 = 1.1 time = 360
* CHECK dout0_11 vdout0_11ck71 = 1.1 time = 360
* CHECK dout0_12 vdout0_12ck71 = 1.1 time = 360
* CHECK dout0_13 vdout0_13ck71 = 0 time = 360
* CHECK dout0_14 vdout0_14ck71 = 1.1 time = 360
* CHECK dout0_15 vdout0_15ck71 = 1.1 time = 360
* CHECK dout0_16 vdout0_16ck71 = 0 time = 360
* CHECK dout0_17 vdout0_17ck71 = 0 time = 360
* CHECK dout0_18 vdout0_18ck71 = 0 time = 360
* CHECK dout0_19 vdout0_19ck71 = 1.1 time = 360
* CHECK dout0_20 vdout0_20ck71 = 0 time = 360
* CHECK dout0_21 vdout0_21ck71 = 1.1 time = 360
* CHECK dout0_22 vdout0_22ck71 = 1.1 time = 360
* CHECK dout0_23 vdout0_23ck71 = 1.1 time = 360
* CHECK dout0_24 vdout0_24ck71 = 0 time = 360
* CHECK dout0_25 vdout0_25ck71 = 0 time = 360
* CHECK dout0_26 vdout0_26ck71 = 0 time = 360
* CHECK dout0_27 vdout0_27ck71 = 1.1 time = 360
* CHECK dout0_28 vdout0_28ck71 = 1.1 time = 360
* CHECK dout0_29 vdout0_29ck71 = 0 time = 360
* CHECK dout0_30 vdout0_30ck71 = 1.1 time = 360
* CHECK dout0_31 vdout0_31ck71 = 0 time = 360
* CHECK dout0_0 vdout0_0ck72 = 1.1 time = 365
* CHECK dout0_1 vdout0_1ck72 = 0 time = 365
* CHECK dout0_2 vdout0_2ck72 = 1.1 time = 365
* CHECK dout0_3 vdout0_3ck72 = 0 time = 365
* CHECK dout0_4 vdout0_4ck72 = 0 time = 365
* CHECK dout0_5 vdout0_5ck72 = 0 time = 365
* CHECK dout0_6 vdout0_6ck72 = 1.1 time = 365
* CHECK dout0_7 vdout0_7ck72 = 0 time = 365
* CHECK dout0_8 vdout0_8ck72 = 1.1 time = 365
* CHECK dout0_9 vdout0_9ck72 = 0 time = 365
* CHECK dout0_10 vdout0_10ck72 = 1.1 time = 365
* CHECK dout0_11 vdout0_11ck72 = 1.1 time = 365
* CHECK dout0_12 vdout0_12ck72 = 1.1 time = 365
* CHECK dout0_13 vdout0_13ck72 = 0 time = 365
* CHECK dout0_14 vdout0_14ck72 = 1.1 time = 365
* CHECK dout0_15 vdout0_15ck72 = 1.1 time = 365
* CHECK dout0_16 vdout0_16ck72 = 0 time = 365
* CHECK dout0_17 vdout0_17ck72 = 0 time = 365
* CHECK dout0_18 vdout0_18ck72 = 0 time = 365
* CHECK dout0_19 vdout0_19ck72 = 1.1 time = 365
* CHECK dout0_20 vdout0_20ck72 = 0 time = 365
* CHECK dout0_21 vdout0_21ck72 = 1.1 time = 365
* CHECK dout0_22 vdout0_22ck72 = 1.1 time = 365
* CHECK dout0_23 vdout0_23ck72 = 1.1 time = 365
* CHECK dout0_24 vdout0_24ck72 = 0 time = 365
* CHECK dout0_25 vdout0_25ck72 = 0 time = 365
* CHECK dout0_26 vdout0_26ck72 = 0 time = 365
* CHECK dout0_27 vdout0_27ck72 = 1.1 time = 365
* CHECK dout0_28 vdout0_28ck72 = 1.1 time = 365
* CHECK dout0_29 vdout0_29ck72 = 0 time = 365
* CHECK dout0_30 vdout0_30ck72 = 1.1 time = 365
* CHECK dout0_31 vdout0_31ck72 = 0 time = 365
* CHECK dout0_0 vdout0_0ck73 = 1.1 time = 370
* CHECK dout0_1 vdout0_1ck73 = 0 time = 370
* CHECK dout0_2 vdout0_2ck73 = 1.1 time = 370
* CHECK dout0_3 vdout0_3ck73 = 0 time = 370
* CHECK dout0_4 vdout0_4ck73 = 0 time = 370
* CHECK dout0_5 vdout0_5ck73 = 0 time = 370
* CHECK dout0_6 vdout0_6ck73 = 1.1 time = 370
* CHECK dout0_7 vdout0_7ck73 = 0 time = 370
* CHECK dout0_8 vdout0_8ck73 = 1.1 time = 370
* CHECK dout0_9 vdout0_9ck73 = 0 time = 370
* CHECK dout0_10 vdout0_10ck73 = 1.1 time = 370
* CHECK dout0_11 vdout0_11ck73 = 1.1 time = 370
* CHECK dout0_12 vdout0_12ck73 = 1.1 time = 370
* CHECK dout0_13 vdout0_13ck73 = 0 time = 370
* CHECK dout0_14 vdout0_14ck73 = 1.1 time = 370
* CHECK dout0_15 vdout0_15ck73 = 1.1 time = 370
* CHECK dout0_16 vdout0_16ck73 = 0 time = 370
* CHECK dout0_17 vdout0_17ck73 = 0 time = 370
* CHECK dout0_18 vdout0_18ck73 = 0 time = 370
* CHECK dout0_19 vdout0_19ck73 = 1.1 time = 370
* CHECK dout0_20 vdout0_20ck73 = 0 time = 370
* CHECK dout0_21 vdout0_21ck73 = 1.1 time = 370
* CHECK dout0_22 vdout0_22ck73 = 1.1 time = 370
* CHECK dout0_23 vdout0_23ck73 = 1.1 time = 370
* CHECK dout0_24 vdout0_24ck73 = 0 time = 370
* CHECK dout0_25 vdout0_25ck73 = 0 time = 370
* CHECK dout0_26 vdout0_26ck73 = 0 time = 370
* CHECK dout0_27 vdout0_27ck73 = 1.1 time = 370
* CHECK dout0_28 vdout0_28ck73 = 1.1 time = 370
* CHECK dout0_29 vdout0_29ck73 = 0 time = 370
* CHECK dout0_30 vdout0_30ck73 = 1.1 time = 370
* CHECK dout0_31 vdout0_31ck73 = 0 time = 370
* CHECK dout0_0 vdout0_0ck76 = 1.1 time = 385
* CHECK dout0_1 vdout0_1ck76 = 0 time = 385
* CHECK dout0_2 vdout0_2ck76 = 1.1 time = 385
* CHECK dout0_3 vdout0_3ck76 = 0 time = 385
* CHECK dout0_4 vdout0_4ck76 = 0 time = 385
* CHECK dout0_5 vdout0_5ck76 = 0 time = 385
* CHECK dout0_6 vdout0_6ck76 = 1.1 time = 385
* CHECK dout0_7 vdout0_7ck76 = 0 time = 385
* CHECK dout0_8 vdout0_8ck76 = 1.1 time = 385
* CHECK dout0_9 vdout0_9ck76 = 0 time = 385
* CHECK dout0_10 vdout0_10ck76 = 1.1 time = 385
* CHECK dout0_11 vdout0_11ck76 = 1.1 time = 385
* CHECK dout0_12 vdout0_12ck76 = 1.1 time = 385
* CHECK dout0_13 vdout0_13ck76 = 0 time = 385
* CHECK dout0_14 vdout0_14ck76 = 1.1 time = 385
* CHECK dout0_15 vdout0_15ck76 = 1.1 time = 385
* CHECK dout0_16 vdout0_16ck76 = 0 time = 385
* CHECK dout0_17 vdout0_17ck76 = 0 time = 385
* CHECK dout0_18 vdout0_18ck76 = 0 time = 385
* CHECK dout0_19 vdout0_19ck76 = 1.1 time = 385
* CHECK dout0_20 vdout0_20ck76 = 0 time = 385
* CHECK dout0_21 vdout0_21ck76 = 1.1 time = 385
* CHECK dout0_22 vdout0_22ck76 = 1.1 time = 385
* CHECK dout0_23 vdout0_23ck76 = 1.1 time = 385
* CHECK dout0_24 vdout0_24ck76 = 0 time = 385
* CHECK dout0_25 vdout0_25ck76 = 0 time = 385
* CHECK dout0_26 vdout0_26ck76 = 0 time = 385
* CHECK dout0_27 vdout0_27ck76 = 1.1 time = 385
* CHECK dout0_28 vdout0_28ck76 = 1.1 time = 385
* CHECK dout0_29 vdout0_29ck76 = 0 time = 385
* CHECK dout0_30 vdout0_30ck76 = 1.1 time = 385
* CHECK dout0_31 vdout0_31ck76 = 0 time = 385
* CHECK dout0_0 vdout0_0ck80 = 1.1 time = 405
* CHECK dout0_1 vdout0_1ck80 = 0 time = 405
* CHECK dout0_2 vdout0_2ck80 = 0 time = 405
* CHECK dout0_3 vdout0_3ck80 = 1.1 time = 405
* CHECK dout0_4 vdout0_4ck80 = 1.1 time = 405
* CHECK dout0_5 vdout0_5ck80 = 1.1 time = 405
* CHECK dout0_6 vdout0_6ck80 = 0 time = 405
* CHECK dout0_7 vdout0_7ck80 = 1.1 time = 405
* CHECK dout0_8 vdout0_8ck80 = 1.1 time = 405
* CHECK dout0_9 vdout0_9ck80 = 0 time = 405
* CHECK dout0_10 vdout0_10ck80 = 1.1 time = 405
* CHECK dout0_11 vdout0_11ck80 = 1.1 time = 405
* CHECK dout0_12 vdout0_12ck80 = 1.1 time = 405
* CHECK dout0_13 vdout0_13ck80 = 0 time = 405
* CHECK dout0_14 vdout0_14ck80 = 1.1 time = 405
* CHECK dout0_15 vdout0_15ck80 = 1.1 time = 405
* CHECK dout0_16 vdout0_16ck80 = 1.1 time = 405
* CHECK dout0_17 vdout0_17ck80 = 0 time = 405
* CHECK dout0_18 vdout0_18ck80 = 0 time = 405
* CHECK dout0_19 vdout0_19ck80 = 0 time = 405
* CHECK dout0_20 vdout0_20ck80 = 1.1 time = 405
* CHECK dout0_21 vdout0_21ck80 = 0 time = 405
* CHECK dout0_22 vdout0_22ck80 = 1.1 time = 405
* CHECK dout0_23 vdout0_23ck80 = 1.1 time = 405
* CHECK dout0_24 vdout0_24ck80 = 0 time = 405
* CHECK dout0_25 vdout0_25ck80 = 0 time = 405
* CHECK dout0_26 vdout0_26ck80 = 0 time = 405
* CHECK dout0_27 vdout0_27ck80 = 1.1 time = 405
* CHECK dout0_28 vdout0_28ck80 = 0 time = 405
* CHECK dout0_29 vdout0_29ck80 = 1.1 time = 405
* CHECK dout0_30 vdout0_30ck80 = 1.1 time = 405
* CHECK dout0_31 vdout0_31ck80 = 1.1 time = 405
* CHECK dout0_0 vdout0_0ck83 = 1.1 time = 420
* CHECK dout0_1 vdout0_1ck83 = 1.1 time = 420
* CHECK dout0_2 vdout0_2ck83 = 0 time = 420
* CHECK dout0_3 vdout0_3ck83 = 1.1 time = 420
* CHECK dout0_4 vdout0_4ck83 = 0 time = 420
* CHECK dout0_5 vdout0_5ck83 = 1.1 time = 420
* CHECK dout0_6 vdout0_6ck83 = 1.1 time = 420
* CHECK dout0_7 vdout0_7ck83 = 0 time = 420
* CHECK dout0_8 vdout0_8ck83 = 1.1 time = 420
* CHECK dout0_9 vdout0_9ck83 = 0 time = 420
* CHECK dout0_10 vdout0_10ck83 = 1.1 time = 420
* CHECK dout0_11 vdout0_11ck83 = 0 time = 420
* CHECK dout0_12 vdout0_12ck83 = 1.1 time = 420
* CHECK dout0_13 vdout0_13ck83 = 0 time = 420
* CHECK dout0_14 vdout0_14ck83 = 0 time = 420
* CHECK dout0_15 vdout0_15ck83 = 0 time = 420
* CHECK dout0_16 vdout0_16ck83 = 1.1 time = 420
* CHECK dout0_17 vdout0_17ck83 = 1.1 time = 420
* CHECK dout0_18 vdout0_18ck83 = 0 time = 420
* CHECK dout0_19 vdout0_19ck83 = 0 time = 420
* CHECK dout0_20 vdout0_20ck83 = 1.1 time = 420
* CHECK dout0_21 vdout0_21ck83 = 0 time = 420
* CHECK dout0_22 vdout0_22ck83 = 0 time = 420
* CHECK dout0_23 vdout0_23ck83 = 0 time = 420
* CHECK dout0_24 vdout0_24ck83 = 0 time = 420
* CHECK dout0_25 vdout0_25ck83 = 1.1 time = 420
* CHECK dout0_26 vdout0_26ck83 = 1.1 time = 420
* CHECK dout0_27 vdout0_27ck83 = 0 time = 420
* CHECK dout0_28 vdout0_28ck83 = 1.1 time = 420
* CHECK dout0_29 vdout0_29ck83 = 1.1 time = 420
* CHECK dout0_30 vdout0_30ck83 = 0 time = 420
* CHECK dout0_31 vdout0_31ck83 = 1.1 time = 420
* CHECK dout0_0 vdout0_0ck84 = 1.1 time = 425
* CHECK dout0_1 vdout0_1ck84 = 1.1 time = 425
* CHECK dout0_2 vdout0_2ck84 = 0 time = 425
* CHECK dout0_3 vdout0_3ck84 = 1.1 time = 425
* CHECK dout0_4 vdout0_4ck84 = 0 time = 425
* CHECK dout0_5 vdout0_5ck84 = 1.1 time = 425
* CHECK dout0_6 vdout0_6ck84 = 1.1 time = 425
* CHECK dout0_7 vdout0_7ck84 = 0 time = 425
* CHECK dout0_8 vdout0_8ck84 = 1.1 time = 425
* CHECK dout0_9 vdout0_9ck84 = 0 time = 425
* CHECK dout0_10 vdout0_10ck84 = 1.1 time = 425
* CHECK dout0_11 vdout0_11ck84 = 0 time = 425
* CHECK dout0_12 vdout0_12ck84 = 1.1 time = 425
* CHECK dout0_13 vdout0_13ck84 = 0 time = 425
* CHECK dout0_14 vdout0_14ck84 = 0 time = 425
* CHECK dout0_15 vdout0_15ck84 = 0 time = 425
* CHECK dout0_16 vdout0_16ck84 = 1.1 time = 425
* CHECK dout0_17 vdout0_17ck84 = 1.1 time = 425
* CHECK dout0_18 vdout0_18ck84 = 0 time = 425
* CHECK dout0_19 vdout0_19ck84 = 0 time = 425
* CHECK dout0_20 vdout0_20ck84 = 1.1 time = 425
* CHECK dout0_21 vdout0_21ck84 = 0 time = 425
* CHECK dout0_22 vdout0_22ck84 = 0 time = 425
* CHECK dout0_23 vdout0_23ck84 = 0 time = 425
* CHECK dout0_24 vdout0_24ck84 = 0 time = 425
* CHECK dout0_25 vdout0_25ck84 = 1.1 time = 425
* CHECK dout0_26 vdout0_26ck84 = 1.1 time = 425
* CHECK dout0_27 vdout0_27ck84 = 0 time = 425
* CHECK dout0_28 vdout0_28ck84 = 1.1 time = 425
* CHECK dout0_29 vdout0_29ck84 = 1.1 time = 425
* CHECK dout0_30 vdout0_30ck84 = 0 time = 425
* CHECK dout0_31 vdout0_31ck84 = 1.1 time = 425
* CHECK dout0_0 vdout0_0ck88 = 1.1 time = 445
* CHECK dout0_1 vdout0_1ck88 = 0 time = 445
* CHECK dout0_2 vdout0_2ck88 = 0 time = 445
* CHECK dout0_3 vdout0_3ck88 = 0 time = 445
* CHECK dout0_4 vdout0_4ck88 = 0 time = 445
* CHECK dout0_5 vdout0_5ck88 = 0 time = 445
* CHECK dout0_6 vdout0_6ck88 = 0 time = 445
* CHECK dout0_7 vdout0_7ck88 = 0 time = 445
* CHECK dout0_8 vdout0_8ck88 = 1.1 time = 445
* CHECK dout0_9 vdout0_9ck88 = 0 time = 445
* CHECK dout0_10 vdout0_10ck88 = 1.1 time = 445
* CHECK dout0_11 vdout0_11ck88 = 1.1 time = 445
* CHECK dout0_12 vdout0_12ck88 = 1.1 time = 445
* CHECK dout0_13 vdout0_13ck88 = 0 time = 445
* CHECK dout0_14 vdout0_14ck88 = 1.1 time = 445
* CHECK dout0_15 vdout0_15ck88 = 1.1 time = 445
* CHECK dout0_16 vdout0_16ck88 = 1.1 time = 445
* CHECK dout0_17 vdout0_17ck88 = 0 time = 445
* CHECK dout0_18 vdout0_18ck88 = 0 time = 445
* CHECK dout0_19 vdout0_19ck88 = 0 time = 445
* CHECK dout0_20 vdout0_20ck88 = 1.1 time = 445
* CHECK dout0_21 vdout0_21ck88 = 0 time = 445
* CHECK dout0_22 vdout0_22ck88 = 1.1 time = 445
* CHECK dout0_23 vdout0_23ck88 = 1.1 time = 445
* CHECK dout0_24 vdout0_24ck88 = 0 time = 445
* CHECK dout0_25 vdout0_25ck88 = 0 time = 445
* CHECK dout0_26 vdout0_26ck88 = 0 time = 445
* CHECK dout0_27 vdout0_27ck88 = 1.1 time = 445
* CHECK dout0_28 vdout0_28ck88 = 0 time = 445
* CHECK dout0_29 vdout0_29ck88 = 1.1 time = 445
* CHECK dout0_30 vdout0_30ck88 = 1.1 time = 445
* CHECK dout0_31 vdout0_31ck88 = 1.1 time = 445
* CHECK dout0_0 vdout0_0ck93 = 0 time = 470
* CHECK dout0_1 vdout0_1ck93 = 1.1 time = 470
* CHECK dout0_2 vdout0_2ck93 = 0 time = 470
* CHECK dout0_3 vdout0_3ck93 = 1.1 time = 470
* CHECK dout0_4 vdout0_4ck93 = 1.1 time = 470
* CHECK dout0_5 vdout0_5ck93 = 1.1 time = 470
* CHECK dout0_6 vdout0_6ck93 = 1.1 time = 470
* CHECK dout0_7 vdout0_7ck93 = 1.1 time = 470
* CHECK dout0_8 vdout0_8ck93 = 1.1 time = 470
* CHECK dout0_9 vdout0_9ck93 = 0 time = 470
* CHECK dout0_10 vdout0_10ck93 = 0 time = 470
* CHECK dout0_11 vdout0_11ck93 = 0 time = 470
* CHECK dout0_12 vdout0_12ck93 = 1.1 time = 470
* CHECK dout0_13 vdout0_13ck93 = 1.1 time = 470
* CHECK dout0_14 vdout0_14ck93 = 0 time = 470
* CHECK dout0_15 vdout0_15ck93 = 1.1 time = 470
* CHECK dout0_16 vdout0_16ck93 = 0 time = 470
* CHECK dout0_17 vdout0_17ck93 = 1.1 time = 470
* CHECK dout0_18 vdout0_18ck93 = 0 time = 470
* CHECK dout0_19 vdout0_19ck93 = 1.1 time = 470
* CHECK dout0_20 vdout0_20ck93 = 1.1 time = 470
* CHECK dout0_21 vdout0_21ck93 = 1.1 time = 470
* CHECK dout0_22 vdout0_22ck93 = 0 time = 470
* CHECK dout0_23 vdout0_23ck93 = 1.1 time = 470
* CHECK dout0_24 vdout0_24ck93 = 1.1 time = 470
* CHECK dout0_25 vdout0_25ck93 = 0 time = 470
* CHECK dout0_26 vdout0_26ck93 = 0 time = 470
* CHECK dout0_27 vdout0_27ck93 = 1.1 time = 470
* CHECK dout0_28 vdout0_28ck93 = 1.1 time = 470
* CHECK dout0_29 vdout0_29ck93 = 0 time = 470
* CHECK dout0_30 vdout0_30ck93 = 1.1 time = 470
* CHECK dout0_31 vdout0_31ck93 = 0 time = 470
* CHECK dout0_0 vdout0_0ck94 = 0 time = 475
* CHECK dout0_1 vdout0_1ck94 = 1.1 time = 475
* CHECK dout0_2 vdout0_2ck94 = 0 time = 475
* CHECK dout0_3 vdout0_3ck94 = 1.1 time = 475
* CHECK dout0_4 vdout0_4ck94 = 1.1 time = 475
* CHECK dout0_5 vdout0_5ck94 = 1.1 time = 475
* CHECK dout0_6 vdout0_6ck94 = 1.1 time = 475
* CHECK dout0_7 vdout0_7ck94 = 1.1 time = 475
* CHECK dout0_8 vdout0_8ck94 = 1.1 time = 475
* CHECK dout0_9 vdout0_9ck94 = 0 time = 475
* CHECK dout0_10 vdout0_10ck94 = 0 time = 475
* CHECK dout0_11 vdout0_11ck94 = 0 time = 475
* CHECK dout0_12 vdout0_12ck94 = 1.1 time = 475
* CHECK dout0_13 vdout0_13ck94 = 1.1 time = 475
* CHECK dout0_14 vdout0_14ck94 = 0 time = 475
* CHECK dout0_15 vdout0_15ck94 = 1.1 time = 475
* CHECK dout0_16 vdout0_16ck94 = 0 time = 475
* CHECK dout0_17 vdout0_17ck94 = 1.1 time = 475
* CHECK dout0_18 vdout0_18ck94 = 0 time = 475
* CHECK dout0_19 vdout0_19ck94 = 1.1 time = 475
* CHECK dout0_20 vdout0_20ck94 = 1.1 time = 475
* CHECK dout0_21 vdout0_21ck94 = 1.1 time = 475
* CHECK dout0_22 vdout0_22ck94 = 0 time = 475
* CHECK dout0_23 vdout0_23ck94 = 1.1 time = 475
* CHECK dout0_24 vdout0_24ck94 = 1.1 time = 475
* CHECK dout0_25 vdout0_25ck94 = 0 time = 475
* CHECK dout0_26 vdout0_26ck94 = 0 time = 475
* CHECK dout0_27 vdout0_27ck94 = 1.1 time = 475
* CHECK dout0_28 vdout0_28ck94 = 1.1 time = 475
* CHECK dout0_29 vdout0_29ck94 = 0 time = 475
* CHECK dout0_30 vdout0_30ck94 = 1.1 time = 475
* CHECK dout0_31 vdout0_31ck94 = 0 time = 475
* CHECK dout0_0 vdout0_0ck99 = 0 time = 500
* CHECK dout0_1 vdout0_1ck99 = 0 time = 500
* CHECK dout0_2 vdout0_2ck99 = 1.1 time = 500
* CHECK dout0_3 vdout0_3ck99 = 0 time = 500
* CHECK dout0_4 vdout0_4ck99 = 0 time = 500
* CHECK dout0_5 vdout0_5ck99 = 1.1 time = 500
* CHECK dout0_6 vdout0_6ck99 = 0 time = 500
* CHECK dout0_7 vdout0_7ck99 = 0 time = 500
* CHECK dout0_8 vdout0_8ck99 = 1.1 time = 500
* CHECK dout0_9 vdout0_9ck99 = 1.1 time = 500
* CHECK dout0_10 vdout0_10ck99 = 0 time = 500
* CHECK dout0_11 vdout0_11ck99 = 1.1 time = 500
* CHECK dout0_12 vdout0_12ck99 = 1.1 time = 500
* CHECK dout0_13 vdout0_13ck99 = 1.1 time = 500
* CHECK dout0_14 vdout0_14ck99 = 1.1 time = 500
* CHECK dout0_15 vdout0_15ck99 = 0 time = 500
* CHECK dout0_16 vdout0_16ck99 = 1.1 time = 500
* CHECK dout0_17 vdout0_17ck99 = 0 time = 500
* CHECK dout0_18 vdout0_18ck99 = 0 time = 500
* CHECK dout0_19 vdout0_19ck99 = 1.1 time = 500
* CHECK dout0_20 vdout0_20ck99 = 0 time = 500
* CHECK dout0_21 vdout0_21ck99 = 1.1 time = 500
* CHECK dout0_22 vdout0_22ck99 = 0 time = 500
* CHECK dout0_23 vdout0_23ck99 = 0 time = 500
* CHECK dout0_24 vdout0_24ck99 = 1.1 time = 500
* CHECK dout0_25 vdout0_25ck99 = 1.1 time = 500
* CHECK dout0_26 vdout0_26ck99 = 0 time = 500
* CHECK dout0_27 vdout0_27ck99 = 1.1 time = 500
* CHECK dout0_28 vdout0_28ck99 = 1.1 time = 500
* CHECK dout0_29 vdout0_29ck99 = 1.1 time = 500
* CHECK dout0_30 vdout0_30ck99 = 0 time = 500
* CHECK dout0_31 vdout0_31ck99 = 0 time = 500
* CHECK dout0_0 vdout0_0ck100 = 0 time = 505
* CHECK dout0_1 vdout0_1ck100 = 0 time = 505
* CHECK dout0_2 vdout0_2ck100 = 1.1 time = 505
* CHECK dout0_3 vdout0_3ck100 = 0 time = 505
* CHECK dout0_4 vdout0_4ck100 = 0 time = 505
* CHECK dout0_5 vdout0_5ck100 = 1.1 time = 505
* CHECK dout0_6 vdout0_6ck100 = 0 time = 505
* CHECK dout0_7 vdout0_7ck100 = 0 time = 505
* CHECK dout0_8 vdout0_8ck100 = 1.1 time = 505
* CHECK dout0_9 vdout0_9ck100 = 1.1 time = 505
* CHECK dout0_10 vdout0_10ck100 = 0 time = 505
* CHECK dout0_11 vdout0_11ck100 = 1.1 time = 505
* CHECK dout0_12 vdout0_12ck100 = 1.1 time = 505
* CHECK dout0_13 vdout0_13ck100 = 1.1 time = 505
* CHECK dout0_14 vdout0_14ck100 = 1.1 time = 505
* CHECK dout0_15 vdout0_15ck100 = 0 time = 505
* CHECK dout0_16 vdout0_16ck100 = 1.1 time = 505
* CHECK dout0_17 vdout0_17ck100 = 0 time = 505
* CHECK dout0_18 vdout0_18ck100 = 0 time = 505
* CHECK dout0_19 vdout0_19ck100 = 1.1 time = 505
* CHECK dout0_20 vdout0_20ck100 = 0 time = 505
* CHECK dout0_21 vdout0_21ck100 = 1.1 time = 505
* CHECK dout0_22 vdout0_22ck100 = 0 time = 505
* CHECK dout0_23 vdout0_23ck100 = 0 time = 505
* CHECK dout0_24 vdout0_24ck100 = 1.1 time = 505
* CHECK dout0_25 vdout0_25ck100 = 1.1 time = 505
* CHECK dout0_26 vdout0_26ck100 = 0 time = 505
* CHECK dout0_27 vdout0_27ck100 = 1.1 time = 505
* CHECK dout0_28 vdout0_28ck100 = 1.1 time = 505
* CHECK dout0_29 vdout0_29ck100 = 1.1 time = 505
* CHECK dout0_30 vdout0_30ck100 = 0 time = 505
* CHECK dout0_31 vdout0_31ck100 = 0 time = 505
* CHECK dout0_0 vdout0_0ck101 = 0 time = 510
* CHECK dout0_1 vdout0_1ck101 = 0 time = 510
* CHECK dout0_2 vdout0_2ck101 = 1.1 time = 510
* CHECK dout0_3 vdout0_3ck101 = 0 time = 510
* CHECK dout0_4 vdout0_4ck101 = 0 time = 510
* CHECK dout0_5 vdout0_5ck101 = 1.1 time = 510
* CHECK dout0_6 vdout0_6ck101 = 0 time = 510
* CHECK dout0_7 vdout0_7ck101 = 0 time = 510
* CHECK dout0_8 vdout0_8ck101 = 1.1 time = 510
* CHECK dout0_9 vdout0_9ck101 = 1.1 time = 510
* CHECK dout0_10 vdout0_10ck101 = 0 time = 510
* CHECK dout0_11 vdout0_11ck101 = 1.1 time = 510
* CHECK dout0_12 vdout0_12ck101 = 1.1 time = 510
* CHECK dout0_13 vdout0_13ck101 = 1.1 time = 510
* CHECK dout0_14 vdout0_14ck101 = 1.1 time = 510
* CHECK dout0_15 vdout0_15ck101 = 0 time = 510
* CHECK dout0_16 vdout0_16ck101 = 1.1 time = 510
* CHECK dout0_17 vdout0_17ck101 = 0 time = 510
* CHECK dout0_18 vdout0_18ck101 = 0 time = 510
* CHECK dout0_19 vdout0_19ck101 = 1.1 time = 510
* CHECK dout0_20 vdout0_20ck101 = 0 time = 510
* CHECK dout0_21 vdout0_21ck101 = 1.1 time = 510
* CHECK dout0_22 vdout0_22ck101 = 0 time = 510
* CHECK dout0_23 vdout0_23ck101 = 0 time = 510
* CHECK dout0_24 vdout0_24ck101 = 1.1 time = 510
* CHECK dout0_25 vdout0_25ck101 = 1.1 time = 510
* CHECK dout0_26 vdout0_26ck101 = 0 time = 510
* CHECK dout0_27 vdout0_27ck101 = 1.1 time = 510
* CHECK dout0_28 vdout0_28ck101 = 1.1 time = 510
* CHECK dout0_29 vdout0_29ck101 = 1.1 time = 510
* CHECK dout0_30 vdout0_30ck101 = 0 time = 510
* CHECK dout0_31 vdout0_31ck101 = 0 time = 510
* CHECK dout0_0 vdout0_0ck104 = 1.1 time = 525
* CHECK dout0_1 vdout0_1ck104 = 0 time = 525
* CHECK dout0_2 vdout0_2ck104 = 0 time = 525
* CHECK dout0_3 vdout0_3ck104 = 0 time = 525
* CHECK dout0_4 vdout0_4ck104 = 1.1 time = 525
* CHECK dout0_5 vdout0_5ck104 = 1.1 time = 525
* CHECK dout0_6 vdout0_6ck104 = 1.1 time = 525
* CHECK dout0_7 vdout0_7ck104 = 0 time = 525
* CHECK dout0_8 vdout0_8ck104 = 1.1 time = 525
* CHECK dout0_9 vdout0_9ck104 = 0 time = 525
* CHECK dout0_10 vdout0_10ck104 = 0 time = 525
* CHECK dout0_11 vdout0_11ck104 = 0 time = 525
* CHECK dout0_12 vdout0_12ck104 = 0 time = 525
* CHECK dout0_13 vdout0_13ck104 = 0 time = 525
* CHECK dout0_14 vdout0_14ck104 = 1.1 time = 525
* CHECK dout0_15 vdout0_15ck104 = 0 time = 525
* CHECK dout0_16 vdout0_16ck104 = 1.1 time = 525
* CHECK dout0_17 vdout0_17ck104 = 1.1 time = 525
* CHECK dout0_18 vdout0_18ck104 = 0 time = 525
* CHECK dout0_19 vdout0_19ck104 = 1.1 time = 525
* CHECK dout0_20 vdout0_20ck104 = 1.1 time = 525
* CHECK dout0_21 vdout0_21ck104 = 1.1 time = 525
* CHECK dout0_22 vdout0_22ck104 = 0 time = 525
* CHECK dout0_23 vdout0_23ck104 = 0 time = 525
* CHECK dout0_24 vdout0_24ck104 = 1.1 time = 525
* CHECK dout0_25 vdout0_25ck104 = 0 time = 525
* CHECK dout0_26 vdout0_26ck104 = 1.1 time = 525
* CHECK dout0_27 vdout0_27ck104 = 0 time = 525
* CHECK dout0_28 vdout0_28ck104 = 1.1 time = 525
* CHECK dout0_29 vdout0_29ck104 = 1.1 time = 525
* CHECK dout0_30 vdout0_30ck104 = 0 time = 525
* CHECK dout0_31 vdout0_31ck104 = 0 time = 525
* CHECK dout0_0 vdout0_0ck105 = 1.1 time = 530
* CHECK dout0_1 vdout0_1ck105 = 0 time = 530
* CHECK dout0_2 vdout0_2ck105 = 0 time = 530
* CHECK dout0_3 vdout0_3ck105 = 0 time = 530
* CHECK dout0_4 vdout0_4ck105 = 1.1 time = 530
* CHECK dout0_5 vdout0_5ck105 = 1.1 time = 530
* CHECK dout0_6 vdout0_6ck105 = 1.1 time = 530
* CHECK dout0_7 vdout0_7ck105 = 0 time = 530
* CHECK dout0_8 vdout0_8ck105 = 1.1 time = 530
* CHECK dout0_9 vdout0_9ck105 = 0 time = 530
* CHECK dout0_10 vdout0_10ck105 = 0 time = 530
* CHECK dout0_11 vdout0_11ck105 = 0 time = 530
* CHECK dout0_12 vdout0_12ck105 = 0 time = 530
* CHECK dout0_13 vdout0_13ck105 = 0 time = 530
* CHECK dout0_14 vdout0_14ck105 = 1.1 time = 530
* CHECK dout0_15 vdout0_15ck105 = 0 time = 530
* CHECK dout0_16 vdout0_16ck105 = 1.1 time = 530
* CHECK dout0_17 vdout0_17ck105 = 1.1 time = 530
* CHECK dout0_18 vdout0_18ck105 = 0 time = 530
* CHECK dout0_19 vdout0_19ck105 = 1.1 time = 530
* CHECK dout0_20 vdout0_20ck105 = 1.1 time = 530
* CHECK dout0_21 vdout0_21ck105 = 1.1 time = 530
* CHECK dout0_22 vdout0_22ck105 = 0 time = 530
* CHECK dout0_23 vdout0_23ck105 = 0 time = 530
* CHECK dout0_24 vdout0_24ck105 = 1.1 time = 530
* CHECK dout0_25 vdout0_25ck105 = 0 time = 530
* CHECK dout0_26 vdout0_26ck105 = 1.1 time = 530
* CHECK dout0_27 vdout0_27ck105 = 0 time = 530
* CHECK dout0_28 vdout0_28ck105 = 1.1 time = 530
* CHECK dout0_29 vdout0_29ck105 = 1.1 time = 530
* CHECK dout0_30 vdout0_30ck105 = 0 time = 530
* CHECK dout0_31 vdout0_31ck105 = 0 time = 530
* CHECK dout0_0 vdout0_0ck112 = 1.1 time = 565
* CHECK dout0_1 vdout0_1ck112 = 0 time = 565
* CHECK dout0_2 vdout0_2ck112 = 0 time = 565
* CHECK dout0_3 vdout0_3ck112 = 0 time = 565
* CHECK dout0_4 vdout0_4ck112 = 1.1 time = 565
* CHECK dout0_5 vdout0_5ck112 = 0 time = 565
* CHECK dout0_6 vdout0_6ck112 = 1.1 time = 565
* CHECK dout0_7 vdout0_7ck112 = 1.1 time = 565
* CHECK dout0_8 vdout0_8ck112 = 1.1 time = 565
* CHECK dout0_9 vdout0_9ck112 = 1.1 time = 565
* CHECK dout0_10 vdout0_10ck112 = 1.1 time = 565
* CHECK dout0_11 vdout0_11ck112 = 0 time = 565
* CHECK dout0_12 vdout0_12ck112 = 0 time = 565
* CHECK dout0_13 vdout0_13ck112 = 1.1 time = 565
* CHECK dout0_14 vdout0_14ck112 = 0 time = 565
* CHECK dout0_15 vdout0_15ck112 = 0 time = 565
* CHECK dout0_16 vdout0_16ck112 = 0 time = 565
* CHECK dout0_17 vdout0_17ck112 = 0 time = 565
* CHECK dout0_18 vdout0_18ck112 = 1.1 time = 565
* CHECK dout0_19 vdout0_19ck112 = 1.1 time = 565
* CHECK dout0_20 vdout0_20ck112 = 1.1 time = 565
* CHECK dout0_21 vdout0_21ck112 = 0 time = 565
* CHECK dout0_22 vdout0_22ck112 = 1.1 time = 565
* CHECK dout0_23 vdout0_23ck112 = 0 time = 565
* CHECK dout0_24 vdout0_24ck112 = 1.1 time = 565
* CHECK dout0_25 vdout0_25ck112 = 1.1 time = 565
* CHECK dout0_26 vdout0_26ck112 = 1.1 time = 565
* CHECK dout0_27 vdout0_27ck112 = 0 time = 565
* CHECK dout0_28 vdout0_28ck112 = 1.1 time = 565
* CHECK dout0_29 vdout0_29ck112 = 1.1 time = 565
* CHECK dout0_30 vdout0_30ck112 = 0 time = 565
* CHECK dout0_31 vdout0_31ck112 = 0 time = 565
* CHECK dout0_0 vdout0_0ck113 = 1.1 time = 570
* CHECK dout0_1 vdout0_1ck113 = 1.1 time = 570
* CHECK dout0_2 vdout0_2ck113 = 0 time = 570
* CHECK dout0_3 vdout0_3ck113 = 0 time = 570
* CHECK dout0_4 vdout0_4ck113 = 0 time = 570
* CHECK dout0_5 vdout0_5ck113 = 0 time = 570
* CHECK dout0_6 vdout0_6ck113 = 0 time = 570
* CHECK dout0_7 vdout0_7ck113 = 1.1 time = 570
* CHECK dout0_8 vdout0_8ck113 = 1.1 time = 570
* CHECK dout0_9 vdout0_9ck113 = 0 time = 570
* CHECK dout0_10 vdout0_10ck113 = 0 time = 570
* CHECK dout0_11 vdout0_11ck113 = 0 time = 570
* CHECK dout0_12 vdout0_12ck113 = 1.1 time = 570
* CHECK dout0_13 vdout0_13ck113 = 1.1 time = 570
* CHECK dout0_14 vdout0_14ck113 = 1.1 time = 570
* CHECK dout0_15 vdout0_15ck113 = 1.1 time = 570
* CHECK dout0_16 vdout0_16ck113 = 1.1 time = 570
* CHECK dout0_17 vdout0_17ck113 = 1.1 time = 570
* CHECK dout0_18 vdout0_18ck113 = 0 time = 570
* CHECK dout0_19 vdout0_19ck113 = 1.1 time = 570
* CHECK dout0_20 vdout0_20ck113 = 1.1 time = 570
* CHECK dout0_21 vdout0_21ck113 = 0 time = 570
* CHECK dout0_22 vdout0_22ck113 = 1.1 time = 570
* CHECK dout0_23 vdout0_23ck113 = 0 time = 570
* CHECK dout0_24 vdout0_24ck113 = 0 time = 570
* CHECK dout0_25 vdout0_25ck113 = 1.1 time = 570
* CHECK dout0_26 vdout0_26ck113 = 0 time = 570
* CHECK dout0_27 vdout0_27ck113 = 0 time = 570
* CHECK dout0_28 vdout0_28ck113 = 0 time = 570
* CHECK dout0_29 vdout0_29ck113 = 1.1 time = 570
* CHECK dout0_30 vdout0_30ck113 = 0 time = 570
* CHECK dout0_31 vdout0_31ck113 = 0 time = 570
* CHECK dout0_0 vdout0_0ck122 = 1.1 time = 615
* CHECK dout0_1 vdout0_1ck122 = 1.1 time = 615
* CHECK dout0_2 vdout0_2ck122 = 0 time = 615
* CHECK dout0_3 vdout0_3ck122 = 0 time = 615
* CHECK dout0_4 vdout0_4ck122 = 0 time = 615
* CHECK dout0_5 vdout0_5ck122 = 0 time = 615
* CHECK dout0_6 vdout0_6ck122 = 0 time = 615
* CHECK dout0_7 vdout0_7ck122 = 1.1 time = 615
* CHECK dout0_8 vdout0_8ck122 = 0 time = 615
* CHECK dout0_9 vdout0_9ck122 = 1.1 time = 615
* CHECK dout0_10 vdout0_10ck122 = 0 time = 615
* CHECK dout0_11 vdout0_11ck122 = 1.1 time = 615
* CHECK dout0_12 vdout0_12ck122 = 1.1 time = 615
* CHECK dout0_13 vdout0_13ck122 = 0 time = 615
* CHECK dout0_14 vdout0_14ck122 = 1.1 time = 615
* CHECK dout0_15 vdout0_15ck122 = 0 time = 615
* CHECK dout0_16 vdout0_16ck122 = 0 time = 615
* CHECK dout0_17 vdout0_17ck122 = 0 time = 615
* CHECK dout0_18 vdout0_18ck122 = 0 time = 615
* CHECK dout0_19 vdout0_19ck122 = 1.1 time = 615
* CHECK dout0_20 vdout0_20ck122 = 0 time = 615
* CHECK dout0_21 vdout0_21ck122 = 1.1 time = 615
* CHECK dout0_22 vdout0_22ck122 = 1.1 time = 615
* CHECK dout0_23 vdout0_23ck122 = 1.1 time = 615
* CHECK dout0_24 vdout0_24ck122 = 1.1 time = 615
* CHECK dout0_25 vdout0_25ck122 = 1.1 time = 615
* CHECK dout0_26 vdout0_26ck122 = 0 time = 615
* CHECK dout0_27 vdout0_27ck122 = 1.1 time = 615
* CHECK dout0_28 vdout0_28ck122 = 1.1 time = 615
* CHECK dout0_29 vdout0_29ck122 = 0 time = 615
* CHECK dout0_30 vdout0_30ck122 = 0 time = 615
* CHECK dout0_31 vdout0_31ck122 = 0 time = 615
* CHECK dout0_0 vdout0_0ck126 = 1.1 time = 635
* CHECK dout0_1 vdout0_1ck126 = 0 time = 635
* CHECK dout0_2 vdout0_2ck126 = 0 time = 635
* CHECK dout0_3 vdout0_3ck126 = 1.1 time = 635
* CHECK dout0_4 vdout0_4ck126 = 1.1 time = 635
* CHECK dout0_5 vdout0_5ck126 = 1.1 time = 635
* CHECK dout0_6 vdout0_6ck126 = 1.1 time = 635
* CHECK dout0_7 vdout0_7ck126 = 0 time = 635
* CHECK dout0_8 vdout0_8ck126 = 1.1 time = 635
* CHECK dout0_9 vdout0_9ck126 = 1.1 time = 635
* CHECK dout0_10 vdout0_10ck126 = 0 time = 635
* CHECK dout0_11 vdout0_11ck126 = 0 time = 635
* CHECK dout0_12 vdout0_12ck126 = 1.1 time = 635
* CHECK dout0_13 vdout0_13ck126 = 0 time = 635
* CHECK dout0_14 vdout0_14ck126 = 0 time = 635
* CHECK dout0_15 vdout0_15ck126 = 0 time = 635
* CHECK dout0_16 vdout0_16ck126 = 1.1 time = 635
* CHECK dout0_17 vdout0_17ck126 = 1.1 time = 635
* CHECK dout0_18 vdout0_18ck126 = 0 time = 635
* CHECK dout0_19 vdout0_19ck126 = 1.1 time = 635
* CHECK dout0_20 vdout0_20ck126 = 1.1 time = 635
* CHECK dout0_21 vdout0_21ck126 = 1.1 time = 635
* CHECK dout0_22 vdout0_22ck126 = 1.1 time = 635
* CHECK dout0_23 vdout0_23ck126 = 0 time = 635
* CHECK dout0_24 vdout0_24ck126 = 0 time = 635
* CHECK dout0_25 vdout0_25ck126 = 0 time = 635
* CHECK dout0_26 vdout0_26ck126 = 1.1 time = 635
* CHECK dout0_27 vdout0_27ck126 = 1.1 time = 635
* CHECK dout0_28 vdout0_28ck126 = 1.1 time = 635
* CHECK dout0_29 vdout0_29ck126 = 1.1 time = 635
* CHECK dout0_30 vdout0_30ck126 = 1.1 time = 635
* CHECK dout0_31 vdout0_31ck126 = 0 time = 635
* CHECK dout0_0 vdout0_0ck127 = 1.1 time = 640
* CHECK dout0_1 vdout0_1ck127 = 1.1 time = 640
* CHECK dout0_2 vdout0_2ck127 = 1.1 time = 640
* CHECK dout0_3 vdout0_3ck127 = 0 time = 640
* CHECK dout0_4 vdout0_4ck127 = 1.1 time = 640
* CHECK dout0_5 vdout0_5ck127 = 1.1 time = 640
* CHECK dout0_6 vdout0_6ck127 = 1.1 time = 640
* CHECK dout0_7 vdout0_7ck127 = 0 time = 640
* CHECK dout0_8 vdout0_8ck127 = 0 time = 640
* CHECK dout0_9 vdout0_9ck127 = 1.1 time = 640
* CHECK dout0_10 vdout0_10ck127 = 0 time = 640
* CHECK dout0_11 vdout0_11ck127 = 1.1 time = 640
* CHECK dout0_12 vdout0_12ck127 = 1.1 time = 640
* CHECK dout0_13 vdout0_13ck127 = 0 time = 640
* CHECK dout0_14 vdout0_14ck127 = 1.1 time = 640
* CHECK dout0_15 vdout0_15ck127 = 0 time = 640
* CHECK dout0_16 vdout0_16ck127 = 1.1 time = 640
* CHECK dout0_17 vdout0_17ck127 = 0 time = 640
* CHECK dout0_18 vdout0_18ck127 = 0 time = 640
* CHECK dout0_19 vdout0_19ck127 = 1.1 time = 640
* CHECK dout0_20 vdout0_20ck127 = 1.1 time = 640
* CHECK dout0_21 vdout0_21ck127 = 1.1 time = 640
* CHECK dout0_22 vdout0_22ck127 = 0 time = 640
* CHECK dout0_23 vdout0_23ck127 = 0 time = 640
* CHECK dout0_24 vdout0_24ck127 = 1.1 time = 640
* CHECK dout0_25 vdout0_25ck127 = 1.1 time = 640
* CHECK dout0_26 vdout0_26ck127 = 0 time = 640
* CHECK dout0_27 vdout0_27ck127 = 0 time = 640
* CHECK dout0_28 vdout0_28ck127 = 1.1 time = 640
* CHECK dout0_29 vdout0_29ck127 = 1.1 time = 640
* CHECK dout0_30 vdout0_30ck127 = 0 time = 640
* CHECK dout0_31 vdout0_31ck127 = 0 time = 640
* CHECK dout0_0 vdout0_0ck130 = 1.1 time = 655
* CHECK dout0_1 vdout0_1ck130 = 1.1 time = 655
* CHECK dout0_2 vdout0_2ck130 = 1.1 time = 655
* CHECK dout0_3 vdout0_3ck130 = 0 time = 655
* CHECK dout0_4 vdout0_4ck130 = 1.1 time = 655
* CHECK dout0_5 vdout0_5ck130 = 1.1 time = 655
* CHECK dout0_6 vdout0_6ck130 = 1.1 time = 655
* CHECK dout0_7 vdout0_7ck130 = 0 time = 655
* CHECK dout0_8 vdout0_8ck130 = 0 time = 655
* CHECK dout0_9 vdout0_9ck130 = 1.1 time = 655
* CHECK dout0_10 vdout0_10ck130 = 0 time = 655
* CHECK dout0_11 vdout0_11ck130 = 1.1 time = 655
* CHECK dout0_12 vdout0_12ck130 = 1.1 time = 655
* CHECK dout0_13 vdout0_13ck130 = 0 time = 655
* CHECK dout0_14 vdout0_14ck130 = 1.1 time = 655
* CHECK dout0_15 vdout0_15ck130 = 0 time = 655
* CHECK dout0_16 vdout0_16ck130 = 1.1 time = 655
* CHECK dout0_17 vdout0_17ck130 = 0 time = 655
* CHECK dout0_18 vdout0_18ck130 = 0 time = 655
* CHECK dout0_19 vdout0_19ck130 = 1.1 time = 655
* CHECK dout0_20 vdout0_20ck130 = 1.1 time = 655
* CHECK dout0_21 vdout0_21ck130 = 1.1 time = 655
* CHECK dout0_22 vdout0_22ck130 = 0 time = 655
* CHECK dout0_23 vdout0_23ck130 = 0 time = 655
* CHECK dout0_24 vdout0_24ck130 = 1.1 time = 655
* CHECK dout0_25 vdout0_25ck130 = 1.1 time = 655
* CHECK dout0_26 vdout0_26ck130 = 0 time = 655
* CHECK dout0_27 vdout0_27ck130 = 0 time = 655
* CHECK dout0_28 vdout0_28ck130 = 1.1 time = 655
* CHECK dout0_29 vdout0_29ck130 = 1.1 time = 655
* CHECK dout0_30 vdout0_30ck130 = 0 time = 655
* CHECK dout0_31 vdout0_31ck130 = 0 time = 655
* CHECK dout0_0 vdout0_0ck131 = 1.1 time = 660
* CHECK dout0_1 vdout0_1ck131 = 0 time = 660
* CHECK dout0_2 vdout0_2ck131 = 0 time = 660
* CHECK dout0_3 vdout0_3ck131 = 0 time = 660
* CHECK dout0_4 vdout0_4ck131 = 1.1 time = 660
* CHECK dout0_5 vdout0_5ck131 = 0 time = 660
* CHECK dout0_6 vdout0_6ck131 = 1.1 time = 660
* CHECK dout0_7 vdout0_7ck131 = 1.1 time = 660
* CHECK dout0_8 vdout0_8ck131 = 1.1 time = 660
* CHECK dout0_9 vdout0_9ck131 = 0 time = 660
* CHECK dout0_10 vdout0_10ck131 = 1.1 time = 660
* CHECK dout0_11 vdout0_11ck131 = 0 time = 660
* CHECK dout0_12 vdout0_12ck131 = 0 time = 660
* CHECK dout0_13 vdout0_13ck131 = 0 time = 660
* CHECK dout0_14 vdout0_14ck131 = 1.1 time = 660
* CHECK dout0_15 vdout0_15ck131 = 0 time = 660
* CHECK dout0_16 vdout0_16ck131 = 1.1 time = 660
* CHECK dout0_17 vdout0_17ck131 = 1.1 time = 660
* CHECK dout0_18 vdout0_18ck131 = 0 time = 660
* CHECK dout0_19 vdout0_19ck131 = 1.1 time = 660
* CHECK dout0_20 vdout0_20ck131 = 1.1 time = 660
* CHECK dout0_21 vdout0_21ck131 = 1.1 time = 660
* CHECK dout0_22 vdout0_22ck131 = 1.1 time = 660
* CHECK dout0_23 vdout0_23ck131 = 0 time = 660
* CHECK dout0_24 vdout0_24ck131 = 0 time = 660
* CHECK dout0_25 vdout0_25ck131 = 0 time = 660
* CHECK dout0_26 vdout0_26ck131 = 1.1 time = 660
* CHECK dout0_27 vdout0_27ck131 = 1.1 time = 660
* CHECK dout0_28 vdout0_28ck131 = 1.1 time = 660
* CHECK dout0_29 vdout0_29ck131 = 1.1 time = 660
* CHECK dout0_30 vdout0_30ck131 = 1.1 time = 660
* CHECK dout0_31 vdout0_31ck131 = 0 time = 660
* CHECK dout0_0 vdout0_0ck132 = 1.1 time = 665
* CHECK dout0_1 vdout0_1ck132 = 1.1 time = 665
* CHECK dout0_2 vdout0_2ck132 = 1.1 time = 665
* CHECK dout0_3 vdout0_3ck132 = 0 time = 665
* CHECK dout0_4 vdout0_4ck132 = 1.1 time = 665
* CHECK dout0_5 vdout0_5ck132 = 1.1 time = 665
* CHECK dout0_6 vdout0_6ck132 = 1.1 time = 665
* CHECK dout0_7 vdout0_7ck132 = 0 time = 665
* CHECK dout0_8 vdout0_8ck132 = 0 time = 665
* CHECK dout0_9 vdout0_9ck132 = 1.1 time = 665
* CHECK dout0_10 vdout0_10ck132 = 0 time = 665
* CHECK dout0_11 vdout0_11ck132 = 1.1 time = 665
* CHECK dout0_12 vdout0_12ck132 = 1.1 time = 665
* CHECK dout0_13 vdout0_13ck132 = 0 time = 665
* CHECK dout0_14 vdout0_14ck132 = 1.1 time = 665
* CHECK dout0_15 vdout0_15ck132 = 0 time = 665
* CHECK dout0_16 vdout0_16ck132 = 1.1 time = 665
* CHECK dout0_17 vdout0_17ck132 = 0 time = 665
* CHECK dout0_18 vdout0_18ck132 = 0 time = 665
* CHECK dout0_19 vdout0_19ck132 = 1.1 time = 665
* CHECK dout0_20 vdout0_20ck132 = 1.1 time = 665
* CHECK dout0_21 vdout0_21ck132 = 1.1 time = 665
* CHECK dout0_22 vdout0_22ck132 = 0 time = 665
* CHECK dout0_23 vdout0_23ck132 = 0 time = 665
* CHECK dout0_24 vdout0_24ck132 = 1.1 time = 665
* CHECK dout0_25 vdout0_25ck132 = 1.1 time = 665
* CHECK dout0_26 vdout0_26ck132 = 0 time = 665
* CHECK dout0_27 vdout0_27ck132 = 0 time = 665
* CHECK dout0_28 vdout0_28ck132 = 1.1 time = 665
* CHECK dout0_29 vdout0_29ck132 = 1.1 time = 665
* CHECK dout0_30 vdout0_30ck132 = 0 time = 665
* CHECK dout0_31 vdout0_31ck132 = 0 time = 665
* CHECK dout0_0 vdout0_0ck143 = 1.1 time = 720
* CHECK dout0_1 vdout0_1ck143 = 0 time = 720
* CHECK dout0_2 vdout0_2ck143 = 1.1 time = 720
* CHECK dout0_3 vdout0_3ck143 = 1.1 time = 720
* CHECK dout0_4 vdout0_4ck143 = 1.1 time = 720
* CHECK dout0_5 vdout0_5ck143 = 1.1 time = 720
* CHECK dout0_6 vdout0_6ck143 = 1.1 time = 720
* CHECK dout0_7 vdout0_7ck143 = 0 time = 720
* CHECK dout0_8 vdout0_8ck143 = 0 time = 720
* CHECK dout0_9 vdout0_9ck143 = 0 time = 720
* CHECK dout0_10 vdout0_10ck143 = 1.1 time = 720
* CHECK dout0_11 vdout0_11ck143 = 0 time = 720
* CHECK dout0_12 vdout0_12ck143 = 0 time = 720
* CHECK dout0_13 vdout0_13ck143 = 0 time = 720
* CHECK dout0_14 vdout0_14ck143 = 1.1 time = 720
* CHECK dout0_15 vdout0_15ck143 = 0 time = 720
* CHECK dout0_16 vdout0_16ck143 = 0 time = 720
* CHECK dout0_17 vdout0_17ck143 = 1.1 time = 720
* CHECK dout0_18 vdout0_18ck143 = 1.1 time = 720
* CHECK dout0_19 vdout0_19ck143 = 1.1 time = 720
* CHECK dout0_20 vdout0_20ck143 = 1.1 time = 720
* CHECK dout0_21 vdout0_21ck143 = 0 time = 720
* CHECK dout0_22 vdout0_22ck143 = 1.1 time = 720
* CHECK dout0_23 vdout0_23ck143 = 0 time = 720
* CHECK dout0_24 vdout0_24ck143 = 1.1 time = 720
* CHECK dout0_25 vdout0_25ck143 = 1.1 time = 720
* CHECK dout0_26 vdout0_26ck143 = 0 time = 720
* CHECK dout0_27 vdout0_27ck143 = 1.1 time = 720
* CHECK dout0_28 vdout0_28ck143 = 0 time = 720
* CHECK dout0_29 vdout0_29ck143 = 1.1 time = 720
* CHECK dout0_30 vdout0_30ck143 = 0 time = 720
* CHECK dout0_31 vdout0_31ck143 = 0 time = 720
* CHECK dout0_0 vdout0_0ck144 = 1.1 time = 725
* CHECK dout0_1 vdout0_1ck144 = 0 time = 725
* CHECK dout0_2 vdout0_2ck144 = 1.1 time = 725
* CHECK dout0_3 vdout0_3ck144 = 1.1 time = 725
* CHECK dout0_4 vdout0_4ck144 = 1.1 time = 725
* CHECK dout0_5 vdout0_5ck144 = 1.1 time = 725
* CHECK dout0_6 vdout0_6ck144 = 1.1 time = 725
* CHECK dout0_7 vdout0_7ck144 = 0 time = 725
* CHECK dout0_8 vdout0_8ck144 = 0 time = 725
* CHECK dout0_9 vdout0_9ck144 = 0 time = 725
* CHECK dout0_10 vdout0_10ck144 = 1.1 time = 725
* CHECK dout0_11 vdout0_11ck144 = 0 time = 725
* CHECK dout0_12 vdout0_12ck144 = 0 time = 725
* CHECK dout0_13 vdout0_13ck144 = 0 time = 725
* CHECK dout0_14 vdout0_14ck144 = 1.1 time = 725
* CHECK dout0_15 vdout0_15ck144 = 0 time = 725
* CHECK dout0_16 vdout0_16ck144 = 0 time = 725
* CHECK dout0_17 vdout0_17ck144 = 1.1 time = 725
* CHECK dout0_18 vdout0_18ck144 = 1.1 time = 725
* CHECK dout0_19 vdout0_19ck144 = 1.1 time = 725
* CHECK dout0_20 vdout0_20ck144 = 1.1 time = 725
* CHECK dout0_21 vdout0_21ck144 = 0 time = 725
* CHECK dout0_22 vdout0_22ck144 = 1.1 time = 725
* CHECK dout0_23 vdout0_23ck144 = 0 time = 725
* CHECK dout0_24 vdout0_24ck144 = 1.1 time = 725
* CHECK dout0_25 vdout0_25ck144 = 1.1 time = 725
* CHECK dout0_26 vdout0_26ck144 = 0 time = 725
* CHECK dout0_27 vdout0_27ck144 = 1.1 time = 725
* CHECK dout0_28 vdout0_28ck144 = 0 time = 725
* CHECK dout0_29 vdout0_29ck144 = 1.1 time = 725
* CHECK dout0_30 vdout0_30ck144 = 0 time = 725
* CHECK dout0_31 vdout0_31ck144 = 0 time = 725
* CHECK dout0_0 vdout0_0ck145 = 1.1 time = 730
* CHECK dout0_1 vdout0_1ck145 = 0 time = 730
* CHECK dout0_2 vdout0_2ck145 = 1.1 time = 730
* CHECK dout0_3 vdout0_3ck145 = 1.1 time = 730
* CHECK dout0_4 vdout0_4ck145 = 1.1 time = 730
* CHECK dout0_5 vdout0_5ck145 = 1.1 time = 730
* CHECK dout0_6 vdout0_6ck145 = 1.1 time = 730
* CHECK dout0_7 vdout0_7ck145 = 0 time = 730
* CHECK dout0_8 vdout0_8ck145 = 0 time = 730
* CHECK dout0_9 vdout0_9ck145 = 0 time = 730
* CHECK dout0_10 vdout0_10ck145 = 1.1 time = 730
* CHECK dout0_11 vdout0_11ck145 = 0 time = 730
* CHECK dout0_12 vdout0_12ck145 = 0 time = 730
* CHECK dout0_13 vdout0_13ck145 = 0 time = 730
* CHECK dout0_14 vdout0_14ck145 = 1.1 time = 730
* CHECK dout0_15 vdout0_15ck145 = 0 time = 730
* CHECK dout0_16 vdout0_16ck145 = 0 time = 730
* CHECK dout0_17 vdout0_17ck145 = 1.1 time = 730
* CHECK dout0_18 vdout0_18ck145 = 1.1 time = 730
* CHECK dout0_19 vdout0_19ck145 = 1.1 time = 730
* CHECK dout0_20 vdout0_20ck145 = 1.1 time = 730
* CHECK dout0_21 vdout0_21ck145 = 0 time = 730
* CHECK dout0_22 vdout0_22ck145 = 1.1 time = 730
* CHECK dout0_23 vdout0_23ck145 = 0 time = 730
* CHECK dout0_24 vdout0_24ck145 = 1.1 time = 730
* CHECK dout0_25 vdout0_25ck145 = 1.1 time = 730
* CHECK dout0_26 vdout0_26ck145 = 0 time = 730
* CHECK dout0_27 vdout0_27ck145 = 1.1 time = 730
* CHECK dout0_28 vdout0_28ck145 = 0 time = 730
* CHECK dout0_29 vdout0_29ck145 = 1.1 time = 730
* CHECK dout0_30 vdout0_30ck145 = 0 time = 730
* CHECK dout0_31 vdout0_31ck145 = 0 time = 730
* CHECK dout0_0 vdout0_0ck146 = 1.1 time = 735
* CHECK dout0_1 vdout0_1ck146 = 0 time = 735
* CHECK dout0_2 vdout0_2ck146 = 1.1 time = 735
* CHECK dout0_3 vdout0_3ck146 = 1.1 time = 735
* CHECK dout0_4 vdout0_4ck146 = 1.1 time = 735
* CHECK dout0_5 vdout0_5ck146 = 1.1 time = 735
* CHECK dout0_6 vdout0_6ck146 = 1.1 time = 735
* CHECK dout0_7 vdout0_7ck146 = 0 time = 735
* CHECK dout0_8 vdout0_8ck146 = 0 time = 735
* CHECK dout0_9 vdout0_9ck146 = 0 time = 735
* CHECK dout0_10 vdout0_10ck146 = 1.1 time = 735
* CHECK dout0_11 vdout0_11ck146 = 0 time = 735
* CHECK dout0_12 vdout0_12ck146 = 0 time = 735
* CHECK dout0_13 vdout0_13ck146 = 0 time = 735
* CHECK dout0_14 vdout0_14ck146 = 1.1 time = 735
* CHECK dout0_15 vdout0_15ck146 = 0 time = 735
* CHECK dout0_16 vdout0_16ck146 = 0 time = 735
* CHECK dout0_17 vdout0_17ck146 = 1.1 time = 735
* CHECK dout0_18 vdout0_18ck146 = 1.1 time = 735
* CHECK dout0_19 vdout0_19ck146 = 1.1 time = 735
* CHECK dout0_20 vdout0_20ck146 = 1.1 time = 735
* CHECK dout0_21 vdout0_21ck146 = 0 time = 735
* CHECK dout0_22 vdout0_22ck146 = 1.1 time = 735
* CHECK dout0_23 vdout0_23ck146 = 0 time = 735
* CHECK dout0_24 vdout0_24ck146 = 1.1 time = 735
* CHECK dout0_25 vdout0_25ck146 = 1.1 time = 735
* CHECK dout0_26 vdout0_26ck146 = 0 time = 735
* CHECK dout0_27 vdout0_27ck146 = 1.1 time = 735
* CHECK dout0_28 vdout0_28ck146 = 0 time = 735
* CHECK dout0_29 vdout0_29ck146 = 1.1 time = 735
* CHECK dout0_30 vdout0_30ck146 = 0 time = 735
* CHECK dout0_31 vdout0_31ck146 = 0 time = 735
* CHECK dout0_0 vdout0_0ck152 = 0 time = 765
* CHECK dout0_1 vdout0_1ck152 = 1.1 time = 765
* CHECK dout0_2 vdout0_2ck152 = 1.1 time = 765
* CHECK dout0_3 vdout0_3ck152 = 1.1 time = 765
* CHECK dout0_4 vdout0_4ck152 = 1.1 time = 765
* CHECK dout0_5 vdout0_5ck152 = 1.1 time = 765
* CHECK dout0_6 vdout0_6ck152 = 1.1 time = 765
* CHECK dout0_7 vdout0_7ck152 = 1.1 time = 765
* CHECK dout0_8 vdout0_8ck152 = 1.1 time = 765
* CHECK dout0_9 vdout0_9ck152 = 1.1 time = 765
* CHECK dout0_10 vdout0_10ck152 = 1.1 time = 765
* CHECK dout0_11 vdout0_11ck152 = 1.1 time = 765
* CHECK dout0_12 vdout0_12ck152 = 1.1 time = 765
* CHECK dout0_13 vdout0_13ck152 = 1.1 time = 765
* CHECK dout0_14 vdout0_14ck152 = 0 time = 765
* CHECK dout0_15 vdout0_15ck152 = 1.1 time = 765
* CHECK dout0_16 vdout0_16ck152 = 0 time = 765
* CHECK dout0_17 vdout0_17ck152 = 0 time = 765
* CHECK dout0_18 vdout0_18ck152 = 1.1 time = 765
* CHECK dout0_19 vdout0_19ck152 = 0 time = 765
* CHECK dout0_20 vdout0_20ck152 = 1.1 time = 765
* CHECK dout0_21 vdout0_21ck152 = 1.1 time = 765
* CHECK dout0_22 vdout0_22ck152 = 0 time = 765
* CHECK dout0_23 vdout0_23ck152 = 0 time = 765
* CHECK dout0_24 vdout0_24ck152 = 0 time = 765
* CHECK dout0_25 vdout0_25ck152 = 1.1 time = 765
* CHECK dout0_26 vdout0_26ck152 = 1.1 time = 765
* CHECK dout0_27 vdout0_27ck152 = 1.1 time = 765
* CHECK dout0_28 vdout0_28ck152 = 1.1 time = 765
* CHECK dout0_29 vdout0_29ck152 = 0 time = 765
* CHECK dout0_30 vdout0_30ck152 = 0 time = 765
* CHECK dout0_31 vdout0_31ck152 = 0 time = 765
* CHECK dout0_0 vdout0_0ck154 = 1.1 time = 775
* CHECK dout0_1 vdout0_1ck154 = 0 time = 775
* CHECK dout0_2 vdout0_2ck154 = 1.1 time = 775
* CHECK dout0_3 vdout0_3ck154 = 1.1 time = 775
* CHECK dout0_4 vdout0_4ck154 = 1.1 time = 775
* CHECK dout0_5 vdout0_5ck154 = 1.1 time = 775
* CHECK dout0_6 vdout0_6ck154 = 1.1 time = 775
* CHECK dout0_7 vdout0_7ck154 = 0 time = 775
* CHECK dout0_8 vdout0_8ck154 = 0 time = 775
* CHECK dout0_9 vdout0_9ck154 = 0 time = 775
* CHECK dout0_10 vdout0_10ck154 = 1.1 time = 775
* CHECK dout0_11 vdout0_11ck154 = 0 time = 775
* CHECK dout0_12 vdout0_12ck154 = 0 time = 775
* CHECK dout0_13 vdout0_13ck154 = 1.1 time = 775
* CHECK dout0_14 vdout0_14ck154 = 0 time = 775
* CHECK dout0_15 vdout0_15ck154 = 0 time = 775
* CHECK dout0_16 vdout0_16ck154 = 0 time = 775
* CHECK dout0_17 vdout0_17ck154 = 1.1 time = 775
* CHECK dout0_18 vdout0_18ck154 = 0 time = 775
* CHECK dout0_19 vdout0_19ck154 = 0 time = 775
* CHECK dout0_20 vdout0_20ck154 = 0 time = 775
* CHECK dout0_21 vdout0_21ck154 = 1.1 time = 775
* CHECK dout0_22 vdout0_22ck154 = 1.1 time = 775
* CHECK dout0_23 vdout0_23ck154 = 0 time = 775
* CHECK dout0_24 vdout0_24ck154 = 1.1 time = 775
* CHECK dout0_25 vdout0_25ck154 = 1.1 time = 775
* CHECK dout0_26 vdout0_26ck154 = 0 time = 775
* CHECK dout0_27 vdout0_27ck154 = 1.1 time = 775
* CHECK dout0_28 vdout0_28ck154 = 0 time = 775
* CHECK dout0_29 vdout0_29ck154 = 1.1 time = 775
* CHECK dout0_30 vdout0_30ck154 = 0 time = 775
* CHECK dout0_31 vdout0_31ck154 = 0 time = 775
* CHECK dout0_0 vdout0_0ck155 = 0 time = 780
* CHECK dout0_1 vdout0_1ck155 = 0 time = 780
* CHECK dout0_2 vdout0_2ck155 = 0 time = 780
* CHECK dout0_3 vdout0_3ck155 = 0 time = 780
* CHECK dout0_4 vdout0_4ck155 = 0 time = 780
* CHECK dout0_5 vdout0_5ck155 = 1.1 time = 780
* CHECK dout0_6 vdout0_6ck155 = 1.1 time = 780
* CHECK dout0_7 vdout0_7ck155 = 0 time = 780
* CHECK dout0_8 vdout0_8ck155 = 1.1 time = 780
* CHECK dout0_9 vdout0_9ck155 = 1.1 time = 780
* CHECK dout0_10 vdout0_10ck155 = 1.1 time = 780
* CHECK dout0_11 vdout0_11ck155 = 1.1 time = 780
* CHECK dout0_12 vdout0_12ck155 = 1.1 time = 780
* CHECK dout0_13 vdout0_13ck155 = 1.1 time = 780
* CHECK dout0_14 vdout0_14ck155 = 0 time = 780
* CHECK dout0_15 vdout0_15ck155 = 1.1 time = 780
* CHECK dout0_16 vdout0_16ck155 = 0 time = 780
* CHECK dout0_17 vdout0_17ck155 = 0 time = 780
* CHECK dout0_18 vdout0_18ck155 = 1.1 time = 780
* CHECK dout0_19 vdout0_19ck155 = 0 time = 780
* CHECK dout0_20 vdout0_20ck155 = 1.1 time = 780
* CHECK dout0_21 vdout0_21ck155 = 1.1 time = 780
* CHECK dout0_22 vdout0_22ck155 = 0 time = 780
* CHECK dout0_23 vdout0_23ck155 = 0 time = 780
* CHECK dout0_24 vdout0_24ck155 = 0 time = 780
* CHECK dout0_25 vdout0_25ck155 = 1.1 time = 780
* CHECK dout0_26 vdout0_26ck155 = 1.1 time = 780
* CHECK dout0_27 vdout0_27ck155 = 1.1 time = 780
* CHECK dout0_28 vdout0_28ck155 = 1.1 time = 780
* CHECK dout0_29 vdout0_29ck155 = 0 time = 780
* CHECK dout0_30 vdout0_30ck155 = 0 time = 780
* CHECK dout0_31 vdout0_31ck155 = 0 time = 780
* CHECK dout0_0 vdout0_0ck156 = 0 time = 785
* CHECK dout0_1 vdout0_1ck156 = 0 time = 785
* CHECK dout0_2 vdout0_2ck156 = 0 time = 785
* CHECK dout0_3 vdout0_3ck156 = 0 time = 785
* CHECK dout0_4 vdout0_4ck156 = 0 time = 785
* CHECK dout0_5 vdout0_5ck156 = 1.1 time = 785
* CHECK dout0_6 vdout0_6ck156 = 1.1 time = 785
* CHECK dout0_7 vdout0_7ck156 = 0 time = 785
* CHECK dout0_8 vdout0_8ck156 = 1.1 time = 785
* CHECK dout0_9 vdout0_9ck156 = 1.1 time = 785
* CHECK dout0_10 vdout0_10ck156 = 1.1 time = 785
* CHECK dout0_11 vdout0_11ck156 = 1.1 time = 785
* CHECK dout0_12 vdout0_12ck156 = 1.1 time = 785
* CHECK dout0_13 vdout0_13ck156 = 1.1 time = 785
* CHECK dout0_14 vdout0_14ck156 = 0 time = 785
* CHECK dout0_15 vdout0_15ck156 = 1.1 time = 785
* CHECK dout0_16 vdout0_16ck156 = 0 time = 785
* CHECK dout0_17 vdout0_17ck156 = 0 time = 785
* CHECK dout0_18 vdout0_18ck156 = 1.1 time = 785
* CHECK dout0_19 vdout0_19ck156 = 0 time = 785
* CHECK dout0_20 vdout0_20ck156 = 1.1 time = 785
* CHECK dout0_21 vdout0_21ck156 = 1.1 time = 785
* CHECK dout0_22 vdout0_22ck156 = 0 time = 785
* CHECK dout0_23 vdout0_23ck156 = 0 time = 785
* CHECK dout0_24 vdout0_24ck156 = 0 time = 785
* CHECK dout0_25 vdout0_25ck156 = 1.1 time = 785
* CHECK dout0_26 vdout0_26ck156 = 1.1 time = 785
* CHECK dout0_27 vdout0_27ck156 = 1.1 time = 785
* CHECK dout0_28 vdout0_28ck156 = 1.1 time = 785
* CHECK dout0_29 vdout0_29ck156 = 0 time = 785
* CHECK dout0_30 vdout0_30ck156 = 0 time = 785
* CHECK dout0_31 vdout0_31ck156 = 0 time = 785
* CHECK dout0_0 vdout0_0ck158 = 0 time = 795
* CHECK dout0_1 vdout0_1ck158 = 0 time = 795
* CHECK dout0_2 vdout0_2ck158 = 0 time = 795
* CHECK dout0_3 vdout0_3ck158 = 0 time = 795
* CHECK dout0_4 vdout0_4ck158 = 0 time = 795
* CHECK dout0_5 vdout0_5ck158 = 1.1 time = 795
* CHECK dout0_6 vdout0_6ck158 = 1.1 time = 795
* CHECK dout0_7 vdout0_7ck158 = 0 time = 795
* CHECK dout0_8 vdout0_8ck158 = 0 time = 795
* CHECK dout0_9 vdout0_9ck158 = 0 time = 795
* CHECK dout0_10 vdout0_10ck158 = 1.1 time = 795
* CHECK dout0_11 vdout0_11ck158 = 0 time = 795
* CHECK dout0_12 vdout0_12ck158 = 0 time = 795
* CHECK dout0_13 vdout0_13ck158 = 1.1 time = 795
* CHECK dout0_14 vdout0_14ck158 = 1.1 time = 795
* CHECK dout0_15 vdout0_15ck158 = 1.1 time = 795
* CHECK dout0_16 vdout0_16ck158 = 0 time = 795
* CHECK dout0_17 vdout0_17ck158 = 0 time = 795
* CHECK dout0_18 vdout0_18ck158 = 1.1 time = 795
* CHECK dout0_19 vdout0_19ck158 = 0 time = 795
* CHECK dout0_20 vdout0_20ck158 = 1.1 time = 795
* CHECK dout0_21 vdout0_21ck158 = 1.1 time = 795
* CHECK dout0_22 vdout0_22ck158 = 0 time = 795
* CHECK dout0_23 vdout0_23ck158 = 0 time = 795
* CHECK dout0_24 vdout0_24ck158 = 0 time = 795
* CHECK dout0_25 vdout0_25ck158 = 1.1 time = 795
* CHECK dout0_26 vdout0_26ck158 = 1.1 time = 795
* CHECK dout0_27 vdout0_27ck158 = 1.1 time = 795
* CHECK dout0_28 vdout0_28ck158 = 1.1 time = 795
* CHECK dout0_29 vdout0_29ck158 = 0 time = 795
* CHECK dout0_30 vdout0_30ck158 = 0 time = 795
* CHECK dout0_31 vdout0_31ck158 = 0 time = 795
* CHECK dout0_0 vdout0_0ck161 = 1.1 time = 810
* CHECK dout0_1 vdout0_1ck161 = 0 time = 810
* CHECK dout0_2 vdout0_2ck161 = 1.1 time = 810
* CHECK dout0_3 vdout0_3ck161 = 1.1 time = 810
* CHECK dout0_4 vdout0_4ck161 = 1.1 time = 810
* CHECK dout0_5 vdout0_5ck161 = 1.1 time = 810
* CHECK dout0_6 vdout0_6ck161 = 1.1 time = 810
* CHECK dout0_7 vdout0_7ck161 = 0 time = 810
* CHECK dout0_8 vdout0_8ck161 = 0 time = 810
* CHECK dout0_9 vdout0_9ck161 = 0 time = 810
* CHECK dout0_10 vdout0_10ck161 = 1.1 time = 810
* CHECK dout0_11 vdout0_11ck161 = 0 time = 810
* CHECK dout0_12 vdout0_12ck161 = 0 time = 810
* CHECK dout0_13 vdout0_13ck161 = 1.1 time = 810
* CHECK dout0_14 vdout0_14ck161 = 0 time = 810
* CHECK dout0_15 vdout0_15ck161 = 0 time = 810
* CHECK dout0_16 vdout0_16ck161 = 0 time = 810
* CHECK dout0_17 vdout0_17ck161 = 1.1 time = 810
* CHECK dout0_18 vdout0_18ck161 = 0 time = 810
* CHECK dout0_19 vdout0_19ck161 = 0 time = 810
* CHECK dout0_20 vdout0_20ck161 = 0 time = 810
* CHECK dout0_21 vdout0_21ck161 = 1.1 time = 810
* CHECK dout0_22 vdout0_22ck161 = 1.1 time = 810
* CHECK dout0_23 vdout0_23ck161 = 0 time = 810
* CHECK dout0_24 vdout0_24ck161 = 1.1 time = 810
* CHECK dout0_25 vdout0_25ck161 = 1.1 time = 810
* CHECK dout0_26 vdout0_26ck161 = 0 time = 810
* CHECK dout0_27 vdout0_27ck161 = 1.1 time = 810
* CHECK dout0_28 vdout0_28ck161 = 0 time = 810
* CHECK dout0_29 vdout0_29ck161 = 1.1 time = 810
* CHECK dout0_30 vdout0_30ck161 = 0 time = 810
* CHECK dout0_31 vdout0_31ck161 = 0 time = 810
* CHECK dout0_0 vdout0_0ck166 = 0 time = 835
* CHECK dout0_1 vdout0_1ck166 = 1.1 time = 835
* CHECK dout0_2 vdout0_2ck166 = 1.1 time = 835
* CHECK dout0_3 vdout0_3ck166 = 1.1 time = 835
* CHECK dout0_4 vdout0_4ck166 = 1.1 time = 835
* CHECK dout0_5 vdout0_5ck166 = 1.1 time = 835
* CHECK dout0_6 vdout0_6ck166 = 1.1 time = 835
* CHECK dout0_7 vdout0_7ck166 = 1.1 time = 835
* CHECK dout0_8 vdout0_8ck166 = 0 time = 835
* CHECK dout0_9 vdout0_9ck166 = 1.1 time = 835
* CHECK dout0_10 vdout0_10ck166 = 1.1 time = 835
* CHECK dout0_11 vdout0_11ck166 = 0 time = 835
* CHECK dout0_12 vdout0_12ck166 = 0 time = 835
* CHECK dout0_13 vdout0_13ck166 = 0 time = 835
* CHECK dout0_14 vdout0_14ck166 = 1.1 time = 835
* CHECK dout0_15 vdout0_15ck166 = 1.1 time = 835
* CHECK dout0_16 vdout0_16ck166 = 0 time = 835
* CHECK dout0_17 vdout0_17ck166 = 0 time = 835
* CHECK dout0_18 vdout0_18ck166 = 1.1 time = 835
* CHECK dout0_19 vdout0_19ck166 = 1.1 time = 835
* CHECK dout0_20 vdout0_20ck166 = 1.1 time = 835
* CHECK dout0_21 vdout0_21ck166 = 1.1 time = 835
* CHECK dout0_22 vdout0_22ck166 = 1.1 time = 835
* CHECK dout0_23 vdout0_23ck166 = 1.1 time = 835
* CHECK dout0_24 vdout0_24ck166 = 1.1 time = 835
* CHECK dout0_25 vdout0_25ck166 = 1.1 time = 835
* CHECK dout0_26 vdout0_26ck166 = 0 time = 835
* CHECK dout0_27 vdout0_27ck166 = 0 time = 835
* CHECK dout0_28 vdout0_28ck166 = 1.1 time = 835
* CHECK dout0_29 vdout0_29ck166 = 1.1 time = 835
* CHECK dout0_30 vdout0_30ck166 = 1.1 time = 835
* CHECK dout0_31 vdout0_31ck166 = 1.1 time = 835
* CHECK dout0_0 vdout0_0ck169 = 0 time = 850
* CHECK dout0_1 vdout0_1ck169 = 0 time = 850
* CHECK dout0_2 vdout0_2ck169 = 0 time = 850
* CHECK dout0_3 vdout0_3ck169 = 1.1 time = 850
* CHECK dout0_4 vdout0_4ck169 = 0 time = 850
* CHECK dout0_5 vdout0_5ck169 = 1.1 time = 850
* CHECK dout0_6 vdout0_6ck169 = 1.1 time = 850
* CHECK dout0_7 vdout0_7ck169 = 0 time = 850
* CHECK dout0_8 vdout0_8ck169 = 0 time = 850
* CHECK dout0_9 vdout0_9ck169 = 1.1 time = 850
* CHECK dout0_10 vdout0_10ck169 = 0 time = 850
* CHECK dout0_11 vdout0_11ck169 = 0 time = 850
* CHECK dout0_12 vdout0_12ck169 = 0 time = 850
* CHECK dout0_13 vdout0_13ck169 = 0 time = 850
* CHECK dout0_14 vdout0_14ck169 = 1.1 time = 850
* CHECK dout0_15 vdout0_15ck169 = 1.1 time = 850
* CHECK dout0_16 vdout0_16ck169 = 0 time = 850
* CHECK dout0_17 vdout0_17ck169 = 1.1 time = 850
* CHECK dout0_18 vdout0_18ck169 = 0 time = 850
* CHECK dout0_19 vdout0_19ck169 = 1.1 time = 850
* CHECK dout0_20 vdout0_20ck169 = 0 time = 850
* CHECK dout0_21 vdout0_21ck169 = 0 time = 850
* CHECK dout0_22 vdout0_22ck169 = 1.1 time = 850
* CHECK dout0_23 vdout0_23ck169 = 1.1 time = 850
* CHECK dout0_24 vdout0_24ck169 = 1.1 time = 850
* CHECK dout0_25 vdout0_25ck169 = 1.1 time = 850
* CHECK dout0_26 vdout0_26ck169 = 0 time = 850
* CHECK dout0_27 vdout0_27ck169 = 0 time = 850
* CHECK dout0_28 vdout0_28ck169 = 0 time = 850
* CHECK dout0_29 vdout0_29ck169 = 1.1 time = 850
* CHECK dout0_30 vdout0_30ck169 = 1.1 time = 850
* CHECK dout0_31 vdout0_31ck169 = 1.1 time = 850
* CHECK dout0_0 vdout0_0ck171 = 0 time = 860
* CHECK dout0_1 vdout0_1ck171 = 0 time = 860
* CHECK dout0_2 vdout0_2ck171 = 0 time = 860
* CHECK dout0_3 vdout0_3ck171 = 1.1 time = 860
* CHECK dout0_4 vdout0_4ck171 = 0 time = 860
* CHECK dout0_5 vdout0_5ck171 = 1.1 time = 860
* CHECK dout0_6 vdout0_6ck171 = 1.1 time = 860
* CHECK dout0_7 vdout0_7ck171 = 0 time = 860
* CHECK dout0_8 vdout0_8ck171 = 0 time = 860
* CHECK dout0_9 vdout0_9ck171 = 1.1 time = 860
* CHECK dout0_10 vdout0_10ck171 = 0 time = 860
* CHECK dout0_11 vdout0_11ck171 = 0 time = 860
* CHECK dout0_12 vdout0_12ck171 = 0 time = 860
* CHECK dout0_13 vdout0_13ck171 = 0 time = 860
* CHECK dout0_14 vdout0_14ck171 = 1.1 time = 860
* CHECK dout0_15 vdout0_15ck171 = 1.1 time = 860
* CHECK dout0_16 vdout0_16ck171 = 0 time = 860
* CHECK dout0_17 vdout0_17ck171 = 1.1 time = 860
* CHECK dout0_18 vdout0_18ck171 = 0 time = 860
* CHECK dout0_19 vdout0_19ck171 = 1.1 time = 860
* CHECK dout0_20 vdout0_20ck171 = 0 time = 860
* CHECK dout0_21 vdout0_21ck171 = 0 time = 860
* CHECK dout0_22 vdout0_22ck171 = 1.1 time = 860
* CHECK dout0_23 vdout0_23ck171 = 1.1 time = 860
* CHECK dout0_24 vdout0_24ck171 = 1.1 time = 860
* CHECK dout0_25 vdout0_25ck171 = 1.1 time = 860
* CHECK dout0_26 vdout0_26ck171 = 0 time = 860
* CHECK dout0_27 vdout0_27ck171 = 0 time = 860
* CHECK dout0_28 vdout0_28ck171 = 0 time = 860
* CHECK dout0_29 vdout0_29ck171 = 1.1 time = 860
* CHECK dout0_30 vdout0_30ck171 = 1.1 time = 860
* CHECK dout0_31 vdout0_31ck171 = 1.1 time = 860
* CHECK dout0_0 vdout0_0ck174 = 1.1 time = 875
* CHECK dout0_1 vdout0_1ck174 = 0 time = 875
* CHECK dout0_2 vdout0_2ck174 = 1.1 time = 875
* CHECK dout0_3 vdout0_3ck174 = 1.1 time = 875
* CHECK dout0_4 vdout0_4ck174 = 0 time = 875
* CHECK dout0_5 vdout0_5ck174 = 1.1 time = 875
* CHECK dout0_6 vdout0_6ck174 = 1.1 time = 875
* CHECK dout0_7 vdout0_7ck174 = 0 time = 875
* CHECK dout0_8 vdout0_8ck174 = 0 time = 875
* CHECK dout0_9 vdout0_9ck174 = 1.1 time = 875
* CHECK dout0_10 vdout0_10ck174 = 1.1 time = 875
* CHECK dout0_11 vdout0_11ck174 = 1.1 time = 875
* CHECK dout0_12 vdout0_12ck174 = 1.1 time = 875
* CHECK dout0_13 vdout0_13ck174 = 0 time = 875
* CHECK dout0_14 vdout0_14ck174 = 1.1 time = 875
* CHECK dout0_15 vdout0_15ck174 = 0 time = 875
* CHECK dout0_16 vdout0_16ck174 = 0 time = 875
* CHECK dout0_17 vdout0_17ck174 = 1.1 time = 875
* CHECK dout0_18 vdout0_18ck174 = 1.1 time = 875
* CHECK dout0_19 vdout0_19ck174 = 0 time = 875
* CHECK dout0_20 vdout0_20ck174 = 0 time = 875
* CHECK dout0_21 vdout0_21ck174 = 0 time = 875
* CHECK dout0_22 vdout0_22ck174 = 0 time = 875
* CHECK dout0_23 vdout0_23ck174 = 0 time = 875
* CHECK dout0_24 vdout0_24ck174 = 1.1 time = 875
* CHECK dout0_25 vdout0_25ck174 = 1.1 time = 875
* CHECK dout0_26 vdout0_26ck174 = 0 time = 875
* CHECK dout0_27 vdout0_27ck174 = 0 time = 875
* CHECK dout0_28 vdout0_28ck174 = 1.1 time = 875
* CHECK dout0_29 vdout0_29ck174 = 0 time = 875
* CHECK dout0_30 vdout0_30ck174 = 1.1 time = 875
* CHECK dout0_31 vdout0_31ck174 = 0 time = 875
* CHECK dout0_0 vdout0_0ck175 = 0 time = 880
* CHECK dout0_1 vdout0_1ck175 = 1.1 time = 880
* CHECK dout0_2 vdout0_2ck175 = 1.1 time = 880
* CHECK dout0_3 vdout0_3ck175 = 1.1 time = 880
* CHECK dout0_4 vdout0_4ck175 = 1.1 time = 880
* CHECK dout0_5 vdout0_5ck175 = 1.1 time = 880
* CHECK dout0_6 vdout0_6ck175 = 1.1 time = 880
* CHECK dout0_7 vdout0_7ck175 = 1.1 time = 880
* CHECK dout0_8 vdout0_8ck175 = 0 time = 880
* CHECK dout0_9 vdout0_9ck175 = 1.1 time = 880
* CHECK dout0_10 vdout0_10ck175 = 1.1 time = 880
* CHECK dout0_11 vdout0_11ck175 = 0 time = 880
* CHECK dout0_12 vdout0_12ck175 = 0 time = 880
* CHECK dout0_13 vdout0_13ck175 = 0 time = 880
* CHECK dout0_14 vdout0_14ck175 = 1.1 time = 880
* CHECK dout0_15 vdout0_15ck175 = 1.1 time = 880
* CHECK dout0_16 vdout0_16ck175 = 0 time = 880
* CHECK dout0_17 vdout0_17ck175 = 0 time = 880
* CHECK dout0_18 vdout0_18ck175 = 1.1 time = 880
* CHECK dout0_19 vdout0_19ck175 = 1.1 time = 880
* CHECK dout0_20 vdout0_20ck175 = 1.1 time = 880
* CHECK dout0_21 vdout0_21ck175 = 1.1 time = 880
* CHECK dout0_22 vdout0_22ck175 = 1.1 time = 880
* CHECK dout0_23 vdout0_23ck175 = 1.1 time = 880
* CHECK dout0_24 vdout0_24ck175 = 1.1 time = 880
* CHECK dout0_25 vdout0_25ck175 = 1.1 time = 880
* CHECK dout0_26 vdout0_26ck175 = 0 time = 880
* CHECK dout0_27 vdout0_27ck175 = 0 time = 880
* CHECK dout0_28 vdout0_28ck175 = 1.1 time = 880
* CHECK dout0_29 vdout0_29ck175 = 1.1 time = 880
* CHECK dout0_30 vdout0_30ck175 = 1.1 time = 880
* CHECK dout0_31 vdout0_31ck175 = 1.1 time = 880
* CHECK dout0_0 vdout0_0ck176 = 0 time = 885
* CHECK dout0_1 vdout0_1ck176 = 1.1 time = 885
* CHECK dout0_2 vdout0_2ck176 = 1.1 time = 885
* CHECK dout0_3 vdout0_3ck176 = 1.1 time = 885
* CHECK dout0_4 vdout0_4ck176 = 1.1 time = 885
* CHECK dout0_5 vdout0_5ck176 = 1.1 time = 885
* CHECK dout0_6 vdout0_6ck176 = 1.1 time = 885
* CHECK dout0_7 vdout0_7ck176 = 1.1 time = 885
* CHECK dout0_8 vdout0_8ck176 = 0 time = 885
* CHECK dout0_9 vdout0_9ck176 = 1.1 time = 885
* CHECK dout0_10 vdout0_10ck176 = 1.1 time = 885
* CHECK dout0_11 vdout0_11ck176 = 0 time = 885
* CHECK dout0_12 vdout0_12ck176 = 0 time = 885
* CHECK dout0_13 vdout0_13ck176 = 0 time = 885
* CHECK dout0_14 vdout0_14ck176 = 1.1 time = 885
* CHECK dout0_15 vdout0_15ck176 = 1.1 time = 885
* CHECK dout0_16 vdout0_16ck176 = 0 time = 885
* CHECK dout0_17 vdout0_17ck176 = 0 time = 885
* CHECK dout0_18 vdout0_18ck176 = 1.1 time = 885
* CHECK dout0_19 vdout0_19ck176 = 1.1 time = 885
* CHECK dout0_20 vdout0_20ck176 = 1.1 time = 885
* CHECK dout0_21 vdout0_21ck176 = 1.1 time = 885
* CHECK dout0_22 vdout0_22ck176 = 1.1 time = 885
* CHECK dout0_23 vdout0_23ck176 = 1.1 time = 885
* CHECK dout0_24 vdout0_24ck176 = 1.1 time = 885
* CHECK dout0_25 vdout0_25ck176 = 1.1 time = 885
* CHECK dout0_26 vdout0_26ck176 = 0 time = 885
* CHECK dout0_27 vdout0_27ck176 = 0 time = 885
* CHECK dout0_28 vdout0_28ck176 = 1.1 time = 885
* CHECK dout0_29 vdout0_29ck176 = 1.1 time = 885
* CHECK dout0_30 vdout0_30ck176 = 1.1 time = 885
* CHECK dout0_31 vdout0_31ck176 = 1.1 time = 885
* CHECK dout0_0 vdout0_0ck177 = 1.1 time = 890
* CHECK dout0_1 vdout0_1ck177 = 0 time = 890
* CHECK dout0_2 vdout0_2ck177 = 1.1 time = 890
* CHECK dout0_3 vdout0_3ck177 = 1.1 time = 890
* CHECK dout0_4 vdout0_4ck177 = 0 time = 890
* CHECK dout0_5 vdout0_5ck177 = 1.1 time = 890
* CHECK dout0_6 vdout0_6ck177 = 1.1 time = 890
* CHECK dout0_7 vdout0_7ck177 = 0 time = 890
* CHECK dout0_8 vdout0_8ck177 = 0 time = 890
* CHECK dout0_9 vdout0_9ck177 = 1.1 time = 890
* CHECK dout0_10 vdout0_10ck177 = 1.1 time = 890
* CHECK dout0_11 vdout0_11ck177 = 1.1 time = 890
* CHECK dout0_12 vdout0_12ck177 = 1.1 time = 890
* CHECK dout0_13 vdout0_13ck177 = 0 time = 890
* CHECK dout0_14 vdout0_14ck177 = 1.1 time = 890
* CHECK dout0_15 vdout0_15ck177 = 0 time = 890
* CHECK dout0_16 vdout0_16ck177 = 0 time = 890
* CHECK dout0_17 vdout0_17ck177 = 1.1 time = 890
* CHECK dout0_18 vdout0_18ck177 = 1.1 time = 890
* CHECK dout0_19 vdout0_19ck177 = 0 time = 890
* CHECK dout0_20 vdout0_20ck177 = 0 time = 890
* CHECK dout0_21 vdout0_21ck177 = 0 time = 890
* CHECK dout0_22 vdout0_22ck177 = 0 time = 890
* CHECK dout0_23 vdout0_23ck177 = 0 time = 890
* CHECK dout0_24 vdout0_24ck177 = 1.1 time = 890
* CHECK dout0_25 vdout0_25ck177 = 1.1 time = 890
* CHECK dout0_26 vdout0_26ck177 = 0 time = 890
* CHECK dout0_27 vdout0_27ck177 = 0 time = 890
* CHECK dout0_28 vdout0_28ck177 = 1.1 time = 890
* CHECK dout0_29 vdout0_29ck177 = 0 time = 890
* CHECK dout0_30 vdout0_30ck177 = 1.1 time = 890
* CHECK dout0_31 vdout0_31ck177 = 0 time = 890
* CHECK dout0_0 vdout0_0ck185 = 1.1 time = 930
* CHECK dout0_1 vdout0_1ck185 = 0 time = 930
* CHECK dout0_2 vdout0_2ck185 = 0 time = 930
* CHECK dout0_3 vdout0_3ck185 = 0 time = 930
* CHECK dout0_4 vdout0_4ck185 = 0 time = 930
* CHECK dout0_5 vdout0_5ck185 = 0 time = 930
* CHECK dout0_6 vdout0_6ck185 = 0 time = 930
* CHECK dout0_7 vdout0_7ck185 = 1.1 time = 930
* CHECK dout0_8 vdout0_8ck185 = 0 time = 930
* CHECK dout0_9 vdout0_9ck185 = 1.1 time = 930
* CHECK dout0_10 vdout0_10ck185 = 1.1 time = 930
* CHECK dout0_11 vdout0_11ck185 = 1.1 time = 930
* CHECK dout0_12 vdout0_12ck185 = 1.1 time = 930
* CHECK dout0_13 vdout0_13ck185 = 1.1 time = 930
* CHECK dout0_14 vdout0_14ck185 = 1.1 time = 930
* CHECK dout0_15 vdout0_15ck185 = 0 time = 930
* CHECK dout0_16 vdout0_16ck185 = 1.1 time = 930
* CHECK dout0_17 vdout0_17ck185 = 1.1 time = 930
* CHECK dout0_18 vdout0_18ck185 = 1.1 time = 930
* CHECK dout0_19 vdout0_19ck185 = 1.1 time = 930
* CHECK dout0_20 vdout0_20ck185 = 1.1 time = 930
* CHECK dout0_21 vdout0_21ck185 = 1.1 time = 930
* CHECK dout0_22 vdout0_22ck185 = 1.1 time = 930
* CHECK dout0_23 vdout0_23ck185 = 1.1 time = 930
* CHECK dout0_24 vdout0_24ck185 = 1.1 time = 930
* CHECK dout0_25 vdout0_25ck185 = 0 time = 930
* CHECK dout0_26 vdout0_26ck185 = 1.1 time = 930
* CHECK dout0_27 vdout0_27ck185 = 0 time = 930
* CHECK dout0_28 vdout0_28ck185 = 1.1 time = 930
* CHECK dout0_29 vdout0_29ck185 = 0 time = 930
* CHECK dout0_30 vdout0_30ck185 = 0 time = 930
* CHECK dout0_31 vdout0_31ck185 = 0 time = 930
* CHECK dout0_0 vdout0_0ck189 = 0 time = 950
* CHECK dout0_1 vdout0_1ck189 = 1.1 time = 950
* CHECK dout0_2 vdout0_2ck189 = 0 time = 950
* CHECK dout0_3 vdout0_3ck189 = 0 time = 950
* CHECK dout0_4 vdout0_4ck189 = 1.1 time = 950
* CHECK dout0_5 vdout0_5ck189 = 0 time = 950
* CHECK dout0_6 vdout0_6ck189 = 0 time = 950
* CHECK dout0_7 vdout0_7ck189 = 1.1 time = 950
* CHECK dout0_8 vdout0_8ck189 = 0 time = 950
* CHECK dout0_9 vdout0_9ck189 = 0 time = 950
* CHECK dout0_10 vdout0_10ck189 = 0 time = 950
* CHECK dout0_11 vdout0_11ck189 = 0 time = 950
* CHECK dout0_12 vdout0_12ck189 = 1.1 time = 950
* CHECK dout0_13 vdout0_13ck189 = 1.1 time = 950
* CHECK dout0_14 vdout0_14ck189 = 1.1 time = 950
* CHECK dout0_15 vdout0_15ck189 = 1.1 time = 950
* CHECK dout0_16 vdout0_16ck189 = 1.1 time = 950
* CHECK dout0_17 vdout0_17ck189 = 1.1 time = 950
* CHECK dout0_18 vdout0_18ck189 = 0 time = 950
* CHECK dout0_19 vdout0_19ck189 = 1.1 time = 950
* CHECK dout0_20 vdout0_20ck189 = 0 time = 950
* CHECK dout0_21 vdout0_21ck189 = 0 time = 950
* CHECK dout0_22 vdout0_22ck189 = 0 time = 950
* CHECK dout0_23 vdout0_23ck189 = 1.1 time = 950
* CHECK dout0_24 vdout0_24ck189 = 1.1 time = 950
* CHECK dout0_25 vdout0_25ck189 = 0 time = 950
* CHECK dout0_26 vdout0_26ck189 = 1.1 time = 950
* CHECK dout0_27 vdout0_27ck189 = 1.1 time = 950
* CHECK dout0_28 vdout0_28ck189 = 0 time = 950
* CHECK dout0_29 vdout0_29ck189 = 0 time = 950
* CHECK dout0_30 vdout0_30ck189 = 1.1 time = 950
* CHECK dout0_31 vdout0_31ck189 = 0 time = 950
* CHECK dout0_0 vdout0_0ck195 = 1.1 time = 980
* CHECK dout0_1 vdout0_1ck195 = 1.1 time = 980
* CHECK dout0_2 vdout0_2ck195 = 1.1 time = 980
* CHECK dout0_3 vdout0_3ck195 = 1.1 time = 980
* CHECK dout0_4 vdout0_4ck195 = 0 time = 980
* CHECK dout0_5 vdout0_5ck195 = 0 time = 980
* CHECK dout0_6 vdout0_6ck195 = 1.1 time = 980
* CHECK dout0_7 vdout0_7ck195 = 1.1 time = 980
* CHECK dout0_8 vdout0_8ck195 = 0 time = 980
* CHECK dout0_9 vdout0_9ck195 = 0 time = 980
* CHECK dout0_10 vdout0_10ck195 = 1.1 time = 980
* CHECK dout0_11 vdout0_11ck195 = 1.1 time = 980
* CHECK dout0_12 vdout0_12ck195 = 1.1 time = 980
* CHECK dout0_13 vdout0_13ck195 = 1.1 time = 980
* CHECK dout0_14 vdout0_14ck195 = 1.1 time = 980
* CHECK dout0_15 vdout0_15ck195 = 1.1 time = 980
* CHECK dout0_16 vdout0_16ck195 = 0 time = 980
* CHECK dout0_17 vdout0_17ck195 = 0 time = 980
* CHECK dout0_18 vdout0_18ck195 = 1.1 time = 980
* CHECK dout0_19 vdout0_19ck195 = 1.1 time = 980
* CHECK dout0_20 vdout0_20ck195 = 0 time = 980
* CHECK dout0_21 vdout0_21ck195 = 0 time = 980
* CHECK dout0_22 vdout0_22ck195 = 1.1 time = 980
* CHECK dout0_23 vdout0_23ck195 = 0 time = 980
* CHECK dout0_24 vdout0_24ck195 = 0 time = 980
* CHECK dout0_25 vdout0_25ck195 = 1.1 time = 980
* CHECK dout0_26 vdout0_26ck195 = 0 time = 980
* CHECK dout0_27 vdout0_27ck195 = 0 time = 980
* CHECK dout0_28 vdout0_28ck195 = 1.1 time = 980
* CHECK dout0_29 vdout0_29ck195 = 1.1 time = 980
* CHECK dout0_30 vdout0_30ck195 = 1.1 time = 980
* CHECK dout0_31 vdout0_31ck195 = 1.1 time = 980
* CHECK dout0_0 vdout0_0ck196 = 1.1 time = 985
* CHECK dout0_1 vdout0_1ck196 = 1.1 time = 985
* CHECK dout0_2 vdout0_2ck196 = 0 time = 985
* CHECK dout0_3 vdout0_3ck196 = 1.1 time = 985
* CHECK dout0_4 vdout0_4ck196 = 0 time = 985
* CHECK dout0_5 vdout0_5ck196 = 1.1 time = 985
* CHECK dout0_6 vdout0_6ck196 = 1.1 time = 985
* CHECK dout0_7 vdout0_7ck196 = 1.1 time = 985
* CHECK dout0_8 vdout0_8ck196 = 0 time = 985
* CHECK dout0_9 vdout0_9ck196 = 0 time = 985
* CHECK dout0_10 vdout0_10ck196 = 0 time = 985
* CHECK dout0_11 vdout0_11ck196 = 0 time = 985
* CHECK dout0_12 vdout0_12ck196 = 1.1 time = 985
* CHECK dout0_13 vdout0_13ck196 = 1.1 time = 985
* CHECK dout0_14 vdout0_14ck196 = 1.1 time = 985
* CHECK dout0_15 vdout0_15ck196 = 1.1 time = 985
* CHECK dout0_16 vdout0_16ck196 = 1.1 time = 985
* CHECK dout0_17 vdout0_17ck196 = 1.1 time = 985
* CHECK dout0_18 vdout0_18ck196 = 0 time = 985
* CHECK dout0_19 vdout0_19ck196 = 1.1 time = 985
* CHECK dout0_20 vdout0_20ck196 = 0 time = 985
* CHECK dout0_21 vdout0_21ck196 = 0 time = 985
* CHECK dout0_22 vdout0_22ck196 = 0 time = 985
* CHECK dout0_23 vdout0_23ck196 = 1.1 time = 985
* CHECK dout0_24 vdout0_24ck196 = 0 time = 985
* CHECK dout0_25 vdout0_25ck196 = 1.1 time = 985
* CHECK dout0_26 vdout0_26ck196 = 0 time = 985
* CHECK dout0_27 vdout0_27ck196 = 1.1 time = 985
* CHECK dout0_28 vdout0_28ck196 = 1.1 time = 985
* CHECK dout0_29 vdout0_29ck196 = 1.1 time = 985
* CHECK dout0_30 vdout0_30ck196 = 0 time = 985
* CHECK dout0_31 vdout0_31ck196 = 1.1 time = 985
* CHECK dout0_0 vdout0_0ck201 = 1.1 time = 1010
* CHECK dout0_1 vdout0_1ck201 = 1.1 time = 1010
* CHECK dout0_2 vdout0_2ck201 = 1.1 time = 1010
* CHECK dout0_3 vdout0_3ck201 = 0 time = 1010
* CHECK dout0_4 vdout0_4ck201 = 0 time = 1010
* CHECK dout0_5 vdout0_5ck201 = 1.1 time = 1010
* CHECK dout0_6 vdout0_6ck201 = 1.1 time = 1010
* CHECK dout0_7 vdout0_7ck201 = 1.1 time = 1010
* CHECK dout0_8 vdout0_8ck201 = 1.1 time = 1010
* CHECK dout0_9 vdout0_9ck201 = 0 time = 1010
* CHECK dout0_10 vdout0_10ck201 = 1.1 time = 1010
* CHECK dout0_11 vdout0_11ck201 = 0 time = 1010
* CHECK dout0_12 vdout0_12ck201 = 0 time = 1010
* CHECK dout0_13 vdout0_13ck201 = 0 time = 1010
* CHECK dout0_14 vdout0_14ck201 = 0 time = 1010
* CHECK dout0_15 vdout0_15ck201 = 0 time = 1010
* CHECK dout0_16 vdout0_16ck201 = 1.1 time = 1010
* CHECK dout0_17 vdout0_17ck201 = 0 time = 1010
* CHECK dout0_18 vdout0_18ck201 = 0 time = 1010
* CHECK dout0_19 vdout0_19ck201 = 1.1 time = 1010
* CHECK dout0_20 vdout0_20ck201 = 1.1 time = 1010
* CHECK dout0_21 vdout0_21ck201 = 1.1 time = 1010
* CHECK dout0_22 vdout0_22ck201 = 0 time = 1010
* CHECK dout0_23 vdout0_23ck201 = 0 time = 1010
* CHECK dout0_24 vdout0_24ck201 = 1.1 time = 1010
* CHECK dout0_25 vdout0_25ck201 = 1.1 time = 1010
* CHECK dout0_26 vdout0_26ck201 = 0 time = 1010
* CHECK dout0_27 vdout0_27ck201 = 1.1 time = 1010
* CHECK dout0_28 vdout0_28ck201 = 1.1 time = 1010
* CHECK dout0_29 vdout0_29ck201 = 0 time = 1010
* CHECK dout0_30 vdout0_30ck201 = 0 time = 1010
* CHECK dout0_31 vdout0_31ck201 = 0 time = 1010
* CHECK dout0_0 vdout0_0ck203 = 1.1 time = 1020
* CHECK dout0_1 vdout0_1ck203 = 1.1 time = 1020
* CHECK dout0_2 vdout0_2ck203 = 1.1 time = 1020
* CHECK dout0_3 vdout0_3ck203 = 0 time = 1020
* CHECK dout0_4 vdout0_4ck203 = 0 time = 1020
* CHECK dout0_5 vdout0_5ck203 = 1.1 time = 1020
* CHECK dout0_6 vdout0_6ck203 = 1.1 time = 1020
* CHECK dout0_7 vdout0_7ck203 = 1.1 time = 1020
* CHECK dout0_8 vdout0_8ck203 = 1.1 time = 1020
* CHECK dout0_9 vdout0_9ck203 = 0 time = 1020
* CHECK dout0_10 vdout0_10ck203 = 1.1 time = 1020
* CHECK dout0_11 vdout0_11ck203 = 0 time = 1020
* CHECK dout0_12 vdout0_12ck203 = 0 time = 1020
* CHECK dout0_13 vdout0_13ck203 = 0 time = 1020
* CHECK dout0_14 vdout0_14ck203 = 0 time = 1020
* CHECK dout0_15 vdout0_15ck203 = 0 time = 1020
* CHECK dout0_16 vdout0_16ck203 = 1.1 time = 1020
* CHECK dout0_17 vdout0_17ck203 = 0 time = 1020
* CHECK dout0_18 vdout0_18ck203 = 0 time = 1020
* CHECK dout0_19 vdout0_19ck203 = 1.1 time = 1020
* CHECK dout0_20 vdout0_20ck203 = 1.1 time = 1020
* CHECK dout0_21 vdout0_21ck203 = 1.1 time = 1020
* CHECK dout0_22 vdout0_22ck203 = 0 time = 1020
* CHECK dout0_23 vdout0_23ck203 = 0 time = 1020
* CHECK dout0_24 vdout0_24ck203 = 1.1 time = 1020
* CHECK dout0_25 vdout0_25ck203 = 1.1 time = 1020
* CHECK dout0_26 vdout0_26ck203 = 0 time = 1020
* CHECK dout0_27 vdout0_27ck203 = 1.1 time = 1020
* CHECK dout0_28 vdout0_28ck203 = 1.1 time = 1020
* CHECK dout0_29 vdout0_29ck203 = 0 time = 1020
* CHECK dout0_30 vdout0_30ck203 = 0 time = 1020
* CHECK dout0_31 vdout0_31ck203 = 0 time = 1020
* CHECK dout0_0 vdout0_0ck204 = 1.1 time = 1025
* CHECK dout0_1 vdout0_1ck204 = 1.1 time = 1025
* CHECK dout0_2 vdout0_2ck204 = 1.1 time = 1025
* CHECK dout0_3 vdout0_3ck204 = 0 time = 1025
* CHECK dout0_4 vdout0_4ck204 = 0 time = 1025
* CHECK dout0_5 vdout0_5ck204 = 1.1 time = 1025
* CHECK dout0_6 vdout0_6ck204 = 1.1 time = 1025
* CHECK dout0_7 vdout0_7ck204 = 1.1 time = 1025
* CHECK dout0_8 vdout0_8ck204 = 1.1 time = 1025
* CHECK dout0_9 vdout0_9ck204 = 0 time = 1025
* CHECK dout0_10 vdout0_10ck204 = 1.1 time = 1025
* CHECK dout0_11 vdout0_11ck204 = 0 time = 1025
* CHECK dout0_12 vdout0_12ck204 = 0 time = 1025
* CHECK dout0_13 vdout0_13ck204 = 0 time = 1025
* CHECK dout0_14 vdout0_14ck204 = 0 time = 1025
* CHECK dout0_15 vdout0_15ck204 = 0 time = 1025
* CHECK dout0_16 vdout0_16ck204 = 1.1 time = 1025
* CHECK dout0_17 vdout0_17ck204 = 0 time = 1025
* CHECK dout0_18 vdout0_18ck204 = 0 time = 1025
* CHECK dout0_19 vdout0_19ck204 = 1.1 time = 1025
* CHECK dout0_20 vdout0_20ck204 = 1.1 time = 1025
* CHECK dout0_21 vdout0_21ck204 = 1.1 time = 1025
* CHECK dout0_22 vdout0_22ck204 = 0 time = 1025
* CHECK dout0_23 vdout0_23ck204 = 0 time = 1025
* CHECK dout0_24 vdout0_24ck204 = 1.1 time = 1025
* CHECK dout0_25 vdout0_25ck204 = 1.1 time = 1025
* CHECK dout0_26 vdout0_26ck204 = 0 time = 1025
* CHECK dout0_27 vdout0_27ck204 = 1.1 time = 1025
* CHECK dout0_28 vdout0_28ck204 = 1.1 time = 1025
* CHECK dout0_29 vdout0_29ck204 = 0 time = 1025
* CHECK dout0_30 vdout0_30ck204 = 0 time = 1025
* CHECK dout0_31 vdout0_31ck204 = 0 time = 1025
.include /home/kuoping/Projects/jv32/syn/lib/openram/./functional_meas.sp
* probe is used for hspice/xa, while plot is used in ngspice
*.probe V(*)
*.plot V(*)
.end
